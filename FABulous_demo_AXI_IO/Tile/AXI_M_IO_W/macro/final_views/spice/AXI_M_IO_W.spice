* NGSPICE file created from AXI_M_IO_W.ext - technology: ihp-sg13cmos5l

* Black-box entry subcircuit for sg13cmos5l_antennanp abstract view
.subckt sg13cmos5l_antennanp A VDD VSS
.ends

* Black-box entry subcircuit for sg13cmos5l_fill_2 abstract view
.subckt sg13cmos5l_fill_2 VDD VSS
.ends

* Black-box entry subcircuit for sg13cmos5l_decap_4 abstract view
.subckt sg13cmos5l_decap_4 VDD VSS
.ends

* Black-box entry subcircuit for sg13cmos5l_dlhq_1 abstract view
.subckt sg13cmos5l_dlhq_1 Q D GATE VDD VSS
.ends

* Black-box entry subcircuit for sg13cmos5l_decap_8 abstract view
.subckt sg13cmos5l_decap_8 VDD VSS
.ends

* Black-box entry subcircuit for sg13cmos5l_fill_1 abstract view
.subckt sg13cmos5l_fill_1 VDD VSS
.ends

* Black-box entry subcircuit for sg13cmos5l_mux4_1 abstract view
.subckt sg13cmos5l_mux4_1 X A0 A1 A2 A3 S0 S1 VDD VSS
.ends

* Black-box entry subcircuit for sg13cmos5l_buf_1 abstract view
.subckt sg13cmos5l_buf_1 X A VDD VSS
.ends

* Black-box entry subcircuit for sg13cmos5l_mux2_1 abstract view
.subckt sg13cmos5l_mux2_1 X A0 A1 S VDD VSS
.ends

* Black-box entry subcircuit for sg13cmos5l_a21oi_1 abstract view
.subckt sg13cmos5l_a21oi_1 Y A1 A2 B1 VDD VSS
.ends

* Black-box entry subcircuit for sg13cmos5l_nand3b_1 abstract view
.subckt sg13cmos5l_nand3b_1 Y A_N B C VDD VSS
.ends

* Black-box entry subcircuit for sg13cmos5l_nor2b_1 abstract view
.subckt sg13cmos5l_nor2b_1 Y A B_N VDD VSS
.ends

* Black-box entry subcircuit for sg13cmos5l_o21ai_1 abstract view
.subckt sg13cmos5l_o21ai_1 Y A1 A2 B1 VDD VSS
.ends

* Black-box entry subcircuit for sg13cmos5l_a21o_1 abstract view
.subckt sg13cmos5l_a21o_1 X A1 A2 B1 VDD VSS
.ends

* Black-box entry subcircuit for sg13cmos5l_nor3_1 abstract view
.subckt sg13cmos5l_nor3_1 Y A B C VDD VSS
.ends

* Black-box entry subcircuit for sg13cmos5l_a221oi_1 abstract view
.subckt sg13cmos5l_a221oi_1 Y A1 A2 B1 B2 C1 VDD VSS
.ends

* Black-box entry subcircuit for sg13cmos5l_nand2b_1 abstract view
.subckt sg13cmos5l_nand2b_1 Y A_N B VDD VSS
.ends

* Black-box entry subcircuit for sg13cmos5l_nor2_1 abstract view
.subckt sg13cmos5l_nor2_1 Y A B VDD VSS
.ends

* Black-box entry subcircuit for sg13cmos5l_inv_1 abstract view
.subckt sg13cmos5l_inv_1 Y A VDD VSS
.ends

* Black-box entry subcircuit for sg13cmos5l_or2_1 abstract view
.subckt sg13cmos5l_or2_1 X A B VDD VSS
.ends

* Black-box entry subcircuit for sg13cmos5l_nand3_1 abstract view
.subckt sg13cmos5l_nand3_1 Y A B C VDD VSS
.ends

* Black-box entry subcircuit for sg13cmos5l_nand2_1 abstract view
.subckt sg13cmos5l_nand2_1 Y A B VDD VSS
.ends

.subckt AXI_M_IO_W AXI_M_SOC_ARADDR0 AXI_M_SOC_ARADDR1 AXI_M_SOC_ARADDR10 AXI_M_SOC_ARADDR11
+ AXI_M_SOC_ARADDR12 AXI_M_SOC_ARADDR13 AXI_M_SOC_ARADDR14 AXI_M_SOC_ARADDR15 AXI_M_SOC_ARADDR16
+ AXI_M_SOC_ARADDR17 AXI_M_SOC_ARADDR18 AXI_M_SOC_ARADDR19 AXI_M_SOC_ARADDR2 AXI_M_SOC_ARADDR20
+ AXI_M_SOC_ARADDR21 AXI_M_SOC_ARADDR22 AXI_M_SOC_ARADDR23 AXI_M_SOC_ARADDR24 AXI_M_SOC_ARADDR25
+ AXI_M_SOC_ARADDR26 AXI_M_SOC_ARADDR27 AXI_M_SOC_ARADDR28 AXI_M_SOC_ARADDR29 AXI_M_SOC_ARADDR3
+ AXI_M_SOC_ARADDR30 AXI_M_SOC_ARADDR31 AXI_M_SOC_ARADDR4 AXI_M_SOC_ARADDR5 AXI_M_SOC_ARADDR6
+ AXI_M_SOC_ARADDR7 AXI_M_SOC_ARADDR8 AXI_M_SOC_ARADDR9 AXI_M_SOC_ARBURST0 AXI_M_SOC_ARBURST1
+ AXI_M_SOC_ARLEN0 AXI_M_SOC_ARLEN1 AXI_M_SOC_ARLEN2 AXI_M_SOC_ARLEN3 AXI_M_SOC_ARLEN4
+ AXI_M_SOC_ARLEN5 AXI_M_SOC_ARLEN6 AXI_M_SOC_ARLEN7 AXI_M_SOC_ARREADY AXI_M_SOC_ARSIZE0
+ AXI_M_SOC_ARSIZE1 AXI_M_SOC_ARSIZE2 AXI_M_SOC_ARVALID AXI_M_SOC_AWADDR0 AXI_M_SOC_AWADDR1
+ AXI_M_SOC_AWADDR10 AXI_M_SOC_AWADDR11 AXI_M_SOC_AWADDR12 AXI_M_SOC_AWADDR13 AXI_M_SOC_AWADDR14
+ AXI_M_SOC_AWADDR15 AXI_M_SOC_AWADDR16 AXI_M_SOC_AWADDR17 AXI_M_SOC_AWADDR18 AXI_M_SOC_AWADDR19
+ AXI_M_SOC_AWADDR2 AXI_M_SOC_AWADDR20 AXI_M_SOC_AWADDR21 AXI_M_SOC_AWADDR22 AXI_M_SOC_AWADDR23
+ AXI_M_SOC_AWADDR24 AXI_M_SOC_AWADDR25 AXI_M_SOC_AWADDR26 AXI_M_SOC_AWADDR27 AXI_M_SOC_AWADDR28
+ AXI_M_SOC_AWADDR29 AXI_M_SOC_AWADDR3 AXI_M_SOC_AWADDR30 AXI_M_SOC_AWADDR31 AXI_M_SOC_AWADDR4
+ AXI_M_SOC_AWADDR5 AXI_M_SOC_AWADDR6 AXI_M_SOC_AWADDR7 AXI_M_SOC_AWADDR8 AXI_M_SOC_AWADDR9
+ AXI_M_SOC_AWBURST0 AXI_M_SOC_AWBURST1 AXI_M_SOC_AWLEN0 AXI_M_SOC_AWLEN1 AXI_M_SOC_AWLEN2
+ AXI_M_SOC_AWLEN3 AXI_M_SOC_AWLEN4 AXI_M_SOC_AWLEN5 AXI_M_SOC_AWLEN6 AXI_M_SOC_AWLEN7
+ AXI_M_SOC_AWREADY AXI_M_SOC_AWSIZE0 AXI_M_SOC_AWSIZE1 AXI_M_SOC_AWSIZE2 AXI_M_SOC_AWVALID
+ AXI_M_SOC_BREADY AXI_M_SOC_BRESP0 AXI_M_SOC_BRESP1 AXI_M_SOC_BVALID AXI_M_SOC_RDATA0
+ AXI_M_SOC_RDATA1 AXI_M_SOC_RDATA10 AXI_M_SOC_RDATA11 AXI_M_SOC_RDATA12 AXI_M_SOC_RDATA13
+ AXI_M_SOC_RDATA14 AXI_M_SOC_RDATA15 AXI_M_SOC_RDATA16 AXI_M_SOC_RDATA17 AXI_M_SOC_RDATA18
+ AXI_M_SOC_RDATA19 AXI_M_SOC_RDATA2 AXI_M_SOC_RDATA20 AXI_M_SOC_RDATA21 AXI_M_SOC_RDATA22
+ AXI_M_SOC_RDATA23 AXI_M_SOC_RDATA24 AXI_M_SOC_RDATA25 AXI_M_SOC_RDATA26 AXI_M_SOC_RDATA27
+ AXI_M_SOC_RDATA28 AXI_M_SOC_RDATA29 AXI_M_SOC_RDATA3 AXI_M_SOC_RDATA30 AXI_M_SOC_RDATA31
+ AXI_M_SOC_RDATA4 AXI_M_SOC_RDATA5 AXI_M_SOC_RDATA6 AXI_M_SOC_RDATA7 AXI_M_SOC_RDATA8
+ AXI_M_SOC_RDATA9 AXI_M_SOC_RLAST AXI_M_SOC_RREADY AXI_M_SOC_RRESP0 AXI_M_SOC_RRESP1
+ AXI_M_SOC_RVALID AXI_M_SOC_WDATA0 AXI_M_SOC_WDATA1 AXI_M_SOC_WDATA10 AXI_M_SOC_WDATA11
+ AXI_M_SOC_WDATA12 AXI_M_SOC_WDATA13 AXI_M_SOC_WDATA14 AXI_M_SOC_WDATA15 AXI_M_SOC_WDATA16
+ AXI_M_SOC_WDATA17 AXI_M_SOC_WDATA18 AXI_M_SOC_WDATA19 AXI_M_SOC_WDATA2 AXI_M_SOC_WDATA20
+ AXI_M_SOC_WDATA21 AXI_M_SOC_WDATA22 AXI_M_SOC_WDATA23 AXI_M_SOC_WDATA24 AXI_M_SOC_WDATA25
+ AXI_M_SOC_WDATA26 AXI_M_SOC_WDATA27 AXI_M_SOC_WDATA28 AXI_M_SOC_WDATA29 AXI_M_SOC_WDATA3
+ AXI_M_SOC_WDATA30 AXI_M_SOC_WDATA31 AXI_M_SOC_WDATA4 AXI_M_SOC_WDATA5 AXI_M_SOC_WDATA6
+ AXI_M_SOC_WDATA7 AXI_M_SOC_WDATA8 AXI_M_SOC_WDATA9 AXI_M_SOC_WLAST AXI_M_SOC_WREADY
+ AXI_M_SOC_WSTRB0 AXI_M_SOC_WSTRB1 AXI_M_SOC_WSTRB2 AXI_M_SOC_WSTRB3 AXI_M_SOC_WVALID
+ Tile_X0Y0_E1BEG[0] Tile_X0Y0_E1BEG[1] Tile_X0Y0_E1BEG[2] Tile_X0Y0_E1BEG[3] Tile_X0Y0_E2BEG[0]
+ Tile_X0Y0_E2BEG[1] Tile_X0Y0_E2BEG[2] Tile_X0Y0_E2BEG[3] Tile_X0Y0_E2BEG[4] Tile_X0Y0_E2BEG[5]
+ Tile_X0Y0_E2BEG[6] Tile_X0Y0_E2BEG[7] Tile_X0Y0_E2BEGb[0] Tile_X0Y0_E2BEGb[1] Tile_X0Y0_E2BEGb[2]
+ Tile_X0Y0_E2BEGb[3] Tile_X0Y0_E2BEGb[4] Tile_X0Y0_E2BEGb[5] Tile_X0Y0_E2BEGb[6]
+ Tile_X0Y0_E2BEGb[7] Tile_X0Y0_E6BEG[0] Tile_X0Y0_E6BEG[10] Tile_X0Y0_E6BEG[11] Tile_X0Y0_E6BEG[1]
+ Tile_X0Y0_E6BEG[2] Tile_X0Y0_E6BEG[3] Tile_X0Y0_E6BEG[4] Tile_X0Y0_E6BEG[5] Tile_X0Y0_E6BEG[6]
+ Tile_X0Y0_E6BEG[7] Tile_X0Y0_E6BEG[8] Tile_X0Y0_E6BEG[9] Tile_X0Y0_EE4BEG[0] Tile_X0Y0_EE4BEG[10]
+ Tile_X0Y0_EE4BEG[11] Tile_X0Y0_EE4BEG[12] Tile_X0Y0_EE4BEG[13] Tile_X0Y0_EE4BEG[14]
+ Tile_X0Y0_EE4BEG[15] Tile_X0Y0_EE4BEG[1] Tile_X0Y0_EE4BEG[2] Tile_X0Y0_EE4BEG[3]
+ Tile_X0Y0_EE4BEG[4] Tile_X0Y0_EE4BEG[5] Tile_X0Y0_EE4BEG[6] Tile_X0Y0_EE4BEG[7]
+ Tile_X0Y0_EE4BEG[8] Tile_X0Y0_EE4BEG[9] Tile_X0Y0_FrameData[0] Tile_X0Y0_FrameData[10]
+ Tile_X0Y0_FrameData[11] Tile_X0Y0_FrameData[12] Tile_X0Y0_FrameData[13] Tile_X0Y0_FrameData[14]
+ Tile_X0Y0_FrameData[15] Tile_X0Y0_FrameData[16] Tile_X0Y0_FrameData[17] Tile_X0Y0_FrameData[18]
+ Tile_X0Y0_FrameData[19] Tile_X0Y0_FrameData[1] Tile_X0Y0_FrameData[20] Tile_X0Y0_FrameData[21]
+ Tile_X0Y0_FrameData[22] Tile_X0Y0_FrameData[23] Tile_X0Y0_FrameData[24] Tile_X0Y0_FrameData[25]
+ Tile_X0Y0_FrameData[26] Tile_X0Y0_FrameData[27] Tile_X0Y0_FrameData[28] Tile_X0Y0_FrameData[29]
+ Tile_X0Y0_FrameData[2] Tile_X0Y0_FrameData[30] Tile_X0Y0_FrameData[31] Tile_X0Y0_FrameData[3]
+ Tile_X0Y0_FrameData[4] Tile_X0Y0_FrameData[5] Tile_X0Y0_FrameData[6] Tile_X0Y0_FrameData[7]
+ Tile_X0Y0_FrameData[8] Tile_X0Y0_FrameData[9] Tile_X0Y0_FrameData_O[0] Tile_X0Y0_FrameData_O[10]
+ Tile_X0Y0_FrameData_O[11] Tile_X0Y0_FrameData_O[12] Tile_X0Y0_FrameData_O[13] Tile_X0Y0_FrameData_O[14]
+ Tile_X0Y0_FrameData_O[15] Tile_X0Y0_FrameData_O[16] Tile_X0Y0_FrameData_O[17] Tile_X0Y0_FrameData_O[18]
+ Tile_X0Y0_FrameData_O[19] Tile_X0Y0_FrameData_O[1] Tile_X0Y0_FrameData_O[20] Tile_X0Y0_FrameData_O[21]
+ Tile_X0Y0_FrameData_O[22] Tile_X0Y0_FrameData_O[23] Tile_X0Y0_FrameData_O[24] Tile_X0Y0_FrameData_O[25]
+ Tile_X0Y0_FrameData_O[26] Tile_X0Y0_FrameData_O[27] Tile_X0Y0_FrameData_O[28] Tile_X0Y0_FrameData_O[29]
+ Tile_X0Y0_FrameData_O[2] Tile_X0Y0_FrameData_O[30] Tile_X0Y0_FrameData_O[31] Tile_X0Y0_FrameData_O[3]
+ Tile_X0Y0_FrameData_O[4] Tile_X0Y0_FrameData_O[5] Tile_X0Y0_FrameData_O[6] Tile_X0Y0_FrameData_O[7]
+ Tile_X0Y0_FrameData_O[8] Tile_X0Y0_FrameData_O[9] Tile_X0Y0_FrameStrobe_O[0] Tile_X0Y0_FrameStrobe_O[10]
+ Tile_X0Y0_FrameStrobe_O[11] Tile_X0Y0_FrameStrobe_O[12] Tile_X0Y0_FrameStrobe_O[13]
+ Tile_X0Y0_FrameStrobe_O[14] Tile_X0Y0_FrameStrobe_O[15] Tile_X0Y0_FrameStrobe_O[16]
+ Tile_X0Y0_FrameStrobe_O[17] Tile_X0Y0_FrameStrobe_O[18] Tile_X0Y0_FrameStrobe_O[19]
+ Tile_X0Y0_FrameStrobe_O[1] Tile_X0Y0_FrameStrobe_O[2] Tile_X0Y0_FrameStrobe_O[3]
+ Tile_X0Y0_FrameStrobe_O[4] Tile_X0Y0_FrameStrobe_O[5] Tile_X0Y0_FrameStrobe_O[6]
+ Tile_X0Y0_FrameStrobe_O[7] Tile_X0Y0_FrameStrobe_O[8] Tile_X0Y0_FrameStrobe_O[9]
+ Tile_X0Y0_N1BEG[0] Tile_X0Y0_N1BEG[1] Tile_X0Y0_N1BEG[2] Tile_X0Y0_N1BEG[3] Tile_X0Y0_N2BEG[0]
+ Tile_X0Y0_N2BEG[1] Tile_X0Y0_N2BEG[2] Tile_X0Y0_N2BEG[3] Tile_X0Y0_N2BEG[4] Tile_X0Y0_N2BEG[5]
+ Tile_X0Y0_N2BEG[6] Tile_X0Y0_N2BEG[7] Tile_X0Y0_N2BEGb[0] Tile_X0Y0_N2BEGb[1] Tile_X0Y0_N2BEGb[2]
+ Tile_X0Y0_N2BEGb[3] Tile_X0Y0_N2BEGb[4] Tile_X0Y0_N2BEGb[5] Tile_X0Y0_N2BEGb[6]
+ Tile_X0Y0_N2BEGb[7] Tile_X0Y0_N4BEG[0] Tile_X0Y0_N4BEG[10] Tile_X0Y0_N4BEG[11] Tile_X0Y0_N4BEG[12]
+ Tile_X0Y0_N4BEG[13] Tile_X0Y0_N4BEG[14] Tile_X0Y0_N4BEG[15] Tile_X0Y0_N4BEG[1] Tile_X0Y0_N4BEG[2]
+ Tile_X0Y0_N4BEG[3] Tile_X0Y0_N4BEG[4] Tile_X0Y0_N4BEG[5] Tile_X0Y0_N4BEG[6] Tile_X0Y0_N4BEG[7]
+ Tile_X0Y0_N4BEG[8] Tile_X0Y0_N4BEG[9] Tile_X0Y0_S1END[0] Tile_X0Y0_S1END[1] Tile_X0Y0_S1END[2]
+ Tile_X0Y0_S1END[3] Tile_X0Y0_S2END[0] Tile_X0Y0_S2END[1] Tile_X0Y0_S2END[2] Tile_X0Y0_S2END[3]
+ Tile_X0Y0_S2END[4] Tile_X0Y0_S2END[5] Tile_X0Y0_S2END[6] Tile_X0Y0_S2END[7] Tile_X0Y0_S2MID[0]
+ Tile_X0Y0_S2MID[1] Tile_X0Y0_S2MID[2] Tile_X0Y0_S2MID[3] Tile_X0Y0_S2MID[4] Tile_X0Y0_S2MID[5]
+ Tile_X0Y0_S2MID[6] Tile_X0Y0_S2MID[7] Tile_X0Y0_S4END[0] Tile_X0Y0_S4END[10] Tile_X0Y0_S4END[11]
+ Tile_X0Y0_S4END[12] Tile_X0Y0_S4END[13] Tile_X0Y0_S4END[14] Tile_X0Y0_S4END[15]
+ Tile_X0Y0_S4END[1] Tile_X0Y0_S4END[2] Tile_X0Y0_S4END[3] Tile_X0Y0_S4END[4] Tile_X0Y0_S4END[5]
+ Tile_X0Y0_S4END[6] Tile_X0Y0_S4END[7] Tile_X0Y0_S4END[8] Tile_X0Y0_S4END[9] Tile_X0Y0_UserCLK
+ Tile_X0Y0_UserCLKo Tile_X0Y0_W1END[0] Tile_X0Y0_W1END[1] Tile_X0Y0_W1END[2] Tile_X0Y0_W1END[3]
+ Tile_X0Y0_W2END[0] Tile_X0Y0_W2END[1] Tile_X0Y0_W2END[2] Tile_X0Y0_W2END[3] Tile_X0Y0_W2END[4]
+ Tile_X0Y0_W2END[5] Tile_X0Y0_W2END[6] Tile_X0Y0_W2END[7] Tile_X0Y0_W2MID[0] Tile_X0Y0_W2MID[1]
+ Tile_X0Y0_W2MID[2] Tile_X0Y0_W2MID[3] Tile_X0Y0_W2MID[4] Tile_X0Y0_W2MID[5] Tile_X0Y0_W2MID[6]
+ Tile_X0Y0_W2MID[7] Tile_X0Y0_W6END[0] Tile_X0Y0_W6END[10] Tile_X0Y0_W6END[11] Tile_X0Y0_W6END[1]
+ Tile_X0Y0_W6END[2] Tile_X0Y0_W6END[3] Tile_X0Y0_W6END[4] Tile_X0Y0_W6END[5] Tile_X0Y0_W6END[6]
+ Tile_X0Y0_W6END[7] Tile_X0Y0_W6END[8] Tile_X0Y0_W6END[9] Tile_X0Y0_WW4END[0] Tile_X0Y0_WW4END[10]
+ Tile_X0Y0_WW4END[11] Tile_X0Y0_WW4END[12] Tile_X0Y0_WW4END[13] Tile_X0Y0_WW4END[14]
+ Tile_X0Y0_WW4END[15] Tile_X0Y0_WW4END[1] Tile_X0Y0_WW4END[2] Tile_X0Y0_WW4END[3]
+ Tile_X0Y0_WW4END[4] Tile_X0Y0_WW4END[5] Tile_X0Y0_WW4END[6] Tile_X0Y0_WW4END[7]
+ Tile_X0Y0_WW4END[8] Tile_X0Y0_WW4END[9] Tile_X0Y1_E1BEG[0] Tile_X0Y1_E1BEG[1] Tile_X0Y1_E1BEG[2]
+ Tile_X0Y1_E1BEG[3] Tile_X0Y1_E2BEG[0] Tile_X0Y1_E2BEG[1] Tile_X0Y1_E2BEG[2] Tile_X0Y1_E2BEG[3]
+ Tile_X0Y1_E2BEG[4] Tile_X0Y1_E2BEG[5] Tile_X0Y1_E2BEG[6] Tile_X0Y1_E2BEG[7] Tile_X0Y1_E2BEGb[0]
+ Tile_X0Y1_E2BEGb[1] Tile_X0Y1_E2BEGb[2] Tile_X0Y1_E2BEGb[3] Tile_X0Y1_E2BEGb[4]
+ Tile_X0Y1_E2BEGb[5] Tile_X0Y1_E2BEGb[6] Tile_X0Y1_E2BEGb[7] Tile_X0Y1_E6BEG[0] Tile_X0Y1_E6BEG[10]
+ Tile_X0Y1_E6BEG[11] Tile_X0Y1_E6BEG[1] Tile_X0Y1_E6BEG[2] Tile_X0Y1_E6BEG[3] Tile_X0Y1_E6BEG[4]
+ Tile_X0Y1_E6BEG[5] Tile_X0Y1_E6BEG[6] Tile_X0Y1_E6BEG[7] Tile_X0Y1_E6BEG[8] Tile_X0Y1_E6BEG[9]
+ Tile_X0Y1_EE4BEG[0] Tile_X0Y1_EE4BEG[10] Tile_X0Y1_EE4BEG[11] Tile_X0Y1_EE4BEG[12]
+ Tile_X0Y1_EE4BEG[13] Tile_X0Y1_EE4BEG[14] Tile_X0Y1_EE4BEG[15] Tile_X0Y1_EE4BEG[1]
+ Tile_X0Y1_EE4BEG[2] Tile_X0Y1_EE4BEG[3] Tile_X0Y1_EE4BEG[4] Tile_X0Y1_EE4BEG[5]
+ Tile_X0Y1_EE4BEG[6] Tile_X0Y1_EE4BEG[7] Tile_X0Y1_EE4BEG[8] Tile_X0Y1_EE4BEG[9]
+ Tile_X0Y1_FrameData[0] Tile_X0Y1_FrameData[10] Tile_X0Y1_FrameData[11] Tile_X0Y1_FrameData[12]
+ Tile_X0Y1_FrameData[13] Tile_X0Y1_FrameData[14] Tile_X0Y1_FrameData[15] Tile_X0Y1_FrameData[16]
+ Tile_X0Y1_FrameData[17] Tile_X0Y1_FrameData[18] Tile_X0Y1_FrameData[19] Tile_X0Y1_FrameData[1]
+ Tile_X0Y1_FrameData[20] Tile_X0Y1_FrameData[21] Tile_X0Y1_FrameData[22] Tile_X0Y1_FrameData[23]
+ Tile_X0Y1_FrameData[24] Tile_X0Y1_FrameData[25] Tile_X0Y1_FrameData[26] Tile_X0Y1_FrameData[27]
+ Tile_X0Y1_FrameData[28] Tile_X0Y1_FrameData[29] Tile_X0Y1_FrameData[2] Tile_X0Y1_FrameData[30]
+ Tile_X0Y1_FrameData[31] Tile_X0Y1_FrameData[3] Tile_X0Y1_FrameData[4] Tile_X0Y1_FrameData[5]
+ Tile_X0Y1_FrameData[6] Tile_X0Y1_FrameData[7] Tile_X0Y1_FrameData[8] Tile_X0Y1_FrameData[9]
+ Tile_X0Y1_FrameData_O[0] Tile_X0Y1_FrameData_O[10] Tile_X0Y1_FrameData_O[11] Tile_X0Y1_FrameData_O[12]
+ Tile_X0Y1_FrameData_O[13] Tile_X0Y1_FrameData_O[14] Tile_X0Y1_FrameData_O[15] Tile_X0Y1_FrameData_O[16]
+ Tile_X0Y1_FrameData_O[17] Tile_X0Y1_FrameData_O[18] Tile_X0Y1_FrameData_O[19] Tile_X0Y1_FrameData_O[1]
+ Tile_X0Y1_FrameData_O[20] Tile_X0Y1_FrameData_O[21] Tile_X0Y1_FrameData_O[22] Tile_X0Y1_FrameData_O[23]
+ Tile_X0Y1_FrameData_O[24] Tile_X0Y1_FrameData_O[25] Tile_X0Y1_FrameData_O[26] Tile_X0Y1_FrameData_O[27]
+ Tile_X0Y1_FrameData_O[28] Tile_X0Y1_FrameData_O[29] Tile_X0Y1_FrameData_O[2] Tile_X0Y1_FrameData_O[30]
+ Tile_X0Y1_FrameData_O[31] Tile_X0Y1_FrameData_O[3] Tile_X0Y1_FrameData_O[4] Tile_X0Y1_FrameData_O[5]
+ Tile_X0Y1_FrameData_O[6] Tile_X0Y1_FrameData_O[7] Tile_X0Y1_FrameData_O[8] Tile_X0Y1_FrameData_O[9]
+ Tile_X0Y1_UserCLK Tile_X0Y1_UserCLKo Tile_X0Y1_W1END[0] Tile_X0Y1_W1END[1] Tile_X0Y1_W1END[2]
+ Tile_X0Y1_W1END[3] Tile_X0Y1_W2END[0] Tile_X0Y1_W2END[1] Tile_X0Y1_W2END[2] Tile_X0Y1_W2END[3]
+ Tile_X0Y1_W2END[4] Tile_X0Y1_W2END[5] Tile_X0Y1_W2END[6] Tile_X0Y1_W2END[7] Tile_X0Y1_W2MID[0]
+ Tile_X0Y1_W2MID[1] Tile_X0Y1_W2MID[2] Tile_X0Y1_W2MID[3] Tile_X0Y1_W2MID[4] Tile_X0Y1_W2MID[5]
+ Tile_X0Y1_W2MID[6] Tile_X0Y1_W2MID[7] Tile_X0Y1_W6END[0] Tile_X0Y1_W6END[10] Tile_X0Y1_W6END[11]
+ Tile_X0Y1_W6END[1] Tile_X0Y1_W6END[2] Tile_X0Y1_W6END[3] Tile_X0Y1_W6END[4] Tile_X0Y1_W6END[5]
+ Tile_X0Y1_W6END[6] Tile_X0Y1_W6END[7] Tile_X0Y1_W6END[8] Tile_X0Y1_W6END[9] Tile_X0Y1_WW4END[0]
+ Tile_X0Y1_WW4END[10] Tile_X0Y1_WW4END[11] Tile_X0Y1_WW4END[12] Tile_X0Y1_WW4END[13]
+ Tile_X0Y1_WW4END[14] Tile_X0Y1_WW4END[15] Tile_X0Y1_WW4END[1] Tile_X0Y1_WW4END[2]
+ Tile_X0Y1_WW4END[3] Tile_X0Y1_WW4END[4] Tile_X0Y1_WW4END[5] Tile_X0Y1_WW4END[6]
+ Tile_X0Y1_WW4END[7] Tile_X0Y1_WW4END[8] Tile_X0Y1_WW4END[9] Tile_X0Y2_E1BEG[0] Tile_X0Y2_E1BEG[1]
+ Tile_X0Y2_E1BEG[2] Tile_X0Y2_E1BEG[3] Tile_X0Y2_E2BEG[0] Tile_X0Y2_E2BEG[1] Tile_X0Y2_E2BEG[2]
+ Tile_X0Y2_E2BEG[3] Tile_X0Y2_E2BEG[4] Tile_X0Y2_E2BEG[5] Tile_X0Y2_E2BEG[6] Tile_X0Y2_E2BEG[7]
+ Tile_X0Y2_E2BEGb[0] Tile_X0Y2_E2BEGb[1] Tile_X0Y2_E2BEGb[2] Tile_X0Y2_E2BEGb[3]
+ Tile_X0Y2_E2BEGb[4] Tile_X0Y2_E2BEGb[5] Tile_X0Y2_E2BEGb[6] Tile_X0Y2_E2BEGb[7]
+ Tile_X0Y2_E6BEG[0] Tile_X0Y2_E6BEG[10] Tile_X0Y2_E6BEG[11] Tile_X0Y2_E6BEG[1] Tile_X0Y2_E6BEG[2]
+ Tile_X0Y2_E6BEG[3] Tile_X0Y2_E6BEG[4] Tile_X0Y2_E6BEG[5] Tile_X0Y2_E6BEG[6] Tile_X0Y2_E6BEG[7]
+ Tile_X0Y2_E6BEG[8] Tile_X0Y2_E6BEG[9] Tile_X0Y2_EE4BEG[0] Tile_X0Y2_EE4BEG[10] Tile_X0Y2_EE4BEG[11]
+ Tile_X0Y2_EE4BEG[12] Tile_X0Y2_EE4BEG[13] Tile_X0Y2_EE4BEG[14] Tile_X0Y2_EE4BEG[15]
+ Tile_X0Y2_EE4BEG[1] Tile_X0Y2_EE4BEG[2] Tile_X0Y2_EE4BEG[3] Tile_X0Y2_EE4BEG[4]
+ Tile_X0Y2_EE4BEG[5] Tile_X0Y2_EE4BEG[6] Tile_X0Y2_EE4BEG[7] Tile_X0Y2_EE4BEG[8]
+ Tile_X0Y2_EE4BEG[9] Tile_X0Y2_FrameData[0] Tile_X0Y2_FrameData[10] Tile_X0Y2_FrameData[11]
+ Tile_X0Y2_FrameData[12] Tile_X0Y2_FrameData[13] Tile_X0Y2_FrameData[14] Tile_X0Y2_FrameData[15]
+ Tile_X0Y2_FrameData[16] Tile_X0Y2_FrameData[17] Tile_X0Y2_FrameData[18] Tile_X0Y2_FrameData[19]
+ Tile_X0Y2_FrameData[1] Tile_X0Y2_FrameData[20] Tile_X0Y2_FrameData[21] Tile_X0Y2_FrameData[22]
+ Tile_X0Y2_FrameData[23] Tile_X0Y2_FrameData[24] Tile_X0Y2_FrameData[25] Tile_X0Y2_FrameData[26]
+ Tile_X0Y2_FrameData[27] Tile_X0Y2_FrameData[28] Tile_X0Y2_FrameData[29] Tile_X0Y2_FrameData[2]
+ Tile_X0Y2_FrameData[30] Tile_X0Y2_FrameData[31] Tile_X0Y2_FrameData[3] Tile_X0Y2_FrameData[4]
+ Tile_X0Y2_FrameData[5] Tile_X0Y2_FrameData[6] Tile_X0Y2_FrameData[7] Tile_X0Y2_FrameData[8]
+ Tile_X0Y2_FrameData[9] Tile_X0Y2_FrameData_O[0] Tile_X0Y2_FrameData_O[10] Tile_X0Y2_FrameData_O[11]
+ Tile_X0Y2_FrameData_O[12] Tile_X0Y2_FrameData_O[13] Tile_X0Y2_FrameData_O[14] Tile_X0Y2_FrameData_O[15]
+ Tile_X0Y2_FrameData_O[16] Tile_X0Y2_FrameData_O[17] Tile_X0Y2_FrameData_O[18] Tile_X0Y2_FrameData_O[19]
+ Tile_X0Y2_FrameData_O[1] Tile_X0Y2_FrameData_O[20] Tile_X0Y2_FrameData_O[21] Tile_X0Y2_FrameData_O[22]
+ Tile_X0Y2_FrameData_O[23] Tile_X0Y2_FrameData_O[24] Tile_X0Y2_FrameData_O[25] Tile_X0Y2_FrameData_O[26]
+ Tile_X0Y2_FrameData_O[27] Tile_X0Y2_FrameData_O[28] Tile_X0Y2_FrameData_O[29] Tile_X0Y2_FrameData_O[2]
+ Tile_X0Y2_FrameData_O[30] Tile_X0Y2_FrameData_O[31] Tile_X0Y2_FrameData_O[3] Tile_X0Y2_FrameData_O[4]
+ Tile_X0Y2_FrameData_O[5] Tile_X0Y2_FrameData_O[6] Tile_X0Y2_FrameData_O[7] Tile_X0Y2_FrameData_O[8]
+ Tile_X0Y2_FrameData_O[9] Tile_X0Y2_UserCLK Tile_X0Y2_UserCLKo Tile_X0Y2_W1END[0]
+ Tile_X0Y2_W1END[1] Tile_X0Y2_W1END[2] Tile_X0Y2_W1END[3] Tile_X0Y2_W2END[0] Tile_X0Y2_W2END[1]
+ Tile_X0Y2_W2END[2] Tile_X0Y2_W2END[3] Tile_X0Y2_W2END[4] Tile_X0Y2_W2END[5] Tile_X0Y2_W2END[6]
+ Tile_X0Y2_W2END[7] Tile_X0Y2_W2MID[0] Tile_X0Y2_W2MID[1] Tile_X0Y2_W2MID[2] Tile_X0Y2_W2MID[3]
+ Tile_X0Y2_W2MID[4] Tile_X0Y2_W2MID[5] Tile_X0Y2_W2MID[6] Tile_X0Y2_W2MID[7] Tile_X0Y2_W6END[0]
+ Tile_X0Y2_W6END[10] Tile_X0Y2_W6END[11] Tile_X0Y2_W6END[1] Tile_X0Y2_W6END[2] Tile_X0Y2_W6END[3]
+ Tile_X0Y2_W6END[4] Tile_X0Y2_W6END[5] Tile_X0Y2_W6END[6] Tile_X0Y2_W6END[7] Tile_X0Y2_W6END[8]
+ Tile_X0Y2_W6END[9] Tile_X0Y2_WW4END[0] Tile_X0Y2_WW4END[10] Tile_X0Y2_WW4END[11]
+ Tile_X0Y2_WW4END[12] Tile_X0Y2_WW4END[13] Tile_X0Y2_WW4END[14] Tile_X0Y2_WW4END[15]
+ Tile_X0Y2_WW4END[1] Tile_X0Y2_WW4END[2] Tile_X0Y2_WW4END[3] Tile_X0Y2_WW4END[4]
+ Tile_X0Y2_WW4END[5] Tile_X0Y2_WW4END[6] Tile_X0Y2_WW4END[7] Tile_X0Y2_WW4END[8]
+ Tile_X0Y2_WW4END[9] Tile_X0Y3_E1BEG[0] Tile_X0Y3_E1BEG[1] Tile_X0Y3_E1BEG[2] Tile_X0Y3_E1BEG[3]
+ Tile_X0Y3_E2BEG[0] Tile_X0Y3_E2BEG[1] Tile_X0Y3_E2BEG[2] Tile_X0Y3_E2BEG[3] Tile_X0Y3_E2BEG[4]
+ Tile_X0Y3_E2BEG[5] Tile_X0Y3_E2BEG[6] Tile_X0Y3_E2BEG[7] Tile_X0Y3_E2BEGb[0] Tile_X0Y3_E2BEGb[1]
+ Tile_X0Y3_E2BEGb[2] Tile_X0Y3_E2BEGb[3] Tile_X0Y3_E2BEGb[4] Tile_X0Y3_E2BEGb[5]
+ Tile_X0Y3_E2BEGb[6] Tile_X0Y3_E2BEGb[7] Tile_X0Y3_E6BEG[0] Tile_X0Y3_E6BEG[10] Tile_X0Y3_E6BEG[11]
+ Tile_X0Y3_E6BEG[1] Tile_X0Y3_E6BEG[2] Tile_X0Y3_E6BEG[3] Tile_X0Y3_E6BEG[4] Tile_X0Y3_E6BEG[5]
+ Tile_X0Y3_E6BEG[6] Tile_X0Y3_E6BEG[7] Tile_X0Y3_E6BEG[8] Tile_X0Y3_E6BEG[9] Tile_X0Y3_EE4BEG[0]
+ Tile_X0Y3_EE4BEG[10] Tile_X0Y3_EE4BEG[11] Tile_X0Y3_EE4BEG[12] Tile_X0Y3_EE4BEG[13]
+ Tile_X0Y3_EE4BEG[14] Tile_X0Y3_EE4BEG[15] Tile_X0Y3_EE4BEG[1] Tile_X0Y3_EE4BEG[2]
+ Tile_X0Y3_EE4BEG[3] Tile_X0Y3_EE4BEG[4] Tile_X0Y3_EE4BEG[5] Tile_X0Y3_EE4BEG[6]
+ Tile_X0Y3_EE4BEG[7] Tile_X0Y3_EE4BEG[8] Tile_X0Y3_EE4BEG[9] Tile_X0Y3_FrameData[0]
+ Tile_X0Y3_FrameData[10] Tile_X0Y3_FrameData[11] Tile_X0Y3_FrameData[12] Tile_X0Y3_FrameData[13]
+ Tile_X0Y3_FrameData[14] Tile_X0Y3_FrameData[15] Tile_X0Y3_FrameData[16] Tile_X0Y3_FrameData[17]
+ Tile_X0Y3_FrameData[18] Tile_X0Y3_FrameData[19] Tile_X0Y3_FrameData[1] Tile_X0Y3_FrameData[20]
+ Tile_X0Y3_FrameData[21] Tile_X0Y3_FrameData[22] Tile_X0Y3_FrameData[23] Tile_X0Y3_FrameData[24]
+ Tile_X0Y3_FrameData[25] Tile_X0Y3_FrameData[26] Tile_X0Y3_FrameData[27] Tile_X0Y3_FrameData[28]
+ Tile_X0Y3_FrameData[29] Tile_X0Y3_FrameData[2] Tile_X0Y3_FrameData[30] Tile_X0Y3_FrameData[31]
+ Tile_X0Y3_FrameData[3] Tile_X0Y3_FrameData[4] Tile_X0Y3_FrameData[5] Tile_X0Y3_FrameData[6]
+ Tile_X0Y3_FrameData[7] Tile_X0Y3_FrameData[8] Tile_X0Y3_FrameData[9] Tile_X0Y3_FrameData_O[0]
+ Tile_X0Y3_FrameData_O[10] Tile_X0Y3_FrameData_O[11] Tile_X0Y3_FrameData_O[12] Tile_X0Y3_FrameData_O[13]
+ Tile_X0Y3_FrameData_O[14] Tile_X0Y3_FrameData_O[15] Tile_X0Y3_FrameData_O[16] Tile_X0Y3_FrameData_O[17]
+ Tile_X0Y3_FrameData_O[18] Tile_X0Y3_FrameData_O[19] Tile_X0Y3_FrameData_O[1] Tile_X0Y3_FrameData_O[20]
+ Tile_X0Y3_FrameData_O[21] Tile_X0Y3_FrameData_O[22] Tile_X0Y3_FrameData_O[23] Tile_X0Y3_FrameData_O[24]
+ Tile_X0Y3_FrameData_O[25] Tile_X0Y3_FrameData_O[26] Tile_X0Y3_FrameData_O[27] Tile_X0Y3_FrameData_O[28]
+ Tile_X0Y3_FrameData_O[29] Tile_X0Y3_FrameData_O[2] Tile_X0Y3_FrameData_O[30] Tile_X0Y3_FrameData_O[31]
+ Tile_X0Y3_FrameData_O[3] Tile_X0Y3_FrameData_O[4] Tile_X0Y3_FrameData_O[5] Tile_X0Y3_FrameData_O[6]
+ Tile_X0Y3_FrameData_O[7] Tile_X0Y3_FrameData_O[8] Tile_X0Y3_FrameData_O[9] Tile_X0Y3_UserCLK
+ Tile_X0Y3_UserCLKo Tile_X0Y3_W1END[0] Tile_X0Y3_W1END[1] Tile_X0Y3_W1END[2] Tile_X0Y3_W1END[3]
+ Tile_X0Y3_W2END[0] Tile_X0Y3_W2END[1] Tile_X0Y3_W2END[2] Tile_X0Y3_W2END[3] Tile_X0Y3_W2END[4]
+ Tile_X0Y3_W2END[5] Tile_X0Y3_W2END[6] Tile_X0Y3_W2END[7] Tile_X0Y3_W2MID[0] Tile_X0Y3_W2MID[1]
+ Tile_X0Y3_W2MID[2] Tile_X0Y3_W2MID[3] Tile_X0Y3_W2MID[4] Tile_X0Y3_W2MID[5] Tile_X0Y3_W2MID[6]
+ Tile_X0Y3_W2MID[7] Tile_X0Y3_W6END[0] Tile_X0Y3_W6END[10] Tile_X0Y3_W6END[11] Tile_X0Y3_W6END[1]
+ Tile_X0Y3_W6END[2] Tile_X0Y3_W6END[3] Tile_X0Y3_W6END[4] Tile_X0Y3_W6END[5] Tile_X0Y3_W6END[6]
+ Tile_X0Y3_W6END[7] Tile_X0Y3_W6END[8] Tile_X0Y3_W6END[9] Tile_X0Y3_WW4END[0] Tile_X0Y3_WW4END[10]
+ Tile_X0Y3_WW4END[11] Tile_X0Y3_WW4END[12] Tile_X0Y3_WW4END[13] Tile_X0Y3_WW4END[14]
+ Tile_X0Y3_WW4END[15] Tile_X0Y3_WW4END[1] Tile_X0Y3_WW4END[2] Tile_X0Y3_WW4END[3]
+ Tile_X0Y3_WW4END[4] Tile_X0Y3_WW4END[5] Tile_X0Y3_WW4END[6] Tile_X0Y3_WW4END[7]
+ Tile_X0Y3_WW4END[8] Tile_X0Y3_WW4END[9] Tile_X0Y4_E1BEG[0] Tile_X0Y4_E1BEG[1] Tile_X0Y4_E1BEG[2]
+ Tile_X0Y4_E1BEG[3] Tile_X0Y4_E2BEG[0] Tile_X0Y4_E2BEG[1] Tile_X0Y4_E2BEG[2] Tile_X0Y4_E2BEG[3]
+ Tile_X0Y4_E2BEG[4] Tile_X0Y4_E2BEG[5] Tile_X0Y4_E2BEG[6] Tile_X0Y4_E2BEG[7] Tile_X0Y4_E2BEGb[0]
+ Tile_X0Y4_E2BEGb[1] Tile_X0Y4_E2BEGb[2] Tile_X0Y4_E2BEGb[3] Tile_X0Y4_E2BEGb[4]
+ Tile_X0Y4_E2BEGb[5] Tile_X0Y4_E2BEGb[6] Tile_X0Y4_E2BEGb[7] Tile_X0Y4_E6BEG[0] Tile_X0Y4_E6BEG[10]
+ Tile_X0Y4_E6BEG[11] Tile_X0Y4_E6BEG[1] Tile_X0Y4_E6BEG[2] Tile_X0Y4_E6BEG[3] Tile_X0Y4_E6BEG[4]
+ Tile_X0Y4_E6BEG[5] Tile_X0Y4_E6BEG[6] Tile_X0Y4_E6BEG[7] Tile_X0Y4_E6BEG[8] Tile_X0Y4_E6BEG[9]
+ Tile_X0Y4_EE4BEG[0] Tile_X0Y4_EE4BEG[10] Tile_X0Y4_EE4BEG[11] Tile_X0Y4_EE4BEG[12]
+ Tile_X0Y4_EE4BEG[13] Tile_X0Y4_EE4BEG[14] Tile_X0Y4_EE4BEG[15] Tile_X0Y4_EE4BEG[1]
+ Tile_X0Y4_EE4BEG[2] Tile_X0Y4_EE4BEG[3] Tile_X0Y4_EE4BEG[4] Tile_X0Y4_EE4BEG[5]
+ Tile_X0Y4_EE4BEG[6] Tile_X0Y4_EE4BEG[7] Tile_X0Y4_EE4BEG[8] Tile_X0Y4_EE4BEG[9]
+ Tile_X0Y4_FrameData[0] Tile_X0Y4_FrameData[10] Tile_X0Y4_FrameData[11] Tile_X0Y4_FrameData[12]
+ Tile_X0Y4_FrameData[13] Tile_X0Y4_FrameData[14] Tile_X0Y4_FrameData[15] Tile_X0Y4_FrameData[16]
+ Tile_X0Y4_FrameData[17] Tile_X0Y4_FrameData[18] Tile_X0Y4_FrameData[19] Tile_X0Y4_FrameData[1]
+ Tile_X0Y4_FrameData[20] Tile_X0Y4_FrameData[21] Tile_X0Y4_FrameData[22] Tile_X0Y4_FrameData[23]
+ Tile_X0Y4_FrameData[24] Tile_X0Y4_FrameData[25] Tile_X0Y4_FrameData[26] Tile_X0Y4_FrameData[27]
+ Tile_X0Y4_FrameData[28] Tile_X0Y4_FrameData[29] Tile_X0Y4_FrameData[2] Tile_X0Y4_FrameData[30]
+ Tile_X0Y4_FrameData[31] Tile_X0Y4_FrameData[3] Tile_X0Y4_FrameData[4] Tile_X0Y4_FrameData[5]
+ Tile_X0Y4_FrameData[6] Tile_X0Y4_FrameData[7] Tile_X0Y4_FrameData[8] Tile_X0Y4_FrameData[9]
+ Tile_X0Y4_FrameData_O[0] Tile_X0Y4_FrameData_O[10] Tile_X0Y4_FrameData_O[11] Tile_X0Y4_FrameData_O[12]
+ Tile_X0Y4_FrameData_O[13] Tile_X0Y4_FrameData_O[14] Tile_X0Y4_FrameData_O[15] Tile_X0Y4_FrameData_O[16]
+ Tile_X0Y4_FrameData_O[17] Tile_X0Y4_FrameData_O[18] Tile_X0Y4_FrameData_O[19] Tile_X0Y4_FrameData_O[1]
+ Tile_X0Y4_FrameData_O[20] Tile_X0Y4_FrameData_O[21] Tile_X0Y4_FrameData_O[22] Tile_X0Y4_FrameData_O[23]
+ Tile_X0Y4_FrameData_O[24] Tile_X0Y4_FrameData_O[25] Tile_X0Y4_FrameData_O[26] Tile_X0Y4_FrameData_O[27]
+ Tile_X0Y4_FrameData_O[28] Tile_X0Y4_FrameData_O[29] Tile_X0Y4_FrameData_O[2] Tile_X0Y4_FrameData_O[30]
+ Tile_X0Y4_FrameData_O[31] Tile_X0Y4_FrameData_O[3] Tile_X0Y4_FrameData_O[4] Tile_X0Y4_FrameData_O[5]
+ Tile_X0Y4_FrameData_O[6] Tile_X0Y4_FrameData_O[7] Tile_X0Y4_FrameData_O[8] Tile_X0Y4_FrameData_O[9]
+ Tile_X0Y4_UserCLK Tile_X0Y4_UserCLKo Tile_X0Y4_W1END[0] Tile_X0Y4_W1END[1] Tile_X0Y4_W1END[2]
+ Tile_X0Y4_W1END[3] Tile_X0Y4_W2END[0] Tile_X0Y4_W2END[1] Tile_X0Y4_W2END[2] Tile_X0Y4_W2END[3]
+ Tile_X0Y4_W2END[4] Tile_X0Y4_W2END[5] Tile_X0Y4_W2END[6] Tile_X0Y4_W2END[7] Tile_X0Y4_W2MID[0]
+ Tile_X0Y4_W2MID[1] Tile_X0Y4_W2MID[2] Tile_X0Y4_W2MID[3] Tile_X0Y4_W2MID[4] Tile_X0Y4_W2MID[5]
+ Tile_X0Y4_W2MID[6] Tile_X0Y4_W2MID[7] Tile_X0Y4_W6END[0] Tile_X0Y4_W6END[10] Tile_X0Y4_W6END[11]
+ Tile_X0Y4_W6END[1] Tile_X0Y4_W6END[2] Tile_X0Y4_W6END[3] Tile_X0Y4_W6END[4] Tile_X0Y4_W6END[5]
+ Tile_X0Y4_W6END[6] Tile_X0Y4_W6END[7] Tile_X0Y4_W6END[8] Tile_X0Y4_W6END[9] Tile_X0Y4_WW4END[0]
+ Tile_X0Y4_WW4END[10] Tile_X0Y4_WW4END[11] Tile_X0Y4_WW4END[12] Tile_X0Y4_WW4END[13]
+ Tile_X0Y4_WW4END[14] Tile_X0Y4_WW4END[15] Tile_X0Y4_WW4END[1] Tile_X0Y4_WW4END[2]
+ Tile_X0Y4_WW4END[3] Tile_X0Y4_WW4END[4] Tile_X0Y4_WW4END[5] Tile_X0Y4_WW4END[6]
+ Tile_X0Y4_WW4END[7] Tile_X0Y4_WW4END[8] Tile_X0Y4_WW4END[9] Tile_X0Y5_E1BEG[0] Tile_X0Y5_E1BEG[1]
+ Tile_X0Y5_E1BEG[2] Tile_X0Y5_E1BEG[3] Tile_X0Y5_E2BEG[0] Tile_X0Y5_E2BEG[1] Tile_X0Y5_E2BEG[2]
+ Tile_X0Y5_E2BEG[3] Tile_X0Y5_E2BEG[4] Tile_X0Y5_E2BEG[5] Tile_X0Y5_E2BEG[6] Tile_X0Y5_E2BEG[7]
+ Tile_X0Y5_E2BEGb[0] Tile_X0Y5_E2BEGb[1] Tile_X0Y5_E2BEGb[2] Tile_X0Y5_E2BEGb[3]
+ Tile_X0Y5_E2BEGb[4] Tile_X0Y5_E2BEGb[5] Tile_X0Y5_E2BEGb[6] Tile_X0Y5_E2BEGb[7]
+ Tile_X0Y5_E6BEG[0] Tile_X0Y5_E6BEG[10] Tile_X0Y5_E6BEG[11] Tile_X0Y5_E6BEG[1] Tile_X0Y5_E6BEG[2]
+ Tile_X0Y5_E6BEG[3] Tile_X0Y5_E6BEG[4] Tile_X0Y5_E6BEG[5] Tile_X0Y5_E6BEG[6] Tile_X0Y5_E6BEG[7]
+ Tile_X0Y5_E6BEG[8] Tile_X0Y5_E6BEG[9] Tile_X0Y5_EE4BEG[0] Tile_X0Y5_EE4BEG[10] Tile_X0Y5_EE4BEG[11]
+ Tile_X0Y5_EE4BEG[12] Tile_X0Y5_EE4BEG[13] Tile_X0Y5_EE4BEG[14] Tile_X0Y5_EE4BEG[15]
+ Tile_X0Y5_EE4BEG[1] Tile_X0Y5_EE4BEG[2] Tile_X0Y5_EE4BEG[3] Tile_X0Y5_EE4BEG[4]
+ Tile_X0Y5_EE4BEG[5] Tile_X0Y5_EE4BEG[6] Tile_X0Y5_EE4BEG[7] Tile_X0Y5_EE4BEG[8]
+ Tile_X0Y5_EE4BEG[9] Tile_X0Y5_FrameData[0] Tile_X0Y5_FrameData[10] Tile_X0Y5_FrameData[11]
+ Tile_X0Y5_FrameData[12] Tile_X0Y5_FrameData[13] Tile_X0Y5_FrameData[14] Tile_X0Y5_FrameData[15]
+ Tile_X0Y5_FrameData[16] Tile_X0Y5_FrameData[17] Tile_X0Y5_FrameData[18] Tile_X0Y5_FrameData[19]
+ Tile_X0Y5_FrameData[1] Tile_X0Y5_FrameData[20] Tile_X0Y5_FrameData[21] Tile_X0Y5_FrameData[22]
+ Tile_X0Y5_FrameData[23] Tile_X0Y5_FrameData[24] Tile_X0Y5_FrameData[25] Tile_X0Y5_FrameData[26]
+ Tile_X0Y5_FrameData[27] Tile_X0Y5_FrameData[28] Tile_X0Y5_FrameData[29] Tile_X0Y5_FrameData[2]
+ Tile_X0Y5_FrameData[30] Tile_X0Y5_FrameData[31] Tile_X0Y5_FrameData[3] Tile_X0Y5_FrameData[4]
+ Tile_X0Y5_FrameData[5] Tile_X0Y5_FrameData[6] Tile_X0Y5_FrameData[7] Tile_X0Y5_FrameData[8]
+ Tile_X0Y5_FrameData[9] Tile_X0Y5_FrameData_O[0] Tile_X0Y5_FrameData_O[10] Tile_X0Y5_FrameData_O[11]
+ Tile_X0Y5_FrameData_O[12] Tile_X0Y5_FrameData_O[13] Tile_X0Y5_FrameData_O[14] Tile_X0Y5_FrameData_O[15]
+ Tile_X0Y5_FrameData_O[16] Tile_X0Y5_FrameData_O[17] Tile_X0Y5_FrameData_O[18] Tile_X0Y5_FrameData_O[19]
+ Tile_X0Y5_FrameData_O[1] Tile_X0Y5_FrameData_O[20] Tile_X0Y5_FrameData_O[21] Tile_X0Y5_FrameData_O[22]
+ Tile_X0Y5_FrameData_O[23] Tile_X0Y5_FrameData_O[24] Tile_X0Y5_FrameData_O[25] Tile_X0Y5_FrameData_O[26]
+ Tile_X0Y5_FrameData_O[27] Tile_X0Y5_FrameData_O[28] Tile_X0Y5_FrameData_O[29] Tile_X0Y5_FrameData_O[2]
+ Tile_X0Y5_FrameData_O[30] Tile_X0Y5_FrameData_O[31] Tile_X0Y5_FrameData_O[3] Tile_X0Y5_FrameData_O[4]
+ Tile_X0Y5_FrameData_O[5] Tile_X0Y5_FrameData_O[6] Tile_X0Y5_FrameData_O[7] Tile_X0Y5_FrameData_O[8]
+ Tile_X0Y5_FrameData_O[9] Tile_X0Y5_FrameStrobe[0] Tile_X0Y5_FrameStrobe[10] Tile_X0Y5_FrameStrobe[11]
+ Tile_X0Y5_FrameStrobe[12] Tile_X0Y5_FrameStrobe[13] Tile_X0Y5_FrameStrobe[14] Tile_X0Y5_FrameStrobe[15]
+ Tile_X0Y5_FrameStrobe[16] Tile_X0Y5_FrameStrobe[17] Tile_X0Y5_FrameStrobe[18] Tile_X0Y5_FrameStrobe[19]
+ Tile_X0Y5_FrameStrobe[1] Tile_X0Y5_FrameStrobe[2] Tile_X0Y5_FrameStrobe[3] Tile_X0Y5_FrameStrobe[4]
+ Tile_X0Y5_FrameStrobe[5] Tile_X0Y5_FrameStrobe[6] Tile_X0Y5_FrameStrobe[7] Tile_X0Y5_FrameStrobe[8]
+ Tile_X0Y5_FrameStrobe[9] Tile_X0Y5_N1END[0] Tile_X0Y5_N1END[1] Tile_X0Y5_N1END[2]
+ Tile_X0Y5_N1END[3] Tile_X0Y5_N2END[0] Tile_X0Y5_N2END[1] Tile_X0Y5_N2END[2] Tile_X0Y5_N2END[3]
+ Tile_X0Y5_N2END[4] Tile_X0Y5_N2END[5] Tile_X0Y5_N2END[6] Tile_X0Y5_N2END[7] Tile_X0Y5_N2MID[0]
+ Tile_X0Y5_N2MID[1] Tile_X0Y5_N2MID[2] Tile_X0Y5_N2MID[3] Tile_X0Y5_N2MID[4] Tile_X0Y5_N2MID[5]
+ Tile_X0Y5_N2MID[6] Tile_X0Y5_N2MID[7] Tile_X0Y5_N4END[0] Tile_X0Y5_N4END[10] Tile_X0Y5_N4END[11]
+ Tile_X0Y5_N4END[12] Tile_X0Y5_N4END[13] Tile_X0Y5_N4END[14] Tile_X0Y5_N4END[15]
+ Tile_X0Y5_N4END[1] Tile_X0Y5_N4END[2] Tile_X0Y5_N4END[3] Tile_X0Y5_N4END[4] Tile_X0Y5_N4END[5]
+ Tile_X0Y5_N4END[6] Tile_X0Y5_N4END[7] Tile_X0Y5_N4END[8] Tile_X0Y5_N4END[9] Tile_X0Y5_S1BEG[0]
+ Tile_X0Y5_S1BEG[1] Tile_X0Y5_S1BEG[2] Tile_X0Y5_S1BEG[3] Tile_X0Y5_S2BEG[0] Tile_X0Y5_S2BEG[1]
+ Tile_X0Y5_S2BEG[2] Tile_X0Y5_S2BEG[3] Tile_X0Y5_S2BEG[4] Tile_X0Y5_S2BEG[5] Tile_X0Y5_S2BEG[6]
+ Tile_X0Y5_S2BEG[7] Tile_X0Y5_S2BEGb[0] Tile_X0Y5_S2BEGb[1] Tile_X0Y5_S2BEGb[2] Tile_X0Y5_S2BEGb[3]
+ Tile_X0Y5_S2BEGb[4] Tile_X0Y5_S2BEGb[5] Tile_X0Y5_S2BEGb[6] Tile_X0Y5_S2BEGb[7]
+ Tile_X0Y5_S4BEG[0] Tile_X0Y5_S4BEG[10] Tile_X0Y5_S4BEG[11] Tile_X0Y5_S4BEG[12] Tile_X0Y5_S4BEG[13]
+ Tile_X0Y5_S4BEG[14] Tile_X0Y5_S4BEG[15] Tile_X0Y5_S4BEG[1] Tile_X0Y5_S4BEG[2] Tile_X0Y5_S4BEG[3]
+ Tile_X0Y5_S4BEG[4] Tile_X0Y5_S4BEG[5] Tile_X0Y5_S4BEG[6] Tile_X0Y5_S4BEG[7] Tile_X0Y5_S4BEG[8]
+ Tile_X0Y5_S4BEG[9] Tile_X0Y5_UserCLK Tile_X0Y5_UserCLKo Tile_X0Y5_W1END[0] Tile_X0Y5_W1END[1]
+ Tile_X0Y5_W1END[2] Tile_X0Y5_W1END[3] Tile_X0Y5_W2END[0] Tile_X0Y5_W2END[1] Tile_X0Y5_W2END[2]
+ Tile_X0Y5_W2END[3] Tile_X0Y5_W2END[4] Tile_X0Y5_W2END[5] Tile_X0Y5_W2END[6] Tile_X0Y5_W2END[7]
+ Tile_X0Y5_W2MID[0] Tile_X0Y5_W2MID[1] Tile_X0Y5_W2MID[2] Tile_X0Y5_W2MID[3] Tile_X0Y5_W2MID[4]
+ Tile_X0Y5_W2MID[5] Tile_X0Y5_W2MID[6] Tile_X0Y5_W2MID[7] Tile_X0Y5_W6END[0] Tile_X0Y5_W6END[10]
+ Tile_X0Y5_W6END[11] Tile_X0Y5_W6END[1] Tile_X0Y5_W6END[2] Tile_X0Y5_W6END[3] Tile_X0Y5_W6END[4]
+ Tile_X0Y5_W6END[5] Tile_X0Y5_W6END[6] Tile_X0Y5_W6END[7] Tile_X0Y5_W6END[8] Tile_X0Y5_W6END[9]
+ Tile_X0Y5_WW4END[0] Tile_X0Y5_WW4END[10] Tile_X0Y5_WW4END[11] Tile_X0Y5_WW4END[12]
+ Tile_X0Y5_WW4END[13] Tile_X0Y5_WW4END[14] Tile_X0Y5_WW4END[15] Tile_X0Y5_WW4END[1]
+ Tile_X0Y5_WW4END[2] Tile_X0Y5_WW4END[3] Tile_X0Y5_WW4END[4] Tile_X0Y5_WW4END[5]
+ Tile_X0Y5_WW4END[6] Tile_X0Y5_WW4END[7] Tile_X0Y5_WW4END[8] Tile_X0Y5_WW4END[9]
+ VGND VPWR
XANTENNA__3261__D Tile_X0Y5_FrameData[19] VPWR VGND sg13cmos5l_antennanp
XFILLER_223_65 VPWR VGND sg13cmos5l_fill_2
XFILLER_239_183 VPWR VGND sg13cmos5l_decap_4
X_3155_ _3155_/Q Tile_X0Y5_FrameData[29] Tile_X0Y5_FrameStrobe[3] VPWR VGND sg13cmos5l_dlhq_1
X_3086_ _3086_/Q Tile_X0Y5_FrameData[2] Tile_X0Y5_FrameStrobe[0] VPWR VGND sg13cmos5l_dlhq_1
X_2106_ _2106_/Q Tile_X0Y1_FrameData[22] Tile_X0Y5_FrameStrobe[4] VPWR VGND sg13cmos5l_dlhq_1
X_2037_ _2037_/Q Tile_X0Y1_FrameData[27] Tile_X0Y5_FrameStrobe[2] VPWR VGND sg13cmos5l_dlhq_1
XANTENNA__1454__A1 AXI_M_SOC_RDATA15 VPWR VGND sg13cmos5l_antennanp
XANTENNA__2605__D Tile_X0Y3_FrameData[3] VPWR VGND sg13cmos5l_antennanp
XANTENNA__3838__X Tile_X0Y5_E6BEG[7] VPWR VGND sg13cmos5l_antennanp
XANTENNA__2330__GATE Tile_X0Y5_FrameStrobe[2] VPWR VGND sg13cmos5l_antennanp
XFILLER_167_105 VPWR VGND sg13cmos5l_decap_8
XFILLER_210_234 VPWR VGND sg13cmos5l_decap_8
XFILLER_22_155 VPWR VGND sg13cmos5l_decap_8
XANTENNA__1206__A1 Tile_X0Y0_W2END[5] VPWR VGND sg13cmos5l_antennanp
XANTENNA__2960__GATE Tile_X0Y5_FrameStrobe[5] VPWR VGND sg13cmos5l_antennanp
XFILLER_309_121 VPWR VGND sg13cmos5l_decap_8
X_2939_ _2939_/Q Tile_X0Y4_FrameData[5] Tile_X0Y5_FrameStrobe[4] VPWR VGND sg13cmos5l_dlhq_1
XFILLER_108_205 VPWR VGND sg13cmos5l_decap_8
XFILLER_248_40 VPWR VGND sg13cmos5l_decap_8
XANTENNA__2345__GATE Tile_X0Y5_FrameStrobe[3] VPWR VGND sg13cmos5l_antennanp
XFILLER_108_238 VPWR VGND sg13cmos5l_decap_4
XFILLER_175_182 VPWR VGND sg13cmos5l_decap_8
XFILLER_248_84 VPWR VGND sg13cmos5l_fill_1
XANTENNA__2340__D Tile_X0Y2_FrameData[28] VPWR VGND sg13cmos5l_antennanp
XANTENNA__2975__GATE Tile_X0Y5_FrameStrobe[5] VPWR VGND sg13cmos5l_antennanp
XANTENNA__3573__X Tile_X0Y0_FrameData_O[4] VPWR VGND sg13cmos5l_antennanp
XFILLER_201_8 VPWR VGND sg13cmos5l_decap_8
XFILLER_116_271 VPWR VGND sg13cmos5l_fill_2
XFILLER_116_293 VPWR VGND sg13cmos5l_fill_2
XFILLER_77_37 VPWR VGND sg13cmos5l_decap_8
XANTENNA__1142__A0 Tile_X0Y4_W2MID[6] VPWR VGND sg13cmos5l_antennanp
XANTENNA__3171__D Tile_X0Y5_FrameData[13] VPWR VGND sg13cmos5l_antennanp
XFILLER_133_43 VPWR VGND sg13cmos5l_decap_8
XANTENNA__1693__A1 Tile_X0Y5_W6END[11] VPWR VGND sg13cmos5l_antennanp
XFILLER_93_25 VPWR VGND sg13cmos5l_decap_8
XFILLER_45_203 VPWR VGND sg13cmos5l_decap_8
XANTENNA__2913__GATE Tile_X0Y5_FrameStrobe[4] VPWR VGND sg13cmos5l_antennanp
XFILLER_245_197 VPWR VGND sg13cmos5l_decap_4
XANTENNA__3748__X Tile_X0Y4_E2BEGb[6] VPWR VGND sg13cmos5l_antennanp
XANTENNA__2515__D Tile_X0Y3_FrameData[29] VPWR VGND sg13cmos5l_antennanp
XANTENNA__2928__GATE Tile_X0Y5_FrameStrobe[4] VPWR VGND sg13cmos5l_antennanp
XFILLER_13_188 VPWR VGND sg13cmos5l_decap_8
XFILLER_42_40 VPWR VGND sg13cmos5l_decap_8
XANTENNA__2250__D Tile_X0Y2_FrameData[22] VPWR VGND sg13cmos5l_antennanp
XANTENNA__3346__D Tile_X0Y5_FrameData[12] VPWR VGND sg13cmos5l_antennanp
XANTENNA__3483__X Tile_X0Y1_E6BEG[3] VPWR VGND sg13cmos5l_antennanp
XFILLER_181_141 VPWR VGND sg13cmos5l_decap_8
XANTENNA__0971__A3 Tile_X0Y0_S4END[15] VPWR VGND sg13cmos5l_antennanp
XFILLER_330_105 VPWR VGND sg13cmos5l_fill_1
XFILLER_107_293 VPWR VGND sg13cmos5l_fill_2
XFILLER_122_230 VPWR VGND sg13cmos5l_decap_8
XANTENNA__1381__A0 Tile_X0Y2_W1END[2] VPWR VGND sg13cmos5l_antennanp
XFILLER_174_94 VPWR VGND sg13cmos5l_fill_1
XFILLER_3_23 VPWR VGND sg13cmos5l_fill_1
XFILLER_283_204 VPWR VGND sg13cmos5l_decap_4
XFILLER_283_226 VPWR VGND sg13cmos5l_fill_2
X_1270_ _1270_/X Tile_X0Y2_W1END[0] Tile_X0Y2_W2MID[3] Tile_X0Y2_W2END[3] _1191_/X
+ _2460_/Q _2459_/Q VPWR VGND sg13cmos5l_mux4_1
XFILLER_95_147 VPWR VGND sg13cmos5l_decap_8
XANTENNA__3081__D Tile_X0Y5_FrameData[7] VPWR VGND sg13cmos5l_antennanp
XFILLER_67_81 VPWR VGND sg13cmos5l_fill_1
XANTENNA__1684__A1 Tile_X0Y4_W6END[4] VPWR VGND sg13cmos5l_antennanp
XFILLER_251_145 VPWR VGND sg13cmos5l_fill_2
XANTENNA__3658__X Tile_X0Y3_E2BEG[5] VPWR VGND sg13cmos5l_antennanp
XFILLER_269_39 VPWR VGND sg13cmos5l_fill_1
X_3911_ Tile_X0Y5_S4BEG[0] _3911_/A VPWR VGND sg13cmos5l_buf_1
XANTENNA__2425__D Tile_X0Y2_FrameData[7] VPWR VGND sg13cmos5l_antennanp
X_3842_ Tile_X0Y5_E6BEG[11] _3842_/A VPWR VGND sg13cmos5l_buf_1
XANTENNA__3060__GATE Tile_X0Y5_FrameStrobe[0] VPWR VGND sg13cmos5l_antennanp
X_3773_ Tile_X0Y4_EE4BEG[11] _3773_/A VPWR VGND sg13cmos5l_buf_1
X_0985_ _0985_/X _0986_/X _0984_/X Tile_X0Y0_S1END[3] Tile_X0Y0_S4END[3] _1738_/Q
+ _1737_/Q VPWR VGND sg13cmos5l_mux4_1
X_2724_ _2724_/Q Tile_X0Y3_FrameData[12] Tile_X0Y5_FrameStrobe[6] VPWR VGND sg13cmos5l_dlhq_1
XFILLER_66_0 VPWR VGND sg13cmos5l_fill_2
XANTENNA__3075__GATE Tile_X0Y5_FrameStrobe[0] VPWR VGND sg13cmos5l_antennanp
XANTENNA__3256__D Tile_X0Y5_FrameData[24] VPWR VGND sg13cmos5l_antennanp
XANTENNA__3393__X Tile_X0Y2_EE4BEG[11] VPWR VGND sg13cmos5l_antennanp
X_2655_ _2655_/Q Tile_X0Y3_FrameData[17] Tile_X0Y5_FrameStrobe[4] VPWR VGND sg13cmos5l_dlhq_1
XANTENNA__0962__A3 Tile_X0Y0_S4END[5] VPWR VGND sg13cmos5l_antennanp
XANTENNA__2160__D Tile_X0Y1_FrameData[0] VPWR VGND sg13cmos5l_antennanp
XFILLER_105_219 VPWR VGND sg13cmos5l_decap_8
X_1606_ _1606_/X Tile_X0Y3_W1END[1] Tile_X0Y3_W6END[9] Tile_X0Y3_WW4END[1] _1530_/X
+ _2756_/Q _2757_/Q VPWR VGND sg13cmos5l_mux4_1
XFILLER_321_116 VPWR VGND sg13cmos5l_fill_2
XFILLER_113_241 VPWR VGND sg13cmos5l_decap_8
X_2586_ _2586_/Q Tile_X0Y3_FrameData[22] Tile_X0Y5_FrameStrobe[2] VPWR VGND sg13cmos5l_dlhq_1
XANTENNA__1372__A0 Tile_X0Y2_W1END[3] VPWR VGND sg13cmos5l_antennanp
XFILLER_113_274 VPWR VGND sg13cmos5l_decap_4
X_1537_ _3670_/A Tile_X0Y5_N4END[9] Tile_X0Y0_S4END[13] _1512_/X _0888_/X _2638_/Q
+ _2637_/Q VPWR VGND sg13cmos5l_mux4_1
X_1468_ _3363_/A Tile_X0Y2_W2END[6] AXI_M_SOC_RDATA20 _1143_/X _1175_/X _2414_/Q _2413_/Q
+ VPWR VGND sg13cmos5l_mux4_1
XANTENNA__1641__X AXI_M_SOC_ARADDR4 VPWR VGND sg13cmos5l_antennanp
X_3207_ _3207_/Q Tile_X0Y5_FrameData[9] Tile_X0Y5_FrameStrobe[4] VPWR VGND sg13cmos5l_dlhq_1
X_1399_ _3376_/A AXI_M_SOC_RDATA16 _1315_/X _1369_/X _1151_/X _2356_/Q _2355_/Q VPWR
+ VGND sg13cmos5l_mux4_1
XFILLER_27_225 VPWR VGND sg13cmos5l_decap_8
X_3138_ _3138_/Q Tile_X0Y5_FrameData[14] Tile_X0Y5_FrameStrobe[2] VPWR VGND sg13cmos5l_dlhq_1
XANTENNA__3013__GATE Tile_X0Y5_FrameStrobe[7] VPWR VGND sg13cmos5l_antennanp
XFILLER_103_57 VPWR VGND sg13cmos5l_decap_8
X_3069_ _3069_/Q Tile_X0Y5_FrameData[19] Tile_X0Y5_FrameStrobe[0] VPWR VGND sg13cmos5l_dlhq_1
XFILLER_63_28 VPWR VGND sg13cmos5l_fill_1
XFILLER_42_217 VPWR VGND sg13cmos5l_fill_2
XANTENNA__1427__A1 Tile_X0Y2_W2END[7] VPWR VGND sg13cmos5l_antennanp
XANTENNA__2335__D Tile_X0Y2_FrameData[1] VPWR VGND sg13cmos5l_antennanp
XANTENNA__3028__GATE Tile_X0Y5_FrameStrobe[7] VPWR VGND sg13cmos5l_antennanp
XANTENNA__3568__X Tile_X0Y0_FrameStrobe_O[19] VPWR VGND sg13cmos5l_antennanp
XFILLER_249_8 VPWR VGND sg13cmos5l_fill_2
XFILLER_50_272 VPWR VGND sg13cmos5l_fill_1
XANTENNA__2284__GATE Tile_X0Y5_FrameStrobe[1] VPWR VGND sg13cmos5l_antennanp
XFILLER_10_169 VPWR VGND sg13cmos5l_decap_8
XFILLER_12_43 VPWR VGND sg13cmos5l_fill_2
XFILLER_337_293 VPWR VGND sg13cmos5l_fill_2
XFILLER_337_260 VPWR VGND sg13cmos5l_fill_2
XANTENNA__3166__D Tile_X0Y5_FrameData[18] VPWR VGND sg13cmos5l_antennanp
XFILLER_128_43 VPWR VGND sg13cmos5l_decap_4
XFILLER_12_87 VPWR VGND sg13cmos5l_fill_2
XANTENNA__0953__A3 Tile_X0Y0_S4END[6] VPWR VGND sg13cmos5l_antennanp
XANTENNA__2070__D Tile_X0Y1_FrameData[26] VPWR VGND sg13cmos5l_antennanp
XANTENNA__2299__GATE Tile_X0Y5_FrameStrobe[1] VPWR VGND sg13cmos5l_antennanp
XFILLER_88_58 VPWR VGND sg13cmos5l_decap_8
XFILLER_104_241 VPWR VGND sg13cmos5l_decap_8
XFILLER_144_31 VPWR VGND sg13cmos5l_fill_1
XANTENNA__2222__GATE Tile_X0Y5_FrameStrobe[7] VPWR VGND sg13cmos5l_antennanp
XANTENNA__1551__X AXI_M_SOC_ARADDR25 VPWR VGND sg13cmos5l_antennanp
XANTENNA__2852__GATE Tile_X0Y5_FrameStrobe[2] VPWR VGND sg13cmos5l_antennanp
XFILLER_37_51 VPWR VGND sg13cmos5l_decap_8
XFILLER_268_0 VPWR VGND sg13cmos5l_fill_2
XANTENNA__1418__A1 Tile_X0Y2_WW4END[11] VPWR VGND sg13cmos5l_antennanp
XANTENNA__2237__GATE Tile_X0Y5_FrameStrobe[8] VPWR VGND sg13cmos5l_antennanp
XANTENNA__2867__GATE Tile_X0Y5_FrameStrobe[2] VPWR VGND sg13cmos5l_antennanp
XFILLER_310_44 VPWR VGND sg13cmos5l_decap_8
XANTENNA__2245__D Tile_X0Y2_FrameData[27] VPWR VGND sg13cmos5l_antennanp
XANTENNA__3478__X Tile_X0Y1_EE4BEG[14] VPWR VGND sg13cmos5l_antennanp
XFILLER_186_222 VPWR VGND sg13cmos5l_decap_8
XANTENNA__0641__A2 Tile_X0Y4_W6END[9] VPWR VGND sg13cmos5l_antennanp
XFILLER_41_294 VPWR VGND sg13cmos5l_fill_1
XFILLER_139_160 VPWR VGND sg13cmos5l_fill_1
X_0770_ _0770_/X Tile_X0Y1_WW4END[0] Tile_X0Y1_WW4END[8] Tile_X0Y1_W6END[0] _1268_/X
+ _2072_/Q _2071_/Q VPWR VGND sg13cmos5l_mux4_1
XFILLER_319_64 VPWR VGND sg13cmos5l_decap_4
XANTENNA__3076__D Tile_X0Y5_FrameData[12] VPWR VGND sg13cmos5l_antennanp
XFILLER_328_293 VPWR VGND sg13cmos5l_fill_2
XANTENNA__0944__A3 Tile_X0Y0_S4END[7] VPWR VGND sg13cmos5l_antennanp
X_2440_ _2440_/Q Tile_X0Y2_FrameData[24] Tile_X0Y5_FrameStrobe[6] VPWR VGND sg13cmos5l_dlhq_1
XANTENNA__2805__GATE Tile_X0Y5_FrameStrobe[0] VPWR VGND sg13cmos5l_antennanp
XFILLER_335_30 VPWR VGND sg13cmos5l_fill_1
X_2371_ _2371_/Q Tile_X0Y2_FrameData[29] Tile_X0Y5_FrameStrobe[4] VPWR VGND sg13cmos5l_dlhq_1
XFILLER_68_103 VPWR VGND sg13cmos5l_decap_8
XFILLER_335_85 VPWR VGND sg13cmos5l_fill_1
XFILLER_335_74 VPWR VGND sg13cmos5l_decap_4
X_1322_ _3501_/A Tile_X0Y1_W2MID[6] AXI_M_SOC_RDATA23 _1105_/X _1083_/X _2158_/Q _2157_/Q
+ VPWR VGND sg13cmos5l_mux4_1
XANTENNA__1106__A0 Tile_X0Y1_W2MID[7] VPWR VGND sg13cmos5l_antennanp
XFILLER_204_34 VPWR VGND sg13cmos5l_decap_8
XFILLER_209_120 VPWR VGND sg13cmos5l_decap_8
XFILLER_256_248 VPWR VGND sg13cmos5l_decap_4
X_1253_ _3629_/A Tile_X0Y0_W2END[7] AXI_M_SOC_AWREADY _1145_/X _1136_/X _1872_/Q _1871_/Q
+ VPWR VGND sg13cmos5l_mux4_1
XANTENNA__1657__A1 AXI_M_SOC_RDATA4 VPWR VGND sg13cmos5l_antennanp
XFILLER_110_277 VPWR VGND sg13cmos5l_fill_2
XANTENNA__1121__A3 Tile_X0Y0_S4END[11] VPWR VGND sg13cmos5l_antennanp
XFILLER_271_229 VPWR VGND sg13cmos5l_fill_1
X_1184_ _3541_/A Tile_X0Y0_W2MID[3] Tile_X0Y0_W2END[3] Tile_X0Y0_W6END[3] _1078_/X
+ _1952_/Q _1951_/Q VPWR VGND sg13cmos5l_mux4_1
XFILLER_91_172 VPWR VGND sg13cmos5l_decap_4
XANTENNA__2155__D Tile_X0Y1_FrameData[5] VPWR VGND sg13cmos5l_antennanp
XANTENNA__3388__X Tile_X0Y2_EE4BEG[6] VPWR VGND sg13cmos5l_antennanp
XANTENNA__1994__D Tile_X0Y1_FrameData[6] VPWR VGND sg13cmos5l_antennanp
X_3825_ Tile_X0Y5_E2BEGb[2] _3825_/A VPWR VGND sg13cmos5l_buf_1
X_3756_ Tile_X0Y4_E6BEG[6] _3756_/A VPWR VGND sg13cmos5l_buf_1
X_0968_ _0968_/X _1123_/X _0712_/X _0904_/Y Tile_X0Y0_S4END[7] _1993_/Q _1994_/Q VPWR
+ VGND sg13cmos5l_mux4_1
X_2707_ _2707_/Q Tile_X0Y3_FrameData[29] Tile_X0Y5_FrameStrobe[6] VPWR VGND sg13cmos5l_dlhq_1
XFILLER_319_293 VPWR VGND sg13cmos5l_fill_2
XANTENNA__1593__A0 Tile_X0Y3_W1END[3] VPWR VGND sg13cmos5l_antennanp
XANTENNA__1636__X AXI_M_SOC_ARADDR8 VPWR VGND sg13cmos5l_antennanp
XANTENNA__3564__A Tile_X0Y5_FrameStrobe[15] VPWR VGND sg13cmos5l_antennanp
XFILLER_145_185 VPWR VGND sg13cmos5l_decap_4
X_3687_ Tile_X0Y3_EE4BEG[6] _3687_/A VPWR VGND sg13cmos5l_buf_1
X_0899_ _0899_/X _0740_/X _0794_/X _3295_/Q VPWR VGND sg13cmos5l_mux2_1
XFILLER_334_263 VPWR VGND sg13cmos5l_fill_2
X_2638_ _2638_/Q Tile_X0Y3_FrameData[2] Tile_X0Y5_FrameStrobe[3] VPWR VGND sg13cmos5l_dlhq_1
XFILLER_334_285 VPWR VGND sg13cmos5l_fill_2
XANTENNA__3851__X Tile_X0Y5_EE4BEG[8] VPWR VGND sg13cmos5l_antennanp
XFILLER_245_63 VPWR VGND sg13cmos5l_decap_8
X_2569_ _2569_/Q Tile_X0Y3_FrameData[7] Tile_X0Y5_FrameStrobe[1] VPWR VGND sg13cmos5l_dlhq_1
XANTENNA__0699__A2 Tile_X0Y5_W6END[6] VPWR VGND sg13cmos5l_antennanp
XFILLER_181_18 VPWR VGND sg13cmos5l_decap_8
XANTENNA__1648__A1 Tile_X0Y4_W2END[2] VPWR VGND sg13cmos5l_antennanp
XFILLER_67_180 VPWR VGND sg13cmos5l_decap_8
XFILLER_15_206 VPWR VGND sg13cmos5l_decap_8
XFILLER_215_134 VPWR VGND sg13cmos5l_fill_2
XFILLER_130_22 VPWR VGND sg13cmos5l_decap_8
XFILLER_130_44 VPWR VGND sg13cmos5l_fill_2
XANTENNA__2065__D Tile_X0Y1_FrameData[31] VPWR VGND sg13cmos5l_antennanp
XANTENNA__0623__A2 Tile_X0Y1_W6END[9] VPWR VGND sg13cmos5l_antennanp
XFILLER_168_255 VPWR VGND sg13cmos5l_fill_1
XFILLER_139_42 VPWR VGND sg13cmos5l_fill_1
XFILLER_136_130 VPWR VGND sg13cmos5l_decap_8
XFILLER_191_280 VPWR VGND sg13cmos5l_fill_1
XFILLER_325_285 VPWR VGND sg13cmos5l_fill_1
XANTENNA__1336__A0 Tile_X0Y1_W2END[5] VPWR VGND sg13cmos5l_antennanp
XANTENNA__3761__X Tile_X0Y4_E6BEG[11] VPWR VGND sg13cmos5l_antennanp
XFILLER_97_209 VPWR VGND sg13cmos5l_decap_8
XANTENNA__2161__GATE Tile_X0Y5_FrameStrobe[6] VPWR VGND sg13cmos5l_antennanp
XANTENNA__2791__GATE Tile_X0Y5_FrameStrobe[0] VPWR VGND sg13cmos5l_antennanp
XFILLER_65_128 VPWR VGND sg13cmos5l_fill_1
XFILLER_65_117 VPWR VGND sg13cmos5l_decap_8
XANTENNA__1639__A1 Tile_X0Y4_WW4END[14] VPWR VGND sg13cmos5l_antennanp
XFILLER_58_191 VPWR VGND sg13cmos5l_decap_4
XANTENNA__0862__B_N Tile_X0Y5_W6END[4] VPWR VGND sg13cmos5l_antennanp
XANTENNA__2176__GATE Tile_X0Y5_FrameStrobe[6] VPWR VGND sg13cmos5l_antennanp
XFILLER_73_183 VPWR VGND sg13cmos5l_decap_4
XFILLER_64_71 VPWR VGND sg13cmos5l_decap_8
XFILLER_159_200 VPWR VGND sg13cmos5l_decap_4
X_1940_ _1940_/Q Tile_X0Y0_FrameData[12] Tile_X0Y5_FrameStrobe[7] VPWR VGND sg13cmos5l_dlhq_1
XFILLER_14_294 VPWR VGND sg13cmos5l_fill_1
X_1871_ _1871_/Q Tile_X0Y0_FrameData[17] Tile_X0Y5_FrameStrobe[5] VPWR VGND sg13cmos5l_dlhq_1
XANTENNA__2703__D Tile_X0Y3_FrameData[1] VPWR VGND sg13cmos5l_antennanp
XFILLER_266_29 VPWR VGND sg13cmos5l_fill_1
XFILLER_308_219 VPWR VGND sg13cmos5l_fill_1
X_3610_ Tile_X0Y0_EE4BEG[9] _3610_/A VPWR VGND sg13cmos5l_buf_1
X_0822_ _3857_/A Tile_X0Y5_WW4END[1] _0771_/X _0648_/X _0786_/X _3188_/Q _3187_/Q
+ VPWR VGND sg13cmos5l_mux4_1
XFILLER_80_70 VPWR VGND sg13cmos5l_decap_8
XANTENNA__2114__GATE Tile_X0Y5_FrameStrobe[4] VPWR VGND sg13cmos5l_antennanp
X_3541_ Tile_X0Y0_N2BEG[4] _3541_/A VPWR VGND sg13cmos5l_buf_1
XANTENNA__2744__GATE Tile_X0Y5_FrameStrobe[7] VPWR VGND sg13cmos5l_antennanp
X_0753_ _0753_/Y _3258_/Q _0749_/X _0752_/Y VPWR VGND sg13cmos5l_a21oi_1
X_3472_ Tile_X0Y1_EE4BEG[8] _3472_/A VPWR VGND sg13cmos5l_buf_1
X_0684_ _0684_/X Tile_X0Y3_W1END[2] Tile_X0Y3_W6END[10] _0888_/X _0683_/X _2744_/Q
+ _2743_/Q VPWR VGND sg13cmos5l_mux4_1
XANTENNA__3671__X Tile_X0Y3_E6BEG[2] VPWR VGND sg13cmos5l_antennanp
XFILLER_142_155 VPWR VGND sg13cmos5l_decap_8
X_2423_ _2423_/Q Tile_X0Y2_FrameData[9] Tile_X0Y5_FrameStrobe[5] VPWR VGND sg13cmos5l_dlhq_1
XFILLER_331_255 VPWR VGND sg13cmos5l_decap_4
XANTENNA__2129__GATE Tile_X0Y5_FrameStrobe[5] VPWR VGND sg13cmos5l_antennanp
X_2354_ _2354_/Q Tile_X0Y2_FrameData[14] Tile_X0Y5_FrameStrobe[3] VPWR VGND sg13cmos5l_dlhq_1
XANTENNA__2759__GATE Tile_X0Y5_FrameStrobe[7] VPWR VGND sg13cmos5l_antennanp
XFILLER_29_0 VPWR VGND sg13cmos5l_fill_2
X_1305_ _3488_/A AXI_M_SOC_RDATA26 _0944_/X _0905_/X _1089_/X _2079_/Q _2080_/Q VPWR
+ VGND sg13cmos5l_mux4_1
XFILLER_229_259 VPWR VGND sg13cmos5l_decap_4
X_2285_ _2285_/Q Tile_X0Y2_FrameData[19] Tile_X0Y5_FrameStrobe[1] VPWR VGND sg13cmos5l_dlhq_1
XFILLER_56_128 VPWR VGND sg13cmos5l_decap_8
XANTENNA__1989__D Tile_X0Y1_FrameData[11] VPWR VGND sg13cmos5l_antennanp
X_1236_ _3610_/A Tile_X0Y0_WW4END[6] _1004_/X AXI_M_SOC_WREADY _1010_/X _1837_/Q _1838_/Q
+ VPWR VGND sg13cmos5l_mux4_1
XFILLER_49_180 VPWR VGND sg13cmos5l_decap_4
X_1167_ _1167_/X Tile_X0Y0_W6END[8] _1074_/X _1075_/X _1145_/X _1942_/Q _1944_/Q VPWR
+ VGND sg13cmos5l_mux4_1
XFILLER_252_240 VPWR VGND sg13cmos5l_fill_1
XFILLER_64_172 VPWR VGND sg13cmos5l_decap_4
XANTENNA__3559__A Tile_X0Y5_FrameStrobe[10] VPWR VGND sg13cmos5l_antennanp
X_1098_ _1098_/X Tile_X0Y3_W2MID[5] Tile_X0Y3_W2END[5] Tile_X0Y3_W6END[5] _1216_/X
+ _2772_/Q _2771_/Q VPWR VGND sg13cmos5l_mux4_1
XANTENNA__0605__A2 Tile_X0Y4_W2END[3] VPWR VGND sg13cmos5l_antennanp
XANTENNA__1953__GATE Tile_X0Y5_FrameStrobe[8] VPWR VGND sg13cmos5l_antennanp
XANTENNA__2613__D Tile_X0Y3_FrameData[27] VPWR VGND sg13cmos5l_antennanp
XANTENNA__3846__X Tile_X0Y5_EE4BEG[3] VPWR VGND sg13cmos5l_antennanp
XFILLER_220_181 VPWR VGND sg13cmos5l_decap_4
X_3808_ Tile_X0Y4_FrameData_O[30] Tile_X0Y4_FrameData[30] VPWR VGND sg13cmos5l_buf_1
X_3739_ Tile_X0Y4_E2BEG[5] _3739_/A VPWR VGND sg13cmos5l_buf_1
XFILLER_322_200 VPWR VGND sg13cmos5l_fill_1
XANTENNA__1030__A2 Tile_X0Y4_W6END[9] VPWR VGND sg13cmos5l_antennanp
XANTENNA__1968__GATE Tile_X0Y5_FrameStrobe[8] VPWR VGND sg13cmos5l_antennanp
XANTENNA__3581__X Tile_X0Y0_FrameData_O[12] VPWR VGND sg13cmos5l_antennanp
XFILLER_322_277 VPWR VGND sg13cmos5l_fill_1
XFILLER_125_55 VPWR VGND sg13cmos5l_fill_2
XANTENNA__1899__D Tile_X0Y0_FrameData[21] VPWR VGND sg13cmos5l_antennanp
XFILLER_141_21 VPWR VGND sg13cmos5l_decap_8
XANTENNA__1097__A2 Tile_X0Y2_W6END[5] VPWR VGND sg13cmos5l_antennanp
XFILLER_62_109 VPWR VGND sg13cmos5l_decap_8
XFILLER_55_161 VPWR VGND sg13cmos5l_decap_8
XFILLER_70_120 VPWR VGND sg13cmos5l_fill_2
XANTENNA__0844__A2 Tile_X0Y5_WW4END[6] VPWR VGND sg13cmos5l_antennanp
XANTENNA__1906__GATE Tile_X0Y5_FrameStrobe[6] VPWR VGND sg13cmos5l_antennanp
XFILLER_141_98 VPWR VGND sg13cmos5l_decap_8
XFILLER_34_74 VPWR VGND sg13cmos5l_decap_4
XANTENNA__2523__D Tile_X0Y3_FrameData[21] VPWR VGND sg13cmos5l_antennanp
XANTENNA__3756__X Tile_X0Y4_E6BEG[6] VPWR VGND sg13cmos5l_antennanp
XFILLER_133_0 VPWR VGND sg13cmos5l_decap_4
XFILLER_156_214 VPWR VGND sg13cmos5l_decap_8
XFILLER_50_40 VPWR VGND sg13cmos5l_fill_1
XANTENNA__1557__A0 Tile_X0Y3_W2MID[2] VPWR VGND sg13cmos5l_antennanp
XFILLER_300_0 VPWR VGND sg13cmos5l_fill_1
XFILLER_124_133 VPWR VGND sg13cmos5l_decap_8
XANTENNA__1309__A0 Tile_X0Y1_W2MID[7] VPWR VGND sg13cmos5l_antennanp
XANTENNA__0780__A1 Tile_X0Y3_W2END[7] VPWR VGND sg13cmos5l_antennanp
XANTENNA__3491__X Tile_X0Y1_E6BEG[11] VPWR VGND sg13cmos5l_antennanp
XFILLER_59_60 VPWR VGND sg13cmos5l_decap_8
XANTENNA__1324__A3 AXI_M_SOC_RDATA27 VPWR VGND sg13cmos5l_antennanp
XFILLER_182_50 VPWR VGND sg13cmos5l_fill_1
XFILLER_278_181 VPWR VGND sg13cmos5l_fill_1
XFILLER_278_192 VPWR VGND sg13cmos5l_decap_4
XFILLER_226_218 VPWR VGND sg13cmos5l_fill_2
X_2070_ _2070_/Q Tile_X0Y1_FrameData[26] Tile_X0Y5_FrameStrobe[3] VPWR VGND sg13cmos5l_dlhq_1
XFILLER_332_42 VPWR VGND sg13cmos5l_fill_1
XANTENNA__1088__A2 Tile_X0Y0_W2END[3] VPWR VGND sg13cmos5l_antennanp
X_1021_ _1021_/Y _3062_/Q _1021_/B _3061_/Q VPWR VGND sg13cmos5l_nand3b_1
XFILLER_46_150 VPWR VGND sg13cmos5l_decap_8
XFILLER_234_240 VPWR VGND sg13cmos5l_fill_2
XFILLER_61_120 VPWR VGND sg13cmos5l_decap_8
X_2972_ _2972_/Q Tile_X0Y4_FrameData[4] Tile_X0Y5_FrameStrobe[5] VPWR VGND sg13cmos5l_dlhq_1
XFILLER_61_186 VPWR VGND sg13cmos5l_decap_8
X_1923_ _1923_/Q Tile_X0Y0_FrameData[29] Tile_X0Y5_FrameStrobe[7] VPWR VGND sg13cmos5l_dlhq_1
XFILLER_91_80 VPWR VGND sg13cmos5l_fill_1
XANTENNA__0599__A1 Tile_X0Y5_N4END[0] VPWR VGND sg13cmos5l_antennanp
XANTENNA__2433__D Tile_X0Y2_FrameData[31] VPWR VGND sg13cmos5l_antennanp
XANTENNA__3666__X Tile_X0Y3_E2BEGb[5] VPWR VGND sg13cmos5l_antennanp
XFILLER_147_203 VPWR VGND sg13cmos5l_fill_2
XANTENNA__1260__A2 AXI_M_SOC_WREADY VPWR VGND sg13cmos5l_antennanp
XANTENNA__2053__GATE Tile_X0Y5_FrameStrobe[2] VPWR VGND sg13cmos5l_antennanp
XANTENNA__2683__GATE Tile_X0Y5_FrameStrobe[5] VPWR VGND sg13cmos5l_antennanp
XFILLER_147_247 VPWR VGND sg13cmos5l_decap_8
X_1854_ _1854_/Q Tile_X0Y0_FrameData[2] Tile_X0Y5_FrameStrobe[4] VPWR VGND sg13cmos5l_dlhq_1
XANTENNA__1548__A0 Tile_X0Y3_WW4END[7] VPWR VGND sg13cmos5l_antennanp
XFILLER_162_217 VPWR VGND sg13cmos5l_decap_8
X_1785_ _1785_/Q Tile_X0Y0_FrameData[7] Tile_X0Y5_FrameStrobe[2] VPWR VGND sg13cmos5l_dlhq_1
X_0805_ _3828_/A Tile_X0Y5_W2END[2] _0765_/X _0790_/X _0656_/X _3222_/Q _3221_/Q VPWR
+ VGND sg13cmos5l_mux4_1
XANTENNA__1012__A2 Tile_X0Y5_N4END[6] VPWR VGND sg13cmos5l_antennanp
X_3524_ Tile_X0Y0_N4BEG[11] _3524_/A VPWR VGND sg13cmos5l_buf_1
X_0736_ _1133_/B Tile_X0Y4_W1END[3] _1127_/X Tile_X0Y4_W6END[11] _0735_/X _3013_/Q
+ _3014_/Q VPWR VGND sg13cmos5l_mux4_1
XANTENNA__2068__GATE Tile_X0Y5_FrameStrobe[3] VPWR VGND sg13cmos5l_antennanp
XANTENNA__3264__D Tile_X0Y5_FrameData[16] VPWR VGND sg13cmos5l_antennanp
X_3455_ Tile_X0Y1_FrameData_O[23] Tile_X0Y1_FrameData[23] VPWR VGND sg13cmos5l_buf_1
XANTENNA__2698__GATE Tile_X0Y5_FrameStrobe[5] VPWR VGND sg13cmos5l_antennanp
X_2406_ _2406_/Q Tile_X0Y2_FrameData[26] Tile_X0Y5_FrameStrobe[5] VPWR VGND sg13cmos5l_dlhq_1
X_0667_ _0667_/Y _1972_/Q _1971_/Q VPWR VGND sg13cmos5l_nor2b_1
XFILLER_130_158 VPWR VGND sg13cmos5l_decap_8
XFILLER_269_170 VPWR VGND sg13cmos5l_decap_4
X_3386_ Tile_X0Y2_EE4BEG[4] _3386_/A VPWR VGND sg13cmos5l_buf_1
X_0598_ _0598_/X Tile_X0Y5_N1END[0] Tile_X0Y5_N4END[0] _1054_/B _0595_/X _3096_/Q
+ _3095_/Q VPWR VGND sg13cmos5l_mux4_1
XANTENNA__1315__A3 Tile_X0Y0_S4END[9] VPWR VGND sg13cmos5l_antennanp
X_2337_ _2337_/Q Tile_X0Y2_FrameData[31] Tile_X0Y5_FrameStrobe[3] VPWR VGND sg13cmos5l_dlhq_1
XFILLER_69_275 VPWR VGND sg13cmos5l_fill_2
XANTENNA__2621__GATE Tile_X0Y5_FrameStrobe[3] VPWR VGND sg13cmos5l_antennanp
X_2268_ _2268_/Q Tile_X0Y2_FrameData[4] Tile_X0Y5_FrameStrobe[0] VPWR VGND sg13cmos5l_dlhq_1
XANTENNA__1079__A2 Tile_X0Y1_W6END[4] VPWR VGND sg13cmos5l_antennanp
XANTENNA__2608__D Tile_X0Y3_FrameData[0] VPWR VGND sg13cmos5l_antennanp
X_1219_ _1219_/X _1142_/X _1048_/X _1047_/X _1141_/X _2534_/Q _2533_/Q VPWR VGND sg13cmos5l_mux4_1
XFILLER_44_109 VPWR VGND sg13cmos5l_fill_2
X_2199_ _2199_/Q Tile_X0Y1_FrameData[25] Tile_X0Y5_FrameStrobe[7] VPWR VGND sg13cmos5l_dlhq_1
XANTENNA__2006__GATE Tile_X0Y5_FrameStrobe[1] VPWR VGND sg13cmos5l_antennanp
XANTENNA__2636__GATE Tile_X0Y5_FrameStrobe[3] VPWR VGND sg13cmos5l_antennanp
XFILLER_71_28 VPWR VGND sg13cmos5l_decap_8
XFILLER_52_186 VPWR VGND sg13cmos5l_decap_8
XANTENNA__1892__GATE Tile_X0Y5_FrameStrobe[6] VPWR VGND sg13cmos5l_antennanp
XANTENNA__2343__D Tile_X0Y2_FrameData[25] VPWR VGND sg13cmos5l_antennanp
XANTENNA__3576__X Tile_X0Y0_FrameData_O[7] VPWR VGND sg13cmos5l_antennanp
XFILLER_138_269 VPWR VGND sg13cmos5l_decap_8
XFILLER_267_61 VPWR VGND sg13cmos5l_fill_1
XFILLER_267_72 VPWR VGND sg13cmos5l_fill_2
XFILLER_4_216 VPWR VGND sg13cmos5l_fill_2
XANTENNA__3174__D Tile_X0Y5_FrameData[10] VPWR VGND sg13cmos5l_antennanp
XFILLER_106_166 VPWR VGND sg13cmos5l_decap_8
XFILLER_136_21 VPWR VGND sg13cmos5l_decap_8
XANTENNA__0762__A1 Tile_X0Y5_W6END[8] VPWR VGND sg13cmos5l_antennanp
XFILLER_161_261 VPWR VGND sg13cmos5l_fill_1
XANTENNA__1830__GATE Tile_X0Y5_FrameStrobe[4] VPWR VGND sg13cmos5l_antennanp
XFILLER_152_31 VPWR VGND sg13cmos5l_decap_8
XFILLER_275_140 VPWR VGND sg13cmos5l_fill_1
XFILLER_29_30 VPWR VGND sg13cmos5l_fill_2
XFILLER_208_207 VPWR VGND sg13cmos5l_fill_1
XANTENNA__2518__D Tile_X0Y3_FrameData[26] VPWR VGND sg13cmos5l_antennanp
XANTENNA__1845__GATE Tile_X0Y5_FrameStrobe[4] VPWR VGND sg13cmos5l_antennanp
XFILLER_290_154 VPWR VGND sg13cmos5l_fill_1
XFILLER_90_226 VPWR VGND sg13cmos5l_decap_8
XANTENNA__0817__A2 AXI_M_SOC_RVALID VPWR VGND sg13cmos5l_antennanp
XFILLER_250_0 VPWR VGND sg13cmos5l_fill_2
XFILLER_28_194 VPWR VGND sg13cmos5l_decap_8
XFILLER_302_67 VPWR VGND sg13cmos5l_decap_8
XFILLER_188_125 VPWR VGND sg13cmos5l_decap_8
XFILLER_45_84 VPWR VGND sg13cmos5l_decap_8
XANTENNA__2253__D Tile_X0Y2_FrameData[19] VPWR VGND sg13cmos5l_antennanp
XANTENNA__3349__D Tile_X0Y5_FrameData[15] VPWR VGND sg13cmos5l_antennanp
XANTENNA__3486__X Tile_X0Y1_E6BEG[6] VPWR VGND sg13cmos5l_antennanp
XANTENNA__3927__A Tile_X0Y5_UserCLK VPWR VGND sg13cmos5l_antennanp
XFILLER_61_50 VPWR VGND sg13cmos5l_decap_8
XANTENNA__1242__A2 Tile_X0Y0_S4END[3] VPWR VGND sg13cmos5l_antennanp
XFILLER_177_94 VPWR VGND sg13cmos5l_decap_4
XFILLER_6_34 VPWR VGND sg13cmos5l_fill_2
XANTENNA_5 Tile_X0Y5_N4END[6] VPWR VGND sg13cmos5l_antennanp
X_1570_ _1570_/Y _2720_/Q _1569_/X _2719_/Q VPWR VGND sg13cmos5l_o21ai_1
XFILLER_327_86 VPWR VGND sg13cmos5l_decap_8
XFILLER_327_75 VPWR VGND sg13cmos5l_fill_2
XANTENNA__3084__D Tile_X0Y5_FrameData[4] VPWR VGND sg13cmos5l_antennanp
XFILLER_298_254 VPWR VGND sg13cmos5l_fill_1
XFILLER_298_276 VPWR VGND sg13cmos5l_fill_2
X_3240_ _3240_/Q Tile_X0Y5_FrameData[8] Tile_X0Y5_FrameStrobe[5] VPWR VGND sg13cmos5l_dlhq_1
X_3171_ _3171_/Q Tile_X0Y5_FrameData[13] Tile_X0Y5_FrameStrobe[3] VPWR VGND sg13cmos5l_dlhq_1
XFILLER_266_162 VPWR VGND sg13cmos5l_fill_2
X_2122_ _2122_/Q Tile_X0Y1_FrameData[6] Tile_X0Y5_FrameStrobe[4] VPWR VGND sg13cmos5l_dlhq_1
XFILLER_66_234 VPWR VGND sg13cmos5l_decap_4
XANTENNA__2428__D Tile_X0Y2_FrameData[4] VPWR VGND sg13cmos5l_antennanp
XFILLER_207_251 VPWR VGND sg13cmos5l_fill_1
XFILLER_281_165 VPWR VGND sg13cmos5l_fill_1
X_2053_ _2053_/Q Tile_X0Y1_FrameData[11] Tile_X0Y5_FrameStrobe[2] VPWR VGND sg13cmos5l_dlhq_1
X_1004_ _1004_/X _1024_/X _1003_/X Tile_X0Y0_S1END[2] Tile_X0Y0_S4END[2] _1740_/Q
+ _1739_/Q VPWR VGND sg13cmos5l_mux4_1
XFILLER_288_49 VPWR VGND sg13cmos5l_fill_1
XFILLER_34_175 VPWR VGND sg13cmos5l_fill_2
XFILLER_96_0 VPWR VGND sg13cmos5l_fill_1
XANTENNA__2163__D Tile_X0Y1_FrameData[29] VPWR VGND sg13cmos5l_antennanp
XANTENNA__3259__D Tile_X0Y5_FrameData[21] VPWR VGND sg13cmos5l_antennanp
XANTENNA__3396__X Tile_X0Y2_EE4BEG[14] VPWR VGND sg13cmos5l_antennanp
X_2955_ _2955_/Q Tile_X0Y4_FrameData[21] Tile_X0Y5_FrameStrobe[5] VPWR VGND sg13cmos5l_dlhq_1
X_2886_ _2886_/Q Tile_X0Y4_FrameData[26] Tile_X0Y5_FrameStrobe[3] VPWR VGND sg13cmos5l_dlhq_1
X_1906_ _1906_/Q Tile_X0Y0_FrameData[14] Tile_X0Y5_FrameStrobe[6] VPWR VGND sg13cmos5l_dlhq_1
X_1837_ _1837_/Q Tile_X0Y0_FrameData[19] Tile_X0Y5_FrameStrobe[4] VPWR VGND sg13cmos5l_dlhq_1
X_3507_ Tile_X0Y1_E2BEG[7] _3507_/A VPWR VGND sg13cmos5l_buf_1
X_1768_ _1768_/Q Tile_X0Y0_FrameData[24] Tile_X0Y5_FrameStrobe[2] VPWR VGND sg13cmos5l_dlhq_1
XANTENNA__1644__X AXI_M_SOC_ARADDR10 VPWR VGND sg13cmos5l_antennanp
XANTENNA__3304__GATE Tile_X0Y5_FrameStrobe[7] VPWR VGND sg13cmos5l_antennanp
XANTENNA__3572__A Tile_X0Y0_FrameData[3] VPWR VGND sg13cmos5l_antennanp
XFILLER_173_19 VPWR VGND sg13cmos5l_fill_1
X_1699_ _1699_/Q Tile_X0Y0_FrameData[29] Tile_X0Y5_FrameStrobe[0] VPWR VGND sg13cmos5l_dlhq_1
X_0719_ _0719_/Y _2242_/Q _2513_/Q VPWR VGND sg13cmos5l_nor2b_1
XFILLER_103_125 VPWR VGND sg13cmos5l_decap_8
XFILLER_103_136 VPWR VGND sg13cmos5l_fill_2
X_3438_ Tile_X0Y1_FrameData_O[6] Tile_X0Y1_FrameData[6] VPWR VGND sg13cmos5l_buf_1
XANTENNA__2560__GATE Tile_X0Y5_FrameStrobe[1] VPWR VGND sg13cmos5l_antennanp
XFILLER_103_169 VPWR VGND sg13cmos5l_decap_8
XFILLER_257_140 VPWR VGND sg13cmos5l_decap_8
X_3369_ Tile_X0Y2_E2BEGb[7] _3369_/A VPWR VGND sg13cmos5l_buf_1
XANTENNA__2338__D Tile_X0Y2_FrameData[30] VPWR VGND sg13cmos5l_antennanp
XANTENNA__3319__GATE Tile_X0Y5_FrameStrobe[8] VPWR VGND sg13cmos5l_antennanp
XFILLER_272_121 VPWR VGND sg13cmos5l_fill_1
XFILLER_272_132 VPWR VGND sg13cmos5l_fill_2
XFILLER_272_154 VPWR VGND sg13cmos5l_fill_1
XANTENNA__2575__GATE Tile_X0Y5_FrameStrobe[1] VPWR VGND sg13cmos5l_antennanp
XFILLER_272_176 VPWR VGND sg13cmos5l_fill_1
XANTENNA__1472__A2 AXI_M_SOC_RDATA20 VPWR VGND sg13cmos5l_antennanp
XFILLER_25_175 VPWR VGND sg13cmos5l_decap_8
XFILLER_80_281 VPWR VGND sg13cmos5l_fill_2
XANTENNA__2073__D Tile_X0Y1_FrameData[23] VPWR VGND sg13cmos5l_antennanp
XANTENNA__3169__D Tile_X0Y5_FrameData[15] VPWR VGND sg13cmos5l_antennanp
XFILLER_278_60 VPWR VGND sg13cmos5l_decap_8
XFILLER_278_71 VPWR VGND sg13cmos5l_fill_2
XFILLER_31_20 VPWR VGND sg13cmos5l_fill_2
XANTENNA__0983__A1 Tile_X0Y4_WW4END[3] VPWR VGND sg13cmos5l_antennanp
XANTENNA__2513__GATE Tile_X0Y5_FrameStrobe[0] VPWR VGND sg13cmos5l_antennanp
XANTENNA__2801__D Tile_X0Y4_FrameData[15] VPWR VGND sg13cmos5l_antennanp
XANTENNA__1554__X AXI_M_SOC_ARADDR28 VPWR VGND sg13cmos5l_antennanp
XFILLER_295_202 VPWR VGND sg13cmos5l_fill_2
XANTENNA__2528__GATE Tile_X0Y5_FrameStrobe[0] VPWR VGND sg13cmos5l_antennanp
XFILLER_298_0 VPWR VGND sg13cmos5l_fill_2
XFILLER_313_22 VPWR VGND sg13cmos5l_fill_1
XANTENNA__1784__GATE Tile_X0Y5_FrameStrobe[2] VPWR VGND sg13cmos5l_antennanp
XANTENNA__2248__D Tile_X0Y2_FrameData[24] VPWR VGND sg13cmos5l_antennanp
XFILLER_263_132 VPWR VGND sg13cmos5l_decap_8
XFILLER_313_99 VPWR VGND sg13cmos5l_fill_1
XFILLER_56_61 VPWR VGND sg13cmos5l_decap_8
XFILLER_16_131 VPWR VGND sg13cmos5l_decap_4
XFILLER_204_210 VPWR VGND sg13cmos5l_decap_8
XFILLER_263_198 VPWR VGND sg13cmos5l_decap_4
XFILLER_16_153 VPWR VGND sg13cmos5l_decap_8
XFILLER_16_175 VPWR VGND sg13cmos5l_decap_8
XFILLER_204_221 VPWR VGND sg13cmos5l_fill_2
XANTENNA__1799__GATE Tile_X0Y5_FrameStrobe[3] VPWR VGND sg13cmos5l_antennanp
XANTENNA__3079__D Tile_X0Y5_FrameData[9] VPWR VGND sg13cmos5l_antennanp
XFILLER_188_60 VPWR VGND sg13cmos5l_decap_8
XFILLER_188_71 VPWR VGND sg13cmos5l_fill_2
X_2740_ _2740_/Q Tile_X0Y3_FrameData[28] Tile_X0Y5_FrameStrobe[7] VPWR VGND sg13cmos5l_dlhq_1
XFILLER_31_189 VPWR VGND sg13cmos5l_decap_4
XFILLER_318_122 VPWR VGND sg13cmos5l_decap_8
XANTENNA__1722__GATE Tile_X0Y5_FrameStrobe[0] VPWR VGND sg13cmos5l_antennanp
X_2671_ _2671_/Q Tile_X0Y3_FrameData[1] Tile_X0Y5_FrameStrobe[4] VPWR VGND sg13cmos5l_dlhq_1
XFILLER_318_166 VPWR VGND sg13cmos5l_fill_1
XANTENNA__0974__A1 Tile_X0Y5_W2END[5] VPWR VGND sg13cmos5l_antennanp
XANTENNA__2711__D Tile_X0Y3_FrameData[25] VPWR VGND sg13cmos5l_antennanp
XFILLER_117_239 VPWR VGND sg13cmos5l_decap_8
X_1622_ _3752_/A Tile_X0Y5_N4END[6] _1040_/X _0995_/X _1046_/X _2907_/Q _2908_/Q VPWR
+ VGND sg13cmos5l_mux4_1
XFILLER_338_96 VPWR VGND sg13cmos5l_fill_1
XFILLER_333_169 VPWR VGND sg13cmos5l_fill_2
XANTENNA__1737__GATE Tile_X0Y5_FrameStrobe[1] VPWR VGND sg13cmos5l_antennanp
XFILLER_207_34 VPWR VGND sg13cmos5l_fill_1
X_1553_ AXI_M_SOC_ARADDR29 Tile_X0Y3_WW4END[5] Tile_X0Y3_WW4END[13] Tile_X0Y3_W6END[5]
+ _1437_/X _2606_/Q _2605_/Q VPWR VGND sg13cmos5l_mux4_1
XFILLER_286_213 VPWR VGND sg13cmos5l_fill_1
X_1484_ _1485_/B Tile_X0Y2_W1END[3] Tile_X0Y2_W6END[7] Tile_X0Y2_WW4END[15] _1371_/X
+ _2442_/Q _2443_/Q VPWR VGND sg13cmos5l_mux4_1
X_3223_ _3223_/Q Tile_X0Y5_FrameData[25] Tile_X0Y5_FrameStrobe[5] VPWR VGND sg13cmos5l_dlhq_1
XFILLER_98_189 VPWR VGND sg13cmos5l_fill_2
XANTENNA__3290__GATE Tile_X0Y5_FrameStrobe[7] VPWR VGND sg13cmos5l_antennanp
XFILLER_239_151 VPWR VGND sg13cmos5l_decap_8
XANTENNA__2158__D Tile_X0Y1_FrameData[2] VPWR VGND sg13cmos5l_antennanp
XFILLER_11_0 VPWR VGND sg13cmos5l_fill_1
XFILLER_223_44 VPWR VGND sg13cmos5l_decap_8
X_3154_ _3154_/Q Tile_X0Y5_FrameData[30] Tile_X0Y5_FrameStrobe[3] VPWR VGND sg13cmos5l_dlhq_1
XFILLER_223_88 VPWR VGND sg13cmos5l_decap_8
X_3085_ _3085_/Q Tile_X0Y5_FrameData[3] Tile_X0Y5_FrameStrobe[0] VPWR VGND sg13cmos5l_dlhq_1
X_2105_ _2105_/Q Tile_X0Y1_FrameData[23] Tile_X0Y5_FrameStrobe[4] VPWR VGND sg13cmos5l_dlhq_1
XFILLER_54_215 VPWR VGND sg13cmos5l_fill_2
XANTENNA__1997__D Tile_X0Y1_FrameData[3] VPWR VGND sg13cmos5l_antennanp
XFILLER_199_209 VPWR VGND sg13cmos5l_fill_2
XFILLER_254_187 VPWR VGND sg13cmos5l_decap_8
X_2036_ _2036_/Q Tile_X0Y1_FrameData[28] Tile_X0Y5_FrameStrobe[2] VPWR VGND sg13cmos5l_dlhq_1
XANTENNA__1639__X AXI_M_SOC_ARADDR6 VPWR VGND sg13cmos5l_antennanp
XANTENNA__3567__A Tile_X0Y5_FrameStrobe[18] VPWR VGND sg13cmos5l_antennanp
XANTENNA__1206__A2 Tile_X0Y0_W6END[5] VPWR VGND sg13cmos5l_antennanp
X_2938_ _2938_/Q Tile_X0Y4_FrameData[6] Tile_X0Y5_FrameStrobe[4] VPWR VGND sg13cmos5l_dlhq_1
XFILLER_309_166 VPWR VGND sg13cmos5l_fill_1
XANTENNA__2621__D Tile_X0Y3_FrameData[19] VPWR VGND sg13cmos5l_antennanp
XANTENNA__3854__X Tile_X0Y5_EE4BEG[11] VPWR VGND sg13cmos5l_antennanp
XFILLER_190_120 VPWR VGND sg13cmos5l_decap_8
XFILLER_309_188 VPWR VGND sg13cmos5l_fill_2
X_2869_ _2869_/Q Tile_X0Y4_FrameData[11] Tile_X0Y5_FrameStrobe[2] VPWR VGND sg13cmos5l_dlhq_1
XANTENNA__3243__GATE Tile_X0Y5_FrameStrobe[5] VPWR VGND sg13cmos5l_antennanp
XFILLER_116_283 VPWR VGND sg13cmos5l_fill_1
XFILLER_117_34 VPWR VGND sg13cmos5l_fill_2
XFILLER_190_186 VPWR VGND sg13cmos5l_fill_2
XFILLER_77_16 VPWR VGND sg13cmos5l_decap_8
XFILLER_89_189 VPWR VGND sg13cmos5l_decap_8
XFILLER_89_156 VPWR VGND sg13cmos5l_decap_4
XANTENNA__3258__GATE Tile_X0Y5_FrameStrobe[6] VPWR VGND sg13cmos5l_antennanp
XFILLER_133_22 VPWR VGND sg13cmos5l_decap_8
XANTENNA__1142__A1 Tile_X0Y4_W2END[6] VPWR VGND sg13cmos5l_antennanp
XANTENNA__2068__D Tile_X0Y1_FrameData[28] VPWR VGND sg13cmos5l_antennanp
XFILLER_280_94 VPWR VGND sg13cmos5l_decap_4
XFILLER_26_64 VPWR VGND sg13cmos5l_decap_4
XANTENNA__1445__A2 AXI_M_SOC_RDATA14 VPWR VGND sg13cmos5l_antennanp
XANTENNA__1700__D Tile_X0Y0_FrameData[28] VPWR VGND sg13cmos5l_antennanp
XANTENNA__1549__X AXI_M_SOC_ARADDR27 VPWR VGND sg13cmos5l_antennanp
XFILLER_13_167 VPWR VGND sg13cmos5l_decap_8
XFILLER_9_105 VPWR VGND sg13cmos5l_decap_8
XANTENNA__2452__GATE Tile_X0Y5_FrameStrobe[6] VPWR VGND sg13cmos5l_antennanp
XFILLER_42_96 VPWR VGND sg13cmos5l_decap_8
XANTENNA__2531__D Tile_X0Y3_FrameData[13] VPWR VGND sg13cmos5l_antennanp
XANTENNA__3764__X Tile_X0Y4_EE4BEG[2] VPWR VGND sg13cmos5l_antennanp
XFILLER_166_172 VPWR VGND sg13cmos5l_decap_8
XFILLER_308_11 VPWR VGND sg13cmos5l_fill_1
XFILLER_107_272 VPWR VGND sg13cmos5l_fill_2
XANTENNA__2467__GATE Tile_X0Y5_FrameStrobe[7] VPWR VGND sg13cmos5l_antennanp
XFILLER_268_202 VPWR VGND sg13cmos5l_fill_1
XFILLER_268_224 VPWR VGND sg13cmos5l_decap_4
XANTENNA__1381__A1 Tile_X0Y2_W6END[10] VPWR VGND sg13cmos5l_antennanp
XFILLER_3_46 VPWR VGND sg13cmos5l_fill_1
XFILLER_236_121 VPWR VGND sg13cmos5l_decap_4
XFILLER_283_238 VPWR VGND sg13cmos5l_decap_4
XFILLER_283_249 VPWR VGND sg13cmos5l_fill_1
XANTENNA__1684__A2 Tile_X0Y4_WW4END[12] VPWR VGND sg13cmos5l_antennanp
XFILLER_236_143 VPWR VGND sg13cmos5l_decap_8
XFILLER_236_154 VPWR VGND sg13cmos5l_fill_2
XFILLER_36_204 VPWR VGND sg13cmos5l_decap_8
XANTENNA__0892__A0 Tile_X0Y3_W1END[3] VPWR VGND sg13cmos5l_antennanp
XFILLER_251_113 VPWR VGND sg13cmos5l_decap_4
XFILLER_36_237 VPWR VGND sg13cmos5l_fill_2
XANTENNA__2706__D Tile_X0Y3_FrameData[30] VPWR VGND sg13cmos5l_antennanp
XFILLER_291_293 VPWR VGND sg13cmos5l_fill_2
XFILLER_83_70 VPWR VGND sg13cmos5l_decap_4
XFILLER_51_218 VPWR VGND sg13cmos5l_decap_8
XANTENNA__1436__A2 Tile_X0Y5_N4END[8] VPWR VGND sg13cmos5l_antennanp
XANTENNA__2405__GATE Tile_X0Y5_FrameStrobe[5] VPWR VGND sg13cmos5l_antennanp
X_3910_ Tile_X0Y5_S2BEGb[7] _3910_/A VPWR VGND sg13cmos5l_buf_1
XFILLER_149_106 VPWR VGND sg13cmos5l_fill_1
X_3841_ Tile_X0Y5_E6BEG[10] _3841_/A VPWR VGND sg13cmos5l_buf_1
X_3772_ Tile_X0Y4_EE4BEG[10] _3772_/A VPWR VGND sg13cmos5l_buf_1
X_2723_ _2723_/Q Tile_X0Y3_FrameData[13] Tile_X0Y5_FrameStrobe[6] VPWR VGND sg13cmos5l_dlhq_1
X_0984_ _0984_/X _0983_/X _0982_/X _3021_/Q VPWR VGND sg13cmos5l_mux2_1
XANTENNA__2441__D Tile_X0Y2_FrameData[23] VPWR VGND sg13cmos5l_antennanp
XANTENNA__3674__X Tile_X0Y3_E6BEG[5] VPWR VGND sg13cmos5l_antennanp
XFILLER_218_11 VPWR VGND sg13cmos5l_fill_1
XFILLER_306_103 VPWR VGND sg13cmos5l_fill_2
XFILLER_218_55 VPWR VGND sg13cmos5l_decap_8
X_2654_ _2654_/Q Tile_X0Y3_FrameData[18] Tile_X0Y5_FrameStrobe[4] VPWR VGND sg13cmos5l_dlhq_1
XANTENNA__1194__X AXI_M_SOC_AWADDR14 VPWR VGND sg13cmos5l_antennanp
XFILLER_172_186 VPWR VGND sg13cmos5l_decap_4
X_2585_ _2585_/Q Tile_X0Y3_FrameData[23] Tile_X0Y5_FrameStrobe[2] VPWR VGND sg13cmos5l_dlhq_1
X_1605_ _1605_/X _1437_/X _1523_/X _0885_/X _1219_/X _2757_/Q _2756_/Q VPWR VGND sg13cmos5l_mux4_1
XFILLER_59_0 VPWR VGND sg13cmos5l_decap_8
X_1536_ _3671_/A Tile_X0Y5_N4END[10] _1523_/X Tile_X0Y0_S4END[14] _0885_/X _2635_/Q
+ _2636_/Q VPWR VGND sg13cmos5l_mux4_1
XANTENNA__1372__A1 Tile_X0Y2_W6END[11] VPWR VGND sg13cmos5l_antennanp
XFILLER_234_32 VPWR VGND sg13cmos5l_decap_4
XANTENNA__3272__D Tile_X0Y5_FrameData[8] VPWR VGND sg13cmos5l_antennanp
X_1467_ _3362_/A Tile_X0Y2_W2END[7] AXI_M_SOC_RDATA21 _1157_/X _1179_/X _2416_/Q _2415_/Q
+ VPWR VGND sg13cmos5l_mux4_1
X_3206_ _3206_/Q Tile_X0Y5_FrameData[10] Tile_X0Y5_FrameStrobe[4] VPWR VGND sg13cmos5l_dlhq_1
X_1398_ _3371_/A Tile_X0Y5_N4END[13] _1379_/X Tile_X0Y0_S4END[9] _0976_/X _2365_/Q
+ _2366_/Q VPWR VGND sg13cmos5l_mux4_1
XFILLER_86_159 VPWR VGND sg13cmos5l_decap_8
XANTENNA__1675__A2 AXI_M_SOC_RRESP0 VPWR VGND sg13cmos5l_antennanp
XFILLER_27_204 VPWR VGND sg13cmos5l_decap_8
X_3137_ _3137_/Q Tile_X0Y5_FrameData[15] Tile_X0Y5_FrameStrobe[2] VPWR VGND sg13cmos5l_dlhq_1
XANTENNA__0883__A0 Tile_X0Y3_W1END[0] VPWR VGND sg13cmos5l_antennanp
XFILLER_103_36 VPWR VGND sg13cmos5l_decap_8
XFILLER_250_31 VPWR VGND sg13cmos5l_fill_1
XFILLER_27_248 VPWR VGND sg13cmos5l_fill_1
XANTENNA__2616__D Tile_X0Y3_FrameData[24] VPWR VGND sg13cmos5l_antennanp
XANTENNA__3849__X Tile_X0Y5_EE4BEG[6] VPWR VGND sg13cmos5l_antennanp
XFILLER_242_146 VPWR VGND sg13cmos5l_fill_1
XFILLER_282_293 VPWR VGND sg13cmos5l_fill_2
X_3068_ _3068_/Q Tile_X0Y5_FrameData[20] Tile_X0Y5_FrameStrobe[0] VPWR VGND sg13cmos5l_dlhq_1
XFILLER_63_18 VPWR VGND sg13cmos5l_decap_8
XANTENNA__1427__A2 Tile_X0Y2_W6END[7] VPWR VGND sg13cmos5l_antennanp
X_2019_ _2019_/Q Tile_X0Y1_FrameData[13] Tile_X0Y5_FrameStrobe[1] VPWR VGND sg13cmos5l_dlhq_1
XANTENNA__0635__A0 Tile_X0Y3_W1END[1] VPWR VGND sg13cmos5l_antennanp
XFILLER_144_8 VPWR VGND sg13cmos5l_decap_8
XANTENNA__0714__A Tile_X0Y1_W6END[3] VPWR VGND sg13cmos5l_antennanp
XFILLER_259_62 VPWR VGND sg13cmos5l_decap_4
XFILLER_10_148 VPWR VGND sg13cmos5l_decap_8
XFILLER_12_11 VPWR VGND sg13cmos5l_fill_2
XFILLER_137_7 VPWR VGND sg13cmos5l_decap_4
XFILLER_195_256 VPWR VGND sg13cmos5l_fill_1
XANTENNA__1060__A0 Tile_X0Y0_W1END[0] VPWR VGND sg13cmos5l_antennanp
XANTENNA__2351__D Tile_X0Y2_FrameData[17] VPWR VGND sg13cmos5l_antennanp
XANTENNA__3182__GATE Tile_X0Y5_FrameStrobe[3] VPWR VGND sg13cmos5l_antennanp
XANTENNA__3584__X Tile_X0Y0_FrameData_O[15] VPWR VGND sg13cmos5l_antennanp
XFILLER_311_8 VPWR VGND sg13cmos5l_fill_2
XFILLER_128_33 VPWR VGND sg13cmos5l_fill_1
XFILLER_275_61 VPWR VGND sg13cmos5l_fill_2
XFILLER_275_94 VPWR VGND sg13cmos5l_fill_1
XFILLER_88_26 VPWR VGND sg13cmos5l_decap_8
XFILLER_104_220 VPWR VGND sg13cmos5l_decap_8
XANTENNA__3197__GATE Tile_X0Y5_FrameStrobe[4] VPWR VGND sg13cmos5l_antennanp
XANTENNA__3182__D Tile_X0Y5_FrameData[2] VPWR VGND sg13cmos5l_antennanp
XFILLER_320_183 VPWR VGND sg13cmos5l_fill_2
XFILLER_218_110 VPWR VGND sg13cmos5l_decap_4
XANTENNA__3120__GATE Tile_X0Y5_FrameStrobe[1] VPWR VGND sg13cmos5l_antennanp
XFILLER_280_208 VPWR VGND sg13cmos5l_decap_4
XFILLER_218_176 VPWR VGND sg13cmos5l_decap_4
XFILLER_280_219 VPWR VGND sg13cmos5l_fill_2
XANTENNA__2526__D Tile_X0Y3_FrameData[18] VPWR VGND sg13cmos5l_antennanp
XANTENNA__3759__X Tile_X0Y4_E6BEG[9] VPWR VGND sg13cmos5l_antennanp
XFILLER_273_293 VPWR VGND sg13cmos5l_fill_2
XANTENNA__1418__A2 Tile_X0Y2_W6END[11] VPWR VGND sg13cmos5l_antennanp
XFILLER_233_179 VPWR VGND sg13cmos5l_decap_4
XANTENNA__3135__GATE Tile_X0Y5_FrameStrobe[2] VPWR VGND sg13cmos5l_antennanp
XFILLER_53_84 VPWR VGND sg13cmos5l_decap_8
XANTENNA__2391__GATE Tile_X0Y5_FrameStrobe[4] VPWR VGND sg13cmos5l_antennanp
XANTENNA__1051__A0 Tile_X0Y3_W1END[0] VPWR VGND sg13cmos5l_antennanp
XANTENNA__2261__D Tile_X0Y2_FrameData[11] VPWR VGND sg13cmos5l_antennanp
XANTENNA__3494__X Tile_X0Y1_E2BEGb[2] VPWR VGND sg13cmos5l_antennanp
XFILLER_319_43 VPWR VGND sg13cmos5l_fill_1
XFILLER_154_142 VPWR VGND sg13cmos5l_decap_8
XFILLER_52_7 VPWR VGND sg13cmos5l_decap_8
XFILLER_303_128 VPWR VGND sg13cmos5l_fill_1
XFILLER_5_174 VPWR VGND sg13cmos5l_decap_8
X_2370_ _2370_/Q Tile_X0Y2_FrameData[30] Tile_X0Y5_FrameStrobe[4] VPWR VGND sg13cmos5l_dlhq_1
XFILLER_335_53 VPWR VGND sg13cmos5l_decap_8
XANTENNA__3092__D Tile_X0Y5_FrameData[28] VPWR VGND sg13cmos5l_antennanp
X_1321_ _3500_/A Tile_X0Y1_W2MID[7] AXI_M_SOC_RDATA22 _1110_/X _1115_/X _2160_/Q _2159_/Q
+ VPWR VGND sg13cmos5l_mux4_1
XFILLER_78_92 VPWR VGND sg13cmos5l_decap_8
XFILLER_68_126 VPWR VGND sg13cmos5l_decap_8
XANTENNA__1106__A1 Tile_X0Y1_W2END[7] VPWR VGND sg13cmos5l_antennanp
XFILLER_311_194 VPWR VGND sg13cmos5l_fill_1
X_1252_ _3644_/A Tile_X0Y0_W2MID[0] _1145_/X AXI_M_SOC_AWREADY _1136_/X _1873_/Q _1874_/Q
+ VPWR VGND sg13cmos5l_mux4_1
XFILLER_83_107 VPWR VGND sg13cmos5l_fill_2
XFILLER_224_102 VPWR VGND sg13cmos5l_decap_8
X_1183_ _1183_/X _1085_/X _1181_/X _1182_/X _1084_/X _2253_/Q _2254_/Q VPWR VGND sg13cmos5l_mux4_1
XANTENNA__2344__GATE Tile_X0Y5_FrameStrobe[3] VPWR VGND sg13cmos5l_antennanp
XANTENNA__3669__X Tile_X0Y3_E6BEG[0] VPWR VGND sg13cmos5l_antennanp
XFILLER_24_218 VPWR VGND sg13cmos5l_decap_8
XFILLER_264_293 VPWR VGND sg13cmos5l_fill_2
XFILLER_91_151 VPWR VGND sg13cmos5l_decap_8
XANTENNA__2436__D Tile_X0Y2_FrameData[28] VPWR VGND sg13cmos5l_antennanp
XANTENNA__2974__GATE Tile_X0Y5_FrameStrobe[5] VPWR VGND sg13cmos5l_antennanp
XFILLER_91_195 VPWR VGND sg13cmos5l_decap_4
XANTENNA__0617__A0 Tile_X0Y0_W1END[1] VPWR VGND sg13cmos5l_antennanp
XANTENNA__1290__A0 Tile_X0Y1_WW4END[7] VPWR VGND sg13cmos5l_antennanp
XANTENNA__2359__GATE Tile_X0Y5_FrameStrobe[3] VPWR VGND sg13cmos5l_antennanp
XFILLER_296_16 VPWR VGND sg13cmos5l_fill_2
XANTENNA__2989__GATE Tile_X0Y5_FrameStrobe[6] VPWR VGND sg13cmos5l_antennanp
X_3824_ Tile_X0Y5_E2BEGb[1] _3824_/A VPWR VGND sg13cmos5l_buf_1
XANTENNA__2171__D Tile_X0Y1_FrameData[21] VPWR VGND sg13cmos5l_antennanp
XANTENNA__3267__D Tile_X0Y5_FrameData[13] VPWR VGND sg13cmos5l_antennanp
XFILLER_229_54 VPWR VGND sg13cmos5l_decap_8
X_3755_ Tile_X0Y4_E6BEG[5] _3755_/A VPWR VGND sg13cmos5l_buf_1
X_0967_ AXI_M_SOC_AWLEN6 _3337_/Q _0966_/X VPWR VGND sg13cmos5l_nor2b_1
XFILLER_145_120 VPWR VGND sg13cmos5l_fill_2
XFILLER_229_76 VPWR VGND sg13cmos5l_decap_8
XFILLER_229_98 VPWR VGND sg13cmos5l_decap_8
X_2706_ _2706_/Q Tile_X0Y3_FrameData[30] Tile_X0Y5_FrameStrobe[6] VPWR VGND sg13cmos5l_dlhq_1
X_3686_ Tile_X0Y3_EE4BEG[5] _3686_/A VPWR VGND sg13cmos5l_buf_1
XANTENNA__1593__A1 Tile_X0Y3_WW4END[15] VPWR VGND sg13cmos5l_antennanp
XANTENNA__2912__GATE Tile_X0Y5_FrameStrobe[3] VPWR VGND sg13cmos5l_antennanp
XFILLER_145_164 VPWR VGND sg13cmos5l_decap_8
X_2637_ _2637_/Q Tile_X0Y3_FrameData[3] Tile_X0Y5_FrameStrobe[3] VPWR VGND sg13cmos5l_dlhq_1
X_0898_ _0898_/Y _0543_/Y _0897_/X _3293_/Q VPWR VGND sg13cmos5l_a21oi_1
X_2568_ _2568_/Q Tile_X0Y3_FrameData[8] Tile_X0Y5_FrameStrobe[1] VPWR VGND sg13cmos5l_dlhq_1
XFILLER_99_251 VPWR VGND sg13cmos5l_fill_2
XANTENNA__1652__X AXI_M_SOC_ARADDR14 VPWR VGND sg13cmos5l_antennanp
XANTENNA__3580__A Tile_X0Y0_FrameData[11] VPWR VGND sg13cmos5l_antennanp
XFILLER_302_150 VPWR VGND sg13cmos5l_fill_2
X_2499_ _2499_/Q Tile_X0Y2_FrameData[29] Tile_X0Y5_FrameStrobe[8] VPWR VGND sg13cmos5l_dlhq_1
X_1519_ _3667_/A Tile_X0Y3_W2END[1] AXI_M_SOC_RDATA7 _1219_/X _1348_/X _2676_/Q _2675_/Q
+ VPWR VGND sg13cmos5l_mux4_1
XANTENNA__2927__GATE Tile_X0Y5_FrameStrobe[4] VPWR VGND sg13cmos5l_antennanp
XFILLER_247_238 VPWR VGND sg13cmos5l_fill_2
XFILLER_59_159 VPWR VGND sg13cmos5l_decap_8
XANTENNA__1648__A2 Tile_X0Y4_W6END[2] VPWR VGND sg13cmos5l_antennanp
XANTENNA__3579__X Tile_X0Y0_FrameData_O[10] VPWR VGND sg13cmos5l_antennanp
XFILLER_215_113 VPWR VGND sg13cmos5l_decap_8
XFILLER_82_162 VPWR VGND sg13cmos5l_decap_8
XANTENNA__2346__D Tile_X0Y2_FrameData[22] VPWR VGND sg13cmos5l_antennanp
XANTENNA__1281__A0 Tile_X0Y1_WW4END[10] VPWR VGND sg13cmos5l_antennanp
XANTENNA__3177__D Tile_X0Y5_FrameData[7] VPWR VGND sg13cmos5l_antennanp
XANTENNA__2081__D Tile_X0Y1_FrameData[15] VPWR VGND sg13cmos5l_antennanp
XFILLER_99_47 VPWR VGND sg13cmos5l_decap_8
XFILLER_325_231 VPWR VGND sg13cmos5l_fill_1
XFILLER_136_175 VPWR VGND sg13cmos5l_decap_8
XFILLER_325_242 VPWR VGND sg13cmos5l_decap_8
XFILLER_155_42 VPWR VGND sg13cmos5l_decap_4
XANTENNA__1336__A1 AXI_M_SOC_RDATA27 VPWR VGND sg13cmos5l_antennanp
XANTENNA__1562__X AXI_M_SOC_BREADY VPWR VGND sg13cmos5l_antennanp
XFILLER_151_189 VPWR VGND sg13cmos5l_fill_1
XFILLER_280_0 VPWR VGND sg13cmos5l_fill_2
XFILLER_48_84 VPWR VGND sg13cmos5l_decap_8
XANTENNA__0619__A Tile_X0Y1_W6END[1] VPWR VGND sg13cmos5l_antennanp
XANTENNA__1639__A2 Tile_X0Y4_W6END[6] VPWR VGND sg13cmos5l_antennanp
XFILLER_58_170 VPWR VGND sg13cmos5l_decap_8
XFILLER_246_293 VPWR VGND sg13cmos5l_fill_2
XFILLER_261_230 VPWR VGND sg13cmos5l_fill_2
XANTENNA__2256__D Tile_X0Y2_FrameData[16] VPWR VGND sg13cmos5l_antennanp
XANTENNA__3074__GATE Tile_X0Y5_FrameStrobe[0] VPWR VGND sg13cmos5l_antennanp
XANTENNA__3489__X Tile_X0Y1_E6BEG[9] VPWR VGND sg13cmos5l_antennanp
XFILLER_64_50 VPWR VGND sg13cmos5l_decap_8
XFILLER_321_66 VPWR VGND sg13cmos5l_fill_2
XANTENNA__1272__A0 Tile_X0Y1_W2END[3] VPWR VGND sg13cmos5l_antennanp
XANTENNA__3089__GATE Tile_X0Y5_FrameStrobe[1] VPWR VGND sg13cmos5l_antennanp
X_1870_ _1870_/Q Tile_X0Y0_FrameData[18] Tile_X0Y5_FrameStrobe[5] VPWR VGND sg13cmos5l_dlhq_1
XANTENNA__3087__D Tile_X0Y5_FrameData[1] VPWR VGND sg13cmos5l_antennanp
X_0821_ _3856_/A Tile_X0Y5_WW4END[2] _0765_/X _0698_/A _0790_/X _3190_/Q _3189_/Q
+ VPWR VGND sg13cmos5l_mux4_1
XANTENNA__1024__A0 Tile_X0Y1_W1END[2] VPWR VGND sg13cmos5l_antennanp
X_3540_ Tile_X0Y0_N2BEG[3] _3540_/A VPWR VGND sg13cmos5l_buf_1
X_0752_ _0752_/Y _3258_/Q _0751_/Y _3257_/Q VPWR VGND sg13cmos5l_o21ai_1
XFILLER_316_231 VPWR VGND sg13cmos5l_fill_2
XANTENNA__3012__GATE Tile_X0Y5_FrameStrobe[7] VPWR VGND sg13cmos5l_antennanp
XFILLER_127_164 VPWR VGND sg13cmos5l_decap_8
X_3471_ Tile_X0Y1_EE4BEG[7] _3471_/A VPWR VGND sg13cmos5l_buf_1
X_0683_ _0683_/X _0678_/X _0679_/Y _0682_/Y VPWR VGND sg13cmos5l_a21o_1
X_2422_ _2422_/Q Tile_X0Y2_FrameData[10] Tile_X0Y5_FrameStrobe[5] VPWR VGND sg13cmos5l_dlhq_1
X_2353_ _2353_/Q Tile_X0Y2_FrameData[15] Tile_X0Y5_FrameStrobe[3] VPWR VGND sg13cmos5l_dlhq_1
XANTENNA__3027__GATE Tile_X0Y5_FrameStrobe[7] VPWR VGND sg13cmos5l_antennanp
XFILLER_229_227 VPWR VGND sg13cmos5l_fill_2
X_1304_ _3489_/A AXI_M_SOC_RDATA27 _0941_/X _1217_/X _1086_/X _2077_/Q _2078_/Q VPWR
+ VGND sg13cmos5l_mux4_1
XFILLER_215_78 VPWR VGND sg13cmos5l_fill_1
X_2284_ _2284_/Q Tile_X0Y2_FrameData[20] Tile_X0Y5_FrameStrobe[1] VPWR VGND sg13cmos5l_dlhq_1
XFILLER_56_107 VPWR VGND sg13cmos5l_decap_8
XANTENNA__2283__GATE Tile_X0Y5_FrameStrobe[1] VPWR VGND sg13cmos5l_antennanp
X_1235_ _3609_/A Tile_X0Y0_WW4END[7] _0985_/X AXI_M_SOC_AWREADY _1136_/X _1839_/Q
+ _1840_/Q VPWR VGND sg13cmos5l_mux4_1
XANTENNA__0838__A0 Tile_X0Y5_WW4END[3] VPWR VGND sg13cmos5l_antennanp
XFILLER_237_293 VPWR VGND sg13cmos5l_fill_2
X_1166_ _3645_/A _1079_/X AXI_M_SOC_BVALID Tile_X0Y0_S1END[0] AXI_M_SOC_AWREADY _1895_/Q
+ _1896_/Q VPWR VGND sg13cmos5l_mux4_1
XANTENNA__2166__D Tile_X0Y1_FrameData[26] VPWR VGND sg13cmos5l_antennanp
XANTENNA__3399__X Tile_X0Y2_FrameData_O[1] VPWR VGND sg13cmos5l_antennanp
X_1097_ _1097_/X Tile_X0Y2_W2MID[5] Tile_X0Y2_W2END[5] Tile_X0Y2_W6END[5] _1151_/X
+ _2500_/Q _2499_/Q VPWR VGND sg13cmos5l_mux4_1
XANTENNA__1263__A0 Tile_X0Y0_W2END[2] VPWR VGND sg13cmos5l_antennanp
XANTENNA__2298__GATE Tile_X0Y5_FrameStrobe[1] VPWR VGND sg13cmos5l_antennanp
XFILLER_220_160 VPWR VGND sg13cmos5l_decap_8
X_3807_ Tile_X0Y4_FrameData_O[29] Tile_X0Y4_FrameData[29] VPWR VGND sg13cmos5l_buf_1
XANTENNA__1015__A0 Tile_X0Y5_W2MID[5] VPWR VGND sg13cmos5l_antennanp
XANTENNA__1647__X AXI_M_SOC_ARADDR19 VPWR VGND sg13cmos5l_antennanp
XANTENNA__2221__GATE Tile_X0Y5_FrameStrobe[7] VPWR VGND sg13cmos5l_antennanp
XANTENNA__2851__GATE Tile_X0Y5_FrameStrobe[2] VPWR VGND sg13cmos5l_antennanp
XANTENNA__3575__A Tile_X0Y0_FrameData[6] VPWR VGND sg13cmos5l_antennanp
XFILLER_307_231 VPWR VGND sg13cmos5l_fill_1
X_1999_ _1999_/Q Tile_X0Y1_FrameData[1] Tile_X0Y5_FrameStrobe[0] VPWR VGND sg13cmos5l_dlhq_1
XFILLER_118_153 VPWR VGND sg13cmos5l_decap_8
XFILLER_180_207 VPWR VGND sg13cmos5l_decap_4
XFILLER_180_229 VPWR VGND sg13cmos5l_decap_8
XFILLER_256_41 VPWR VGND sg13cmos5l_fill_2
XFILLER_307_253 VPWR VGND sg13cmos5l_decap_8
X_3738_ Tile_X0Y4_E2BEG[4] _3738_/A VPWR VGND sg13cmos5l_buf_1
XANTENNA__3862__X Tile_X0Y5_FrameData_O[3] VPWR VGND sg13cmos5l_antennanp
XFILLER_109_79 VPWR VGND sg13cmos5l_decap_8
X_3669_ Tile_X0Y3_E6BEG[0] _3669_/A VPWR VGND sg13cmos5l_buf_1
XFILLER_69_39 VPWR VGND sg13cmos5l_decap_8
XANTENNA__2236__GATE Tile_X0Y5_FrameStrobe[8] VPWR VGND sg13cmos5l_antennanp
XFILLER_279_149 VPWR VGND sg13cmos5l_fill_1
XFILLER_322_256 VPWR VGND sg13cmos5l_decap_8
XANTENNA__2866__GATE Tile_X0Y5_FrameStrobe[2] VPWR VGND sg13cmos5l_antennanp
XFILLER_125_12 VPWR VGND sg13cmos5l_fill_1
XFILLER_272_40 VPWR VGND sg13cmos5l_fill_1
XFILLER_228_293 VPWR VGND sg13cmos5l_fill_2
XANTENNA__2076__D Tile_X0Y1_FrameData[20] VPWR VGND sg13cmos5l_antennanp
XFILLER_141_77 VPWR VGND sg13cmos5l_decap_8
XANTENNA__1254__A0 Tile_X0Y0_W2END[6] VPWR VGND sg13cmos5l_antennanp
XANTENNA__2804__GATE Tile_X0Y5_FrameStrobe[0] VPWR VGND sg13cmos5l_antennanp
XFILLER_70_176 VPWR VGND sg13cmos5l_fill_1
XANTENNA__2804__D Tile_X0Y4_FrameData[12] VPWR VGND sg13cmos5l_antennanp
XFILLER_297_70 VPWR VGND sg13cmos5l_decap_4
XFILLER_34_97 VPWR VGND sg13cmos5l_decap_8
XFILLER_211_193 VPWR VGND sg13cmos5l_decap_8
XANTENNA__1557__X AXI_M_SOC_WDATA2 VPWR VGND sg13cmos5l_antennanp
XANTENNA__2819__GATE Tile_X0Y5_FrameStrobe[1] VPWR VGND sg13cmos5l_antennanp
XFILLER_126_0 VPWR VGND sg13cmos5l_fill_2
XANTENNA__1557__A1 Tile_X0Y3_W2END[2] VPWR VGND sg13cmos5l_antennanp
XFILLER_171_207 VPWR VGND sg13cmos5l_decap_8
XFILLER_171_218 VPWR VGND sg13cmos5l_fill_1
XFILLER_7_269 VPWR VGND sg13cmos5l_fill_1
XANTENNA__3772__X Tile_X0Y4_EE4BEG[10] VPWR VGND sg13cmos5l_antennanp
XFILLER_109_186 VPWR VGND sg13cmos5l_decap_8
XANTENNA__1309__A1 Tile_X0Y1_W2END[7] VPWR VGND sg13cmos5l_antennanp
XFILLER_316_33 VPWR VGND sg13cmos5l_fill_1
XANTENNA__0780__A2 Tile_X0Y3_W6END[8] VPWR VGND sg13cmos5l_antennanp
XFILLER_124_189 VPWR VGND sg13cmos5l_decap_4
XFILLER_316_66 VPWR VGND sg13cmos5l_decap_4
XFILLER_316_55 VPWR VGND sg13cmos5l_fill_2
XFILLER_78_221 VPWR VGND sg13cmos5l_fill_2
XFILLER_219_293 VPWR VGND sg13cmos5l_fill_2
XFILLER_293_196 VPWR VGND sg13cmos5l_decap_4
X_1020_ _1020_/Y Tile_X0Y5_W6END[1] _3062_/Q _1019_/Y VPWR VGND sg13cmos5l_a21oi_1
XFILLER_75_60 VPWR VGND sg13cmos5l_fill_2
XANTENNA__1493__A0 Tile_X0Y3_W2MID[4] VPWR VGND sg13cmos5l_antennanp
XFILLER_201_36 VPWR VGND sg13cmos5l_fill_2
X_2971_ _2971_/Q Tile_X0Y4_FrameData[5] Tile_X0Y5_FrameStrobe[5] VPWR VGND sg13cmos5l_dlhq_1
XANTENNA__1245__A0 AXI_M_SOC_RDATA30 VPWR VGND sg13cmos5l_antennanp
XANTENNA__2714__D Tile_X0Y3_FrameData[22] VPWR VGND sg13cmos5l_antennanp
X_1922_ _1922_/Q Tile_X0Y0_FrameData[30] Tile_X0Y5_FrameStrobe[7] VPWR VGND sg13cmos5l_dlhq_1
X_1853_ _1853_/Q Tile_X0Y0_FrameData[3] Tile_X0Y5_FrameStrobe[4] VPWR VGND sg13cmos5l_dlhq_1
X_0804_ _3827_/A Tile_X0Y5_W2END[3] _0759_/X _0794_/X _0607_/X _3224_/Q _3223_/Q VPWR
+ VGND sg13cmos5l_mux4_1
XANTENNA__1548__A1 Tile_X0Y3_WW4END[15] VPWR VGND sg13cmos5l_antennanp
X_1784_ _1784_/Q Tile_X0Y0_FrameData[8] Tile_X0Y5_FrameStrobe[2] VPWR VGND sg13cmos5l_dlhq_1
XANTENNA__3682__X Tile_X0Y3_EE4BEG[1] VPWR VGND sg13cmos5l_antennanp
XFILLER_226_11 VPWR VGND sg13cmos5l_fill_1
X_3523_ Tile_X0Y0_N4BEG[10] _3523_/A VPWR VGND sg13cmos5l_buf_1
X_0735_ _0735_/X _0730_/X _0731_/Y _0734_/Y VPWR VGND sg13cmos5l_a21o_1
XFILLER_304_234 VPWR VGND sg13cmos5l_decap_8
X_3454_ Tile_X0Y1_FrameData_O[22] Tile_X0Y1_FrameData[22] VPWR VGND sg13cmos5l_buf_1
X_0666_ _0666_/X Tile_X0Y0_W1END[2] Tile_X0Y0_W6END[10] _1006_/X _0665_/Y _1928_/Q
+ _1927_/Q VPWR VGND sg13cmos5l_mux4_1
XFILLER_276_108 VPWR VGND sg13cmos5l_fill_2
X_2405_ _2405_/Q Tile_X0Y2_FrameData[27] Tile_X0Y5_FrameStrobe[5] VPWR VGND sg13cmos5l_dlhq_1
XFILLER_41_0 VPWR VGND sg13cmos5l_decap_8
XFILLER_226_88 VPWR VGND sg13cmos5l_decap_4
X_3385_ Tile_X0Y2_EE4BEG[3] _3385_/A VPWR VGND sg13cmos5l_buf_1
X_0597_ _0597_/X Tile_X0Y5_N1END[0] Tile_X0Y5_N4END[0] _1054_/B _0595_/X _3104_/Q
+ _3103_/Q VPWR VGND sg13cmos5l_mux4_1
XFILLER_29_118 VPWR VGND sg13cmos5l_decap_8
X_2336_ _2336_/Q Tile_X0Y2_FrameData[0] Tile_X0Y5_FrameStrobe[2] VPWR VGND sg13cmos5l_dlhq_1
XANTENNA__3280__D Tile_X0Y5_FrameData[0] VPWR VGND sg13cmos5l_antennanp
XFILLER_284_163 VPWR VGND sg13cmos5l_decap_4
X_2267_ _2267_/Q Tile_X0Y2_FrameData[5] Tile_X0Y5_FrameStrobe[0] VPWR VGND sg13cmos5l_dlhq_1
X_1218_ _1218_/X _1139_/X _0617_/X _0926_/X Tile_X0Y0_S4END[5] _2021_/Q _2022_/Q VPWR
+ VGND sg13cmos5l_mux4_1
XANTENNA__1484__A0 Tile_X0Y2_W1END[3] VPWR VGND sg13cmos5l_antennanp
X_2198_ _2198_/Q Tile_X0Y1_FrameData[26] Tile_X0Y5_FrameStrobe[7] VPWR VGND sg13cmos5l_dlhq_1
XFILLER_111_36 VPWR VGND sg13cmos5l_decap_8
X_1149_ _1149_/X Tile_X0Y1_W2MID[5] Tile_X0Y1_W2END[5] Tile_X0Y1_W6END[10] _1100_/X
+ _2192_/Q _2191_/Q VPWR VGND sg13cmos5l_mux4_1
XFILLER_52_165 VPWR VGND sg13cmos5l_decap_8
XANTENNA__1236__A0 Tile_X0Y0_WW4END[6] VPWR VGND sg13cmos5l_antennanp
XANTENNA__2624__D Tile_X0Y3_FrameData[16] VPWR VGND sg13cmos5l_antennanp
XANTENNA__3857__X Tile_X0Y5_EE4BEG[14] VPWR VGND sg13cmos5l_antennanp
XFILLER_240_277 VPWR VGND sg13cmos5l_fill_1
XANTENNA__2160__GATE Tile_X0Y5_FrameStrobe[5] VPWR VGND sg13cmos5l_antennanp
XFILLER_138_226 VPWR VGND sg13cmos5l_fill_2
XANTENNA__2790__GATE Tile_X0Y5_FrameStrobe[0] VPWR VGND sg13cmos5l_antennanp
XFILLER_224_8 VPWR VGND sg13cmos5l_fill_1
XFILLER_267_40 VPWR VGND sg13cmos5l_fill_1
XANTENNA__2175__GATE Tile_X0Y5_FrameStrobe[6] VPWR VGND sg13cmos5l_antennanp
XANTENNA__3592__X Tile_X0Y0_FrameData_O[23] VPWR VGND sg13cmos5l_antennanp
XFILLER_106_145 VPWR VGND sg13cmos5l_decap_8
XANTENNA__0762__A2 Tile_X0Y5_WW4END[8] VPWR VGND sg13cmos5l_antennanp
XFILLER_267_108 VPWR VGND sg13cmos5l_decap_8
XFILLER_96_15 VPWR VGND sg13cmos5l_decap_4
XFILLER_121_137 VPWR VGND sg13cmos5l_fill_1
XFILLER_267_119 VPWR VGND sg13cmos5l_fill_1
XFILLER_29_20 VPWR VGND sg13cmos5l_fill_1
XFILLER_29_53 VPWR VGND sg13cmos5l_fill_2
XANTENNA__1703__D Tile_X0Y0_FrameData[25] VPWR VGND sg13cmos5l_antennanp
XANTENNA__3190__D Tile_X0Y5_FrameData[26] VPWR VGND sg13cmos5l_antennanp
XFILLER_29_86 VPWR VGND sg13cmos5l_decap_4
XFILLER_152_65 VPWR VGND sg13cmos5l_decap_8
XFILLER_152_76 VPWR VGND sg13cmos5l_fill_1
XFILLER_275_196 VPWR VGND sg13cmos5l_decap_8
XANTENNA__2113__GATE Tile_X0Y5_FrameStrobe[4] VPWR VGND sg13cmos5l_antennanp
XFILLER_302_35 VPWR VGND sg13cmos5l_decap_8
XANTENNA__2743__GATE Tile_X0Y5_FrameStrobe[7] VPWR VGND sg13cmos5l_antennanp
XFILLER_45_63 VPWR VGND sg13cmos5l_decap_8
XFILLER_231_222 VPWR VGND sg13cmos5l_fill_2
XANTENNA__1227__A0 Tile_X0Y0_WW4END[10] VPWR VGND sg13cmos5l_antennanp
XANTENNA__2128__GATE Tile_X0Y5_FrameStrobe[4] VPWR VGND sg13cmos5l_antennanp
XANTENNA__2534__D Tile_X0Y3_FrameData[10] VPWR VGND sg13cmos5l_antennanp
XANTENNA__3767__X Tile_X0Y4_EE4BEG[5] VPWR VGND sg13cmos5l_antennanp
XFILLER_243_0 VPWR VGND sg13cmos5l_fill_2
XANTENNA__2758__GATE Tile_X0Y5_FrameStrobe[7] VPWR VGND sg13cmos5l_antennanp
XFILLER_77_9 VPWR VGND sg13cmos5l_decap_8
XFILLER_177_73 VPWR VGND sg13cmos5l_fill_2
XANTENNA_6 Tile_X0Y5_N4END[6] VPWR VGND sg13cmos5l_antennanp
XFILLER_137_281 VPWR VGND sg13cmos5l_fill_1
XFILLER_327_43 VPWR VGND sg13cmos5l_fill_2
XFILLER_298_222 VPWR VGND sg13cmos5l_fill_1
XFILLER_3_261 VPWR VGND sg13cmos5l_fill_1
X_3170_ _3170_/Q Tile_X0Y5_FrameData[14] Tile_X0Y5_FrameStrobe[3] VPWR VGND sg13cmos5l_dlhq_1
XANTENNA__2709__D Tile_X0Y3_FrameData[27] VPWR VGND sg13cmos5l_antennanp
X_2121_ _2121_/Q Tile_X0Y1_FrameData[7] Tile_X0Y5_FrameStrobe[4] VPWR VGND sg13cmos5l_dlhq_1
XANTENNA__1952__GATE Tile_X0Y5_FrameStrobe[7] VPWR VGND sg13cmos5l_antennanp
XFILLER_281_111 VPWR VGND sg13cmos5l_fill_2
X_2052_ _2052_/Q Tile_X0Y1_FrameData[12] Tile_X0Y5_FrameStrobe[2] VPWR VGND sg13cmos5l_dlhq_1
XFILLER_66_279 VPWR VGND sg13cmos5l_fill_2
XFILLER_66_257 VPWR VGND sg13cmos5l_decap_4
XANTENNA__1466__A0 Tile_X0Y2_W2END[4] VPWR VGND sg13cmos5l_antennanp
XFILLER_212_46 VPWR VGND sg13cmos5l_decap_4
XFILLER_281_155 VPWR VGND sg13cmos5l_decap_4
X_1003_ _1003_/X _0537_/Y _0997_/X _1002_/Y VPWR VGND sg13cmos5l_a21o_1
XFILLER_81_216 VPWR VGND sg13cmos5l_fill_2
XFILLER_34_165 VPWR VGND sg13cmos5l_decap_4
XANTENNA__1967__GATE Tile_X0Y5_FrameStrobe[8] VPWR VGND sg13cmos5l_antennanp
XANTENNA__2444__D Tile_X0Y2_FrameData[20] VPWR VGND sg13cmos5l_antennanp
XANTENNA__3677__X Tile_X0Y3_E6BEG[8] VPWR VGND sg13cmos5l_antennanp
XFILLER_179_148 VPWR VGND sg13cmos5l_decap_8
XFILLER_187_170 VPWR VGND sg13cmos5l_decap_8
X_2954_ _2954_/Q Tile_X0Y4_FrameData[22] Tile_X0Y5_FrameStrobe[5] VPWR VGND sg13cmos5l_dlhq_1
XFILLER_89_0 VPWR VGND sg13cmos5l_decap_4
XANTENNA__1197__X AXI_M_SOC_AWADDR11 VPWR VGND sg13cmos5l_antennanp
XFILLER_187_181 VPWR VGND sg13cmos5l_fill_1
X_2885_ _2885_/Q Tile_X0Y4_FrameData[27] Tile_X0Y5_FrameStrobe[3] VPWR VGND sg13cmos5l_dlhq_1
X_1905_ _1905_/Q Tile_X0Y0_FrameData[15] Tile_X0Y5_FrameStrobe[6] VPWR VGND sg13cmos5l_dlhq_1
XANTENNA__0542__A Tile_X0Y0_W6END[2] VPWR VGND sg13cmos5l_antennanp
XFILLER_237_10 VPWR VGND sg13cmos5l_decap_4
X_1836_ _1836_/Q Tile_X0Y0_FrameData[20] Tile_X0Y5_FrameStrobe[4] VPWR VGND sg13cmos5l_dlhq_1
XANTENNA__0992__A2 Tile_X0Y5_W6END[6] VPWR VGND sg13cmos5l_antennanp
XANTENNA__3275__D Tile_X0Y5_FrameData[5] VPWR VGND sg13cmos5l_antennanp
XFILLER_289_200 VPWR VGND sg13cmos5l_decap_8
X_1767_ _1767_/Q Tile_X0Y0_FrameData[25] Tile_X0Y5_FrameStrobe[2] VPWR VGND sg13cmos5l_dlhq_1
XFILLER_237_65 VPWR VGND sg13cmos5l_decap_8
X_3506_ Tile_X0Y1_E2BEG[6] _3506_/A VPWR VGND sg13cmos5l_buf_1
X_0718_ _0718_/X Tile_X0Y1_W1END[3] _0968_/X Tile_X0Y1_W6END[11] _0717_/X _2197_/Q
+ _2198_/Q VPWR VGND sg13cmos5l_mux4_1
XANTENNA__0744__A2 Tile_X0Y5_W6END[7] VPWR VGND sg13cmos5l_antennanp
XANTENNA__1905__GATE Tile_X0Y5_FrameStrobe[6] VPWR VGND sg13cmos5l_antennanp
X_1698_ _1698_/Q Tile_X0Y0_FrameData[30] Tile_X0Y5_FrameStrobe[0] VPWR VGND sg13cmos5l_dlhq_1
XFILLER_106_14 VPWR VGND sg13cmos5l_decap_8
XFILLER_106_25 VPWR VGND sg13cmos5l_decap_8
X_3437_ Tile_X0Y1_FrameData_O[5] Tile_X0Y1_FrameData[5] VPWR VGND sg13cmos5l_buf_1
X_0649_ _0650_/A _3265_/Q Tile_X0Y5_W6END[5] _3264_/Q VPWR VGND sg13cmos5l_o21ai_1
X_3368_ Tile_X0Y2_E2BEGb[6] _3368_/A VPWR VGND sg13cmos5l_buf_1
XANTENNA__2619__D Tile_X0Y3_FrameData[21] VPWR VGND sg13cmos5l_antennanp
X_2319_ _2319_/Q Tile_X0Y2_FrameData[17] Tile_X0Y5_FrameStrobe[2] VPWR VGND sg13cmos5l_dlhq_1
XFILLER_66_29 VPWR VGND sg13cmos5l_fill_2
X_3299_ _3299_/Q Tile_X0Y5_FrameData[13] Tile_X0Y5_FrameStrobe[7] VPWR VGND sg13cmos5l_dlhq_1
XANTENNA__1457__A0 Tile_X0Y2_W2MID[3] VPWR VGND sg13cmos5l_antennanp
XFILLER_72_205 VPWR VGND sg13cmos5l_decap_8
XANTENNA__1209__A0 Tile_X0Y0_W1END[1] VPWR VGND sg13cmos5l_antennanp
XANTENNA__2354__D Tile_X0Y2_FrameData[14] VPWR VGND sg13cmos5l_antennanp
XANTENNA__3587__X Tile_X0Y0_FrameData_O[18] VPWR VGND sg13cmos5l_antennanp
XFILLER_15_66 VPWR VGND sg13cmos5l_decap_8
XFILLER_202_90 VPWR VGND sg13cmos5l_fill_1
XFILLER_213_255 VPWR VGND sg13cmos5l_fill_1
XFILLER_80_293 VPWR VGND sg13cmos5l_fill_2
XFILLER_327_134 VPWR VGND sg13cmos5l_fill_1
XFILLER_327_156 VPWR VGND sg13cmos5l_decap_8
XFILLER_31_43 VPWR VGND sg13cmos5l_fill_2
XANTENNA__0983__A2 Tile_X0Y4_W6END[11] VPWR VGND sg13cmos5l_antennanp
XANTENNA__3185__D Tile_X0Y5_FrameData[31] VPWR VGND sg13cmos5l_antennanp
XFILLER_294_93 VPWR VGND sg13cmos5l_fill_2
XANTENNA__1696__A0 Tile_X0Y5_W1END[1] VPWR VGND sg13cmos5l_antennanp
XANTENNA__2529__D Tile_X0Y3_FrameData[15] VPWR VGND sg13cmos5l_antennanp
XFILLER_193_0 VPWR VGND sg13cmos5l_fill_2
XANTENNA__2052__GATE Tile_X0Y5_FrameStrobe[2] VPWR VGND sg13cmos5l_antennanp
XANTENNA__2682__GATE Tile_X0Y5_FrameStrobe[5] VPWR VGND sg13cmos5l_antennanp
XANTENNA__1448__A0 Tile_X0Y2_WW4END[9] VPWR VGND sg13cmos5l_antennanp
XFILLER_16_110 VPWR VGND sg13cmos5l_decap_4
XFILLER_204_244 VPWR VGND sg13cmos5l_decap_4
XANTENNA__2067__GATE Tile_X0Y5_FrameStrobe[3] VPWR VGND sg13cmos5l_antennanp
XANTENNA__2264__D Tile_X0Y2_FrameData[8] VPWR VGND sg13cmos5l_antennanp
XANTENNA__3497__X Tile_X0Y1_E2BEGb[5] VPWR VGND sg13cmos5l_antennanp
XFILLER_112_90 VPWR VGND sg13cmos5l_fill_1
XFILLER_16_198 VPWR VGND sg13cmos5l_fill_1
XFILLER_204_277 VPWR VGND sg13cmos5l_fill_1
XFILLER_71_293 VPWR VGND sg13cmos5l_fill_2
XANTENNA__2697__GATE Tile_X0Y5_FrameStrobe[5] VPWR VGND sg13cmos5l_antennanp
XANTENNA__1620__A0 Tile_X0Y4_WW4END[1] VPWR VGND sg13cmos5l_antennanp
XFILLER_184_151 VPWR VGND sg13cmos5l_decap_8
X_2670_ _2670_/Q Tile_X0Y3_FrameData[2] Tile_X0Y5_FrameStrobe[4] VPWR VGND sg13cmos5l_dlhq_1
XANTENNA__0974__A2 Tile_X0Y5_W6END[10] VPWR VGND sg13cmos5l_antennanp
XANTENNA__2620__GATE Tile_X0Y5_FrameStrobe[3] VPWR VGND sg13cmos5l_antennanp
XANTENNA__3095__D Tile_X0Y5_FrameData[25] VPWR VGND sg13cmos5l_antennanp
XFILLER_117_218 VPWR VGND sg13cmos5l_decap_8
X_1621_ _3775_/A Tile_X0Y4_WW4END[2] AXI_M_SOC_RDATA0 _0996_/X _1016_/X _2918_/Q _2917_/Q
+ VPWR VGND sg13cmos5l_mux4_1
XFILLER_338_75 VPWR VGND sg13cmos5l_fill_1
XANTENNA__2005__GATE Tile_X0Y5_FrameStrobe[1] VPWR VGND sg13cmos5l_antennanp
X_1552_ AXI_M_SOC_ARADDR30 Tile_X0Y3_WW4END[6] Tile_X0Y3_WW4END[14] Tile_X0Y3_W6END[6]
+ _1434_/X _2604_/Q _2603_/Q VPWR VGND sg13cmos5l_mux4_1
XANTENNA__2635__GATE Tile_X0Y5_FrameStrobe[3] VPWR VGND sg13cmos5l_antennanp
XFILLER_207_57 VPWR VGND sg13cmos5l_decap_8
X_1483_ _3913_/A _1480_/Y _1482_/Y _1478_/Y VPWR VGND sg13cmos5l_o21ai_1
XFILLER_98_135 VPWR VGND sg13cmos5l_decap_8
X_3222_ _3222_/Q Tile_X0Y5_FrameData[26] Tile_X0Y5_FrameStrobe[5] VPWR VGND sg13cmos5l_dlhq_1
XANTENNA__1687__A0 Tile_X0Y4_W1END[1] VPWR VGND sg13cmos5l_antennanp
XANTENNA__1891__GATE Tile_X0Y5_FrameStrobe[6] VPWR VGND sg13cmos5l_antennanp
XANTENNA__2439__D Tile_X0Y2_FrameData[25] VPWR VGND sg13cmos5l_antennanp
X_3153_ _3153_/Q Tile_X0Y5_FrameData[31] Tile_X0Y5_FrameStrobe[3] VPWR VGND sg13cmos5l_dlhq_1
XFILLER_254_122 VPWR VGND sg13cmos5l_decap_8
X_2104_ _2104_/Q Tile_X0Y1_FrameData[24] Tile_X0Y5_FrameStrobe[4] VPWR VGND sg13cmos5l_dlhq_1
X_3084_ _3084_/Q Tile_X0Y5_FrameData[4] Tile_X0Y5_FrameStrobe[0] VPWR VGND sg13cmos5l_dlhq_1
X_2035_ _2035_/Q Tile_X0Y1_FrameData[29] Tile_X0Y5_FrameStrobe[2] VPWR VGND sg13cmos5l_dlhq_1
XFILLER_54_249 VPWR VGND sg13cmos5l_decap_8
XANTENNA__2174__D Tile_X0Y1_FrameData[18] VPWR VGND sg13cmos5l_antennanp
XFILLER_22_124 VPWR VGND sg13cmos5l_decap_8
XFILLER_62_293 VPWR VGND sg13cmos5l_fill_2
X_2937_ _2937_/Q Tile_X0Y4_FrameData[7] Tile_X0Y5_FrameStrobe[4] VPWR VGND sg13cmos5l_dlhq_1
XANTENNA__1611__A0 Tile_X0Y4_WW4END[3] VPWR VGND sg13cmos5l_antennanp
XANTENNA__2902__D Tile_X0Y4_FrameData[10] VPWR VGND sg13cmos5l_antennanp
X_2868_ _2868_/Q Tile_X0Y4_FrameData[12] Tile_X0Y5_FrameStrobe[2] VPWR VGND sg13cmos5l_dlhq_1
XANTENNA__1655__X AXI_M_SOC_ARADDR21 VPWR VGND sg13cmos5l_antennanp
XANTENNA__1844__GATE Tile_X0Y5_FrameStrobe[4] VPWR VGND sg13cmos5l_antennanp
XANTENNA__3583__A Tile_X0Y0_FrameData[14] VPWR VGND sg13cmos5l_antennanp
XFILLER_184_19 VPWR VGND sg13cmos5l_decap_8
X_2799_ _2799_/Q Tile_X0Y4_FrameData[17] Tile_X0Y5_FrameStrobe[0] VPWR VGND sg13cmos5l_dlhq_1
X_1819_ _1819_/Q Tile_X0Y0_FrameData[5] Tile_X0Y5_FrameStrobe[3] VPWR VGND sg13cmos5l_dlhq_1
XFILLER_324_148 VPWR VGND sg13cmos5l_decap_8
XANTENNA__3870__X Tile_X0Y5_FrameData_O[11] VPWR VGND sg13cmos5l_antennanp
XFILLER_117_57 VPWR VGND sg13cmos5l_decap_4
XFILLER_131_221 VPWR VGND sg13cmos5l_fill_2
XFILLER_131_232 VPWR VGND sg13cmos5l_decap_4
XFILLER_264_52 VPWR VGND sg13cmos5l_fill_1
XFILLER_89_135 VPWR VGND sg13cmos5l_decap_8
XFILLER_332_192 VPWR VGND sg13cmos5l_decap_8
XANTENNA__1678__A0 Tile_X0Y4_W2END[1] VPWR VGND sg13cmos5l_antennanp
XANTENNA__1859__GATE Tile_X0Y5_FrameStrobe[5] VPWR VGND sg13cmos5l_antennanp
XANTENNA__2349__D Tile_X0Y2_FrameData[19] VPWR VGND sg13cmos5l_antennanp
XANTENNA__1142__A2 Tile_X0Y4_W6END[6] VPWR VGND sg13cmos5l_antennanp
XFILLER_280_62 VPWR VGND sg13cmos5l_fill_2
XFILLER_284_7 VPWR VGND sg13cmos5l_decap_8
XFILLER_245_144 VPWR VGND sg13cmos5l_decap_4
XFILLER_245_166 VPWR VGND sg13cmos5l_decap_8
XFILLER_45_249 VPWR VGND sg13cmos5l_decap_8
XANTENNA__2084__D Tile_X0Y1_FrameData[12] VPWR VGND sg13cmos5l_antennanp
XFILLER_260_169 VPWR VGND sg13cmos5l_decap_4
XFILLER_26_87 VPWR VGND sg13cmos5l_fill_1
XFILLER_53_293 VPWR VGND sg13cmos5l_fill_2
XFILLER_53_282 VPWR VGND sg13cmos5l_fill_2
XFILLER_13_146 VPWR VGND sg13cmos5l_decap_8
XFILLER_158_129 VPWR VGND sg13cmos5l_decap_4
XANTENNA__2812__D Tile_X0Y4_FrameData[4] VPWR VGND sg13cmos5l_antennanp
XFILLER_42_75 VPWR VGND sg13cmos5l_decap_8
XFILLER_206_0 VPWR VGND sg13cmos5l_fill_2
XFILLER_107_251 VPWR VGND sg13cmos5l_decap_8
XFILLER_323_181 VPWR VGND sg13cmos5l_fill_2
XANTENNA__1381__A2 Tile_X0Y2_WW4END[2] VPWR VGND sg13cmos5l_antennanp
XANTENNA__3780__X Tile_X0Y4_FrameData_O[2] VPWR VGND sg13cmos5l_antennanp
XFILLER_95_105 VPWR VGND sg13cmos5l_decap_4
XANTENNA__1669__A0 Tile_X0Y4_W2MID[7] VPWR VGND sg13cmos5l_antennanp
XANTENNA__2259__D Tile_X0Y2_FrameData[13] VPWR VGND sg13cmos5l_antennanp
XFILLER_88_190 VPWR VGND sg13cmos5l_decap_8
XANTENNA__0892__A1 Tile_X0Y3_WW4END[15] VPWR VGND sg13cmos5l_antennanp
XFILLER_251_147 VPWR VGND sg13cmos5l_fill_1
XANTENNA__1436__A3 Tile_X0Y0_S4END[12] VPWR VGND sg13cmos5l_antennanp
XANTENNA__3303__GATE Tile_X0Y5_FrameStrobe[7] VPWR VGND sg13cmos5l_antennanp
X_3840_ Tile_X0Y5_E6BEG[9] _3840_/A VPWR VGND sg13cmos5l_buf_1
X_3771_ Tile_X0Y4_EE4BEG[9] _3771_/A VPWR VGND sg13cmos5l_buf_1
X_0983_ _0983_/X Tile_X0Y4_W1END[3] Tile_X0Y4_WW4END[3] Tile_X0Y4_W6END[11] _0981_/X
+ _3023_/Q _3022_/Q VPWR VGND sg13cmos5l_mux4_1
XANTENNA__2722__D Tile_X0Y3_FrameData[14] VPWR VGND sg13cmos5l_antennanp
X_2722_ _2722_/Q Tile_X0Y3_FrameData[14] Tile_X0Y5_FrameStrobe[6] VPWR VGND sg13cmos5l_dlhq_1
XANTENNA__3318__GATE Tile_X0Y5_FrameStrobe[8] VPWR VGND sg13cmos5l_antennanp
XFILLER_157_173 VPWR VGND sg13cmos5l_decap_8
XFILLER_200_280 VPWR VGND sg13cmos5l_fill_1
XFILLER_218_34 VPWR VGND sg13cmos5l_decap_8
X_2653_ _2653_/Q Tile_X0Y3_FrameData[19] Tile_X0Y5_FrameStrobe[4] VPWR VGND sg13cmos5l_dlhq_1
XANTENNA__2574__GATE Tile_X0Y5_FrameStrobe[1] VPWR VGND sg13cmos5l_antennanp
X_2584_ _2584_/Q Tile_X0Y3_FrameData[24] Tile_X0Y5_FrameStrobe[2] VPWR VGND sg13cmos5l_dlhq_1
X_1604_ _3513_/A _1603_/X _1602_/X _2758_/Q VPWR VGND sg13cmos5l_mux2_1
X_1535_ _3672_/A Tile_X0Y5_N4END[11] _1521_/X Tile_X0Y0_S4END[15] _0882_/X _2633_/Q
+ _2634_/Q VPWR VGND sg13cmos5l_mux4_1
XFILLER_321_118 VPWR VGND sg13cmos5l_fill_1
XANTENNA__1372__A2 Tile_X0Y2_WW4END[3] VPWR VGND sg13cmos5l_antennanp
XANTENNA__3690__X Tile_X0Y3_EE4BEG[9] VPWR VGND sg13cmos5l_antennanp
XFILLER_86_105 VPWR VGND sg13cmos5l_fill_1
XANTENNA__0580__A0 Tile_X0Y2_W1END[0] VPWR VGND sg13cmos5l_antennanp
XANTENNA__2169__D Tile_X0Y1_FrameData[23] VPWR VGND sg13cmos5l_antennanp
XFILLER_234_44 VPWR VGND sg13cmos5l_decap_8
XFILLER_234_66 VPWR VGND sg13cmos5l_fill_2
X_1466_ _3365_/A Tile_X0Y2_W2END[4] AXI_M_SOC_RDATA18 _1187_/X _1191_/X _2410_/Q _2409_/Q
+ VPWR VGND sg13cmos5l_mux4_1
XANTENNA__1124__A2 Tile_X0Y0_S1END[3] VPWR VGND sg13cmos5l_antennanp
XANTENNA__2589__GATE Tile_X0Y5_FrameStrobe[2] VPWR VGND sg13cmos5l_antennanp
XFILLER_227_100 VPWR VGND sg13cmos5l_fill_1
XFILLER_234_88 VPWR VGND sg13cmos5l_decap_4
XFILLER_267_280 VPWR VGND sg13cmos5l_fill_1
X_3205_ _3205_/Q Tile_X0Y5_FrameData[11] Tile_X0Y5_FrameStrobe[4] VPWR VGND sg13cmos5l_dlhq_1
X_1397_ _3372_/A Tile_X0Y5_N4END[14] _1369_/X Tile_X0Y0_S4END[10] _1025_/X _2363_/Q
+ _2364_/Q VPWR VGND sg13cmos5l_mux4_1
XFILLER_103_15 VPWR VGND sg13cmos5l_decap_8
XFILLER_227_122 VPWR VGND sg13cmos5l_fill_1
XFILLER_227_144 VPWR VGND sg13cmos5l_decap_4
X_3136_ _3136_/Q Tile_X0Y5_FrameData[16] Tile_X0Y5_FrameStrobe[2] VPWR VGND sg13cmos5l_dlhq_1
XANTENNA__0883__A1 Tile_X0Y3_WW4END[12] VPWR VGND sg13cmos5l_antennanp
XANTENNA__1801__D Tile_X0Y0_FrameData[23] VPWR VGND sg13cmos5l_antennanp
XFILLER_227_166 VPWR VGND sg13cmos5l_fill_2
XFILLER_242_114 VPWR VGND sg13cmos5l_decap_4
XFILLER_282_261 VPWR VGND sg13cmos5l_fill_1
X_3067_ _3067_/Q Tile_X0Y5_FrameData[21] Tile_X0Y5_FrameStrobe[0] VPWR VGND sg13cmos5l_dlhq_1
XFILLER_94_193 VPWR VGND sg13cmos5l_decap_8
XANTENNA__2512__GATE Tile_X0Y5_FrameStrobe[8] VPWR VGND sg13cmos5l_antennanp
X_2018_ _2018_/Q Tile_X0Y1_FrameData[14] Tile_X0Y5_FrameStrobe[1] VPWR VGND sg13cmos5l_dlhq_1
XFILLER_42_219 VPWR VGND sg13cmos5l_fill_1
XANTENNA__3578__A Tile_X0Y0_FrameData[9] VPWR VGND sg13cmos5l_antennanp
XANTENNA__0635__A1 Tile_X0Y3_W6END[9] VPWR VGND sg13cmos5l_antennanp
XFILLER_195_202 VPWR VGND sg13cmos5l_decap_8
XFILLER_250_180 VPWR VGND sg13cmos5l_fill_2
XFILLER_50_241 VPWR VGND sg13cmos5l_fill_2
XFILLER_329_218 VPWR VGND sg13cmos5l_decap_8
XANTENNA__2527__GATE Tile_X0Y5_FrameStrobe[0] VPWR VGND sg13cmos5l_antennanp
XANTENNA__2632__D Tile_X0Y3_FrameData[8] VPWR VGND sg13cmos5l_antennanp
XANTENNA__3865__X Tile_X0Y5_FrameData_O[6] VPWR VGND sg13cmos5l_antennanp
XFILLER_12_45 VPWR VGND sg13cmos5l_fill_1
XANTENNA__1060__A1 Tile_X0Y0_WW4END[12] VPWR VGND sg13cmos5l_antennanp
XANTENNA__1783__GATE Tile_X0Y5_FrameStrobe[2] VPWR VGND sg13cmos5l_antennanp
XFILLER_163_132 VPWR VGND sg13cmos5l_decap_4
XFILLER_128_78 VPWR VGND sg13cmos5l_decap_8
XFILLER_128_89 VPWR VGND sg13cmos5l_fill_2
XFILLER_163_187 VPWR VGND sg13cmos5l_decap_8
XANTENNA__1798__GATE Tile_X0Y5_FrameStrobe[3] VPWR VGND sg13cmos5l_antennanp
XFILLER_144_22 VPWR VGND sg13cmos5l_decap_8
XANTENNA__2079__D Tile_X0Y1_FrameData[17] VPWR VGND sg13cmos5l_antennanp
XFILLER_144_66 VPWR VGND sg13cmos5l_decap_8
XFILLER_144_77 VPWR VGND sg13cmos5l_fill_2
XANTENNA__1721__GATE Tile_X0Y5_FrameStrobe[0] VPWR VGND sg13cmos5l_antennanp
XFILLER_218_133 VPWR VGND sg13cmos5l_decap_4
XANTENNA__2807__D Tile_X0Y4_FrameData[9] VPWR VGND sg13cmos5l_antennanp
XFILLER_18_249 VPWR VGND sg13cmos5l_decap_4
XANTENNA__1711__D Tile_X0Y0_FrameData[17] VPWR VGND sg13cmos5l_antennanp
XFILLER_160_54 VPWR VGND sg13cmos5l_decap_4
XANTENNA__1736__GATE Tile_X0Y5_FrameStrobe[1] VPWR VGND sg13cmos5l_antennanp
XFILLER_156_0 VPWR VGND sg13cmos5l_fill_2
XFILLER_26_293 VPWR VGND sg13cmos5l_fill_2
XFILLER_53_63 VPWR VGND sg13cmos5l_decap_8
XANTENNA__2542__D Tile_X0Y3_FrameData[2] VPWR VGND sg13cmos5l_antennanp
XANTENNA__3775__X Tile_X0Y4_EE4BEG[13] VPWR VGND sg13cmos5l_antennanp
XFILLER_186_257 VPWR VGND sg13cmos5l_decap_8
XFILLER_323_0 VPWR VGND sg13cmos5l_fill_2
XFILLER_328_262 VPWR VGND sg13cmos5l_decap_4
XANTENNA__1051__A1 Tile_X0Y3_W6END[4] VPWR VGND sg13cmos5l_antennanp
XFILLER_154_121 VPWR VGND sg13cmos5l_decap_8
XFILLER_185_51 VPWR VGND sg13cmos5l_fill_2
XFILLER_5_153 VPWR VGND sg13cmos5l_decap_8
XFILLER_335_43 VPWR VGND sg13cmos5l_fill_2
X_1320_ _3511_/A _1123_/X _0712_/X AXI_M_SOC_RDATA22 AXI_M_SOC_RDATA26 _2162_/Q _2161_/Q
+ VPWR VGND sg13cmos5l_mux4_1
XANTENNA__0562__A0 Tile_X0Y3_W1END[3] VPWR VGND sg13cmos5l_antennanp
XFILLER_110_224 VPWR VGND sg13cmos5l_decap_8
XFILLER_110_235 VPWR VGND sg13cmos5l_fill_2
XFILLER_249_280 VPWR VGND sg13cmos5l_fill_1
X_1251_ _3638_/A Tile_X0Y0_W2MID[6] AXI_M_SOC_RDATA31 _1140_/X _1010_/X _1886_/Q _1885_/Q
+ VPWR VGND sg13cmos5l_mux4_1
XANTENNA__1106__A2 Tile_X0Y1_W6END[7] VPWR VGND sg13cmos5l_antennanp
X_1182_ _1182_/X Tile_X0Y4_W2MID[2] Tile_X0Y4_W2END[2] Tile_X0Y4_W6END[2] _1318_/X
+ _3038_/Q _3037_/Q VPWR VGND sg13cmos5l_mux4_1
XANTENNA__0865__A1 Tile_X0Y5_W2END[4] VPWR VGND sg13cmos5l_antennanp
XANTENNA__2717__D Tile_X0Y3_FrameData[19] VPWR VGND sg13cmos5l_antennanp
XFILLER_76_182 VPWR VGND sg13cmos5l_fill_2
XFILLER_76_171 VPWR VGND sg13cmos5l_decap_8
XFILLER_209_199 VPWR VGND sg13cmos5l_decap_8
XANTENNA__3242__GATE Tile_X0Y5_FrameStrobe[5] VPWR VGND sg13cmos5l_antennanp
XFILLER_224_158 VPWR VGND sg13cmos5l_fill_1
XANTENNA__0617__A1 Tile_X0Y0_W6END[9] VPWR VGND sg13cmos5l_antennanp
XANTENNA__3398__A Tile_X0Y2_FrameData[0] VPWR VGND sg13cmos5l_antennanp
XANTENNA__1290__A1 AXI_M_SOC_RDATA29 VPWR VGND sg13cmos5l_antennanp
XFILLER_177_213 VPWR VGND sg13cmos5l_decap_8
X_3823_ Tile_X0Y5_E2BEGb[0] _3823_/A VPWR VGND sg13cmos5l_buf_1
XANTENNA__2452__D Tile_X0Y2_FrameData[12] VPWR VGND sg13cmos5l_antennanp
XANTENNA__3257__GATE Tile_X0Y5_FrameStrobe[6] VPWR VGND sg13cmos5l_antennanp
XANTENNA__3685__X Tile_X0Y3_EE4BEG[4] VPWR VGND sg13cmos5l_antennanp
XFILLER_192_205 VPWR VGND sg13cmos5l_decap_4
XFILLER_229_33 VPWR VGND sg13cmos5l_decap_8
X_3754_ Tile_X0Y4_E6BEG[4] _3754_/A VPWR VGND sg13cmos5l_buf_1
X_0966_ _0966_/X Tile_X0Y1_W1END[2] Tile_X0Y1_WW4END[6] Tile_X0Y1_WW4END[14] _0965_/X
+ _2044_/Q _2043_/Q VPWR VGND sg13cmos5l_mux4_1
XFILLER_71_0 VPWR VGND sg13cmos5l_decap_8
XFILLER_319_251 VPWR VGND sg13cmos5l_decap_4
XFILLER_145_143 VPWR VGND sg13cmos5l_decap_8
X_2705_ _2705_/Q Tile_X0Y3_FrameData[31] Tile_X0Y5_FrameStrobe[6] VPWR VGND sg13cmos5l_dlhq_1
X_3685_ Tile_X0Y3_EE4BEG[4] _3685_/A VPWR VGND sg13cmos5l_buf_1
XANTENNA__1593__A2 Tile_X0Y3_W6END[7] VPWR VGND sg13cmos5l_antennanp
X_2636_ _2636_/Q Tile_X0Y3_FrameData[4] Tile_X0Y5_FrameStrobe[3] VPWR VGND sg13cmos5l_dlhq_1
X_0897_ _0897_/X Tile_X0Y5_W1END[3] Tile_X0Y5_WW4END[3] _3295_/Q VPWR VGND sg13cmos5l_mux2_1
XFILLER_334_254 VPWR VGND sg13cmos5l_fill_2
XFILLER_334_243 VPWR VGND sg13cmos5l_fill_2
XFILLER_160_113 VPWR VGND sg13cmos5l_decap_4
XFILLER_245_32 VPWR VGND sg13cmos5l_decap_8
XANTENNA__3283__D Tile_X0Y5_FrameData[29] VPWR VGND sg13cmos5l_antennanp
XANTENNA__3861__A Tile_X0Y5_FrameData[2] VPWR VGND sg13cmos5l_antennanp
X_2567_ _2567_/Q Tile_X0Y3_FrameData[9] Tile_X0Y5_FrameStrobe[1] VPWR VGND sg13cmos5l_dlhq_1
XFILLER_101_202 VPWR VGND sg13cmos5l_decap_8
XFILLER_245_98 VPWR VGND sg13cmos5l_fill_1
X_2498_ _2498_/Q Tile_X0Y2_FrameData[30] Tile_X0Y5_FrameStrobe[8] VPWR VGND sg13cmos5l_dlhq_1
X_1518_ _3668_/A Tile_X0Y3_W2END[0] AXI_M_SOC_RDATA6 _1267_/X _1351_/X _2674_/Q _2673_/Q
+ VPWR VGND sg13cmos5l_mux4_1
X_1449_ _3389_/A Tile_X0Y2_WW4END[8] AXI_M_SOC_RDATA21 _1355_/X _1157_/X _2386_/Q
+ _2385_/Q VPWR VGND sg13cmos5l_mux4_1
XFILLER_59_138 VPWR VGND sg13cmos5l_decap_8
XFILLER_4_90 VPWR VGND sg13cmos5l_fill_2
XANTENNA__0709__B Tile_X0Y0_W6END[3] VPWR VGND sg13cmos5l_antennanp
XANTENNA__2451__GATE Tile_X0Y5_FrameStrobe[6] VPWR VGND sg13cmos5l_antennanp
XANTENNA__2627__D Tile_X0Y3_FrameData[13] VPWR VGND sg13cmos5l_antennanp
XFILLER_255_250 VPWR VGND sg13cmos5l_decap_4
XFILLER_261_97 VPWR VGND sg13cmos5l_decap_4
XFILLER_74_29 VPWR VGND sg13cmos5l_decap_8
XFILLER_74_18 VPWR VGND sg13cmos5l_fill_1
XFILLER_255_294 VPWR VGND sg13cmos5l_fill_1
X_3119_ _3119_/Q Tile_X0Y5_FrameData[1] Tile_X0Y5_FrameStrobe[1] VPWR VGND sg13cmos5l_dlhq_1
XFILLER_82_141 VPWR VGND sg13cmos5l_decap_8
XANTENNA__1281__A1 AXI_M_SOC_RDATA27 VPWR VGND sg13cmos5l_antennanp
XANTENNA__2466__GATE Tile_X0Y5_FrameStrobe[7] VPWR VGND sg13cmos5l_antennanp
XFILLER_90_39 VPWR VGND sg13cmos5l_decap_8
XANTENNA__2362__D Tile_X0Y2_FrameData[6] VPWR VGND sg13cmos5l_antennanp
XANTENNA__3595__X Tile_X0Y0_FrameData_O[26] VPWR VGND sg13cmos5l_antennanp
XFILLER_139_22 VPWR VGND sg13cmos5l_fill_2
XFILLER_136_110 VPWR VGND sg13cmos5l_fill_2
XFILLER_286_94 VPWR VGND sg13cmos5l_fill_2
XFILLER_191_260 VPWR VGND sg13cmos5l_fill_2
XFILLER_99_59 VPWR VGND sg13cmos5l_fill_2
XANTENNA__0792__A0 Tile_X0Y4_W2MID[4] VPWR VGND sg13cmos5l_antennanp
XFILLER_151_113 VPWR VGND sg13cmos5l_decap_8
XFILLER_151_124 VPWR VGND sg13cmos5l_fill_1
XFILLER_191_293 VPWR VGND sg13cmos5l_fill_2
XFILLER_2_101 VPWR VGND sg13cmos5l_decap_8
XANTENNA__1706__D Tile_X0Y0_FrameData[22] VPWR VGND sg13cmos5l_antennanp
XANTENNA__2404__GATE Tile_X0Y5_FrameStrobe[5] VPWR VGND sg13cmos5l_antennanp
XANTENNA__3193__D Tile_X0Y5_FrameData[23] VPWR VGND sg13cmos5l_antennanp
XFILLER_151_168 VPWR VGND sg13cmos5l_decap_8
XFILLER_297_139 VPWR VGND sg13cmos5l_fill_2
XANTENNA__2419__GATE Tile_X0Y5_FrameStrobe[5] VPWR VGND sg13cmos5l_antennanp
XANTENNA__2537__D Tile_X0Y3_FrameData[7] VPWR VGND sg13cmos5l_antennanp
XFILLER_273_0 VPWR VGND sg13cmos5l_fill_2
XFILLER_321_12 VPWR VGND sg13cmos5l_fill_2
XFILLER_206_169 VPWR VGND sg13cmos5l_decap_8
XFILLER_221_117 VPWR VGND sg13cmos5l_decap_8
XANTENNA__1272__A1 AXI_M_SOC_RDATA25 VPWR VGND sg13cmos5l_antennanp
XFILLER_9_24 VPWR VGND sg13cmos5l_fill_2
XANTENNA__2272__D Tile_X0Y2_FrameData[0] VPWR VGND sg13cmos5l_antennanp
X_0820_ _3855_/A Tile_X0Y5_WW4END[3] _0759_/X _0743_/X _0794_/X _3192_/Q _3191_/Q
+ VPWR VGND sg13cmos5l_mux4_1
XFILLER_127_132 VPWR VGND sg13cmos5l_fill_1
XFILLER_196_61 VPWR VGND sg13cmos5l_decap_8
X_0751_ _0751_/Y _3259_/Q _0741_/X _0750_/Y VPWR VGND sg13cmos5l_o21ai_1
XFILLER_316_221 VPWR VGND sg13cmos5l_fill_2
XFILLER_316_254 VPWR VGND sg13cmos5l_decap_4
XANTENNA__0783__A0 Tile_X0Y5_W2MID[7] VPWR VGND sg13cmos5l_antennanp
XFILLER_182_293 VPWR VGND sg13cmos5l_fill_2
X_3470_ Tile_X0Y1_EE4BEG[6] _3470_/A VPWR VGND sg13cmos5l_buf_1
X_0682_ _0682_/Y _2515_/Q _0682_/B _0682_/C VPWR VGND sg13cmos5l_nor3_1
XFILLER_331_224 VPWR VGND sg13cmos5l_fill_2
XFILLER_288_139 VPWR VGND sg13cmos5l_decap_8
X_2421_ _2421_/Q Tile_X0Y2_FrameData[11] Tile_X0Y5_FrameStrobe[5] VPWR VGND sg13cmos5l_dlhq_1
XFILLER_142_179 VPWR VGND sg13cmos5l_decap_8
X_2352_ _2352_/Q Tile_X0Y2_FrameData[16] Tile_X0Y5_FrameStrobe[3] VPWR VGND sg13cmos5l_dlhq_1
XFILLER_331_279 VPWR VGND sg13cmos5l_fill_1
XFILLER_215_46 VPWR VGND sg13cmos5l_decap_8
XFILLER_296_183 VPWR VGND sg13cmos5l_decap_8
X_2283_ _2283_/Q Tile_X0Y2_FrameData[21] Tile_X0Y5_FrameStrobe[1] VPWR VGND sg13cmos5l_dlhq_1
X_1303_ _3490_/A AXI_M_SOC_RDATA28 _0927_/X _1218_/X _1083_/X _2075_/Q _2076_/Q VPWR
+ VGND sg13cmos5l_mux4_1
X_1234_ _3613_/A Tile_X0Y0_WW4END[3] AXI_M_SOC_BVALID _1080_/X _1148_/X _1832_/Q _1831_/Q
+ VPWR VGND sg13cmos5l_mux4_1
XFILLER_96_277 VPWR VGND sg13cmos5l_fill_1
XFILLER_96_266 VPWR VGND sg13cmos5l_decap_8
XANTENNA__2447__D Tile_X0Y2_FrameData[17] VPWR VGND sg13cmos5l_antennanp
XANTENNA__0838__A1 Tile_X0Y5_W6END[11] VPWR VGND sg13cmos5l_antennanp
XANTENNA__3181__GATE Tile_X0Y5_FrameStrobe[3] VPWR VGND sg13cmos5l_antennanp
XFILLER_231_45 VPWR VGND sg13cmos5l_fill_2
XFILLER_252_220 VPWR VGND sg13cmos5l_fill_2
X_1165_ _3527_/A _1164_/X _1163_/X _1937_/Q VPWR VGND sg13cmos5l_mux2_1
X_1096_ _3531_/A Tile_X0Y1_W2MID[5] Tile_X0Y1_W2END[5] Tile_X0Y1_W6END[5] _1100_/X
+ _2228_/Q _2227_/Q VPWR VGND sg13cmos5l_mux4_1
XFILLER_205_191 VPWR VGND sg13cmos5l_fill_1
XANTENNA__2182__D Tile_X0Y1_FrameData[10] VPWR VGND sg13cmos5l_antennanp
XANTENNA__3196__GATE Tile_X0Y5_FrameStrobe[4] VPWR VGND sg13cmos5l_antennanp
XANTENNA__3278__D Tile_X0Y5_FrameData[2] VPWR VGND sg13cmos5l_antennanp
X_3806_ Tile_X0Y4_FrameData_O[28] Tile_X0Y4_FrameData[28] VPWR VGND sg13cmos5l_buf_1
XANTENNA__1015__A1 Tile_X0Y5_W2END[5] VPWR VGND sg13cmos5l_antennanp
XFILLER_118_132 VPWR VGND sg13cmos5l_decap_8
X_3737_ Tile_X0Y4_E2BEG[3] _3737_/A VPWR VGND sg13cmos5l_buf_1
X_1998_ _1998_/Q Tile_X0Y1_FrameData[2] Tile_X0Y5_FrameStrobe[0] VPWR VGND sg13cmos5l_dlhq_1
XANTENNA__2910__D Tile_X0Y4_FrameData[2] VPWR VGND sg13cmos5l_antennanp
XFILLER_173_260 VPWR VGND sg13cmos5l_decap_8
X_0949_ AXI_M_SOC_AWLEN0 _3337_/Q _0948_/X VPWR VGND sg13cmos5l_nor2b_1
XANTENNA__0774__A0 Tile_X0Y5_N1END[2] VPWR VGND sg13cmos5l_antennanp
XFILLER_118_198 VPWR VGND sg13cmos5l_decap_4
XFILLER_173_293 VPWR VGND sg13cmos5l_fill_2
XFILLER_256_53 VPWR VGND sg13cmos5l_fill_1
X_3668_ Tile_X0Y3_E2BEGb[7] _3668_/A VPWR VGND sg13cmos5l_buf_1
XFILLER_69_18 VPWR VGND sg13cmos5l_decap_8
XANTENNA__3591__A Tile_X0Y0_FrameData[22] VPWR VGND sg13cmos5l_antennanp
XFILLER_133_146 VPWR VGND sg13cmos5l_decap_8
X_2619_ _2619_/Q Tile_X0Y3_FrameData[21] Tile_X0Y5_FrameStrobe[3] VPWR VGND sg13cmos5l_dlhq_1
X_3599_ Tile_X0Y0_FrameData_O[30] Tile_X0Y0_FrameData[30] VPWR VGND sg13cmos5l_buf_1
XANTENNA__1318__A2 Tile_X0Y5_N2MID[5] VPWR VGND sg13cmos5l_antennanp
XANTENNA__3134__GATE Tile_X0Y5_FrameStrobe[2] VPWR VGND sg13cmos5l_antennanp
XFILLER_133_179 VPWR VGND sg13cmos5l_decap_8
XFILLER_125_57 VPWR VGND sg13cmos5l_fill_1
XANTENNA__2390__GATE Tile_X0Y5_FrameStrobe[4] VPWR VGND sg13cmos5l_antennanp
XFILLER_125_79 VPWR VGND sg13cmos5l_fill_2
XFILLER_85_39 VPWR VGND sg13cmos5l_decap_8
XANTENNA__2357__D Tile_X0Y2_FrameData[11] VPWR VGND sg13cmos5l_antennanp
XANTENNA__3149__GATE Tile_X0Y5_FrameStrobe[2] VPWR VGND sg13cmos5l_antennanp
XFILLER_228_272 VPWR VGND sg13cmos5l_fill_2
XFILLER_203_106 VPWR VGND sg13cmos5l_decap_8
XFILLER_203_117 VPWR VGND sg13cmos5l_fill_1
XFILLER_243_275 VPWR VGND sg13cmos5l_fill_2
XFILLER_55_196 VPWR VGND sg13cmos5l_decap_8
XFILLER_34_43 VPWR VGND sg13cmos5l_decap_8
XANTENNA__1254__A1 AXI_M_SOC_WREADY VPWR VGND sg13cmos5l_antennanp
XANTENNA__2092__D Tile_X0Y1_FrameData[4] VPWR VGND sg13cmos5l_antennanp
XANTENNA__3188__D Tile_X0Y5_FrameData[28] VPWR VGND sg13cmos5l_antennanp
XFILLER_211_150 VPWR VGND sg13cmos5l_decap_4
XFILLER_7_248 VPWR VGND sg13cmos5l_decap_8
XANTENNA__1557__A2 Tile_X0Y3_W6END[2] VPWR VGND sg13cmos5l_antennanp
XANTENNA__2820__D Tile_X0Y4_FrameData[28] VPWR VGND sg13cmos5l_antennanp
XFILLER_109_165 VPWR VGND sg13cmos5l_decap_8
XFILLER_50_53 VPWR VGND sg13cmos5l_fill_2
XANTENNA__2343__GATE Tile_X0Y5_FrameStrobe[3] VPWR VGND sg13cmos5l_antennanp
XFILLER_164_282 VPWR VGND sg13cmos5l_fill_1
XFILLER_164_293 VPWR VGND sg13cmos5l_fill_2
XANTENNA__2973__GATE Tile_X0Y5_FrameStrobe[5] VPWR VGND sg13cmos5l_antennanp
XFILLER_313_257 VPWR VGND sg13cmos5l_fill_2
XANTENNA__1309__A2 Tile_X0Y1_W6END[7] VPWR VGND sg13cmos5l_antennanp
XFILLER_124_168 VPWR VGND sg13cmos5l_decap_8
XFILLER_1_0 VPWR VGND sg13cmos5l_fill_2
XANTENNA__1190__A0 Tile_X0Y1_W1END[0] VPWR VGND sg13cmos5l_antennanp
XANTENNA__2358__GATE Tile_X0Y5_FrameStrobe[3] VPWR VGND sg13cmos5l_antennanp
XFILLER_182_96 VPWR VGND sg13cmos5l_decap_8
XANTENNA__2988__GATE Tile_X0Y5_FrameStrobe[6] VPWR VGND sg13cmos5l_antennanp
XFILLER_226_209 VPWR VGND sg13cmos5l_decap_4
XANTENNA__2267__D Tile_X0Y2_FrameData[5] VPWR VGND sg13cmos5l_antennanp
XFILLER_75_72 VPWR VGND sg13cmos5l_decap_8
XANTENNA__1493__A1 AXI_M_SOC_RDATA9 VPWR VGND sg13cmos5l_antennanp
XANTENNA__2911__GATE Tile_X0Y5_FrameStrobe[3] VPWR VGND sg13cmos5l_antennanp
XFILLER_201_15 VPWR VGND sg13cmos5l_decap_8
X_2970_ _2970_/Q Tile_X0Y4_FrameData[6] Tile_X0Y5_FrameStrobe[5] VPWR VGND sg13cmos5l_dlhq_1
XFILLER_61_155 VPWR VGND sg13cmos5l_decap_8
XANTENNA__3098__D Tile_X0Y5_FrameData[22] VPWR VGND sg13cmos5l_antennanp
XFILLER_202_150 VPWR VGND sg13cmos5l_decap_4
X_1921_ _1921_/Q Tile_X0Y0_FrameData[31] Tile_X0Y5_FrameStrobe[7] VPWR VGND sg13cmos5l_dlhq_1
XANTENNA__2926__GATE Tile_X0Y5_FrameStrobe[4] VPWR VGND sg13cmos5l_antennanp
XFILLER_147_205 VPWR VGND sg13cmos5l_fill_1
X_1852_ _1852_/Q Tile_X0Y0_FrameData[4] Tile_X0Y5_FrameStrobe[4] VPWR VGND sg13cmos5l_dlhq_1
X_0803_ _3826_/A Tile_X0Y5_W2END[4] _0778_/X _0794_/X _0607_/X _3226_/Q _3225_/Q VPWR
+ VGND sg13cmos5l_mux4_1
XANTENNA__1548__A2 Tile_X0Y3_W6END[7] VPWR VGND sg13cmos5l_antennanp
XANTENNA__2730__D Tile_X0Y3_FrameData[6] VPWR VGND sg13cmos5l_antennanp
X_1783_ _1783_/Q Tile_X0Y0_FrameData[9] Tile_X0Y5_FrameStrobe[2] VPWR VGND sg13cmos5l_dlhq_1
XANTENNA__0756__A0 Tile_X0Y3_WW4END[0] VPWR VGND sg13cmos5l_antennanp
XFILLER_155_293 VPWR VGND sg13cmos5l_fill_2
XFILLER_304_202 VPWR VGND sg13cmos5l_fill_1
X_3522_ Tile_X0Y0_N4BEG[9] _3522_/A VPWR VGND sg13cmos5l_buf_1
X_0734_ _0734_/Y _3057_/Q _0734_/B _0734_/C VPWR VGND sg13cmos5l_nor3_1
XFILLER_115_146 VPWR VGND sg13cmos5l_fill_1
XFILLER_170_230 VPWR VGND sg13cmos5l_fill_1
XFILLER_170_252 VPWR VGND sg13cmos5l_decap_8
XFILLER_226_23 VPWR VGND sg13cmos5l_fill_2
X_3453_ Tile_X0Y1_FrameData_O[21] Tile_X0Y1_FrameData[21] VPWR VGND sg13cmos5l_buf_1
X_0665_ _0665_/Y _1700_/Q _0542_/Y _0663_/Y _1699_/Q _0664_/Y VPWR VGND sg13cmos5l_a221oi_1
XFILLER_115_168 VPWR VGND sg13cmos5l_fill_2
XFILLER_304_268 VPWR VGND sg13cmos5l_decap_4
X_2404_ _2404_/Q Tile_X0Y2_FrameData[28] Tile_X0Y5_FrameStrobe[5] VPWR VGND sg13cmos5l_dlhq_1
XFILLER_130_127 VPWR VGND sg13cmos5l_decap_8
X_3384_ Tile_X0Y2_EE4BEG[2] _3384_/A VPWR VGND sg13cmos5l_buf_1
X_0596_ _0596_/X Tile_X0Y5_N1END[0] Tile_X0Y5_N4END[0] _1054_/B _0595_/X _3088_/Q
+ _3087_/Q VPWR VGND sg13cmos5l_mux4_1
XFILLER_34_0 VPWR VGND sg13cmos5l_fill_2
XANTENNA__1181__A0 Tile_X0Y1_W1END[1] VPWR VGND sg13cmos5l_antennanp
X_2335_ _2335_/Q Tile_X0Y2_FrameData[1] Tile_X0Y5_FrameStrobe[2] VPWR VGND sg13cmos5l_dlhq_1
X_2266_ _2266_/Q Tile_X0Y2_FrameData[6] Tile_X0Y5_FrameStrobe[0] VPWR VGND sg13cmos5l_dlhq_1
XANTENNA__2177__D Tile_X0Y1_FrameData[15] VPWR VGND sg13cmos5l_antennanp
X_2197_ _2197_/Q Tile_X0Y1_FrameData[27] Tile_X0Y5_FrameStrobe[7] VPWR VGND sg13cmos5l_dlhq_1
X_1217_ _1217_/X _1122_/X _0666_/X _0940_/Y Tile_X0Y0_S4END[6] _2019_/Q _2020_/Q VPWR
+ VGND sg13cmos5l_mux4_1
XANTENNA__1484__A1 Tile_X0Y2_W6END[7] VPWR VGND sg13cmos5l_antennanp
XFILLER_225_231 VPWR VGND sg13cmos5l_decap_8
XANTENNA__2905__D Tile_X0Y4_FrameData[7] VPWR VGND sg13cmos5l_antennanp
X_1148_ _1148_/X _3532_/A _1092_/X Tile_X0Y0_S2MID[3] Tile_X0Y0_S2END[3] _1714_/Q
+ _1713_/Q VPWR VGND sg13cmos5l_mux4_1
X_1079_ _1079_/X Tile_X0Y1_W1END[0] _0959_/X Tile_X0Y1_W6END[4] _0573_/X _2239_/Q
+ _2240_/Q VPWR VGND sg13cmos5l_mux4_1
XFILLER_200_109 VPWR VGND sg13cmos5l_decap_8
XFILLER_240_256 VPWR VGND sg13cmos5l_fill_1
XANTENNA__3586__A Tile_X0Y0_FrameData[17] VPWR VGND sg13cmos5l_antennanp
XANTENNA__1539__A2 Tile_X0Y5_N4END[8] VPWR VGND sg13cmos5l_antennanp
XANTENNA__2640__D Tile_X0Y3_FrameData[0] VPWR VGND sg13cmos5l_antennanp
XANTENNA__3873__X Tile_X0Y5_FrameData_O[14] VPWR VGND sg13cmos5l_antennanp
XANTENNA__0747__A0 Tile_X0Y5_W1END[3] VPWR VGND sg13cmos5l_antennanp
XFILLER_106_124 VPWR VGND sg13cmos5l_decap_8
XFILLER_4_218 VPWR VGND sg13cmos5l_fill_1
XANTENNA__3073__GATE Tile_X0Y5_FrameStrobe[0] VPWR VGND sg13cmos5l_antennanp
XFILLER_146_293 VPWR VGND sg13cmos5l_fill_2
XFILLER_161_241 VPWR VGND sg13cmos5l_decap_8
XFILLER_136_56 VPWR VGND sg13cmos5l_fill_2
XFILLER_283_73 VPWR VGND sg13cmos5l_fill_2
XFILLER_283_84 VPWR VGND sg13cmos5l_fill_2
XFILLER_96_49 VPWR VGND sg13cmos5l_decap_8
XFILLER_152_11 VPWR VGND sg13cmos5l_fill_2
XANTENNA__3088__GATE Tile_X0Y5_FrameStrobe[0] VPWR VGND sg13cmos5l_antennanp
XANTENNA__2087__D Tile_X0Y1_FrameData[9] VPWR VGND sg13cmos5l_antennanp
XFILLER_216_220 VPWR VGND sg13cmos5l_decap_4
XFILLER_290_145 VPWR VGND sg13cmos5l_decap_8
XANTENNA__2815__D Tile_X0Y4_FrameData[1] VPWR VGND sg13cmos5l_antennanp
XANTENNA__3011__GATE Tile_X0Y5_FrameStrobe[7] VPWR VGND sg13cmos5l_antennanp
XFILLER_45_42 VPWR VGND sg13cmos5l_decap_8
XANTENNA__1227__A1 AXI_M_SOC_BRESP1 VPWR VGND sg13cmos5l_antennanp
XANTENNA__3026__GATE Tile_X0Y5_FrameStrobe[7] VPWR VGND sg13cmos5l_antennanp
XFILLER_101_81 VPWR VGND sg13cmos5l_decap_8
XFILLER_101_92 VPWR VGND sg13cmos5l_fill_2
XFILLER_236_0 VPWR VGND sg13cmos5l_decap_8
XANTENNA__0986__A0 Tile_X0Y1_W1END[3] VPWR VGND sg13cmos5l_antennanp
XFILLER_61_85 VPWR VGND sg13cmos5l_decap_8
XANTENNA__2550__D Tile_X0Y3_FrameData[26] VPWR VGND sg13cmos5l_antennanp
XANTENNA__3783__X Tile_X0Y4_FrameData_O[5] VPWR VGND sg13cmos5l_antennanp
XFILLER_177_63 VPWR VGND sg13cmos5l_fill_1
XFILLER_327_11 VPWR VGND sg13cmos5l_fill_2
XANTENNA_7 Tile_X0Y5_N4END[6] VPWR VGND sg13cmos5l_antennanp
XANTENNA__0738__A0 Tile_X0Y1_W1END[3] VPWR VGND sg13cmos5l_antennanp
XANTENNA__2282__GATE Tile_X0Y5_FrameStrobe[1] VPWR VGND sg13cmos5l_antennanp
XFILLER_6_36 VPWR VGND sg13cmos5l_fill_1
XFILLER_137_293 VPWR VGND sg13cmos5l_fill_2
XANTENNA__2297__GATE Tile_X0Y5_FrameStrobe[1] VPWR VGND sg13cmos5l_antennanp
XFILLER_193_95 VPWR VGND sg13cmos5l_decap_8
XFILLER_258_109 VPWR VGND sg13cmos5l_decap_4
XFILLER_3_273 VPWR VGND sg13cmos5l_fill_2
XANTENNA__1163__A0 Tile_X0Y0_W6END[10] VPWR VGND sg13cmos5l_antennanp
XFILLER_266_131 VPWR VGND sg13cmos5l_fill_2
X_2120_ _2120_/Q Tile_X0Y1_FrameData[8] Tile_X0Y5_FrameStrobe[4] VPWR VGND sg13cmos5l_dlhq_1
XANTENNA__2220__GATE Tile_X0Y5_FrameStrobe[7] VPWR VGND sg13cmos5l_antennanp
XFILLER_281_123 VPWR VGND sg13cmos5l_fill_2
X_2051_ _2051_/Q Tile_X0Y1_FrameData[13] Tile_X0Y5_FrameStrobe[2] VPWR VGND sg13cmos5l_dlhq_1
XANTENNA__2850__GATE Tile_X0Y5_FrameStrobe[2] VPWR VGND sg13cmos5l_antennanp
X_1002_ _1002_/Y _3025_/Q _1000_/Y _1001_/Y VPWR VGND sg13cmos5l_a21oi_1
XANTENNA__1466__A1 AXI_M_SOC_RDATA18 VPWR VGND sg13cmos5l_antennanp
XANTENNA__2725__D Tile_X0Y3_FrameData[11] VPWR VGND sg13cmos5l_antennanp
XFILLER_34_144 VPWR VGND sg13cmos5l_fill_2
XANTENNA__2235__GATE Tile_X0Y5_FrameStrobe[8] VPWR VGND sg13cmos5l_antennanp
XFILLER_222_267 VPWR VGND sg13cmos5l_fill_1
X_2953_ _2953_/Q Tile_X0Y4_FrameData[23] Tile_X0Y5_FrameStrobe[5] VPWR VGND sg13cmos5l_dlhq_1
XFILLER_34_188 VPWR VGND sg13cmos5l_decap_8
XFILLER_34_177 VPWR VGND sg13cmos5l_fill_1
XANTENNA__2865__GATE Tile_X0Y5_FrameStrobe[2] VPWR VGND sg13cmos5l_antennanp
X_1904_ _1904_/Q Tile_X0Y0_FrameData[16] Tile_X0Y5_FrameStrobe[6] VPWR VGND sg13cmos5l_dlhq_1
XANTENNA__0977__A0 Tile_X0Y3_W1END[2] VPWR VGND sg13cmos5l_antennanp
X_2884_ _2884_/Q Tile_X0Y4_FrameData[28] Tile_X0Y5_FrameStrobe[3] VPWR VGND sg13cmos5l_dlhq_1
XANTENNA__2460__D Tile_X0Y2_FrameData[4] VPWR VGND sg13cmos5l_antennanp
XANTENNA__3693__X Tile_X0Y3_EE4BEG[12] VPWR VGND sg13cmos5l_antennanp
X_1835_ _1835_/Q Tile_X0Y0_FrameData[21] Tile_X0Y5_FrameStrobe[4] VPWR VGND sg13cmos5l_dlhq_1
XFILLER_336_168 VPWR VGND sg13cmos5l_fill_1
X_1766_ _1766_/Q Tile_X0Y0_FrameData[26] Tile_X0Y5_FrameStrobe[2] VPWR VGND sg13cmos5l_dlhq_1
XFILLER_128_293 VPWR VGND sg13cmos5l_fill_2
X_3505_ Tile_X0Y1_E2BEG[5] _3505_/A VPWR VGND sg13cmos5l_buf_1
X_0717_ _0717_/X _0712_/X _0713_/Y _0716_/Y VPWR VGND sg13cmos5l_a21o_1
XFILLER_289_256 VPWR VGND sg13cmos5l_fill_1
X_1697_ _3891_/A Tile_X0Y5_W1END[0] Tile_X0Y5_W6END[8] _0596_/X _1055_/Y _3292_/Q
+ _3291_/Q VPWR VGND sg13cmos5l_mux4_1
XANTENNA__2803__GATE Tile_X0Y5_FrameStrobe[0] VPWR VGND sg13cmos5l_antennanp
XFILLER_289_278 VPWR VGND sg13cmos5l_fill_1
X_3436_ Tile_X0Y1_FrameData_O[4] Tile_X0Y1_FrameData[4] VPWR VGND sg13cmos5l_buf_1
X_0648_ _0648_/X Tile_X0Y5_N1END[1] Tile_X0Y5_N4END[1] _1021_/B _0644_/X _3110_/Q
+ _3109_/Q VPWR VGND sg13cmos5l_mux4_1
XANTENNA__1154__A0 Tile_X0Y0_W1END[2] VPWR VGND sg13cmos5l_antennanp
XANTENNA__1804__D Tile_X0Y0_FrameData[20] VPWR VGND sg13cmos5l_antennanp
XANTENNA__3291__D Tile_X0Y5_FrameData[21] VPWR VGND sg13cmos5l_antennanp
X_3367_ Tile_X0Y2_E2BEGb[5] _3367_/A VPWR VGND sg13cmos5l_buf_1
X_0579_ _0579_/X _0574_/X _0575_/Y _0578_/Y VPWR VGND sg13cmos5l_a21o_1
XFILLER_111_171 VPWR VGND sg13cmos5l_decap_4
X_2318_ _2318_/Q Tile_X0Y2_FrameData[18] Tile_X0Y5_FrameStrobe[2] VPWR VGND sg13cmos5l_dlhq_1
XFILLER_57_214 VPWR VGND sg13cmos5l_decap_8
XFILLER_57_203 VPWR VGND sg13cmos5l_fill_1
XFILLER_111_193 VPWR VGND sg13cmos5l_decap_8
XFILLER_257_186 VPWR VGND sg13cmos5l_decap_4
XFILLER_300_293 VPWR VGND sg13cmos5l_fill_2
X_3298_ _3298_/Q Tile_X0Y5_FrameData[14] Tile_X0Y5_FrameStrobe[7] VPWR VGND sg13cmos5l_dlhq_1
XFILLER_57_247 VPWR VGND sg13cmos5l_decap_8
XANTENNA__2818__GATE Tile_X0Y5_FrameStrobe[1] VPWR VGND sg13cmos5l_antennanp
XFILLER_272_134 VPWR VGND sg13cmos5l_fill_1
X_2249_ _2249_/Q Tile_X0Y2_FrameData[23] Tile_X0Y5_FrameStrobe[0] VPWR VGND sg13cmos5l_dlhq_1
XANTENNA__1457__A1 AXI_M_SOC_RDATA18 VPWR VGND sg13cmos5l_antennanp
XANTENNA__3868__X Tile_X0Y5_FrameData_O[9] VPWR VGND sg13cmos5l_antennanp
XFILLER_25_100 VPWR VGND sg13cmos5l_fill_2
XFILLER_82_29 VPWR VGND sg13cmos5l_decap_8
XANTENNA__2635__D Tile_X0Y3_FrameData[5] VPWR VGND sg13cmos5l_antennanp
XFILLER_15_23 VPWR VGND sg13cmos5l_decap_4
XFILLER_198_29 VPWR VGND sg13cmos5l_decap_8
XFILLER_213_212 VPWR VGND sg13cmos5l_fill_2
XANTENNA__1209__A1 Tile_X0Y0_WW4END[13] VPWR VGND sg13cmos5l_antennanp
XFILLER_15_34 VPWR VGND sg13cmos5l_fill_2
XFILLER_15_45 VPWR VGND sg13cmos5l_decap_4
XFILLER_80_283 VPWR VGND sg13cmos5l_fill_1
XFILLER_178_171 VPWR VGND sg13cmos5l_fill_2
XANTENNA__2370__D Tile_X0Y2_FrameData[30] VPWR VGND sg13cmos5l_antennanp
XFILLER_126_219 VPWR VGND sg13cmos5l_decap_8
XFILLER_147_22 VPWR VGND sg13cmos5l_decap_8
XFILLER_119_293 VPWR VGND sg13cmos5l_fill_2
XFILLER_147_66 VPWR VGND sg13cmos5l_decap_8
XFILLER_134_252 VPWR VGND sg13cmos5l_fill_2
XFILLER_0_210 VPWR VGND sg13cmos5l_fill_2
XANTENNA__1714__D Tile_X0Y0_FrameData[14] VPWR VGND sg13cmos5l_antennanp
XFILLER_163_54 VPWR VGND sg13cmos5l_fill_2
XANTENNA__1696__A1 Tile_X0Y5_W6END[9] VPWR VGND sg13cmos5l_antennanp
XFILLER_248_142 VPWR VGND sg13cmos5l_decap_8
XFILLER_48_203 VPWR VGND sg13cmos5l_decap_8
XFILLER_186_0 VPWR VGND sg13cmos5l_decap_4
XFILLER_248_175 VPWR VGND sg13cmos5l_fill_2
XANTENNA__2545__D Tile_X0Y3_FrameData[31] VPWR VGND sg13cmos5l_antennanp
XANTENNA__3778__X Tile_X0Y4_FrameData_O[0] VPWR VGND sg13cmos5l_antennanp
XFILLER_204_256 VPWR VGND sg13cmos5l_decap_4
XFILLER_72_40 VPWR VGND sg13cmos5l_decap_8
XFILLER_31_103 VPWR VGND sg13cmos5l_decap_8
XFILLER_31_136 VPWR VGND sg13cmos5l_decap_8
XFILLER_169_171 VPWR VGND sg13cmos5l_decap_4
XFILLER_169_193 VPWR VGND sg13cmos5l_decap_8
XFILLER_82_8 VPWR VGND sg13cmos5l_decap_8
XANTENNA__1620__A1 AXI_M_SOC_RRESP1 VPWR VGND sg13cmos5l_antennanp
XFILLER_75_7 VPWR VGND sg13cmos5l_decap_8
XFILLER_318_157 VPWR VGND sg13cmos5l_decap_8
XANTENNA__2280__D Tile_X0Y2_FrameData[24] VPWR VGND sg13cmos5l_antennanp
X_1620_ _3776_/A Tile_X0Y4_WW4END[1] AXI_M_SOC_RRESP1 _1029_/X _1049_/X _2916_/Q _2915_/Q
+ VPWR VGND sg13cmos5l_mux4_1
XFILLER_333_116 VPWR VGND sg13cmos5l_fill_1
XFILLER_125_263 VPWR VGND sg13cmos5l_decap_8
X_1551_ AXI_M_SOC_ARADDR25 Tile_X0Y3_WW4END[1] Tile_X0Y3_WW4END[9] Tile_X0Y3_W6END[1]
+ _1530_/X _2614_/Q _2613_/Q VPWR VGND sg13cmos5l_mux4_1
X_1482_ _1482_/Y _2445_/Q _1481_/X _2444_/Q VPWR VGND sg13cmos5l_o21ai_1
XFILLER_98_114 VPWR VGND sg13cmos5l_decap_8
XFILLER_286_248 VPWR VGND sg13cmos5l_decap_4
XFILLER_286_259 VPWR VGND sg13cmos5l_fill_1
X_3221_ _3221_/Q Tile_X0Y5_FrameData[27] Tile_X0Y5_FrameStrobe[5] VPWR VGND sg13cmos5l_dlhq_1
XFILLER_98_169 VPWR VGND sg13cmos5l_fill_2
XANTENNA__1687__A1 Tile_X0Y4_W6END[5] VPWR VGND sg13cmos5l_antennanp
XFILLER_140_277 VPWR VGND sg13cmos5l_fill_1
X_3152_ _3152_/Q Tile_X0Y5_FrameData[0] Tile_X0Y5_FrameStrobe[2] VPWR VGND sg13cmos5l_dlhq_1
X_2103_ _2103_/Q Tile_X0Y1_FrameData[25] Tile_X0Y5_FrameStrobe[4] VPWR VGND sg13cmos5l_dlhq_1
XFILLER_39_258 VPWR VGND sg13cmos5l_decap_8
X_3083_ _3083_/Q Tile_X0Y5_FrameData[5] Tile_X0Y5_FrameStrobe[0] VPWR VGND sg13cmos5l_dlhq_1
XFILLER_54_217 VPWR VGND sg13cmos5l_fill_1
XFILLER_299_17 VPWR VGND sg13cmos5l_fill_1
X_2034_ _2034_/Q Tile_X0Y1_FrameData[30] Tile_X0Y5_FrameStrobe[2] VPWR VGND sg13cmos5l_dlhq_1
XANTENNA__2174__GATE Tile_X0Y5_FrameStrobe[6] VPWR VGND sg13cmos5l_antennanp
XANTENNA__2455__D Tile_X0Y2_FrameData[9] VPWR VGND sg13cmos5l_antennanp
XANTENNA__3688__X Tile_X0Y3_EE4BEG[7] VPWR VGND sg13cmos5l_antennanp
XFILLER_22_103 VPWR VGND sg13cmos5l_decap_8
XFILLER_167_119 VPWR VGND sg13cmos5l_decap_8
XANTENNA__2189__GATE Tile_X0Y5_FrameStrobe[6] VPWR VGND sg13cmos5l_antennanp
XFILLER_22_169 VPWR VGND sg13cmos5l_fill_2
X_2936_ _2936_/Q Tile_X0Y4_FrameData[8] Tile_X0Y5_FrameStrobe[4] VPWR VGND sg13cmos5l_dlhq_1
XANTENNA__1611__A1 AXI_M_SOC_RDATA1 VPWR VGND sg13cmos5l_antennanp
XANTENNA__3286__D Tile_X0Y5_FrameData[26] VPWR VGND sg13cmos5l_antennanp
XFILLER_248_54 VPWR VGND sg13cmos5l_fill_2
XFILLER_309_135 VPWR VGND sg13cmos5l_fill_1
XFILLER_309_157 VPWR VGND sg13cmos5l_decap_8
X_2867_ _2867_/Q Tile_X0Y4_FrameData[13] Tile_X0Y5_FrameStrobe[2] VPWR VGND sg13cmos5l_dlhq_1
XANTENNA__0965__A3 Tile_X0Y0_S4END[6] VPWR VGND sg13cmos5l_antennanp
XANTENNA__2190__D Tile_X0Y1_FrameData[2] VPWR VGND sg13cmos5l_antennanp
XANTENNA__3864__A Tile_X0Y5_FrameData[5] VPWR VGND sg13cmos5l_antennanp
X_1818_ _1818_/Q Tile_X0Y0_FrameData[6] Tile_X0Y5_FrameStrobe[3] VPWR VGND sg13cmos5l_dlhq_1
XANTENNA__2112__GATE Tile_X0Y5_FrameStrobe[4] VPWR VGND sg13cmos5l_antennanp
XFILLER_175_196 VPWR VGND sg13cmos5l_decap_8
X_2798_ _2798_/Q Tile_X0Y4_FrameData[18] Tile_X0Y5_FrameStrobe[0] VPWR VGND sg13cmos5l_dlhq_1
XANTENNA__2742__GATE Tile_X0Y5_FrameStrobe[7] VPWR VGND sg13cmos5l_antennanp
XFILLER_117_14 VPWR VGND sg13cmos5l_decap_4
XFILLER_117_36 VPWR VGND sg13cmos5l_fill_1
XFILLER_190_166 VPWR VGND sg13cmos5l_fill_2
X_1749_ _1749_/Q Tile_X0Y0_FrameData[11] Tile_X0Y5_FrameStrobe[1] VPWR VGND sg13cmos5l_dlhq_1
XFILLER_89_114 VPWR VGND sg13cmos5l_decap_8
XFILLER_277_248 VPWR VGND sg13cmos5l_decap_8
X_3419_ Tile_X0Y2_FrameData_O[21] Tile_X0Y2_FrameData[21] VPWR VGND sg13cmos5l_buf_1
XANTENNA__1678__A1 AXI_M_SOC_RRESP1 VPWR VGND sg13cmos5l_antennanp
XANTENNA__2127__GATE Tile_X0Y5_FrameStrobe[4] VPWR VGND sg13cmos5l_antennanp
XANTENNA__2757__GATE Tile_X0Y5_FrameStrobe[7] VPWR VGND sg13cmos5l_antennanp
XFILLER_93_39 VPWR VGND sg13cmos5l_decap_8
XANTENNA__2365__D Tile_X0Y2_FrameData[3] VPWR VGND sg13cmos5l_antennanp
XANTENNA__3598__X Tile_X0Y0_FrameData_O[29] VPWR VGND sg13cmos5l_antennanp
XFILLER_158_108 VPWR VGND sg13cmos5l_decap_8
XANTENNA__1709__D Tile_X0Y0_FrameData[19] VPWR VGND sg13cmos5l_antennanp
XANTENNA__3196__D Tile_X0Y5_FrameData[20] VPWR VGND sg13cmos5l_antennanp
XFILLER_42_54 VPWR VGND sg13cmos5l_decap_8
XANTENNA__0956__A3 Tile_X0Y0_S4END[7] VPWR VGND sg13cmos5l_antennanp
XANTENNA__1951__GATE Tile_X0Y5_FrameStrobe[7] VPWR VGND sg13cmos5l_antennanp
XFILLER_166_196 VPWR VGND sg13cmos5l_decap_8
XFILLER_181_133 VPWR VGND sg13cmos5l_decap_4
XFILLER_308_24 VPWR VGND sg13cmos5l_fill_1
XFILLER_101_0 VPWR VGND sg13cmos5l_fill_2
XFILLER_181_155 VPWR VGND sg13cmos5l_fill_1
XFILLER_181_177 VPWR VGND sg13cmos5l_fill_2
XFILLER_174_64 VPWR VGND sg13cmos5l_decap_8
XANTENNA__1966__GATE Tile_X0Y5_FrameStrobe[8] VPWR VGND sg13cmos5l_antennanp
XFILLER_122_244 VPWR VGND sg13cmos5l_decap_8
XFILLER_324_12 VPWR VGND sg13cmos5l_fill_1
XANTENNA__1669__A1 AXI_M_SOC_RRESP0 VPWR VGND sg13cmos5l_antennanp
XANTENNA__0892__A2 Tile_X0Y3_WW4END[7] VPWR VGND sg13cmos5l_antennanp
XANTENNA__2275__D Tile_X0Y2_FrameData[29] VPWR VGND sg13cmos5l_antennanp
XFILLER_199_50 VPWR VGND sg13cmos5l_decap_8
XFILLER_199_61 VPWR VGND sg13cmos5l_fill_1
XFILLER_199_72 VPWR VGND sg13cmos5l_decap_8
XANTENNA__1904__GATE Tile_X0Y5_FrameStrobe[6] VPWR VGND sg13cmos5l_antennanp
X_3770_ Tile_X0Y4_EE4BEG[8] _3770_/A VPWR VGND sg13cmos5l_buf_1
X_0982_ _0982_/X _1125_/X _1126_/X _1127_/X _1130_/X _3023_/Q _3022_/Q VPWR VGND sg13cmos5l_mux4_1
X_2721_ _2721_/Q Tile_X0Y3_FrameData[15] Tile_X0Y5_FrameStrobe[6] VPWR VGND sg13cmos5l_dlhq_1
XANTENNA__0947__A3 Tile_X0Y0_S4END[4] VPWR VGND sg13cmos5l_antennanp
XANTENNA__1919__GATE Tile_X0Y5_FrameStrobe[6] VPWR VGND sg13cmos5l_antennanp
XFILLER_73_4 VPWR VGND sg13cmos5l_fill_1
XFILLER_172_133 VPWR VGND sg13cmos5l_fill_1
X_2652_ _2652_/Q Tile_X0Y3_FrameData[20] Tile_X0Y5_FrameStrobe[4] VPWR VGND sg13cmos5l_dlhq_1
XFILLER_8_184 VPWR VGND sg13cmos5l_decap_8
X_2583_ _2583_/Q Tile_X0Y3_FrameData[25] Tile_X0Y5_FrameStrobe[2] VPWR VGND sg13cmos5l_dlhq_1
X_1603_ _1603_/X Tile_X0Y3_W1END[0] Tile_X0Y3_W6END[8] Tile_X0Y3_WW4END[0] _1539_/X
+ _2759_/Q _2760_/Q VPWR VGND sg13cmos5l_mux4_1
X_1534_ _3673_/A AXI_M_SOC_RDATA6 _0971_/X _1435_/X _1267_/X _2631_/Q _2632_/Q VPWR
+ VGND sg13cmos5l_mux4_1
XANTENNA__1109__A0 Tile_X0Y2_W2MID[7] VPWR VGND sg13cmos5l_antennanp
XFILLER_113_255 VPWR VGND sg13cmos5l_fill_2
XFILLER_234_12 VPWR VGND sg13cmos5l_decap_8
XFILLER_259_215 VPWR VGND sg13cmos5l_decap_8
XANTENNA__0580__A1 Tile_X0Y2_W6END[8] VPWR VGND sg13cmos5l_antennanp
X_3204_ _3204_/Q Tile_X0Y5_FrameData[12] Tile_X0Y5_FrameStrobe[4] VPWR VGND sg13cmos5l_dlhq_1
X_1465_ _3364_/A Tile_X0Y2_W2END[5] AXI_M_SOC_RDATA19 _1151_/X _1183_/X _2412_/Q _2411_/Q
+ VPWR VGND sg13cmos5l_mux4_1
XFILLER_274_229 VPWR VGND sg13cmos5l_decap_8
X_1396_ _3373_/A Tile_X0Y5_N4END[15] _1355_/X Tile_X0Y0_S4END[11] _1058_/X _2361_/Q
+ _2362_/Q VPWR VGND sg13cmos5l_mux4_1
XANTENNA__1124__A3 Tile_X0Y0_S4END[3] VPWR VGND sg13cmos5l_antennanp
X_3135_ _3135_/Q Tile_X0Y5_FrameData[17] Tile_X0Y5_FrameStrobe[2] VPWR VGND sg13cmos5l_dlhq_1
XANTENNA__0883__A2 Tile_X0Y3_WW4END[4] VPWR VGND sg13cmos5l_antennanp
XFILLER_27_239 VPWR VGND sg13cmos5l_decap_8
X_3066_ _3066_/Q Tile_X0Y5_FrameData[22] Tile_X0Y5_FrameStrobe[0] VPWR VGND sg13cmos5l_dlhq_1
XANTENNA__2185__D Tile_X0Y1_FrameData[7] VPWR VGND sg13cmos5l_antennanp
XANTENNA__3859__A Tile_X0Y5_FrameData[0] VPWR VGND sg13cmos5l_antennanp
XFILLER_242_137 VPWR VGND sg13cmos5l_decap_8
X_2017_ _2017_/Q Tile_X0Y1_FrameData[15] Tile_X0Y5_FrameStrobe[1] VPWR VGND sg13cmos5l_dlhq_1
XFILLER_250_88 VPWR VGND sg13cmos5l_decap_8
XANTENNA__2913__D Tile_X0Y4_FrameData[31] VPWR VGND sg13cmos5l_antennanp
X_2919_ _2919_/Q Tile_X0Y4_FrameData[25] Tile_X0Y5_FrameStrobe[4] VPWR VGND sg13cmos5l_dlhq_1
XFILLER_337_230 VPWR VGND sg13cmos5l_fill_2
XANTENNA__3594__A Tile_X0Y0_FrameData[25] VPWR VGND sg13cmos5l_antennanp
XFILLER_12_24 VPWR VGND sg13cmos5l_fill_2
XFILLER_148_152 VPWR VGND sg13cmos5l_decap_8
X_3899_ Tile_X0Y5_S2BEG[4] _3899_/A VPWR VGND sg13cmos5l_buf_1
XANTENNA__2051__GATE Tile_X0Y5_FrameStrobe[2] VPWR VGND sg13cmos5l_antennanp
XFILLER_148_185 VPWR VGND sg13cmos5l_fill_1
XFILLER_304_9 VPWR VGND sg13cmos5l_fill_2
XANTENNA__2681__GATE Tile_X0Y5_FrameStrobe[5] VPWR VGND sg13cmos5l_antennanp
XANTENNA__3881__X Tile_X0Y5_FrameData_O[22] VPWR VGND sg13cmos5l_antennanp
XFILLER_128_57 VPWR VGND sg13cmos5l_decap_8
XFILLER_163_155 VPWR VGND sg13cmos5l_fill_1
XFILLER_275_74 VPWR VGND sg13cmos5l_fill_2
XFILLER_275_85 VPWR VGND sg13cmos5l_fill_2
XANTENNA__2066__GATE Tile_X0Y5_FrameStrobe[3] VPWR VGND sg13cmos5l_antennanp
XFILLER_104_255 VPWR VGND sg13cmos5l_decap_4
XFILLER_305_193 VPWR VGND sg13cmos5l_decap_8
XANTENNA__2696__GATE Tile_X0Y5_FrameStrobe[5] VPWR VGND sg13cmos5l_antennanp
XFILLER_77_106 VPWR VGND sg13cmos5l_decap_8
XFILLER_265_229 VPWR VGND sg13cmos5l_decap_8
XANTENNA__1115__A3 Tile_X0Y0_S2MID[7] VPWR VGND sg13cmos5l_antennanp
XANTENNA__1520__A0 Tile_X0Y3_WW4END[8] VPWR VGND sg13cmos5l_antennanp
XFILLER_18_217 VPWR VGND sg13cmos5l_decap_8
XFILLER_218_156 VPWR VGND sg13cmos5l_fill_2
XFILLER_273_262 VPWR VGND sg13cmos5l_fill_2
XFILLER_85_172 VPWR VGND sg13cmos5l_fill_1
XFILLER_37_65 VPWR VGND sg13cmos5l_decap_8
XANTENNA__2095__D Tile_X0Y1_FrameData[1] VPWR VGND sg13cmos5l_antennanp
XFILLER_160_88 VPWR VGND sg13cmos5l_decap_8
XANTENNA__2004__GATE Tile_X0Y5_FrameStrobe[1] VPWR VGND sg13cmos5l_antennanp
XFILLER_186_203 VPWR VGND sg13cmos5l_fill_2
XFILLER_53_42 VPWR VGND sg13cmos5l_decap_8
XANTENNA__2634__GATE Tile_X0Y5_FrameStrobe[3] VPWR VGND sg13cmos5l_antennanp
XANTENNA__2823__D Tile_X0Y4_FrameData[25] VPWR VGND sg13cmos5l_antennanp
XFILLER_149_0 VPWR VGND sg13cmos5l_decap_4
XFILLER_169_31 VPWR VGND sg13cmos5l_decap_4
XFILLER_169_53 VPWR VGND sg13cmos5l_decap_4
XFILLER_186_236 VPWR VGND sg13cmos5l_decap_4
XFILLER_169_64 VPWR VGND sg13cmos5l_fill_2
XANTENNA__1890__GATE Tile_X0Y5_FrameStrobe[6] VPWR VGND sg13cmos5l_antennanp
XANTENNA__2019__GATE Tile_X0Y5_FrameStrobe[1] VPWR VGND sg13cmos5l_antennanp
XFILLER_316_0 VPWR VGND sg13cmos5l_fill_2
XANTENNA__2649__GATE Tile_X0Y5_FrameStrobe[4] VPWR VGND sg13cmos5l_antennanp
XFILLER_185_30 VPWR VGND sg13cmos5l_decap_8
XFILLER_194_280 VPWR VGND sg13cmos5l_fill_1
XANTENNA__1339__A0 Tile_X0Y1_W2MID[0] VPWR VGND sg13cmos5l_antennanp
XANTENNA__3791__X Tile_X0Y4_FrameData_O[13] VPWR VGND sg13cmos5l_antennanp
XFILLER_185_74 VPWR VGND sg13cmos5l_decap_8
XFILLER_118_90 VPWR VGND sg13cmos5l_decap_4
XANTENNA__0562__A1 Tile_X0Y3_W2MID[0] VPWR VGND sg13cmos5l_antennanp
XFILLER_110_203 VPWR VGND sg13cmos5l_decap_8
XFILLER_68_117 VPWR VGND sg13cmos5l_decap_4
XFILLER_335_99 VPWR VGND sg13cmos5l_decap_8
X_1250_ _3637_/A Tile_X0Y0_W2MID[7] AXI_M_SOC_RDATA30 _1145_/X _1136_/X _1888_/Q _1887_/Q
+ VPWR VGND sg13cmos5l_mux4_1
XANTENNA__1511__A0 Tile_X0Y3_WW4END[10] VPWR VGND sg13cmos5l_antennanp
XANTENNA__1902__D Tile_X0Y0_FrameData[18] VPWR VGND sg13cmos5l_antennanp
XFILLER_110_258 VPWR VGND sg13cmos5l_decap_8
X_1181_ _1181_/X Tile_X0Y1_W1END[1] Tile_X0Y1_W2MID[2] Tile_X0Y1_W2END[2] _1086_/X
+ _2186_/Q _2185_/Q VPWR VGND sg13cmos5l_mux4_1
XFILLER_209_156 VPWR VGND sg13cmos5l_decap_8
XANTENNA__1843__GATE Tile_X0Y5_FrameStrobe[4] VPWR VGND sg13cmos5l_antennanp
XFILLER_17_283 VPWR VGND sg13cmos5l_fill_1
XFILLER_17_294 VPWR VGND sg13cmos5l_fill_1
XANTENNA__2733__D Tile_X0Y3_FrameData[3] VPWR VGND sg13cmos5l_antennanp
XFILLER_232_192 VPWR VGND sg13cmos5l_fill_1
XFILLER_296_18 VPWR VGND sg13cmos5l_fill_1
X_3822_ Tile_X0Y5_E2BEG[7] _3822_/A VPWR VGND sg13cmos5l_buf_1
XFILLER_32_253 VPWR VGND sg13cmos5l_fill_2
XFILLER_177_247 VPWR VGND sg13cmos5l_decap_8
XFILLER_296_29 VPWR VGND sg13cmos5l_decap_8
XANTENNA__1858__GATE Tile_X0Y5_FrameStrobe[5] VPWR VGND sg13cmos5l_antennanp
XFILLER_192_228 VPWR VGND sg13cmos5l_decap_4
X_3753_ Tile_X0Y4_E6BEG[3] _3753_/A VPWR VGND sg13cmos5l_buf_1
X_0965_ _0965_/X _1122_/X _0666_/X _0940_/Y Tile_X0Y0_S4END[6] _1995_/Q _1996_/Q VPWR
+ VGND sg13cmos5l_mux4_1
XFILLER_319_274 VPWR VGND sg13cmos5l_fill_2
XANTENNA__1042__A2 Tile_X0Y0_S1END[1] VPWR VGND sg13cmos5l_antennanp
XFILLER_229_67 VPWR VGND sg13cmos5l_fill_2
X_2704_ _2704_/Q Tile_X0Y3_FrameData[0] Tile_X0Y5_FrameStrobe[5] VPWR VGND sg13cmos5l_dlhq_1
X_3684_ Tile_X0Y3_EE4BEG[3] _3684_/A VPWR VGND sg13cmos5l_buf_1
X_0896_ _0896_/Y _0544_/Y _0743_/X _0895_/Y VPWR VGND sg13cmos5l_o21ai_1
XFILLER_64_0 VPWR VGND sg13cmos5l_decap_4
XFILLER_334_211 VPWR VGND sg13cmos5l_fill_2
X_2635_ _2635_/Q Tile_X0Y3_FrameData[5] Tile_X0Y5_FrameStrobe[3] VPWR VGND sg13cmos5l_dlhq_1
X_2566_ _2566_/Q Tile_X0Y3_FrameData[10] Tile_X0Y5_FrameStrobe[1] VPWR VGND sg13cmos5l_dlhq_1
XFILLER_302_152 VPWR VGND sg13cmos5l_fill_1
X_2497_ _2497_/Q Tile_X0Y2_FrameData[31] Tile_X0Y5_FrameStrobe[8] VPWR VGND sg13cmos5l_dlhq_1
X_1517_ _3681_/A Tile_X0Y3_WW4END[15] AXI_M_SOC_RDATA6 _1586_/B _1351_/X _2672_/Q
+ _2671_/Q VPWR VGND sg13cmos5l_mux4_1
XFILLER_99_275 VPWR VGND sg13cmos5l_fill_2
XFILLER_59_117 VPWR VGND sg13cmos5l_decap_8
XFILLER_302_174 VPWR VGND sg13cmos5l_decap_4
X_1448_ _3388_/A Tile_X0Y2_WW4END[9] _1369_/X AXI_M_SOC_RDATA20 _1143_/X _2387_/Q
+ _2388_/Q VPWR VGND sg13cmos5l_mux4_1
XANTENNA__1502__A0 Tile_X0Y3_W2END[7] VPWR VGND sg13cmos5l_antennanp
XANTENNA__1812__D Tile_X0Y0_FrameData[12] VPWR VGND sg13cmos5l_antennanp
XANTENNA__2908__D Tile_X0Y4_FrameData[4] VPWR VGND sg13cmos5l_antennanp
X_3118_ _3118_/Q Tile_X0Y5_FrameData[2] Tile_X0Y5_FrameStrobe[1] VPWR VGND sg13cmos5l_dlhq_1
X_1379_ _1379_/X _0977_/X _0672_/X Tile_X0Y5_N4END[14] Tile_X0Y0_S4END[10] _2275_/Q
+ _2276_/Q VPWR VGND sg13cmos5l_mux4_1
XFILLER_67_194 VPWR VGND sg13cmos5l_decap_8
XFILLER_67_161 VPWR VGND sg13cmos5l_fill_2
XANTENNA__3589__A Tile_X0Y0_FrameData[20] VPWR VGND sg13cmos5l_antennanp
XFILLER_255_273 VPWR VGND sg13cmos5l_decap_8
XFILLER_270_254 VPWR VGND sg13cmos5l_fill_2
X_3049_ _3049_/Q Tile_X0Y4_FrameData[23] Tile_X0Y5_FrameStrobe[8] VPWR VGND sg13cmos5l_dlhq_1
XFILLER_90_18 VPWR VGND sg13cmos5l_decap_8
XANTENNA__2643__D Tile_X0Y3_FrameData[29] VPWR VGND sg13cmos5l_antennanp
XANTENNA__3876__X Tile_X0Y5_FrameData_O[17] VPWR VGND sg13cmos5l_antennanp
XFILLER_23_78 VPWR VGND sg13cmos5l_decap_8
XFILLER_286_62 VPWR VGND sg13cmos5l_fill_1
XANTENNA__0792__A1 Tile_X0Y4_W2END[4] VPWR VGND sg13cmos5l_antennanp
XANTENNA__3302__GATE Tile_X0Y5_FrameStrobe[7] VPWR VGND sg13cmos5l_antennanp
XFILLER_238_229 VPWR VGND sg13cmos5l_fill_1
XFILLER_48_42 VPWR VGND sg13cmos5l_decap_8
XANTENNA__1722__D Tile_X0Y0_FrameData[6] VPWR VGND sg13cmos5l_antennanp
XANTENNA__2818__D Tile_X0Y4_FrameData[30] VPWR VGND sg13cmos5l_antennanp
XANTENNA__3317__GATE Tile_X0Y5_FrameStrobe[8] VPWR VGND sg13cmos5l_antennanp
XFILLER_246_273 VPWR VGND sg13cmos5l_decap_4
XFILLER_206_148 VPWR VGND sg13cmos5l_decap_8
XFILLER_261_232 VPWR VGND sg13cmos5l_fill_1
XFILLER_261_254 VPWR VGND sg13cmos5l_fill_2
XFILLER_266_0 VPWR VGND sg13cmos5l_fill_2
XANTENNA__2573__GATE Tile_X0Y5_FrameStrobe[1] VPWR VGND sg13cmos5l_antennanp
XFILLER_64_85 VPWR VGND sg13cmos5l_decap_8
XANTENNA__2553__D Tile_X0Y3_FrameData[23] VPWR VGND sg13cmos5l_antennanp
XANTENNA__3786__X Tile_X0Y4_FrameData_O[8] VPWR VGND sg13cmos5l_antennanp
XFILLER_159_214 VPWR VGND sg13cmos5l_decap_8
XFILLER_214_181 VPWR VGND sg13cmos5l_decap_4
XFILLER_159_269 VPWR VGND sg13cmos5l_fill_2
XANTENNA__2588__GATE Tile_X0Y5_FrameStrobe[2] VPWR VGND sg13cmos5l_antennanp
XFILLER_196_40 VPWR VGND sg13cmos5l_decap_8
XANTENNA__1024__A2 Tile_X0Y1_W6END[6] VPWR VGND sg13cmos5l_antennanp
X_0750_ _0750_/Y _0742_/X _3259_/Q VPWR VGND sg13cmos5l_nand2b_1
XANTENNA__2511__GATE Tile_X0Y5_FrameStrobe[8] VPWR VGND sg13cmos5l_antennanp
XFILLER_127_199 VPWR VGND sg13cmos5l_decap_4
X_2420_ _2420_/Q Tile_X0Y2_FrameData[12] Tile_X0Y5_FrameStrobe[5] VPWR VGND sg13cmos5l_dlhq_1
X_0681_ _0682_/C _2516_/Q _0987_/X VPWR VGND sg13cmos5l_nor2_1
XFILLER_331_247 VPWR VGND sg13cmos5l_fill_1
XFILLER_215_14 VPWR VGND sg13cmos5l_fill_1
XFILLER_215_25 VPWR VGND sg13cmos5l_decap_8
X_2351_ _2351_/Q Tile_X0Y2_FrameData[17] Tile_X0Y5_FrameStrobe[3] VPWR VGND sg13cmos5l_dlhq_1
XFILLER_96_212 VPWR VGND sg13cmos5l_decap_4
XFILLER_229_207 VPWR VGND sg13cmos5l_fill_2
XFILLER_229_229 VPWR VGND sg13cmos5l_fill_1
X_2282_ _2282_/Q Tile_X0Y2_FrameData[22] Tile_X0Y5_FrameStrobe[1] VPWR VGND sg13cmos5l_dlhq_1
X_1302_ _3491_/A AXI_M_SOC_RDATA29 _0919_/X _1268_/X _1115_/X _2073_/Q _2074_/Q VPWR
+ VGND sg13cmos5l_mux4_1
XANTENNA__2526__GATE Tile_X0Y5_FrameStrobe[0] VPWR VGND sg13cmos5l_antennanp
XANTENNA__2728__D Tile_X0Y3_FrameData[8] VPWR VGND sg13cmos5l_antennanp
X_1233_ _3612_/A Tile_X0Y0_WW4END[4] AXI_M_SOC_BRESP0 _1068_/X _1078_/X _1834_/Q _1833_/Q
+ VPWR VGND sg13cmos5l_mux4_1
XFILLER_237_251 VPWR VGND sg13cmos5l_decap_4
XANTENNA__0838__A2 Tile_X0Y5_WW4END[11] VPWR VGND sg13cmos5l_antennanp
XANTENNA__1782__GATE Tile_X0Y5_FrameStrobe[2] VPWR VGND sg13cmos5l_antennanp
XFILLER_231_24 VPWR VGND sg13cmos5l_fill_1
X_1164_ _1164_/X Tile_X0Y0_W1END[2] Tile_X0Y0_WW4END[2] _1004_/X _1005_/X _1938_/Q
+ _1936_/Q VPWR VGND sg13cmos5l_mux4_1
XFILLER_64_142 VPWR VGND sg13cmos5l_decap_8
XFILLER_49_194 VPWR VGND sg13cmos5l_decap_8
X_1095_ _3545_/A Tile_X0Y0_W1END[0] Tile_X0Y0_W6END[4] _1074_/X _0567_/Y _1968_/Q
+ _1967_/Q VPWR VGND sg13cmos5l_mux4_1
XFILLER_252_276 VPWR VGND sg13cmos5l_decap_4
XANTENNA__2463__D Tile_X0Y2_FrameData[1] VPWR VGND sg13cmos5l_antennanp
XANTENNA__3696__X Tile_X0Y3_EE4BEG[15] VPWR VGND sg13cmos5l_antennanp
XFILLER_100_17 VPWR VGND sg13cmos5l_fill_2
XANTENNA__1263__A2 AXI_M_SOC_ARREADY VPWR VGND sg13cmos5l_antennanp
XANTENNA__1797__GATE Tile_X0Y5_FrameStrobe[3] VPWR VGND sg13cmos5l_antennanp
XFILLER_100_39 VPWR VGND sg13cmos5l_decap_8
X_3805_ Tile_X0Y4_FrameData_O[27] Tile_X0Y4_FrameData[27] VPWR VGND sg13cmos5l_buf_1
X_1997_ _1997_/Q Tile_X0Y1_FrameData[3] Tile_X0Y5_FrameStrobe[0] VPWR VGND sg13cmos5l_dlhq_1
XANTENNA__1015__A2 Tile_X0Y5_W6END[5] VPWR VGND sg13cmos5l_antennanp
XFILLER_118_111 VPWR VGND sg13cmos5l_decap_8
X_3736_ Tile_X0Y4_E2BEG[2] _3736_/A VPWR VGND sg13cmos5l_buf_1
X_0948_ _0948_/X Tile_X0Y1_WW4END[0] Tile_X0Y1_WW4END[8] Tile_X0Y1_W6END[8] _0947_/X
+ _2056_/Q _2055_/Q VPWR VGND sg13cmos5l_mux4_1
XANTENNA__1720__GATE Tile_X0Y5_FrameStrobe[0] VPWR VGND sg13cmos5l_antennanp
XFILLER_109_15 VPWR VGND sg13cmos5l_decap_8
XFILLER_256_21 VPWR VGND sg13cmos5l_fill_1
XANTENNA__1807__D Tile_X0Y0_FrameData[17] VPWR VGND sg13cmos5l_antennanp
XANTENNA__3294__D Tile_X0Y5_FrameData[18] VPWR VGND sg13cmos5l_antennanp
XANTENNA__3872__A Tile_X0Y5_FrameData[13] VPWR VGND sg13cmos5l_antennanp
XFILLER_118_177 VPWR VGND sg13cmos5l_decap_8
X_3667_ Tile_X0Y3_E2BEGb[6] _3667_/A VPWR VGND sg13cmos5l_buf_1
X_0879_ _0879_/Y _3114_/Q Tile_X0Y5_W2MID[7] VPWR VGND sg13cmos5l_nand2b_1
XFILLER_279_118 VPWR VGND sg13cmos5l_fill_2
X_2618_ _2618_/Q Tile_X0Y3_FrameData[22] Tile_X0Y5_FrameStrobe[3] VPWR VGND sg13cmos5l_dlhq_1
X_3598_ Tile_X0Y0_FrameData_O[29] Tile_X0Y0_FrameData[29] VPWR VGND sg13cmos5l_buf_1
XANTENNA__1735__GATE Tile_X0Y5_FrameStrobe[1] VPWR VGND sg13cmos5l_antennanp
X_2549_ _2549_/Q Tile_X0Y3_FrameData[27] Tile_X0Y5_FrameStrobe[1] VPWR VGND sg13cmos5l_dlhq_1
XFILLER_87_223 VPWR VGND sg13cmos5l_decap_8
XANTENNA__2638__D Tile_X0Y3_FrameData[2] VPWR VGND sg13cmos5l_antennanp
XFILLER_197_8 VPWR VGND sg13cmos5l_fill_2
XFILLER_85_18 VPWR VGND sg13cmos5l_decap_8
XFILLER_47_109 VPWR VGND sg13cmos5l_decap_8
XFILLER_205_91 VPWR VGND sg13cmos5l_fill_1
XFILLER_141_35 VPWR VGND sg13cmos5l_decap_8
XFILLER_243_221 VPWR VGND sg13cmos5l_decap_4
XFILLER_70_101 VPWR VGND sg13cmos5l_decap_4
XFILLER_55_175 VPWR VGND sg13cmos5l_decap_8
XFILLER_70_145 VPWR VGND sg13cmos5l_decap_8
XANTENNA__2373__D Tile_X0Y2_FrameData[27] VPWR VGND sg13cmos5l_antennanp
XFILLER_70_156 VPWR VGND sg13cmos5l_fill_1
XANTENNA__1006__A2 Tile_X0Y0_S1END[2] VPWR VGND sg13cmos5l_antennanp
XFILLER_11_278 VPWR VGND sg13cmos5l_fill_1
XFILLER_109_144 VPWR VGND sg13cmos5l_decap_8
XANTENNA__1717__D Tile_X0Y0_FrameData[11] VPWR VGND sg13cmos5l_antennanp
XANTENNA__3782__A Tile_X0Y4_FrameData[4] VPWR VGND sg13cmos5l_antennanp
XFILLER_50_87 VPWR VGND sg13cmos5l_fill_2
XANTENNA__3241__GATE Tile_X0Y5_FrameStrobe[5] VPWR VGND sg13cmos5l_antennanp
XFILLER_124_147 VPWR VGND sg13cmos5l_decap_8
XFILLER_278_151 VPWR VGND sg13cmos5l_fill_2
XFILLER_59_74 VPWR VGND sg13cmos5l_decap_8
XANTENNA__1190__A1 Tile_X0Y1_W2MID[3] VPWR VGND sg13cmos5l_antennanp
XANTENNA__2548__D Tile_X0Y3_FrameData[28] VPWR VGND sg13cmos5l_antennanp
XFILLER_182_75 VPWR VGND sg13cmos5l_decap_8
XFILLER_293_132 VPWR VGND sg13cmos5l_decap_4
XFILLER_332_23 VPWR VGND sg13cmos5l_decap_8
XFILLER_332_12 VPWR VGND sg13cmos5l_fill_1
XANTENNA__3256__GATE Tile_X0Y5_FrameStrobe[6] VPWR VGND sg13cmos5l_antennanp
XFILLER_293_154 VPWR VGND sg13cmos5l_decap_8
XFILLER_93_237 VPWR VGND sg13cmos5l_fill_2
XFILLER_75_40 VPWR VGND sg13cmos5l_decap_4
XFILLER_332_56 VPWR VGND sg13cmos5l_fill_1
XFILLER_219_262 VPWR VGND sg13cmos5l_fill_2
XFILLER_219_273 VPWR VGND sg13cmos5l_decap_8
XFILLER_201_38 VPWR VGND sg13cmos5l_fill_1
XFILLER_61_134 VPWR VGND sg13cmos5l_decap_8
XANTENNA__2283__D Tile_X0Y2_FrameData[21] VPWR VGND sg13cmos5l_antennanp
XFILLER_201_49 VPWR VGND sg13cmos5l_decap_8
XFILLER_199_180 VPWR VGND sg13cmos5l_fill_1
X_1920_ _1920_/Q Tile_X0Y0_FrameData[0] Tile_X0Y5_FrameStrobe[6] VPWR VGND sg13cmos5l_dlhq_1
XFILLER_202_173 VPWR VGND sg13cmos5l_decap_8
XFILLER_202_184 VPWR VGND sg13cmos5l_fill_1
X_1851_ _1851_/Q Tile_X0Y0_FrameData[5] Tile_X0Y5_FrameStrobe[4] VPWR VGND sg13cmos5l_dlhq_1
X_0802_ _3825_/A Tile_X0Y5_W2END[5] _0773_/X _0790_/X _0656_/X _3228_/Q _3227_/Q VPWR
+ VGND sg13cmos5l_mux4_1
X_3521_ Tile_X0Y0_N4BEG[8] _3521_/A VPWR VGND sg13cmos5l_buf_1
X_1782_ _1782_/Q Tile_X0Y0_FrameData[10] Tile_X0Y5_FrameStrobe[2] VPWR VGND sg13cmos5l_dlhq_1
XANTENNA__0756__A1 Tile_X0Y3_WW4END[8] VPWR VGND sg13cmos5l_antennanp
XANTENNA__2450__GATE Tile_X0Y5_FrameStrobe[6] VPWR VGND sg13cmos5l_antennanp
X_0733_ _0734_/C _2786_/Q _1135_/X VPWR VGND sg13cmos5l_nor2_1
XFILLER_6_260 VPWR VGND sg13cmos5l_decap_8
XANTENNA__3209__GATE Tile_X0Y5_FrameStrobe[4] VPWR VGND sg13cmos5l_antennanp
XFILLER_226_35 VPWR VGND sg13cmos5l_decap_8
X_3452_ Tile_X0Y1_FrameData_O[20] Tile_X0Y1_FrameData[20] VPWR VGND sg13cmos5l_buf_1
X_0664_ _0664_/Y _1700_/Q _1699_/Q _1024_/X VPWR VGND sg13cmos5l_nor3_1
XFILLER_6_293 VPWR VGND sg13cmos5l_fill_2
X_2403_ _2403_/Q Tile_X0Y2_FrameData[29] Tile_X0Y5_FrameStrobe[5] VPWR VGND sg13cmos5l_dlhq_1
X_3383_ Tile_X0Y2_EE4BEG[1] _3383_/A VPWR VGND sg13cmos5l_buf_1
XANTENNA__2465__GATE Tile_X0Y5_FrameStrobe[7] VPWR VGND sg13cmos5l_antennanp
X_2334_ _2334_/Q Tile_X0Y2_FrameData[2] Tile_X0Y5_FrameStrobe[2] VPWR VGND sg13cmos5l_dlhq_1
X_0595_ _0595_/X _0594_/X _0593_/X _2179_/Q VPWR VGND sg13cmos5l_mux2_1
XANTENNA__1181__A1 Tile_X0Y1_W2MID[2] VPWR VGND sg13cmos5l_antennanp
XANTENNA__2458__D Tile_X0Y2_FrameData[6] VPWR VGND sg13cmos5l_antennanp
XFILLER_123_191 VPWR VGND sg13cmos5l_decap_8
XFILLER_27_0 VPWR VGND sg13cmos5l_fill_2
X_2265_ _2265_/Q Tile_X0Y2_FrameData[7] Tile_X0Y5_FrameStrobe[0] VPWR VGND sg13cmos5l_dlhq_1
X_2196_ _2196_/Q Tile_X0Y1_FrameData[28] Tile_X0Y5_FrameStrobe[7] VPWR VGND sg13cmos5l_dlhq_1
X_1216_ _1216_/X _1150_/X _1015_/X _1014_/X _1149_/X _2532_/Q _2531_/Q VPWR VGND sg13cmos5l_mux4_1
XFILLER_84_248 VPWR VGND sg13cmos5l_decap_8
XFILLER_1_92 VPWR VGND sg13cmos5l_fill_2
X_1147_ _1147_/X _3531_/A _1097_/X Tile_X0Y0_S2MID[2] Tile_X0Y0_S2END[2] _1716_/Q
+ _1715_/Q VPWR VGND sg13cmos5l_mux4_1
XFILLER_37_153 VPWR VGND sg13cmos5l_decap_8
XANTENNA__0692__A0 Tile_X0Y1_W1END[2] VPWR VGND sg13cmos5l_antennanp
XANTENNA__1484__A2 Tile_X0Y2_WW4END[15] VPWR VGND sg13cmos5l_antennanp
XFILLER_240_202 VPWR VGND sg13cmos5l_decap_8
XANTENNA__2193__D Tile_X0Y1_FrameData[31] VPWR VGND sg13cmos5l_antennanp
XANTENNA__3289__D Tile_X0Y5_FrameData[23] VPWR VGND sg13cmos5l_antennanp
XANTENNA__3867__A Tile_X0Y5_FrameData[8] VPWR VGND sg13cmos5l_antennanp
X_1078_ _1078_/X _3533_/A _1076_/X Tile_X0Y0_S2MID[4] Tile_X0Y0_S2END[4] _1712_/Q
+ _1711_/Q VPWR VGND sg13cmos5l_mux4_1
XANTENNA__1236__A2 AXI_M_SOC_WREADY VPWR VGND sg13cmos5l_antennanp
XANTENNA__2403__GATE Tile_X0Y5_FrameStrobe[5] VPWR VGND sg13cmos5l_antennanp
XANTENNA__2921__D Tile_X0Y4_FrameData[23] VPWR VGND sg13cmos5l_antennanp
XFILLER_267_31 VPWR VGND sg13cmos5l_fill_1
XFILLER_267_53 VPWR VGND sg13cmos5l_fill_2
XFILLER_339_199 VPWR VGND sg13cmos5l_decap_4
XANTENNA__2418__GATE Tile_X0Y5_FrameStrobe[5] VPWR VGND sg13cmos5l_antennanp
XANTENNA__0747__A1 Tile_X0Y5_WW4END[15] VPWR VGND sg13cmos5l_antennanp
XANTENNA__1539__A3 Tile_X0Y0_S4END[12] VPWR VGND sg13cmos5l_antennanp
XFILLER_106_103 VPWR VGND sg13cmos5l_decap_8
X_3719_ Tile_X0Y3_FrameData_O[22] Tile_X0Y3_FrameData[22] VPWR VGND sg13cmos5l_buf_1
XFILLER_136_35 VPWR VGND sg13cmos5l_decap_8
XFILLER_161_220 VPWR VGND sg13cmos5l_decap_8
XFILLER_20_68 VPWR VGND sg13cmos5l_decap_8
XFILLER_20_79 VPWR VGND sg13cmos5l_fill_2
XFILLER_96_28 VPWR VGND sg13cmos5l_decap_8
XANTENNA__2368__D Tile_X0Y2_FrameData[0] VPWR VGND sg13cmos5l_antennanp
XFILLER_275_110 VPWR VGND sg13cmos5l_fill_2
XFILLER_275_121 VPWR VGND sg13cmos5l_decap_4
XFILLER_45_21 VPWR VGND sg13cmos5l_decap_8
XANTENNA__1475__A2 AXI_M_SOC_RDATA17 VPWR VGND sg13cmos5l_antennanp
XFILLER_290_179 VPWR VGND sg13cmos5l_decap_4
XFILLER_43_134 VPWR VGND sg13cmos5l_decap_8
XANTENNA__3199__D Tile_X0Y5_FrameData[17] VPWR VGND sg13cmos5l_antennanp
XFILLER_231_224 VPWR VGND sg13cmos5l_fill_1
XFILLER_231_246 VPWR VGND sg13cmos5l_decap_8
XFILLER_45_98 VPWR VGND sg13cmos5l_decap_8
XFILLER_43_145 VPWR VGND sg13cmos5l_decap_4
XANTENNA__2831__D Tile_X0Y4_FrameData[17] VPWR VGND sg13cmos5l_antennanp
XFILLER_131_0 VPWR VGND sg13cmos5l_fill_2
XFILLER_196_183 VPWR VGND sg13cmos5l_decap_8
XFILLER_229_0 VPWR VGND sg13cmos5l_fill_2
XFILLER_61_64 VPWR VGND sg13cmos5l_decap_8
XANTENNA_8 Tile_X0Y5_N4END[6] VPWR VGND sg13cmos5l_antennanp
XANTENNA__3180__GATE Tile_X0Y5_FrameStrobe[3] VPWR VGND sg13cmos5l_antennanp
XFILLER_10_90 VPWR VGND sg13cmos5l_decap_4
XANTENNA__3195__GATE Tile_X0Y5_FrameStrobe[4] VPWR VGND sg13cmos5l_antennanp
XFILLER_105_191 VPWR VGND sg13cmos5l_decap_8
XFILLER_126_90 VPWR VGND sg13cmos5l_decap_8
XANTENNA__2278__D Tile_X0Y2_FrameData[26] VPWR VGND sg13cmos5l_antennanp
XFILLER_120_161 VPWR VGND sg13cmos5l_decap_8
XFILLER_86_72 VPWR VGND sg13cmos5l_fill_2
XFILLER_281_113 VPWR VGND sg13cmos5l_fill_1
X_2050_ _2050_/Q Tile_X0Y1_FrameData[14] Tile_X0Y5_FrameStrobe[2] VPWR VGND sg13cmos5l_dlhq_1
XFILLER_19_142 VPWR VGND sg13cmos5l_decap_4
X_1001_ _1001_/Y _3025_/Q _0998_/X _3024_/Q VPWR VGND sg13cmos5l_o21ai_1
XFILLER_81_218 VPWR VGND sg13cmos5l_fill_1
XANTENNA__1910__D Tile_X0Y0_FrameData[10] VPWR VGND sg13cmos5l_antennanp
XFILLER_34_123 VPWR VGND sg13cmos5l_decap_8
XFILLER_288_19 VPWR VGND sg13cmos5l_decap_4
X_2952_ _2952_/Q Tile_X0Y4_FrameData[24] Tile_X0Y5_FrameStrobe[5] VPWR VGND sg13cmos5l_dlhq_1
XANTENNA__3133__GATE Tile_X0Y5_FrameStrobe[2] VPWR VGND sg13cmos5l_antennanp
X_1903_ _1903_/Q Tile_X0Y0_FrameData[17] Tile_X0Y5_FrameStrobe[6] VPWR VGND sg13cmos5l_dlhq_1
XANTENNA__0977__A1 Tile_X0Y3_W6END[6] VPWR VGND sg13cmos5l_antennanp
XANTENNA__2741__D Tile_X0Y3_FrameData[27] VPWR VGND sg13cmos5l_antennanp
X_2883_ _2883_/Q Tile_X0Y4_FrameData[29] Tile_X0Y5_FrameStrobe[3] VPWR VGND sg13cmos5l_dlhq_1
X_1834_ _1834_/Q Tile_X0Y0_FrameData[22] Tile_X0Y5_FrameStrobe[4] VPWR VGND sg13cmos5l_dlhq_1
XFILLER_336_158 VPWR VGND sg13cmos5l_decap_8
XANTENNA__3148__GATE Tile_X0Y5_FrameStrobe[2] VPWR VGND sg13cmos5l_antennanp
X_1765_ _1765_/Q Tile_X0Y0_FrameData[27] Tile_X0Y5_FrameStrobe[2] VPWR VGND sg13cmos5l_dlhq_1
XFILLER_143_220 VPWR VGND sg13cmos5l_decap_8
X_3504_ Tile_X0Y1_E2BEG[4] _3504_/A VPWR VGND sg13cmos5l_buf_1
X_0716_ _0716_/Y _2241_/Q _0716_/B _0716_/C VPWR VGND sg13cmos5l_nor3_1
X_3435_ Tile_X0Y1_FrameData_O[3] Tile_X0Y1_FrameData[3] VPWR VGND sg13cmos5l_buf_1
X_1696_ _3892_/A Tile_X0Y5_W1END[1] Tile_X0Y5_W6END[9] _0645_/X _1022_/Y _3290_/Q
+ _3289_/Q VPWR VGND sg13cmos5l_mux4_1
XFILLER_253_11 VPWR VGND sg13cmos5l_fill_1
X_0647_ _0647_/X Tile_X0Y5_N1END[1] Tile_X0Y5_N4END[1] _1021_/B _0644_/X _3094_/Q
+ _3093_/Q VPWR VGND sg13cmos5l_mux4_1
XANTENNA__1154__A1 Tile_X0Y0_W6END[6] VPWR VGND sg13cmos5l_antennanp
X_3366_ Tile_X0Y2_E2BEGb[4] _3366_/A VPWR VGND sg13cmos5l_buf_1
X_0578_ _0578_/Y _2247_/Q _0578_/B _0578_/C VPWR VGND sg13cmos5l_nor3_1
XANTENNA__2188__D Tile_X0Y1_FrameData[4] VPWR VGND sg13cmos5l_antennanp
X_3297_ _3297_/Q Tile_X0Y5_FrameData[15] Tile_X0Y5_FrameStrobe[7] VPWR VGND sg13cmos5l_dlhq_1
X_2317_ _2317_/Q Tile_X0Y2_FrameData[19] Tile_X0Y5_FrameStrobe[2] VPWR VGND sg13cmos5l_dlhq_1
XFILLER_257_165 VPWR VGND sg13cmos5l_decap_8
XFILLER_300_283 VPWR VGND sg13cmos5l_fill_1
X_2248_ _2248_/Q Tile_X0Y2_FrameData[24] Tile_X0Y5_FrameStrobe[0] VPWR VGND sg13cmos5l_dlhq_1
XANTENNA__2916__D Tile_X0Y4_FrameData[28] VPWR VGND sg13cmos5l_antennanp
XANTENNA__1820__D Tile_X0Y0_FrameData[4] VPWR VGND sg13cmos5l_antennanp
XFILLER_25_123 VPWR VGND sg13cmos5l_decap_8
X_2179_ _2179_/Q Tile_X0Y1_FrameData[13] Tile_X0Y5_FrameStrobe[6] VPWR VGND sg13cmos5l_dlhq_1
XANTENNA__2342__GATE Tile_X0Y5_FrameStrobe[3] VPWR VGND sg13cmos5l_antennanp
XFILLER_280_190 VPWR VGND sg13cmos5l_decap_4
XANTENNA__1209__A2 Tile_X0Y0_WW4END[5] VPWR VGND sg13cmos5l_antennanp
XANTENNA__2972__GATE Tile_X0Y5_FrameStrobe[5] VPWR VGND sg13cmos5l_antennanp
XANTENNA__3597__A Tile_X0Y0_FrameData[28] VPWR VGND sg13cmos5l_antennanp
XFILLER_40_126 VPWR VGND sg13cmos5l_decap_8
XFILLER_185_109 VPWR VGND sg13cmos5l_decap_8
XFILLER_40_159 VPWR VGND sg13cmos5l_decap_8
XANTENNA__1090__A0 Tile_X0Y1_W2MID[4] VPWR VGND sg13cmos5l_antennanp
XANTENNA__2651__D Tile_X0Y3_FrameData[21] VPWR VGND sg13cmos5l_antennanp
XANTENNA__3884__X Tile_X0Y5_FrameData_O[25] VPWR VGND sg13cmos5l_antennanp
XFILLER_278_85 VPWR VGND sg13cmos5l_fill_1
XANTENNA__2357__GATE Tile_X0Y5_FrameStrobe[3] VPWR VGND sg13cmos5l_antennanp
XANTENNA__2987__GATE Tile_X0Y5_FrameStrobe[6] VPWR VGND sg13cmos5l_antennanp
XFILLER_119_272 VPWR VGND sg13cmos5l_decap_8
XFILLER_193_164 VPWR VGND sg13cmos5l_fill_1
XFILLER_119_283 VPWR VGND sg13cmos5l_fill_1
XANTENNA__2910__GATE Tile_X0Y5_FrameStrobe[3] VPWR VGND sg13cmos5l_antennanp
XFILLER_103_4 VPWR VGND sg13cmos5l_fill_1
XFILLER_134_286 VPWR VGND sg13cmos5l_fill_1
XFILLER_0_255 VPWR VGND sg13cmos5l_fill_2
XANTENNA__2098__D Tile_X0Y1_FrameData[30] VPWR VGND sg13cmos5l_antennanp
XANTENNA__2925__GATE Tile_X0Y5_FrameStrobe[4] VPWR VGND sg13cmos5l_antennanp
XFILLER_56_31 VPWR VGND sg13cmos5l_decap_8
XANTENNA__2826__D Tile_X0Y4_FrameData[22] VPWR VGND sg13cmos5l_antennanp
XFILLER_56_75 VPWR VGND sg13cmos5l_decap_8
XANTENNA__0656__A0 Tile_X0Y5_N2MID[5] VPWR VGND sg13cmos5l_antennanp
XANTENNA__1448__A2 AXI_M_SOC_RDATA20 VPWR VGND sg13cmos5l_antennanp
XANTENNA__1730__D Tile_X0Y0_FrameData[30] VPWR VGND sg13cmos5l_antennanp
XFILLER_179_0 VPWR VGND sg13cmos5l_fill_2
XFILLER_263_157 VPWR VGND sg13cmos5l_fill_2
XFILLER_56_270 VPWR VGND sg13cmos5l_fill_2
XFILLER_16_189 VPWR VGND sg13cmos5l_decap_8
XFILLER_31_115 VPWR VGND sg13cmos5l_decap_4
XFILLER_169_150 VPWR VGND sg13cmos5l_decap_4
XANTENNA__1081__A0 Tile_X0Y0_W1END[2] VPWR VGND sg13cmos5l_antennanp
XANTENNA__2561__D Tile_X0Y3_FrameData[15] VPWR VGND sg13cmos5l_antennanp
XANTENNA__3794__X Tile_X0Y4_FrameData_O[16] VPWR VGND sg13cmos5l_antennanp
XFILLER_338_11 VPWR VGND sg13cmos5l_fill_1
XFILLER_184_186 VPWR VGND sg13cmos5l_decap_8
XFILLER_338_88 VPWR VGND sg13cmos5l_decap_4
XFILLER_333_106 VPWR VGND sg13cmos5l_decap_8
X_1550_ AXI_M_SOC_ARADDR26 Tile_X0Y3_WW4END[2] Tile_X0Y3_WW4END[10] Tile_X0Y3_W6END[2]
+ _1524_/X _2612_/Q _2611_/Q VPWR VGND sg13cmos5l_mux4_1
XFILLER_125_242 VPWR VGND sg13cmos5l_decap_8
XANTENNA__1905__D Tile_X0Y0_FrameData[15] VPWR VGND sg13cmos5l_antennanp
X_1481_ _1481_/X _1313_/X _1379_/X _2446_/Q VPWR VGND sg13cmos5l_mux2_1
XFILLER_286_238 VPWR VGND sg13cmos5l_fill_1
X_3220_ _3220_/Q Tile_X0Y5_FrameData[28] Tile_X0Y5_FrameStrobe[5] VPWR VGND sg13cmos5l_dlhq_1
X_3151_ _3151_/Q Tile_X0Y5_FrameData[1] Tile_X0Y5_FrameStrobe[2] VPWR VGND sg13cmos5l_dlhq_1
XANTENNA__1687__A2 Tile_X0Y4_WW4END[13] VPWR VGND sg13cmos5l_antennanp
XFILLER_223_36 VPWR VGND sg13cmos5l_fill_1
XFILLER_239_176 VPWR VGND sg13cmos5l_decap_8
XFILLER_239_187 VPWR VGND sg13cmos5l_fill_2
X_2102_ _2102_/Q Tile_X0Y1_FrameData[26] Tile_X0Y5_FrameStrobe[4] VPWR VGND sg13cmos5l_dlhq_1
XANTENNA__2736__D Tile_X0Y3_FrameData[0] VPWR VGND sg13cmos5l_antennanp
XFILLER_223_58 VPWR VGND sg13cmos5l_decap_8
XFILLER_294_293 VPWR VGND sg13cmos5l_fill_2
X_3082_ _3082_/Q Tile_X0Y5_FrameData[6] Tile_X0Y5_FrameStrobe[0] VPWR VGND sg13cmos5l_dlhq_1
X_2033_ _2033_/Q Tile_X0Y1_FrameData[31] Tile_X0Y5_FrameStrobe[2] VPWR VGND sg13cmos5l_dlhq_1
XANTENNA__0647__A0 Tile_X0Y5_N1END[1] VPWR VGND sg13cmos5l_antennanp
XANTENNA__3072__GATE Tile_X0Y5_FrameStrobe[0] VPWR VGND sg13cmos5l_antennanp
XFILLER_62_273 VPWR VGND sg13cmos5l_fill_2
XFILLER_210_227 VPWR VGND sg13cmos5l_fill_2
XFILLER_94_0 VPWR VGND sg13cmos5l_fill_2
XANTENNA__1072__A0 Tile_X0Y5_W2MID[7] VPWR VGND sg13cmos5l_antennanp
XANTENNA__2471__D Tile_X0Y2_FrameData[25] VPWR VGND sg13cmos5l_antennanp
X_2935_ _2935_/Q Tile_X0Y4_FrameData[9] Tile_X0Y5_FrameStrobe[4] VPWR VGND sg13cmos5l_dlhq_1
XANTENNA__3087__GATE Tile_X0Y5_FrameStrobe[0] VPWR VGND sg13cmos5l_antennanp
XFILLER_248_33 VPWR VGND sg13cmos5l_decap_8
X_2866_ _2866_/Q Tile_X0Y4_FrameData[14] Tile_X0Y5_FrameStrobe[2] VPWR VGND sg13cmos5l_dlhq_1
XFILLER_175_153 VPWR VGND sg13cmos5l_fill_1
XFILLER_175_175 VPWR VGND sg13cmos5l_decap_8
XFILLER_248_77 VPWR VGND sg13cmos5l_decap_8
X_1817_ _1817_/Q Tile_X0Y0_FrameData[7] Tile_X0Y5_FrameStrobe[3] VPWR VGND sg13cmos5l_dlhq_1
X_2797_ _2797_/Q Tile_X0Y4_FrameData[19] Tile_X0Y5_FrameStrobe[0] VPWR VGND sg13cmos5l_dlhq_1
XANTENNA__3010__GATE Tile_X0Y5_FrameStrobe[7] VPWR VGND sg13cmos5l_antennanp
X_1748_ _1748_/Q Tile_X0Y0_FrameData[12] Tile_X0Y5_FrameStrobe[1] VPWR VGND sg13cmos5l_dlhq_1
XANTENNA__1815__D Tile_X0Y0_FrameData[9] VPWR VGND sg13cmos5l_antennanp
XANTENNA__3880__A Tile_X0Y5_FrameData[21] VPWR VGND sg13cmos5l_antennanp
XFILLER_131_223 VPWR VGND sg13cmos5l_fill_1
XFILLER_264_43 VPWR VGND sg13cmos5l_fill_2
X_1679_ _3749_/A Tile_X0Y4_W2END[0] AXI_M_SOC_RRESP0 _1073_/X _1361_/X _2946_/Q _2945_/Q
+ VPWR VGND sg13cmos5l_mux4_1
X_3418_ Tile_X0Y2_FrameData_O[20] Tile_X0Y2_FrameData[20] VPWR VGND sg13cmos5l_buf_1
XFILLER_131_278 VPWR VGND sg13cmos5l_fill_2
X_3349_ _3349_/Q Tile_X0Y5_FrameData[15] Tile_X0Y5_FrameStrobe[8] VPWR VGND sg13cmos5l_dlhq_1
XANTENNA__0886__A0 Tile_X0Y3_W1END[1] VPWR VGND sg13cmos5l_antennanp
XANTENNA__3025__GATE Tile_X0Y5_FrameStrobe[7] VPWR VGND sg13cmos5l_antennanp
XFILLER_133_36 VPWR VGND sg13cmos5l_decap_8
XFILLER_280_42 VPWR VGND sg13cmos5l_fill_1
XFILLER_97_181 VPWR VGND sg13cmos5l_decap_8
XANTENNA__3879__X Tile_X0Y5_FrameData_O[20] VPWR VGND sg13cmos5l_antennanp
XFILLER_277_8 VPWR VGND sg13cmos5l_fill_1
XFILLER_280_86 VPWR VGND sg13cmos5l_fill_1
XFILLER_285_293 VPWR VGND sg13cmos5l_fill_2
XFILLER_93_18 VPWR VGND sg13cmos5l_decap_8
XANTENNA__2281__GATE Tile_X0Y5_FrameStrobe[1] VPWR VGND sg13cmos5l_antennanp
XANTENNA__2646__D Tile_X0Y3_FrameData[26] VPWR VGND sg13cmos5l_antennanp
XFILLER_213_91 VPWR VGND sg13cmos5l_decap_4
XFILLER_198_223 VPWR VGND sg13cmos5l_decap_4
XANTENNA__2296__GATE Tile_X0Y5_FrameStrobe[1] VPWR VGND sg13cmos5l_antennanp
XANTENNA__2381__D Tile_X0Y2_FrameData[19] VPWR VGND sg13cmos5l_antennanp
XFILLER_9_119 VPWR VGND sg13cmos5l_decap_4
XANTENNA__0810__A0 Tile_X0Y5_WW4END[13] VPWR VGND sg13cmos5l_antennanp
XFILLER_315_128 VPWR VGND sg13cmos5l_decap_4
XFILLER_107_231 VPWR VGND sg13cmos5l_decap_8
XFILLER_107_242 VPWR VGND sg13cmos5l_fill_2
XFILLER_330_109 VPWR VGND sg13cmos5l_decap_4
XANTENNA__1725__D Tile_X0Y0_FrameData[3] VPWR VGND sg13cmos5l_antennanp
XANTENNA__3790__A Tile_X0Y4_FrameData[12] VPWR VGND sg13cmos5l_antennanp
XFILLER_122_223 VPWR VGND sg13cmos5l_decap_8
XFILLER_174_43 VPWR VGND sg13cmos5l_decap_4
XANTENNA__2234__GATE Tile_X0Y5_FrameStrobe[8] VPWR VGND sg13cmos5l_antennanp
XFILLER_268_249 VPWR VGND sg13cmos5l_fill_1
XANTENNA__2864__GATE Tile_X0Y5_FrameStrobe[2] VPWR VGND sg13cmos5l_antennanp
XFILLER_107_70 VPWR VGND sg13cmos5l_decap_8
XFILLER_296_0 VPWR VGND sg13cmos5l_fill_1
XFILLER_67_52 VPWR VGND sg13cmos5l_decap_8
XANTENNA__3789__X Tile_X0Y4_FrameData_O[11] VPWR VGND sg13cmos5l_antennanp
XFILLER_276_293 VPWR VGND sg13cmos5l_fill_2
XFILLER_67_85 VPWR VGND sg13cmos5l_decap_8
XANTENNA__2249__GATE Tile_X0Y5_FrameStrobe[0] VPWR VGND sg13cmos5l_antennanp
XANTENNA__2556__D Tile_X0Y3_FrameData[20] VPWR VGND sg13cmos5l_antennanp
XFILLER_291_241 VPWR VGND sg13cmos5l_fill_2
XANTENNA__0629__A0 Tile_X0Y2_W1END[1] VPWR VGND sg13cmos5l_antennanp
XANTENNA__2879__GATE Tile_X0Y5_FrameStrobe[2] VPWR VGND sg13cmos5l_antennanp
XFILLER_251_138 VPWR VGND sg13cmos5l_decap_8
XANTENNA__2291__D Tile_X0Y2_FrameData[13] VPWR VGND sg13cmos5l_antennanp
XANTENNA__2802__GATE Tile_X0Y5_FrameStrobe[0] VPWR VGND sg13cmos5l_antennanp
X_0981_ _0981_/X _1135_/X _0730_/X Tile_X0Y5_N4END[7] _0980_/X _2833_/Q _2834_/Q VPWR
+ VGND sg13cmos5l_mux4_1
XFILLER_12_170 VPWR VGND sg13cmos5l_decap_8
XFILLER_12_181 VPWR VGND sg13cmos5l_fill_1
XFILLER_157_142 VPWR VGND sg13cmos5l_decap_8
X_2720_ _2720_/Q Tile_X0Y3_FrameData[16] Tile_X0Y5_FrameStrobe[6] VPWR VGND sg13cmos5l_dlhq_1
XANTENNA__0801__A0 Tile_X0Y5_W2END[6] VPWR VGND sg13cmos5l_antennanp
XFILLER_172_101 VPWR VGND sg13cmos5l_fill_1
X_2651_ _2651_/Q Tile_X0Y3_FrameData[21] Tile_X0Y5_FrameStrobe[4] VPWR VGND sg13cmos5l_dlhq_1
XANTENNA__2817__GATE Tile_X0Y5_FrameStrobe[1] VPWR VGND sg13cmos5l_antennanp
XFILLER_200_293 VPWR VGND sg13cmos5l_fill_2
X_1602_ _1602_/X _1436_/X _1521_/X _0882_/X _1267_/X _2760_/Q _2759_/Q VPWR VGND sg13cmos5l_mux4_1
X_2582_ _2582_/Q Tile_X0Y3_FrameData[26] Tile_X0Y5_FrameStrobe[2] VPWR VGND sg13cmos5l_dlhq_1
X_1533_ _3674_/A AXI_M_SOC_RDATA7 _1512_/X _1434_/X _1219_/X _2629_/Q _2630_/Q VPWR
+ VGND sg13cmos5l_mux4_1
X_1464_ _3361_/A Tile_X0Y2_W2MID[0] AXI_M_SOC_RDATA21 _1157_/X _1179_/X _2418_/Q _2417_/Q
+ VPWR VGND sg13cmos5l_mux4_1
XANTENNA__1109__A1 Tile_X0Y2_W2END[7] VPWR VGND sg13cmos5l_antennanp
XFILLER_113_278 VPWR VGND sg13cmos5l_fill_2
X_3203_ _3203_/Q Tile_X0Y5_FrameData[13] Tile_X0Y5_FrameStrobe[4] VPWR VGND sg13cmos5l_dlhq_1
X_1395_ _3518_/A _1392_/Y _1394_/Y _1390_/Y VPWR VGND sg13cmos5l_o21ai_1
XANTENNA__3699__X Tile_X0Y3_FrameData_O[2] VPWR VGND sg13cmos5l_antennanp
XFILLER_267_293 VPWR VGND sg13cmos5l_fill_2
X_3134_ _3134_/Q Tile_X0Y5_FrameData[18] Tile_X0Y5_FrameStrobe[2] VPWR VGND sg13cmos5l_dlhq_1
XANTENNA__2466__D Tile_X0Y2_FrameData[30] VPWR VGND sg13cmos5l_antennanp
XFILLER_27_218 VPWR VGND sg13cmos5l_decap_8
X_3065_ _3065_/Q Tile_X0Y5_FrameData[23] Tile_X0Y5_FrameStrobe[0] VPWR VGND sg13cmos5l_dlhq_1
X_2016_ _2016_/Q Tile_X0Y1_FrameData[16] Tile_X0Y5_FrameStrobe[1] VPWR VGND sg13cmos5l_dlhq_1
XFILLER_35_284 VPWR VGND sg13cmos5l_fill_2
XANTENNA__3297__D Tile_X0Y5_FrameData[15] VPWR VGND sg13cmos5l_antennanp
XFILLER_50_265 VPWR VGND sg13cmos5l_decap_8
XFILLER_50_243 VPWR VGND sg13cmos5l_fill_1
XANTENNA__3875__A Tile_X0Y5_FrameData[16] VPWR VGND sg13cmos5l_antennanp
X_2918_ _2918_/Q Tile_X0Y4_FrameData[26] Tile_X0Y5_FrameStrobe[4] VPWR VGND sg13cmos5l_dlhq_1
X_3898_ Tile_X0Y5_S2BEG[3] _3898_/A VPWR VGND sg13cmos5l_buf_1
X_2849_ _2849_/Q Tile_X0Y4_FrameData[31] Tile_X0Y5_FrameStrobe[2] VPWR VGND sg13cmos5l_dlhq_1
XFILLER_337_286 VPWR VGND sg13cmos5l_fill_1
XFILLER_275_53 VPWR VGND sg13cmos5l_fill_2
XFILLER_104_234 VPWR VGND sg13cmos5l_decap_8
XFILLER_224_90 VPWR VGND sg13cmos5l_fill_2
XFILLER_258_293 VPWR VGND sg13cmos5l_fill_2
XFILLER_85_151 VPWR VGND sg13cmos5l_decap_4
XFILLER_37_33 VPWR VGND sg13cmos5l_fill_1
XANTENNA__2376__D Tile_X0Y2_FrameData[24] VPWR VGND sg13cmos5l_antennanp
XFILLER_160_23 VPWR VGND sg13cmos5l_fill_1
XFILLER_273_252 VPWR VGND sg13cmos5l_decap_8
XFILLER_37_44 VPWR VGND sg13cmos5l_decap_8
XANTENNA__3402__X Tile_X0Y2_FrameData_O[4] VPWR VGND sg13cmos5l_antennanp
XANTENNA__1284__A0 Tile_X0Y1_WW4END[1] VPWR VGND sg13cmos5l_antennanp
XFILLER_310_37 VPWR VGND sg13cmos5l_fill_1
XFILLER_53_21 VPWR VGND sg13cmos5l_decap_8
XANTENNA__3000__D Tile_X0Y4_FrameData[8] VPWR VGND sg13cmos5l_antennanp
XANTENNA__3785__A Tile_X0Y4_FrameData[7] VPWR VGND sg13cmos5l_antennanp
XFILLER_139_120 VPWR VGND sg13cmos5l_fill_2
XFILLER_53_98 VPWR VGND sg13cmos5l_decap_8
XFILLER_211_0 VPWR VGND sg13cmos5l_fill_2
XFILLER_319_68 VPWR VGND sg13cmos5l_fill_1
XFILLER_319_57 VPWR VGND sg13cmos5l_fill_1
XANTENNA__1339__A1 AXI_M_SOC_RDATA29 VPWR VGND sg13cmos5l_antennanp
XFILLER_309_0 VPWR VGND sg13cmos5l_fill_2
XANTENNA__2173__GATE Tile_X0Y5_FrameStrobe[6] VPWR VGND sg13cmos5l_antennanp
XFILLER_5_188 VPWR VGND sg13cmos5l_fill_1
XFILLER_335_34 VPWR VGND sg13cmos5l_decap_4
XFILLER_335_45 VPWR VGND sg13cmos5l_fill_1
XANTENNA__0562__A2 Tile_X0Y3_W2END[0] VPWR VGND sg13cmos5l_antennanp
XFILLER_311_164 VPWR VGND sg13cmos5l_fill_2
XFILLER_335_89 VPWR VGND sg13cmos5l_fill_1
XFILLER_335_78 VPWR VGND sg13cmos5l_fill_1
XANTENNA__2188__GATE Tile_X0Y5_FrameStrobe[6] VPWR VGND sg13cmos5l_antennanp
XFILLER_209_113 VPWR VGND sg13cmos5l_decap_8
XFILLER_249_293 VPWR VGND sg13cmos5l_fill_2
X_1180_ _3544_/A Tile_X0Y0_W2MID[0] Tile_X0Y0_W2END[0] Tile_X0Y0_W6END[0] _1136_/X
+ _1946_/Q _1945_/Q VPWR VGND sg13cmos5l_mux4_1
XFILLER_76_140 VPWR VGND sg13cmos5l_fill_2
XANTENNA__2286__D Tile_X0Y2_FrameData[18] VPWR VGND sg13cmos5l_antennanp
XFILLER_264_241 VPWR VGND sg13cmos5l_decap_8
XFILLER_264_252 VPWR VGND sg13cmos5l_fill_1
XFILLER_224_116 VPWR VGND sg13cmos5l_fill_1
XANTENNA__1275__A0 Tile_X0Y1_WW4END[14] VPWR VGND sg13cmos5l_antennanp
XANTENNA__2111__GATE Tile_X0Y5_FrameStrobe[4] VPWR VGND sg13cmos5l_antennanp
XFILLER_217_190 VPWR VGND sg13cmos5l_decap_8
XFILLER_220_15 VPWR VGND sg13cmos5l_fill_2
XFILLER_91_176 VPWR VGND sg13cmos5l_fill_2
XFILLER_91_165 VPWR VGND sg13cmos5l_decap_8
XANTENNA__2741__GATE Tile_X0Y5_FrameStrobe[7] VPWR VGND sg13cmos5l_antennanp
X_3821_ Tile_X0Y5_E2BEG[6] _3821_/A VPWR VGND sg13cmos5l_buf_1
XANTENNA__1027__A0 Tile_X0Y0_W1END[1] VPWR VGND sg13cmos5l_antennanp
XFILLER_319_220 VPWR VGND sg13cmos5l_decap_8
XANTENNA__2126__GATE Tile_X0Y5_FrameStrobe[4] VPWR VGND sg13cmos5l_antennanp
XFILLER_229_24 VPWR VGND sg13cmos5l_decap_4
X_3752_ Tile_X0Y4_E6BEG[2] _3752_/A VPWR VGND sg13cmos5l_buf_1
X_0964_ AXI_M_SOC_AWLEN5 _3337_/Q _0963_/X VPWR VGND sg13cmos5l_nor2b_1
XANTENNA__1042__A3 Tile_X0Y0_S4END[1] VPWR VGND sg13cmos5l_antennanp
XANTENNA__2756__GATE Tile_X0Y5_FrameStrobe[7] VPWR VGND sg13cmos5l_antennanp
X_2703_ _2703_/Q Tile_X0Y3_FrameData[1] Tile_X0Y5_FrameStrobe[5] VPWR VGND sg13cmos5l_dlhq_1
X_3683_ Tile_X0Y3_EE4BEG[2] _3683_/A VPWR VGND sg13cmos5l_buf_1
X_0895_ _0895_/Y _0895_/A VPWR VGND sg13cmos5l_inv_1
XFILLER_334_223 VPWR VGND sg13cmos5l_fill_2
XFILLER_319_286 VPWR VGND sg13cmos5l_fill_1
X_2634_ _2634_/Q Tile_X0Y3_FrameData[6] Tile_X0Y5_FrameStrobe[3] VPWR VGND sg13cmos5l_dlhq_1
XFILLER_145_178 VPWR VGND sg13cmos5l_decap_8
XFILLER_145_189 VPWR VGND sg13cmos5l_fill_2
X_2565_ _2565_/Q Tile_X0Y3_FrameData[11] Tile_X0Y5_FrameStrobe[1] VPWR VGND sg13cmos5l_dlhq_1
XFILLER_99_210 VPWR VGND sg13cmos5l_decap_8
XFILLER_57_0 VPWR VGND sg13cmos5l_decap_8
X_1516_ _3682_/A Tile_X0Y3_WW4END[14] AXI_M_SOC_RDATA7 _0888_/X _1348_/X _2670_/Q
+ _2669_/Q VPWR VGND sg13cmos5l_mux4_1
X_2496_ _2496_/Q Tile_X0Y2_FrameData[0] Tile_X0Y5_FrameStrobe[7] VPWR VGND sg13cmos5l_dlhq_1
X_1447_ _3387_/A Tile_X0Y2_WW4END[10] _1379_/X AXI_M_SOC_RDATA19 _1151_/X _2389_/Q
+ _2390_/Q VPWR VGND sg13cmos5l_mux4_1
XFILLER_261_44 VPWR VGND sg13cmos5l_decap_4
X_1378_ _3520_/A _1375_/Y _1377_/Y _1373_/Y VPWR VGND sg13cmos5l_o21ai_1
XANTENNA__1502__A1 AXI_M_SOC_RDATA13 VPWR VGND sg13cmos5l_antennanp
XANTENNA__2196__D Tile_X0Y1_FrameData[28] VPWR VGND sg13cmos5l_antennanp
X_3117_ _3117_/Q Tile_X0Y5_FrameData[3] Tile_X0Y5_FrameStrobe[1] VPWR VGND sg13cmos5l_dlhq_1
XANTENNA__1950__GATE Tile_X0Y5_FrameStrobe[7] VPWR VGND sg13cmos5l_antennanp
XFILLER_215_127 VPWR VGND sg13cmos5l_decap_8
XFILLER_130_15 VPWR VGND sg13cmos5l_decap_8
X_3048_ _3048_/Q Tile_X0Y4_FrameData[24] Tile_X0Y5_FrameStrobe[8] VPWR VGND sg13cmos5l_dlhq_1
XANTENNA__1266__A0 Tile_X0Y0_W2END[0] VPWR VGND sg13cmos5l_antennanp
XANTENNA__2709__GATE Tile_X0Y5_FrameStrobe[6] VPWR VGND sg13cmos5l_antennanp
XANTENNA__2924__D Tile_X0Y4_FrameData[20] VPWR VGND sg13cmos5l_antennanp
XFILLER_142_8 VPWR VGND sg13cmos5l_fill_2
XANTENNA__1018__A0 Tile_X0Y3_W1END[1] VPWR VGND sg13cmos5l_antennanp
XANTENNA__1965__GATE Tile_X0Y5_FrameStrobe[8] VPWR VGND sg13cmos5l_antennanp
XFILLER_168_248 VPWR VGND sg13cmos5l_decap_8
XFILLER_135_7 VPWR VGND sg13cmos5l_decap_8
XFILLER_139_24 VPWR VGND sg13cmos5l_fill_1
XANTENNA__3892__X Tile_X0Y5_S1BEG[1] VPWR VGND sg13cmos5l_antennanp
XFILLER_136_112 VPWR VGND sg13cmos5l_fill_1
XFILLER_286_85 VPWR VGND sg13cmos5l_fill_1
XFILLER_325_212 VPWR VGND sg13cmos5l_fill_2
XFILLER_325_201 VPWR VGND sg13cmos5l_decap_8
XANTENNA__0792__A2 Tile_X0Y4_W6END[11] VPWR VGND sg13cmos5l_antennanp
XFILLER_191_262 VPWR VGND sg13cmos5l_fill_1
XFILLER_155_67 VPWR VGND sg13cmos5l_decap_4
XANTENNA__1903__GATE Tile_X0Y5_FrameStrobe[6] VPWR VGND sg13cmos5l_antennanp
XFILLER_48_21 VPWR VGND sg13cmos5l_decap_8
XFILLER_58_151 VPWR VGND sg13cmos5l_fill_2
XFILLER_58_140 VPWR VGND sg13cmos5l_decap_8
XFILLER_171_66 VPWR VGND sg13cmos5l_fill_1
XFILLER_58_184 VPWR VGND sg13cmos5l_decap_8
XFILLER_48_98 VPWR VGND sg13cmos5l_decap_8
XANTENNA__1918__GATE Tile_X0Y5_FrameStrobe[6] VPWR VGND sg13cmos5l_antennanp
XFILLER_206_127 VPWR VGND sg13cmos5l_decap_4
XFILLER_321_14 VPWR VGND sg13cmos5l_fill_1
XFILLER_104_93 VPWR VGND sg13cmos5l_decap_4
XFILLER_73_176 VPWR VGND sg13cmos5l_decap_8
XFILLER_73_154 VPWR VGND sg13cmos5l_fill_1
XFILLER_64_64 VPWR VGND sg13cmos5l_decap_8
XANTENNA__1257__A0 Tile_X0Y0_W2MID[3] VPWR VGND sg13cmos5l_antennanp
XANTENNA__2834__D Tile_X0Y4_FrameData[14] VPWR VGND sg13cmos5l_antennanp
XFILLER_259_0 VPWR VGND sg13cmos5l_fill_2
XFILLER_73_187 VPWR VGND sg13cmos5l_fill_2
XANTENNA__1009__A0 Tile_X0Y1_W2MID[1] VPWR VGND sg13cmos5l_antennanp
XFILLER_80_63 VPWR VGND sg13cmos5l_decap_8
XFILLER_13_90 VPWR VGND sg13cmos5l_fill_1
XFILLER_182_251 VPWR VGND sg13cmos5l_fill_2
X_0680_ _0682_/B Tile_X0Y3_W6END[2] _2516_/Q VPWR VGND sg13cmos5l_nor2b_1
XFILLER_127_178 VPWR VGND sg13cmos5l_decap_4
XFILLER_89_50 VPWR VGND sg13cmos5l_decap_8
XFILLER_142_148 VPWR VGND sg13cmos5l_decap_8
XFILLER_331_237 VPWR VGND sg13cmos5l_decap_8
XFILLER_331_226 VPWR VGND sg13cmos5l_fill_1
X_2350_ _2350_/Q Tile_X0Y2_FrameData[18] Tile_X0Y5_FrameStrobe[3] VPWR VGND sg13cmos5l_dlhq_1
XANTENNA__1913__D Tile_X0Y0_FrameData[7] VPWR VGND sg13cmos5l_antennanp
XFILLER_296_163 VPWR VGND sg13cmos5l_fill_2
X_2281_ _2281_/Q Tile_X0Y2_FrameData[23] Tile_X0Y5_FrameStrobe[1] VPWR VGND sg13cmos5l_dlhq_1
X_1301_ AXI_M_SOC_AWADDR0 Tile_X0Y1_W2MID[0] Tile_X0Y1_W2END[0] Tile_X0Y1_W6END[0]
+ _1110_/X _2040_/Q _2039_/Q VPWR VGND sg13cmos5l_mux4_1
XFILLER_96_235 VPWR VGND sg13cmos5l_decap_8
X_1232_ _3608_/A Tile_X0Y0_WW4END[8] _1069_/X AXI_M_SOC_AWREADY _1145_/X _1841_/Q
+ _1842_/Q VPWR VGND sg13cmos5l_mux4_1
XFILLER_49_173 VPWR VGND sg13cmos5l_decap_8
XANTENNA__2050__GATE Tile_X0Y5_FrameStrobe[2] VPWR VGND sg13cmos5l_antennanp
X_1163_ _1163_/X Tile_X0Y0_W6END[10] _1006_/X _1007_/X _1147_/X _1936_/Q _1938_/Q
+ VPWR VGND sg13cmos5l_mux4_1
XANTENNA__2680__GATE Tile_X0Y5_FrameStrobe[5] VPWR VGND sg13cmos5l_antennanp
XFILLER_231_47 VPWR VGND sg13cmos5l_fill_1
XFILLER_231_58 VPWR VGND sg13cmos5l_fill_1
XFILLER_252_222 VPWR VGND sg13cmos5l_fill_1
X_1094_ _1094_/X _1092_/X _1093_/X _1091_/X Tile_X0Y0_S2MID[3] _1985_/Q _1986_/Q VPWR
+ VGND sg13cmos5l_mux4_1
XFILLER_64_176 VPWR VGND sg13cmos5l_fill_1
XFILLER_64_165 VPWR VGND sg13cmos5l_fill_2
XANTENNA__2744__D Tile_X0Y3_FrameData[24] VPWR VGND sg13cmos5l_antennanp
XANTENNA__2065__GATE Tile_X0Y5_FrameStrobe[3] VPWR VGND sg13cmos5l_antennanp
XANTENNA__2695__GATE Tile_X0Y5_FrameStrobe[5] VPWR VGND sg13cmos5l_antennanp
XFILLER_220_174 VPWR VGND sg13cmos5l_decap_8
XFILLER_220_185 VPWR VGND sg13cmos5l_fill_1
X_3804_ Tile_X0Y4_FrameData_O[26] Tile_X0Y4_FrameData[26] VPWR VGND sg13cmos5l_buf_1
X_1996_ _1996_/Q Tile_X0Y1_FrameData[4] Tile_X0Y5_FrameStrobe[0] VPWR VGND sg13cmos5l_dlhq_1
X_3735_ Tile_X0Y4_E2BEG[1] _3735_/A VPWR VGND sg13cmos5l_buf_1
X_0947_ _0947_/X _1138_/X _0568_/X _0918_/Y Tile_X0Y0_S4END[4] _2007_/Q _2008_/Q VPWR
+ VGND sg13cmos5l_mux4_1
XANTENNA__1420__A0 Tile_X0Y2_WW4END[1] VPWR VGND sg13cmos5l_antennanp
X_3666_ Tile_X0Y3_E2BEGb[5] _3666_/A VPWR VGND sg13cmos5l_buf_1
X_0878_ _0878_/Y _3114_/Q _0563_/X _0877_/Y VPWR VGND sg13cmos5l_a21oi_1
X_2617_ _2617_/Q Tile_X0Y3_FrameData[23] Tile_X0Y5_FrameStrobe[3] VPWR VGND sg13cmos5l_dlhq_1
X_3597_ Tile_X0Y0_FrameData_O[28] Tile_X0Y0_FrameData[28] VPWR VGND sg13cmos5l_buf_1
XANTENNA__2003__GATE Tile_X0Y5_FrameStrobe[1] VPWR VGND sg13cmos5l_antennanp
X_2548_ _2548_/Q Tile_X0Y3_FrameData[28] Tile_X0Y5_FrameStrobe[1] VPWR VGND sg13cmos5l_dlhq_1
XANTENNA__1823__D Tile_X0Y0_FrameData[1] VPWR VGND sg13cmos5l_antennanp
XANTENNA__2633__GATE Tile_X0Y5_FrameStrobe[3] VPWR VGND sg13cmos5l_antennanp
XANTENNA__2919__D Tile_X0Y4_FrameData[25] VPWR VGND sg13cmos5l_antennanp
XFILLER_125_48 VPWR VGND sg13cmos5l_decap_8
X_2479_ _2479_/Q Tile_X0Y2_FrameData[17] Tile_X0Y5_FrameStrobe[7] VPWR VGND sg13cmos5l_dlhq_1
XANTENNA__2018__GATE Tile_X0Y5_FrameStrobe[1] VPWR VGND sg13cmos5l_antennanp
XFILLER_141_14 VPWR VGND sg13cmos5l_decap_8
XANTENNA__2648__GATE Tile_X0Y5_FrameStrobe[4] VPWR VGND sg13cmos5l_antennanp
XANTENNA__1239__A0 Tile_X0Y0_WW4END[0] VPWR VGND sg13cmos5l_antennanp
XANTENNA__2654__D Tile_X0Y3_FrameData[18] VPWR VGND sg13cmos5l_antennanp
XANTENNA__3887__X Tile_X0Y5_FrameData_O[28] VPWR VGND sg13cmos5l_antennanp
XFILLER_70_113 VPWR VGND sg13cmos5l_decap_8
XFILLER_221_80 VPWR VGND sg13cmos5l_decap_8
XANTENNA__1200__X AXI_M_SOC_AWADDR9 VPWR VGND sg13cmos5l_antennanp
XFILLER_133_4 VPWR VGND sg13cmos5l_fill_1
XFILLER_156_207 VPWR VGND sg13cmos5l_decap_8
XFILLER_297_95 VPWR VGND sg13cmos5l_decap_4
XANTENNA__1006__A3 Tile_X0Y0_S4END[2] VPWR VGND sg13cmos5l_antennanp
XFILLER_149_270 VPWR VGND sg13cmos5l_fill_2
XFILLER_7_206 VPWR VGND sg13cmos5l_decap_4
XFILLER_50_22 VPWR VGND sg13cmos5l_decap_4
XANTENNA__1411__A0 Tile_X0Y2_WW4END[2] VPWR VGND sg13cmos5l_antennanp
XFILLER_50_55 VPWR VGND sg13cmos5l_fill_1
XFILLER_164_273 VPWR VGND sg13cmos5l_fill_2
XFILLER_124_126 VPWR VGND sg13cmos5l_decap_8
XFILLER_313_226 VPWR VGND sg13cmos5l_fill_2
XANTENNA__1842__GATE Tile_X0Y5_FrameStrobe[4] VPWR VGND sg13cmos5l_antennanp
XFILLER_59_42 VPWR VGND sg13cmos5l_decap_8
XFILLER_316_47 VPWR VGND sg13cmos5l_fill_1
XANTENNA__1733__D Tile_X0Y0_FrameData[27] VPWR VGND sg13cmos5l_antennanp
XANTENNA__2829__D Tile_X0Y4_FrameData[19] VPWR VGND sg13cmos5l_antennanp
XFILLER_182_32 VPWR VGND sg13cmos5l_decap_8
XFILLER_59_53 VPWR VGND sg13cmos5l_decap_8
XANTENNA__1190__A2 Tile_X0Y1_W2END[3] VPWR VGND sg13cmos5l_antennanp
XFILLER_278_185 VPWR VGND sg13cmos5l_decap_8
XFILLER_278_196 VPWR VGND sg13cmos5l_fill_1
XFILLER_78_257 VPWR VGND sg13cmos5l_decap_8
XANTENNA__1857__GATE Tile_X0Y5_FrameStrobe[5] VPWR VGND sg13cmos5l_antennanp
XFILLER_219_241 VPWR VGND sg13cmos5l_decap_8
XFILLER_219_252 VPWR VGND sg13cmos5l_fill_2
XFILLER_332_46 VPWR VGND sg13cmos5l_fill_1
XFILLER_219_285 VPWR VGND sg13cmos5l_fill_2
XFILLER_46_143 VPWR VGND sg13cmos5l_decap_8
XANTENNA__2564__D Tile_X0Y3_FrameData[12] VPWR VGND sg13cmos5l_antennanp
XANTENNA__3797__X Tile_X0Y4_FrameData_O[19] VPWR VGND sg13cmos5l_antennanp
XFILLER_61_113 VPWR VGND sg13cmos5l_decap_8
XFILLER_46_198 VPWR VGND sg13cmos5l_decap_8
XFILLER_91_73 VPWR VGND sg13cmos5l_decap_8
XFILLER_61_179 VPWR VGND sg13cmos5l_decap_8
XANTENNA__1650__A0 Tile_X0Y4_W2MID[0] VPWR VGND sg13cmos5l_antennanp
X_1850_ _1850_/Q Tile_X0Y0_FrameData[6] Tile_X0Y5_FrameStrobe[4] VPWR VGND sg13cmos5l_dlhq_1
X_1781_ _1781_/Q Tile_X0Y0_FrameData[11] Tile_X0Y5_FrameStrobe[2] VPWR VGND sg13cmos5l_dlhq_1
X_0801_ _3824_/A Tile_X0Y5_W2END[6] _0786_/X AXI_M_SOC_RVALID _0559_/X _3229_/Q _3230_/Q
+ VPWR VGND sg13cmos5l_mux4_1
XANTENNA__1402__A0 Tile_X0Y2_WW4END[1] VPWR VGND sg13cmos5l_antennanp
XANTENNA__1908__D Tile_X0Y0_FrameData[12] VPWR VGND sg13cmos5l_antennanp
X_3520_ Tile_X0Y0_N4BEG[7] _3520_/A VPWR VGND sg13cmos5l_buf_1
XANTENNA__0756__A2 Tile_X0Y3_W6END[8] VPWR VGND sg13cmos5l_antennanp
X_0732_ _0734_/B Tile_X0Y4_W6END[3] _2786_/Q VPWR VGND sg13cmos5l_nor2b_1
XFILLER_115_126 VPWR VGND sg13cmos5l_fill_2
X_3451_ Tile_X0Y1_FrameData_O[19] Tile_X0Y1_FrameData[19] VPWR VGND sg13cmos5l_buf_1
X_0663_ _0663_/Y _1700_/Q Tile_X0Y0_S1END[2] VPWR VGND sg13cmos5l_nand2b_1
XFILLER_226_69 VPWR VGND sg13cmos5l_fill_2
X_2402_ _2402_/Q Tile_X0Y2_FrameData[30] Tile_X0Y5_FrameStrobe[5] VPWR VGND sg13cmos5l_dlhq_1
X_3382_ Tile_X0Y2_EE4BEG[0] _3382_/A VPWR VGND sg13cmos5l_buf_1
X_0594_ _0594_/X Tile_X0Y1_W1END[0] _0919_/X Tile_X0Y1_WW4END[12] _0947_/X _2178_/Q
+ _2180_/Q VPWR VGND sg13cmos5l_mux4_1
XANTENNA__2739__D Tile_X0Y3_FrameData[29] VPWR VGND sg13cmos5l_antennanp
XFILLER_269_163 VPWR VGND sg13cmos5l_decap_8
X_2333_ _2333_/Q Tile_X0Y2_FrameData[3] Tile_X0Y5_FrameStrobe[2] VPWR VGND sg13cmos5l_dlhq_1
XANTENNA__1181__A2 Tile_X0Y1_W2END[2] VPWR VGND sg13cmos5l_antennanp
XFILLER_306_80 VPWR VGND sg13cmos5l_fill_2
X_2264_ _2264_/Q Tile_X0Y2_FrameData[8] Tile_X0Y5_FrameStrobe[0] VPWR VGND sg13cmos5l_dlhq_1
XANTENNA__1469__A0 Tile_X0Y2_WW4END[3] VPWR VGND sg13cmos5l_antennanp
XFILLER_242_57 VPWR VGND sg13cmos5l_fill_2
X_2195_ _2195_/Q Tile_X0Y1_FrameData[29] Tile_X0Y5_FrameStrobe[7] VPWR VGND sg13cmos5l_dlhq_1
X_1215_ _1587_/B _1186_/X _1129_/X _1128_/X _1185_/X _2530_/Q _2529_/Q VPWR VGND sg13cmos5l_mux4_1
XFILLER_77_290 VPWR VGND sg13cmos5l_decap_4
XFILLER_37_132 VPWR VGND sg13cmos5l_decap_8
XFILLER_1_60 VPWR VGND sg13cmos5l_fill_2
X_1146_ _3540_/A Tile_X0Y0_W2MID[4] Tile_X0Y0_W2END[4] Tile_X0Y0_W6END[4] _1148_/X
+ _1954_/Q _1953_/Q VPWR VGND sg13cmos5l_mux4_1
XANTENNA__2474__D Tile_X0Y2_FrameData[22] VPWR VGND sg13cmos5l_antennanp
XFILLER_92_293 VPWR VGND sg13cmos5l_fill_2
XANTENNA__3500__X Tile_X0Y1_E2BEG[0] VPWR VGND sg13cmos5l_antennanp
X_1077_ _3533_/A Tile_X0Y1_W2MID[3] Tile_X0Y1_W2END[3] Tile_X0Y1_W6END[3] _1089_/X
+ _2224_/Q _2223_/Q VPWR VGND sg13cmos5l_mux4_1
XANTENNA__0843__Y AXI_M_SOC_ARSIZE0 VPWR VGND sg13cmos5l_antennanp
XFILLER_52_179 VPWR VGND sg13cmos5l_decap_8
XANTENNA__1641__A0 Tile_X0Y4_WW4END[4] VPWR VGND sg13cmos5l_antennanp
XANTENNA__3301__GATE Tile_X0Y5_FrameStrobe[7] VPWR VGND sg13cmos5l_antennanp
XANTENNA__1818__D Tile_X0Y0_FrameData[6] VPWR VGND sg13cmos5l_antennanp
XANTENNA__3883__A Tile_X0Y5_FrameData[24] VPWR VGND sg13cmos5l_antennanp
X_1979_ _1979_/Q Tile_X0Y1_FrameData[21] Tile_X0Y5_FrameStrobe[0] VPWR VGND sg13cmos5l_dlhq_1
XANTENNA__3316__GATE Tile_X0Y5_FrameStrobe[8] VPWR VGND sg13cmos5l_antennanp
X_3718_ Tile_X0Y3_FrameData_O[21] Tile_X0Y3_FrameData[21] VPWR VGND sg13cmos5l_buf_1
XFILLER_136_14 VPWR VGND sg13cmos5l_decap_8
X_3649_ Tile_X0Y3_E1BEG[0] _3649_/A VPWR VGND sg13cmos5l_buf_1
XANTENNA__2572__GATE Tile_X0Y5_FrameStrobe[1] VPWR VGND sg13cmos5l_antennanp
XFILLER_106_159 VPWR VGND sg13cmos5l_decap_8
XFILLER_161_265 VPWR VGND sg13cmos5l_fill_1
XFILLER_283_64 VPWR VGND sg13cmos5l_decap_4
XANTENNA__2649__D Tile_X0Y3_FrameData[23] VPWR VGND sg13cmos5l_antennanp
XFILLER_283_86 VPWR VGND sg13cmos5l_fill_1
XFILLER_152_13 VPWR VGND sg13cmos5l_fill_1
XANTENNA__2587__GATE Tile_X0Y5_FrameStrobe[2] VPWR VGND sg13cmos5l_antennanp
XFILLER_90_219 VPWR VGND sg13cmos5l_decap_8
XANTENNA__1475__A3 AXI_M_SOC_RDATA21 VPWR VGND sg13cmos5l_antennanp
XANTENNA__2384__D Tile_X0Y2_FrameData[16] VPWR VGND sg13cmos5l_antennanp
XFILLER_28_187 VPWR VGND sg13cmos5l_decap_8
XFILLER_83_293 VPWR VGND sg13cmos5l_fill_2
XANTENNA__2510__GATE Tile_X0Y5_FrameStrobe[8] VPWR VGND sg13cmos5l_antennanp
XANTENNA__3410__X Tile_X0Y2_FrameData_O[12] VPWR VGND sg13cmos5l_antennanp
XFILLER_188_118 VPWR VGND sg13cmos5l_decap_8
XFILLER_45_77 VPWR VGND sg13cmos5l_decap_8
XFILLER_101_61 VPWR VGND sg13cmos5l_fill_1
XANTENNA__1632__A0 Tile_X0Y4_WW4END[0] VPWR VGND sg13cmos5l_antennanp
XFILLER_196_162 VPWR VGND sg13cmos5l_decap_8
XFILLER_61_43 VPWR VGND sg13cmos5l_decap_8
XANTENNA__0986__A2 Tile_X0Y1_W6END[7] VPWR VGND sg13cmos5l_antennanp
XANTENNA__1728__D Tile_X0Y0_FrameData[0] VPWR VGND sg13cmos5l_antennanp
XANTENNA__2525__GATE Tile_X0Y5_FrameStrobe[0] VPWR VGND sg13cmos5l_antennanp
XANTENNA__3793__A Tile_X0Y4_FrameData[15] VPWR VGND sg13cmos5l_antennanp
XFILLER_177_54 VPWR VGND sg13cmos5l_decap_4
XANTENNA__0738__A2 Tile_X0Y1_WW4END[15] VPWR VGND sg13cmos5l_antennanp
XFILLER_177_87 VPWR VGND sg13cmos5l_decap_8
XFILLER_177_98 VPWR VGND sg13cmos5l_fill_1
XFILLER_6_49 VPWR VGND sg13cmos5l_decap_8
XANTENNA__1781__GATE Tile_X0Y5_FrameStrobe[2] VPWR VGND sg13cmos5l_antennanp
XANTENNA__2559__D Tile_X0Y3_FrameData[17] VPWR VGND sg13cmos5l_antennanp
XFILLER_105_170 VPWR VGND sg13cmos5l_decap_8
XFILLER_298_269 VPWR VGND sg13cmos5l_decap_8
XANTENNA__1796__GATE Tile_X0Y5_FrameStrobe[3] VPWR VGND sg13cmos5l_antennanp
XFILLER_120_140 VPWR VGND sg13cmos5l_decap_8
XFILLER_266_133 VPWR VGND sg13cmos5l_fill_1
XFILLER_266_155 VPWR VGND sg13cmos5l_decap_8
XFILLER_19_110 VPWR VGND sg13cmos5l_fill_2
XFILLER_266_188 VPWR VGND sg13cmos5l_decap_4
XFILLER_66_238 VPWR VGND sg13cmos5l_fill_2
X_1000_ _1000_/Y _3026_/Q _1016_/X _0999_/Y VPWR VGND sg13cmos5l_a21oi_1
XANTENNA__2294__D Tile_X0Y2_FrameData[10] VPWR VGND sg13cmos5l_antennanp
XFILLER_207_277 VPWR VGND sg13cmos5l_fill_2
XFILLER_74_293 VPWR VGND sg13cmos5l_fill_2
XANTENNA__1218__A3 Tile_X0Y0_S4END[5] VPWR VGND sg13cmos5l_antennanp
X_2951_ _2951_/Q Tile_X0Y4_FrameData[25] Tile_X0Y5_FrameStrobe[5] VPWR VGND sg13cmos5l_dlhq_1
XANTENNA__1623__A0 Tile_X0Y5_N4END[5] VPWR VGND sg13cmos5l_antennanp
XANTENNA__1734__GATE Tile_X0Y5_FrameStrobe[1] VPWR VGND sg13cmos5l_antennanp
X_1902_ _1902_/Q Tile_X0Y0_FrameData[18] Tile_X0Y5_FrameStrobe[6] VPWR VGND sg13cmos5l_dlhq_1
X_2882_ _2882_/Q Tile_X0Y4_FrameData[30] Tile_X0Y5_FrameStrobe[3] VPWR VGND sg13cmos5l_dlhq_1
XFILLER_336_115 VPWR VGND sg13cmos5l_fill_2
X_1833_ _1833_/Q Tile_X0Y0_FrameData[23] Tile_X0Y5_FrameStrobe[4] VPWR VGND sg13cmos5l_dlhq_1
XANTENNA__1749__GATE Tile_X0Y5_FrameStrobe[1] VPWR VGND sg13cmos5l_antennanp
XFILLER_128_251 VPWR VGND sg13cmos5l_decap_8
XFILLER_128_262 VPWR VGND sg13cmos5l_fill_2
X_1764_ _1764_/Q Tile_X0Y0_FrameData[28] Tile_X0Y5_FrameStrobe[2] VPWR VGND sg13cmos5l_dlhq_1
X_3503_ Tile_X0Y1_E2BEG[3] _3503_/A VPWR VGND sg13cmos5l_buf_1
X_0715_ _0716_/C _1970_/Q _1123_/X VPWR VGND sg13cmos5l_nor2_1
X_3434_ Tile_X0Y1_FrameData_O[2] Tile_X0Y1_FrameData[2] VPWR VGND sg13cmos5l_buf_1
X_1695_ _3896_/A Tile_X0Y5_W2MID[6] Tile_X0Y5_W2END[6] Tile_X0Y5_W6END[9] _0786_/X
+ _3282_/Q _3281_/Q VPWR VGND sg13cmos5l_mux4_1
XANTENNA__2469__D Tile_X0Y2_FrameData[27] VPWR VGND sg13cmos5l_antennanp
XFILLER_103_118 VPWR VGND sg13cmos5l_decap_8
X_0646_ _0646_/X Tile_X0Y5_N1END[1] Tile_X0Y5_N4END[1] _1021_/B _0644_/X _3102_/Q
+ _3101_/Q VPWR VGND sg13cmos5l_mux4_1
XFILLER_106_39 VPWR VGND sg13cmos5l_decap_4
X_3365_ Tile_X0Y2_E2BEGb[3] _3365_/A VPWR VGND sg13cmos5l_buf_1
X_0577_ _0578_/C _2248_/Q _1051_/X VPWR VGND sg13cmos5l_nor2_1
XFILLER_257_133 VPWR VGND sg13cmos5l_decap_8
X_3296_ _3296_/Q Tile_X0Y5_FrameData[16] Tile_X0Y5_FrameStrobe[7] VPWR VGND sg13cmos5l_dlhq_1
X_2316_ _2316_/Q Tile_X0Y2_FrameData[20] Tile_X0Y5_FrameStrobe[2] VPWR VGND sg13cmos5l_dlhq_1
X_2247_ _2247_/Q Tile_X0Y2_FrameData[25] Tile_X0Y5_FrameStrobe[0] VPWR VGND sg13cmos5l_dlhq_1
XFILLER_57_238 VPWR VGND sg13cmos5l_decap_4
XFILLER_272_125 VPWR VGND sg13cmos5l_decap_8
XANTENNA__3878__A Tile_X0Y5_FrameData[19] VPWR VGND sg13cmos5l_antennanp
X_2178_ _2178_/Q Tile_X0Y1_FrameData[14] Tile_X0Y5_FrameStrobe[6] VPWR VGND sg13cmos5l_dlhq_1
XFILLER_65_293 VPWR VGND sg13cmos5l_fill_2
X_1129_ _1129_/X Tile_X0Y5_W2MID[4] Tile_X0Y5_W2END[4] Tile_X0Y5_W6END[4] _0794_/X
+ _3314_/Q _3313_/Q VPWR VGND sg13cmos5l_mux4_1
XANTENNA__3240__GATE Tile_X0Y5_FrameStrobe[5] VPWR VGND sg13cmos5l_antennanp
XFILLER_25_168 VPWR VGND sg13cmos5l_decap_8
XFILLER_80_274 VPWR VGND sg13cmos5l_decap_8
XFILLER_40_105 VPWR VGND sg13cmos5l_decap_4
XANTENNA__1614__A0 Tile_X0Y4_WW4END[10] VPWR VGND sg13cmos5l_antennanp
XANTENNA__2932__D Tile_X0Y4_FrameData[12] VPWR VGND sg13cmos5l_antennanp
XANTENNA__1090__A1 Tile_X0Y1_W2END[4] VPWR VGND sg13cmos5l_antennanp
XFILLER_178_173 VPWR VGND sg13cmos5l_fill_1
XFILLER_178_195 VPWR VGND sg13cmos5l_decap_8
XFILLER_193_121 VPWR VGND sg13cmos5l_decap_4
XFILLER_31_13 VPWR VGND sg13cmos5l_decap_8
XANTENNA__3255__GATE Tile_X0Y5_FrameStrobe[6] VPWR VGND sg13cmos5l_antennanp
XFILLER_294_30 VPWR VGND sg13cmos5l_fill_2
XFILLER_335_181 VPWR VGND sg13cmos5l_fill_2
XFILLER_134_254 VPWR VGND sg13cmos5l_fill_1
XANTENNA__2379__D Tile_X0Y2_FrameData[21] VPWR VGND sg13cmos5l_antennanp
XFILLER_134_276 VPWR VGND sg13cmos5l_decap_4
XANTENNA__1145__A2 Tile_X0Y0_S2MID[0] VPWR VGND sg13cmos5l_antennanp
XANTENNA__3405__X Tile_X0Y2_FrameData_O[7] VPWR VGND sg13cmos5l_antennanp
XFILLER_313_15 VPWR VGND sg13cmos5l_fill_1
XFILLER_56_21 VPWR VGND sg13cmos5l_decap_8
XFILLER_56_54 VPWR VGND sg13cmos5l_decap_8
XANTENNA__3788__A Tile_X0Y4_FrameData[10] VPWR VGND sg13cmos5l_antennanp
XFILLER_16_102 VPWR VGND sg13cmos5l_decap_4
XANTENNA__0656__A1 Tile_X0Y5_N2END[5] VPWR VGND sg13cmos5l_antennanp
XANTENNA__3003__D Tile_X0Y4_FrameData[5] VPWR VGND sg13cmos5l_antennanp
XFILLER_16_135 VPWR VGND sg13cmos5l_fill_1
XFILLER_16_146 VPWR VGND sg13cmos5l_decap_8
XFILLER_204_203 VPWR VGND sg13cmos5l_decap_8
XFILLER_56_293 VPWR VGND sg13cmos5l_fill_2
XANTENNA__3208__GATE Tile_X0Y5_FrameStrobe[4] VPWR VGND sg13cmos5l_antennanp
XANTENNA__2842__D Tile_X0Y4_FrameData[6] VPWR VGND sg13cmos5l_antennanp
XFILLER_241_0 VPWR VGND sg13cmos5l_fill_2
XFILLER_339_0 VPWR VGND sg13cmos5l_fill_2
XANTENNA__2464__GATE Tile_X0Y5_FrameStrobe[6] VPWR VGND sg13cmos5l_antennanp
XANTENNA__1081__A1 Tile_X0Y0_W2MID[1] VPWR VGND sg13cmos5l_antennanp
XANTENNA__2479__GATE Tile_X0Y5_FrameStrobe[7] VPWR VGND sg13cmos5l_antennanp
XFILLER_68_8 VPWR VGND sg13cmos5l_decap_8
XANTENNA__0592__A0 Tile_X0Y4_W1END[0] VPWR VGND sg13cmos5l_antennanp
XANTENNA__2289__D Tile_X0Y2_FrameData[15] VPWR VGND sg13cmos5l_antennanp
X_1480_ _1480_/Y _2446_/Q _1175_/X _1479_/Y VPWR VGND sg13cmos5l_a21oi_1
XANTENNA__2402__GATE Tile_X0Y5_FrameStrobe[5] VPWR VGND sg13cmos5l_antennanp
XANTENNA__1136__A2 Tile_X0Y0_S2MID[7] VPWR VGND sg13cmos5l_antennanp
X_3150_ _3150_/Q Tile_X0Y5_FrameData[2] Tile_X0Y5_FrameStrobe[2] VPWR VGND sg13cmos5l_dlhq_1
X_3081_ _3081_/Q Tile_X0Y5_FrameData[7] Tile_X0Y5_FrameStrobe[0] VPWR VGND sg13cmos5l_dlhq_1
X_2101_ _2101_/Q Tile_X0Y1_FrameData[27] Tile_X0Y5_FrameStrobe[4] VPWR VGND sg13cmos5l_dlhq_1
XANTENNA__1921__D Tile_X0Y0_FrameData[31] VPWR VGND sg13cmos5l_antennanp
X_2032_ _2032_/Q Tile_X0Y1_FrameData[0] Tile_X0Y5_FrameStrobe[1] VPWR VGND sg13cmos5l_dlhq_1
XFILLER_54_208 VPWR VGND sg13cmos5l_decap_8
XANTENNA__2417__GATE Tile_X0Y5_FrameStrobe[5] VPWR VGND sg13cmos5l_antennanp
XANTENNA__3698__A Tile_X0Y3_FrameData[1] VPWR VGND sg13cmos5l_antennanp
XFILLER_47_271 VPWR VGND sg13cmos5l_fill_2
XANTENNA__0647__A1 Tile_X0Y5_N4END[1] VPWR VGND sg13cmos5l_antennanp
XFILLER_62_241 VPWR VGND sg13cmos5l_decap_4
XFILLER_262_180 VPWR VGND sg13cmos5l_decap_8
XANTENNA__2752__D Tile_X0Y3_FrameData[16] VPWR VGND sg13cmos5l_antennanp
X_2934_ _2934_/Q Tile_X0Y4_FrameData[10] Tile_X0Y5_FrameStrobe[4] VPWR VGND sg13cmos5l_dlhq_1
XFILLER_87_0 VPWR VGND sg13cmos5l_decap_8
XANTENNA__1072__A1 Tile_X0Y5_W2END[7] VPWR VGND sg13cmos5l_antennanp
XFILLER_175_132 VPWR VGND sg13cmos5l_decap_8
X_2865_ _2865_/Q Tile_X0Y4_FrameData[15] Tile_X0Y5_FrameStrobe[2] VPWR VGND sg13cmos5l_dlhq_1
XFILLER_30_193 VPWR VGND sg13cmos5l_decap_8
X_1816_ _1816_/Q Tile_X0Y0_FrameData[8] Tile_X0Y5_FrameStrobe[3] VPWR VGND sg13cmos5l_dlhq_1
XFILLER_190_113 VPWR VGND sg13cmos5l_decap_8
X_2796_ _2796_/Q Tile_X0Y4_FrameData[20] Tile_X0Y5_FrameStrobe[0] VPWR VGND sg13cmos5l_dlhq_1
XFILLER_190_168 VPWR VGND sg13cmos5l_fill_1
X_1747_ _1747_/Q Tile_X0Y0_FrameData[13] Tile_X0Y5_FrameStrobe[1] VPWR VGND sg13cmos5l_dlhq_1
X_1678_ _3748_/A Tile_X0Y4_W2END[1] AXI_M_SOC_RRESP1 _1049_/X _1360_/X _2948_/Q _2947_/Q
+ VPWR VGND sg13cmos5l_mux4_1
XANTENNA__2199__D Tile_X0Y1_FrameData[25] VPWR VGND sg13cmos5l_antennanp
X_3417_ Tile_X0Y2_FrameData_O[19] Tile_X0Y2_FrameData[19] VPWR VGND sg13cmos5l_buf_1
X_0629_ _0629_/X Tile_X0Y2_W1END[1] Tile_X0Y2_W6END[9] _1025_/X _0628_/X _2474_/Q
+ _2473_/Q VPWR VGND sg13cmos5l_mux4_1
XFILLER_89_149 VPWR VGND sg13cmos5l_decap_8
XANTENNA__1127__A2 Tile_X0Y5_N4END[7] VPWR VGND sg13cmos5l_antennanp
X_3348_ _3348_/Q Tile_X0Y5_FrameData[14] Tile_X0Y5_FrameStrobe[8] VPWR VGND sg13cmos5l_dlhq_1
XFILLER_97_160 VPWR VGND sg13cmos5l_decap_8
XANTENNA__0886__A1 Tile_X0Y3_WW4END[13] VPWR VGND sg13cmos5l_antennanp
XANTENNA__2927__D Tile_X0Y4_FrameData[17] VPWR VGND sg13cmos5l_antennanp
XFILLER_133_15 VPWR VGND sg13cmos5l_decap_8
XANTENNA__1831__D Tile_X0Y0_FrameData[25] VPWR VGND sg13cmos5l_antennanp
X_3279_ _3279_/Q Tile_X0Y5_FrameData[1] Tile_X0Y5_FrameStrobe[6] VPWR VGND sg13cmos5l_dlhq_1
XFILLER_198_202 VPWR VGND sg13cmos5l_decap_8
XANTENNA__3401__A Tile_X0Y2_FrameData[3] VPWR VGND sg13cmos5l_antennanp
XFILLER_26_68 VPWR VGND sg13cmos5l_fill_2
XFILLER_289_30 VPWR VGND sg13cmos5l_fill_2
XFILLER_289_63 VPWR VGND sg13cmos5l_fill_1
XANTENNA__2662__D Tile_X0Y3_FrameData[10] VPWR VGND sg13cmos5l_antennanp
XANTENNA__3895__X Tile_X0Y5_S2BEG[0] VPWR VGND sg13cmos5l_antennanp
XFILLER_289_74 VPWR VGND sg13cmos5l_fill_2
XANTENNA__3194__GATE Tile_X0Y5_FrameStrobe[4] VPWR VGND sg13cmos5l_antennanp
XFILLER_166_165 VPWR VGND sg13cmos5l_decap_8
XFILLER_42_89 VPWR VGND sg13cmos5l_decap_8
XFILLER_107_210 VPWR VGND sg13cmos5l_decap_8
XFILLER_308_181 VPWR VGND sg13cmos5l_fill_2
XANTENNA__0574__A0 Tile_X0Y1_W1END[0] VPWR VGND sg13cmos5l_antennanp
XFILLER_107_265 VPWR VGND sg13cmos5l_decap_4
XFILLER_268_228 VPWR VGND sg13cmos5l_fill_1
XANTENNA__3132__GATE Tile_X0Y5_FrameStrobe[2] VPWR VGND sg13cmos5l_antennanp
XFILLER_88_160 VPWR VGND sg13cmos5l_decap_4
XFILLER_67_31 VPWR VGND sg13cmos5l_decap_8
XANTENNA__2837__D Tile_X0Y4_FrameData[11] VPWR VGND sg13cmos5l_antennanp
XFILLER_190_21 VPWR VGND sg13cmos5l_decap_8
XFILLER_191_0 VPWR VGND sg13cmos5l_fill_2
XFILLER_289_0 VPWR VGND sg13cmos5l_fill_2
XANTENNA__1741__D Tile_X0Y0_FrameData[19] VPWR VGND sg13cmos5l_antennanp
XFILLER_236_114 VPWR VGND sg13cmos5l_decap_8
XFILLER_236_125 VPWR VGND sg13cmos5l_fill_1
XANTENNA__0629__A1 Tile_X0Y2_W6END[9] VPWR VGND sg13cmos5l_antennanp
XANTENNA__3147__GATE Tile_X0Y5_FrameStrobe[2] VPWR VGND sg13cmos5l_antennanp
XFILLER_123_81 VPWR VGND sg13cmos5l_decap_8
XFILLER_29_293 VPWR VGND sg13cmos5l_fill_2
XFILLER_83_96 VPWR VGND sg13cmos5l_decap_8
XFILLER_83_74 VPWR VGND sg13cmos5l_fill_1
XFILLER_83_63 VPWR VGND sg13cmos5l_decap_8
XFILLER_44_274 VPWR VGND sg13cmos5l_decap_8
XANTENNA__2572__D Tile_X0Y3_FrameData[4] VPWR VGND sg13cmos5l_antennanp
X_0980_ _0980_/X _0979_/X _0978_/X _1898_/Q VPWR VGND sg13cmos5l_mux2_1
XFILLER_157_121 VPWR VGND sg13cmos5l_decap_8
XFILLER_200_250 VPWR VGND sg13cmos5l_fill_2
XFILLER_80_7 VPWR VGND sg13cmos5l_decap_8
X_2650_ _2650_/Q Tile_X0Y3_FrameData[22] Tile_X0Y5_FrameStrobe[4] VPWR VGND sg13cmos5l_dlhq_1
XFILLER_157_187 VPWR VGND sg13cmos5l_decap_4
X_1601_ _3917_/A _1598_/Y _1600_/Y _1596_/Y VPWR VGND sg13cmos5l_o21ai_1
XANTENNA__1357__A2 Tile_X0Y5_N4END[12] VPWR VGND sg13cmos5l_antennanp
XANTENNA__1916__D Tile_X0Y0_FrameData[4] VPWR VGND sg13cmos5l_antennanp
XFILLER_218_48 VPWR VGND sg13cmos5l_decap_8
X_2581_ _2581_/Q Tile_X0Y3_FrameData[27] Tile_X0Y5_FrameStrobe[2] VPWR VGND sg13cmos5l_dlhq_1
XFILLER_172_179 VPWR VGND sg13cmos5l_decap_8
X_1532_ _3690_/A Tile_X0Y3_WW4END[6] AXI_M_SOC_RDATA12 _1434_/X _1348_/X _2654_/Q
+ _2653_/Q VPWR VGND sg13cmos5l_mux4_1
XANTENNA__2341__GATE Tile_X0Y5_FrameStrobe[3] VPWR VGND sg13cmos5l_antennanp
XANTENNA__2971__GATE Tile_X0Y5_FrameStrobe[5] VPWR VGND sg13cmos5l_antennanp
X_1463_ _3369_/A Tile_X0Y2_W2END[0] AXI_M_SOC_RDATA14 _1157_/X _1179_/X _2402_/Q _2401_/Q
+ VPWR VGND sg13cmos5l_mux4_1
XANTENNA__1109__A2 Tile_X0Y2_W6END[7] VPWR VGND sg13cmos5l_antennanp
XFILLER_234_36 VPWR VGND sg13cmos5l_fill_2
XFILLER_234_58 VPWR VGND sg13cmos5l_decap_4
X_3202_ _3202_/Q Tile_X0Y5_FrameData[14] Tile_X0Y5_FrameStrobe[4] VPWR VGND sg13cmos5l_dlhq_1
XANTENNA__2747__D Tile_X0Y3_FrameData[21] VPWR VGND sg13cmos5l_antennanp
X_1394_ _1394_/Y _2484_/Q _1393_/X _2483_/Q VPWR VGND sg13cmos5l_o21ai_1
XANTENNA__2356__GATE Tile_X0Y5_FrameStrobe[3] VPWR VGND sg13cmos5l_antennanp
X_3133_ _3133_/Q Tile_X0Y5_FrameData[19] Tile_X0Y5_FrameStrobe[2] VPWR VGND sg13cmos5l_dlhq_1
XANTENNA__2986__GATE Tile_X0Y5_FrameStrobe[6] VPWR VGND sg13cmos5l_antennanp
XFILLER_103_29 VPWR VGND sg13cmos5l_decap_8
X_3064_ _3064_/Q Tile_X0Y5_FrameData[24] Tile_X0Y5_FrameStrobe[0] VPWR VGND sg13cmos5l_dlhq_1
XFILLER_242_128 VPWR VGND sg13cmos5l_fill_2
XFILLER_250_68 VPWR VGND sg13cmos5l_fill_2
XFILLER_282_286 VPWR VGND sg13cmos5l_fill_1
X_2015_ _2015_/Q Tile_X0Y1_FrameData[17] Tile_X0Y5_FrameStrobe[1] VPWR VGND sg13cmos5l_dlhq_1
XANTENNA__2482__D Tile_X0Y2_FrameData[14] VPWR VGND sg13cmos5l_antennanp
XFILLER_259_11 VPWR VGND sg13cmos5l_fill_2
XFILLER_259_22 VPWR VGND sg13cmos5l_fill_1
XFILLER_259_55 VPWR VGND sg13cmos5l_decap_8
XFILLER_195_249 VPWR VGND sg13cmos5l_decap_8
XFILLER_259_66 VPWR VGND sg13cmos5l_fill_1
X_2917_ _2917_/Q Tile_X0Y4_FrameData[27] Tile_X0Y5_FrameStrobe[4] VPWR VGND sg13cmos5l_dlhq_1
XFILLER_50_277 VPWR VGND sg13cmos5l_fill_2
X_3897_ Tile_X0Y5_S2BEG[2] _3897_/A VPWR VGND sg13cmos5l_buf_1
XANTENNA__2924__GATE Tile_X0Y5_FrameStrobe[4] VPWR VGND sg13cmos5l_antennanp
X_2848_ _2848_/Q Tile_X0Y4_FrameData[0] Tile_X0Y5_FrameStrobe[1] VPWR VGND sg13cmos5l_dlhq_1
XANTENNA__1826__D Tile_X0Y0_FrameData[30] VPWR VGND sg13cmos5l_antennanp
X_2779_ _2779_/Q Tile_X0Y3_FrameData[21] Tile_X0Y5_FrameStrobe[8] VPWR VGND sg13cmos5l_dlhq_1
XANTENNA__2309__GATE Tile_X0Y5_FrameStrobe[2] VPWR VGND sg13cmos5l_antennanp
XFILLER_275_87 VPWR VGND sg13cmos5l_fill_1
XFILLER_275_98 VPWR VGND sg13cmos5l_fill_1
XFILLER_305_151 VPWR VGND sg13cmos5l_decap_4
XANTENNA__2939__GATE Tile_X0Y5_FrameStrobe[4] VPWR VGND sg13cmos5l_antennanp
XFILLER_208_92 VPWR VGND sg13cmos5l_fill_1
XANTENNA__2657__D Tile_X0Y3_FrameData[15] VPWR VGND sg13cmos5l_antennanp
XFILLER_320_176 VPWR VGND sg13cmos5l_decap_8
XFILLER_218_114 VPWR VGND sg13cmos5l_fill_2
XFILLER_273_220 VPWR VGND sg13cmos5l_decap_4
XFILLER_85_130 VPWR VGND sg13cmos5l_decap_8
XANTENNA__1520__A2 AXI_M_SOC_RDATA13 VPWR VGND sg13cmos5l_antennanp
XFILLER_218_158 VPWR VGND sg13cmos5l_fill_1
XANTENNA__1203__X AXI_M_SOC_AWADDR26 VPWR VGND sg13cmos5l_antennanp
XANTENNA__1284__A1 AXI_M_SOC_RDATA23 VPWR VGND sg13cmos5l_antennanp
XANTENNA__2392__D Tile_X0Y2_FrameData[8] VPWR VGND sg13cmos5l_antennanp
XFILLER_241_194 VPWR VGND sg13cmos5l_fill_2
XFILLER_53_77 VPWR VGND sg13cmos5l_decap_8
XFILLER_319_47 VPWR VGND sg13cmos5l_fill_1
XANTENNA__0795__A0 Tile_X0Y5_W2MID[4] VPWR VGND sg13cmos5l_antennanp
XFILLER_194_293 VPWR VGND sg13cmos5l_fill_2
XANTENNA__1736__D Tile_X0Y0_FrameData[24] VPWR VGND sg13cmos5l_antennanp
XFILLER_154_135 VPWR VGND sg13cmos5l_decap_8
XFILLER_204_0 VPWR VGND sg13cmos5l_fill_2
XFILLER_5_167 VPWR VGND sg13cmos5l_decap_8
XANTENNA__3071__GATE Tile_X0Y5_FrameStrobe[0] VPWR VGND sg13cmos5l_antennanp
XANTENNA__2567__D Tile_X0Y3_FrameData[9] VPWR VGND sg13cmos5l_antennanp
XFILLER_311_187 VPWR VGND sg13cmos5l_decap_8
XANTENNA__1511__A2 AXI_M_SOC_RDATA11 VPWR VGND sg13cmos5l_antennanp
XANTENNA__3086__GATE Tile_X0Y5_FrameStrobe[0] VPWR VGND sg13cmos5l_antennanp
XFILLER_264_286 VPWR VGND sg13cmos5l_fill_1
XFILLER_94_84 VPWR VGND sg13cmos5l_decap_4
XFILLER_91_133 VPWR VGND sg13cmos5l_fill_1
XANTENNA__1275__A1 AXI_M_SOC_RDATA23 VPWR VGND sg13cmos5l_antennanp
XFILLER_91_199 VPWR VGND sg13cmos5l_fill_2
XFILLER_177_227 VPWR VGND sg13cmos5l_decap_4
X_3820_ Tile_X0Y5_E2BEG[5] _3820_/A VPWR VGND sg13cmos5l_buf_1
XFILLER_32_255 VPWR VGND sg13cmos5l_fill_1
XANTENNA__1027__A1 Tile_X0Y0_WW4END[13] VPWR VGND sg13cmos5l_antennanp
X_3751_ Tile_X0Y4_E6BEG[1] _3751_/A VPWR VGND sg13cmos5l_buf_1
XFILLER_32_277 VPWR VGND sg13cmos5l_fill_1
XFILLER_229_47 VPWR VGND sg13cmos5l_decap_8
X_2702_ _2702_/Q Tile_X0Y3_FrameData[2] Tile_X0Y5_FrameStrobe[5] VPWR VGND sg13cmos5l_dlhq_1
X_0963_ _0963_/X Tile_X0Y1_W1END[1] Tile_X0Y1_WW4END[13] Tile_X0Y1_WW4END[5] _0962_/X
+ _2045_/Q _2046_/Q VPWR VGND sg13cmos5l_mux4_1
XANTENNA__0786__A0 Tile_X0Y5_N2MID[1] VPWR VGND sg13cmos5l_antennanp
XANTENNA__3024__GATE Tile_X0Y5_FrameStrobe[7] VPWR VGND sg13cmos5l_antennanp
XFILLER_145_113 VPWR VGND sg13cmos5l_decap_8
X_3682_ Tile_X0Y3_EE4BEG[1] _3682_/A VPWR VGND sg13cmos5l_buf_1
X_0894_ _0895_/A Tile_X0Y5_W6END[11] _3295_/Q _3294_/Q VPWR VGND sg13cmos5l_o21ai_1
XFILLER_319_276 VPWR VGND sg13cmos5l_fill_1
XFILLER_145_157 VPWR VGND sg13cmos5l_decap_8
X_2633_ _2633_/Q Tile_X0Y3_FrameData[7] Tile_X0Y5_FrameStrobe[3] VPWR VGND sg13cmos5l_dlhq_1
XANTENNA__2280__GATE Tile_X0Y5_FrameStrobe[1] VPWR VGND sg13cmos5l_antennanp
X_2564_ _2564_/Q Tile_X0Y3_FrameData[12] Tile_X0Y5_FrameStrobe[1] VPWR VGND sg13cmos5l_dlhq_1
XANTENNA__3039__GATE Tile_X0Y5_FrameStrobe[7] VPWR VGND sg13cmos5l_antennanp
XFILLER_153_190 VPWR VGND sg13cmos5l_decap_8
X_1515_ _3683_/A Tile_X0Y3_WW4END[13] AXI_M_SOC_RDATA8 _0885_/X _1342_/X _2668_/Q
+ _2667_/Q VPWR VGND sg13cmos5l_mux4_1
XFILLER_302_143 VPWR VGND sg13cmos5l_decap_8
X_2495_ _2495_/Q Tile_X0Y2_FrameData[1] Tile_X0Y5_FrameStrobe[7] VPWR VGND sg13cmos5l_dlhq_1
XANTENNA__2295__GATE Tile_X0Y5_FrameStrobe[1] VPWR VGND sg13cmos5l_antennanp
XFILLER_101_216 VPWR VGND sg13cmos5l_fill_2
XFILLER_261_12 VPWR VGND sg13cmos5l_fill_2
X_1446_ _3386_/A Tile_X0Y2_WW4END[11] _1370_/X AXI_M_SOC_RDATA18 _1187_/X _2391_/Q
+ _2392_/Q VPWR VGND sg13cmos5l_mux4_1
XFILLER_325_90 VPWR VGND sg13cmos5l_fill_2
XANTENNA__2477__D Tile_X0Y2_FrameData[19] VPWR VGND sg13cmos5l_antennanp
X_1377_ _1377_/Y _2478_/Q _1376_/X _2477_/Q VPWR VGND sg13cmos5l_o21ai_1
XFILLER_67_141 VPWR VGND sg13cmos5l_decap_8
XANTENNA__3503__X Tile_X0Y1_E2BEG[3] VPWR VGND sg13cmos5l_antennanp
X_3116_ _3116_/Q Tile_X0Y5_FrameData[4] Tile_X0Y5_FrameStrobe[1] VPWR VGND sg13cmos5l_dlhq_1
X_3047_ _3047_/Q Tile_X0Y4_FrameData[25] Tile_X0Y5_FrameStrobe[8] VPWR VGND sg13cmos5l_dlhq_1
XFILLER_82_155 VPWR VGND sg13cmos5l_decap_8
XANTENNA__1266__A1 AXI_M_SOC_RDATA30 VPWR VGND sg13cmos5l_antennanp
XFILLER_130_49 VPWR VGND sg13cmos5l_fill_1
XANTENNA__3101__D Tile_X0Y5_FrameData[19] VPWR VGND sg13cmos5l_antennanp
XANTENNA__3886__A Tile_X0Y5_FrameData[27] VPWR VGND sg13cmos5l_antennanp
XANTENNA__1018__A1 Tile_X0Y3_W6END[5] VPWR VGND sg13cmos5l_antennanp
XANTENNA__2233__GATE Tile_X0Y5_FrameStrobe[8] VPWR VGND sg13cmos5l_antennanp
XANTENNA__2863__GATE Tile_X0Y5_FrameStrobe[2] VPWR VGND sg13cmos5l_antennanp
XANTENNA__2940__D Tile_X0Y4_FrameData[4] VPWR VGND sg13cmos5l_antennanp
XANTENNA__2248__GATE Tile_X0Y5_FrameStrobe[0] VPWR VGND sg13cmos5l_antennanp
XFILLER_191_241 VPWR VGND sg13cmos5l_fill_2
XFILLER_325_235 VPWR VGND sg13cmos5l_decap_8
XANTENNA__2878__GATE Tile_X0Y5_FrameStrobe[2] VPWR VGND sg13cmos5l_antennanp
XFILLER_144_190 VPWR VGND sg13cmos5l_decap_4
XFILLER_151_149 VPWR VGND sg13cmos5l_fill_2
XFILLER_155_35 VPWR VGND sg13cmos5l_decap_8
XFILLER_2_115 VPWR VGND sg13cmos5l_fill_2
XANTENNA__2801__GATE Tile_X0Y5_FrameStrobe[0] VPWR VGND sg13cmos5l_antennanp
XANTENNA__2387__D Tile_X0Y2_FrameData[13] VPWR VGND sg13cmos5l_antennanp
XANTENNA__3413__X Tile_X0Y2_FrameData_O[15] VPWR VGND sg13cmos5l_antennanp
XFILLER_48_77 VPWR VGND sg13cmos5l_decap_8
XANTENNA__0701__A0 Tile_X0Y5_W1END[2] VPWR VGND sg13cmos5l_antennanp
XFILLER_100_293 VPWR VGND sg13cmos5l_fill_2
XANTENNA__2816__GATE Tile_X0Y5_FrameStrobe[0] VPWR VGND sg13cmos5l_antennanp
XFILLER_64_43 VPWR VGND sg13cmos5l_decap_8
XFILLER_321_59 VPWR VGND sg13cmos5l_decap_8
XANTENNA__1257__A1 AXI_M_SOC_BRESP0 VPWR VGND sg13cmos5l_antennanp
XFILLER_214_150 VPWR VGND sg13cmos5l_decap_8
XFILLER_261_256 VPWR VGND sg13cmos5l_fill_1
XANTENNA__0772__X AXI_M_SOC_AWVALID VPWR VGND sg13cmos5l_antennanp
XANTENNA__3011__D Tile_X0Y4_FrameData[29] VPWR VGND sg13cmos5l_antennanp
XANTENNA__3796__A Tile_X0Y4_FrameData[18] VPWR VGND sg13cmos5l_antennanp
XFILLER_154_0 VPWR VGND sg13cmos5l_fill_1
XANTENNA__1009__A1 Tile_X0Y1_W2END[1] VPWR VGND sg13cmos5l_antennanp
XFILLER_159_227 VPWR VGND sg13cmos5l_decap_4
XFILLER_9_38 VPWR VGND sg13cmos5l_fill_2
XFILLER_80_42 VPWR VGND sg13cmos5l_decap_8
XANTENNA__2850__D Tile_X0Y4_FrameData[30] VPWR VGND sg13cmos5l_antennanp
XANTENNA__0768__A0 Tile_X0Y5_WW4END[7] VPWR VGND sg13cmos5l_antennanp
XFILLER_196_75 VPWR VGND sg13cmos5l_fill_1
XFILLER_127_157 VPWR VGND sg13cmos5l_decap_8
XFILLER_167_293 VPWR VGND sg13cmos5l_fill_2
XFILLER_129_91 VPWR VGND sg13cmos5l_decap_4
XFILLER_182_274 VPWR VGND sg13cmos5l_fill_2
XFILLER_50_8 VPWR VGND sg13cmos5l_decap_8
XFILLER_316_279 VPWR VGND sg13cmos5l_fill_2
XANTENNA__1193__A0 Tile_X0Y0_WW4END[7] VPWR VGND sg13cmos5l_antennanp
XFILLER_229_209 VPWR VGND sg13cmos5l_fill_1
X_2280_ _2280_/Q Tile_X0Y2_FrameData[24] Tile_X0Y5_FrameStrobe[1] VPWR VGND sg13cmos5l_dlhq_1
X_1300_ AXI_M_SOC_AWADDR1 Tile_X0Y1_W2MID[1] Tile_X0Y1_W2END[1] Tile_X0Y1_W6END[1]
+ _1105_/X _2038_/Q _2037_/Q VPWR VGND sg13cmos5l_mux4_1
XANTENNA__2297__D Tile_X0Y2_FrameData[7] VPWR VGND sg13cmos5l_antennanp
XFILLER_1_192 VPWR VGND sg13cmos5l_fill_2
XFILLER_296_197 VPWR VGND sg13cmos5l_fill_2
X_1231_ _3616_/A Tile_X0Y0_WW4END[0] AXI_M_SOC_RDATA30 _1075_/X _1145_/X _1826_/Q
+ _1825_/Q VPWR VGND sg13cmos5l_mux4_1
XFILLER_237_286 VPWR VGND sg13cmos5l_fill_1
X_1162_ _3528_/A _1161_/X _1160_/X _1934_/Q VPWR VGND sg13cmos5l_mux2_1
XFILLER_64_122 VPWR VGND sg13cmos5l_fill_2
X_1093_ _1093_/X Tile_X0Y0_W2MID[4] Tile_X0Y0_W2END[4] Tile_X0Y0_W6END[11] _1148_/X
+ _1918_/Q _1917_/Q VPWR VGND sg13cmos5l_mux4_1
XANTENNA__1248__A1 AXI_M_SOC_RDATA31 VPWR VGND sg13cmos5l_antennanp
XFILLER_100_19 VPWR VGND sg13cmos5l_fill_1
XFILLER_220_120 VPWR VGND sg13cmos5l_decap_4
X_3803_ Tile_X0Y4_FrameData_O[25] Tile_X0Y4_FrameData[25] VPWR VGND sg13cmos5l_buf_1
XANTENNA__2760__D Tile_X0Y3_FrameData[8] VPWR VGND sg13cmos5l_antennanp
XFILLER_220_153 VPWR VGND sg13cmos5l_decap_8
X_1995_ _1995_/Q Tile_X0Y1_FrameData[5] Tile_X0Y5_FrameStrobe[0] VPWR VGND sg13cmos5l_dlhq_1
X_3734_ Tile_X0Y4_E2BEG[0] _3734_/A VPWR VGND sg13cmos5l_buf_1
X_0946_ AXI_M_SOC_AWSIZE2 _3336_/Q _0945_/X VPWR VGND sg13cmos5l_nor2b_1
XANTENNA__1420__A1 Tile_X0Y2_WW4END[9] VPWR VGND sg13cmos5l_antennanp
XFILLER_118_146 VPWR VGND sg13cmos5l_decap_8
XFILLER_158_293 VPWR VGND sg13cmos5l_fill_2
XFILLER_307_224 VPWR VGND sg13cmos5l_decap_8
X_3665_ Tile_X0Y3_E2BEGb[4] _3665_/A VPWR VGND sg13cmos5l_buf_1
XFILLER_133_116 VPWR VGND sg13cmos5l_fill_2
X_2616_ _2616_/Q Tile_X0Y3_FrameData[24] Tile_X0Y5_FrameStrobe[3] VPWR VGND sg13cmos5l_dlhq_1
X_0877_ _0877_/Y _3114_/Q Tile_X0Y5_W6END[7] VPWR VGND sg13cmos5l_nor2b_1
X_3596_ Tile_X0Y0_FrameData_O[27] Tile_X0Y0_FrameData[27] VPWR VGND sg13cmos5l_buf_1
XANTENNA__1184__A0 Tile_X0Y0_W2MID[3] VPWR VGND sg13cmos5l_antennanp
X_2547_ _2547_/Q Tile_X0Y3_FrameData[29] Tile_X0Y5_FrameStrobe[1] VPWR VGND sg13cmos5l_dlhq_1
XFILLER_272_44 VPWR VGND sg13cmos5l_fill_2
X_2478_ _2478_/Q Tile_X0Y2_FrameData[18] Tile_X0Y5_FrameStrobe[7] VPWR VGND sg13cmos5l_dlhq_1
X_1429_ AXI_M_SOC_WDATA29 Tile_X0Y2_W2MID[5] Tile_X0Y2_W2END[5] Tile_X0Y2_W6END[5]
+ _1183_/X _2302_/Q _2301_/Q VPWR VGND sg13cmos5l_mux4_1
XFILLER_330_293 VPWR VGND sg13cmos5l_fill_2
XANTENNA__2000__D Tile_X0Y1_FrameData[0] VPWR VGND sg13cmos5l_antennanp
XANTENNA__2935__D Tile_X0Y4_FrameData[9] VPWR VGND sg13cmos5l_antennanp
XFILLER_243_212 VPWR VGND sg13cmos5l_decap_4
XFILLER_18_69 VPWR VGND sg13cmos5l_decap_8
XANTENNA__1239__A1 Tile_X0Y0_WW4END[8] VPWR VGND sg13cmos5l_antennanp
XFILLER_243_256 VPWR VGND sg13cmos5l_fill_2
XFILLER_70_125 VPWR VGND sg13cmos5l_decap_8
XANTENNA__2172__GATE Tile_X0Y5_FrameStrobe[6] VPWR VGND sg13cmos5l_antennanp
XFILLER_34_24 VPWR VGND sg13cmos5l_fill_2
XFILLER_11_214 VPWR VGND sg13cmos5l_decap_4
XFILLER_34_57 VPWR VGND sg13cmos5l_decap_8
XANTENNA__2670__D Tile_X0Y3_FrameData[2] VPWR VGND sg13cmos5l_antennanp
XFILLER_11_236 VPWR VGND sg13cmos5l_decap_4
XFILLER_297_63 VPWR VGND sg13cmos5l_decap_8
XANTENNA__1411__A1 Tile_X0Y2_WW4END[10] VPWR VGND sg13cmos5l_antennanp
XANTENNA__2187__GATE Tile_X0Y5_FrameStrobe[6] VPWR VGND sg13cmos5l_antennanp
XFILLER_149_293 VPWR VGND sg13cmos5l_fill_2
XANTENNA__3408__X Tile_X0Y2_FrameData_O[10] VPWR VGND sg13cmos5l_antennanp
XFILLER_109_179 VPWR VGND sg13cmos5l_decap_8
XFILLER_50_89 VPWR VGND sg13cmos5l_fill_1
XANTENNA__2110__GATE Tile_X0Y5_FrameStrobe[4] VPWR VGND sg13cmos5l_antennanp
XFILLER_117_190 VPWR VGND sg13cmos5l_decap_8
XFILLER_59_21 VPWR VGND sg13cmos5l_decap_8
XANTENNA__0922__A0 Tile_X0Y5_W6END[9] VPWR VGND sg13cmos5l_antennanp
XANTENNA__2740__GATE Tile_X0Y5_FrameStrobe[7] VPWR VGND sg13cmos5l_antennanp
XFILLER_78_214 VPWR VGND sg13cmos5l_decap_8
XFILLER_321_293 VPWR VGND sg13cmos5l_fill_2
XANTENNA__2125__GATE Tile_X0Y5_FrameStrobe[4] VPWR VGND sg13cmos5l_antennanp
XANTENNA__3006__D Tile_X0Y4_FrameData[2] VPWR VGND sg13cmos5l_antennanp
XANTENNA__2755__GATE Tile_X0Y5_FrameStrobe[7] VPWR VGND sg13cmos5l_antennanp
XFILLER_271_0 VPWR VGND sg13cmos5l_fill_2
XFILLER_293_189 VPWR VGND sg13cmos5l_decap_8
XFILLER_75_53 VPWR VGND sg13cmos5l_decap_8
XANTENNA__2845__D Tile_X0Y4_FrameData[3] VPWR VGND sg13cmos5l_antennanp
XFILLER_234_223 VPWR VGND sg13cmos5l_fill_2
XFILLER_75_97 VPWR VGND sg13cmos5l_fill_1
XFILLER_201_29 VPWR VGND sg13cmos5l_decap_8
XANTENNA__1650__A1 Tile_X0Y4_W2END[0] VPWR VGND sg13cmos5l_antennanp
XANTENNA__2580__D Tile_X0Y3_FrameData[28] VPWR VGND sg13cmos5l_antennanp
X_1780_ _1780_/Q Tile_X0Y0_FrameData[12] Tile_X0Y5_FrameStrobe[2] VPWR VGND sg13cmos5l_dlhq_1
X_0800_ _3823_/A Tile_X0Y5_W2END[7] _0782_/X AXI_M_SOC_RLAST _0563_/X _3231_/Q _3232_/Q
+ VPWR VGND sg13cmos5l_mux4_1
XANTENNA__1402__A1 AXI_M_SOC_RDATA15 VPWR VGND sg13cmos5l_antennanp
XFILLER_155_241 VPWR VGND sg13cmos5l_decap_8
X_0731_ _0731_/Y _2786_/Q _3057_/Q VPWR VGND sg13cmos5l_nor2b_1
XFILLER_226_15 VPWR VGND sg13cmos5l_fill_2
XFILLER_304_227 VPWR VGND sg13cmos5l_decap_8
X_3450_ Tile_X0Y1_FrameData_O[18] Tile_X0Y1_FrameData[18] VPWR VGND sg13cmos5l_buf_1
X_0662_ _3924_/A _0651_/Y _0653_/Y _0661_/Y VPWR VGND sg13cmos5l_a21oi_1
XANTENNA__1924__D Tile_X0Y0_FrameData[28] VPWR VGND sg13cmos5l_antennanp
XANTENNA__2708__GATE Tile_X0Y5_FrameStrobe[6] VPWR VGND sg13cmos5l_antennanp
XFILLER_226_48 VPWR VGND sg13cmos5l_fill_2
X_2401_ _2401_/Q Tile_X0Y2_FrameData[31] Tile_X0Y5_FrameStrobe[5] VPWR VGND sg13cmos5l_dlhq_1
X_3381_ Tile_X0Y2_E6BEG[11] _3381_/A VPWR VGND sg13cmos5l_buf_1
X_0593_ _0593_/X Tile_X0Y1_W6END[4] _0959_/X _1268_/X _1089_/X _2178_/Q _2180_/Q VPWR
+ VGND sg13cmos5l_mux4_1
X_2332_ _2332_/Q Tile_X0Y2_FrameData[4] Tile_X0Y5_FrameStrobe[2] VPWR VGND sg13cmos5l_dlhq_1
XANTENNA__1964__GATE Tile_X0Y5_FrameStrobe[8] VPWR VGND sg13cmos5l_antennanp
XFILLER_312_293 VPWR VGND sg13cmos5l_fill_2
XFILLER_242_14 VPWR VGND sg13cmos5l_fill_2
X_2263_ _2263_/Q Tile_X0Y2_FrameData[9] Tile_X0Y5_FrameStrobe[0] VPWR VGND sg13cmos5l_dlhq_1
XANTENNA__1469__A1 AXI_M_SOC_RDATA17 VPWR VGND sg13cmos5l_antennanp
XFILLER_284_167 VPWR VGND sg13cmos5l_fill_2
X_2194_ _2194_/Q Tile_X0Y1_FrameData[30] Tile_X0Y5_FrameStrobe[7] VPWR VGND sg13cmos5l_dlhq_1
X_1214_ AXI_M_SOC_AWADDR30 Tile_X0Y0_W2MID[6] Tile_X0Y0_W2END[6] Tile_X0Y0_W6END[6]
+ _1010_/X _1756_/Q _1755_/Q VPWR VGND sg13cmos5l_mux4_1
XFILLER_37_111 VPWR VGND sg13cmos5l_decap_8
XANTENNA__2755__D Tile_X0Y3_FrameData[13] VPWR VGND sg13cmos5l_antennanp
X_1145_ _1145_/X _3529_/A _1109_/X Tile_X0Y0_S2MID[0] Tile_X0Y0_S2END[0] _1720_/Q
+ _1719_/Q VPWR VGND sg13cmos5l_mux4_1
XANTENNA__0692__A2 Tile_X0Y1_WW4END[14] VPWR VGND sg13cmos5l_antennanp
XANTENNA__1979__GATE Tile_X0Y5_FrameStrobe[0] VPWR VGND sg13cmos5l_antennanp
XFILLER_111_29 VPWR VGND sg13cmos5l_decap_8
XFILLER_92_272 VPWR VGND sg13cmos5l_decap_4
X_1076_ _1076_/X Tile_X0Y2_W2MID[3] Tile_X0Y2_W2END[3] Tile_X0Y2_W6END[3] _1191_/X
+ _2496_/Q _2495_/Q VPWR VGND sg13cmos5l_mux4_1
XANTENNA__1301__X AXI_M_SOC_AWADDR0 VPWR VGND sg13cmos5l_antennanp
XFILLER_240_248 VPWR VGND sg13cmos5l_decap_4
XANTENNA__1641__A1 Tile_X0Y4_WW4END[12] VPWR VGND sg13cmos5l_antennanp
XANTENNA__1902__GATE Tile_X0Y5_FrameStrobe[6] VPWR VGND sg13cmos5l_antennanp
XANTENNA__2490__D Tile_X0Y2_FrameData[6] VPWR VGND sg13cmos5l_antennanp
X_3717_ Tile_X0Y3_FrameData_O[20] Tile_X0Y3_FrameData[20] VPWR VGND sg13cmos5l_buf_1
X_1978_ _1978_/Q Tile_X0Y1_FrameData[22] Tile_X0Y5_FrameStrobe[0] VPWR VGND sg13cmos5l_dlhq_1
XANTENNA__1917__GATE Tile_X0Y5_FrameStrobe[6] VPWR VGND sg13cmos5l_antennanp
X_0929_ AXI_M_SOC_AWSIZE0 _3336_/Q _0928_/X VPWR VGND sg13cmos5l_nor2b_1
XFILLER_106_138 VPWR VGND sg13cmos5l_decap_8
X_3648_ Tile_X0Y0_E1BEG[3] _3648_/A VPWR VGND sg13cmos5l_buf_1
XANTENNA__1834__D Tile_X0Y0_FrameData[22] VPWR VGND sg13cmos5l_antennanp
X_3579_ Tile_X0Y0_FrameData_O[10] Tile_X0Y0_FrameData[10] VPWR VGND sg13cmos5l_buf_1
XFILLER_161_277 VPWR VGND sg13cmos5l_fill_1
XFILLER_114_182 VPWR VGND sg13cmos5l_decap_8
XFILLER_303_293 VPWR VGND sg13cmos5l_fill_2
XANTENNA__3404__A Tile_X0Y2_FrameData[6] VPWR VGND sg13cmos5l_antennanp
XFILLER_152_58 VPWR VGND sg13cmos5l_decap_8
XANTENNA__2665__D Tile_X0Y3_FrameData[7] VPWR VGND sg13cmos5l_antennanp
XANTENNA__3898__X Tile_X0Y5_S2BEG[3] VPWR VGND sg13cmos5l_antennanp
XFILLER_302_17 VPWR VGND sg13cmos5l_fill_2
XFILLER_302_28 VPWR VGND sg13cmos5l_decap_8
XFILLER_83_250 VPWR VGND sg13cmos5l_fill_1
XFILLER_83_272 VPWR VGND sg13cmos5l_fill_2
XFILLER_45_56 VPWR VGND sg13cmos5l_decap_8
XFILLER_231_215 VPWR VGND sg13cmos5l_decap_8
XANTENNA__1211__X AXI_M_SOC_AWADDR28 VPWR VGND sg13cmos5l_antennanp
XANTENNA__1632__A1 Tile_X0Y4_W6END[0] VPWR VGND sg13cmos5l_antennanp
XFILLER_61_22 VPWR VGND sg13cmos5l_decap_8
XFILLER_61_99 VPWR VGND sg13cmos5l_decap_8
XANTENNA__1396__A0 Tile_X0Y5_N4END[15] VPWR VGND sg13cmos5l_antennanp
XFILLER_117_0 VPWR VGND sg13cmos5l_fill_2
XANTENNA__1744__D Tile_X0Y0_FrameData[16] VPWR VGND sg13cmos5l_antennanp
XFILLER_112_119 VPWR VGND sg13cmos5l_decap_4
XANTENNA__2064__GATE Tile_X0Y5_FrameStrobe[2] VPWR VGND sg13cmos5l_antennanp
XFILLER_266_101 VPWR VGND sg13cmos5l_fill_2
XANTENNA__2694__GATE Tile_X0Y5_FrameStrobe[5] VPWR VGND sg13cmos5l_antennanp
XFILLER_281_104 VPWR VGND sg13cmos5l_fill_1
XANTENNA__2575__D Tile_X0Y3_FrameData[1] VPWR VGND sg13cmos5l_antennanp
XFILLER_207_212 VPWR VGND sg13cmos5l_decap_8
XFILLER_212_39 VPWR VGND sg13cmos5l_decap_8
XFILLER_81_209 VPWR VGND sg13cmos5l_decap_8
XANTENNA__2079__GATE Tile_X0Y5_FrameStrobe[3] VPWR VGND sg13cmos5l_antennanp
XANTENNA__3601__X Tile_X0Y0_EE4BEG[0] VPWR VGND sg13cmos5l_antennanp
XFILLER_34_158 VPWR VGND sg13cmos5l_decap_8
X_2950_ _2950_/Q Tile_X0Y4_FrameData[26] Tile_X0Y5_FrameStrobe[5] VPWR VGND sg13cmos5l_dlhq_1
XFILLER_34_169 VPWR VGND sg13cmos5l_fill_1
XANTENNA__1919__D Tile_X0Y0_FrameData[1] VPWR VGND sg13cmos5l_antennanp
XANTENNA__2002__GATE Tile_X0Y5_FrameStrobe[1] VPWR VGND sg13cmos5l_antennanp
X_2881_ _2881_/Q Tile_X0Y4_FrameData[31] Tile_X0Y5_FrameStrobe[3] VPWR VGND sg13cmos5l_dlhq_1
X_1901_ _1901_/Q Tile_X0Y0_FrameData[19] Tile_X0Y5_FrameStrobe[6] VPWR VGND sg13cmos5l_dlhq_1
XANTENNA__2632__GATE Tile_X0Y5_FrameStrobe[3] VPWR VGND sg13cmos5l_antennanp
X_1832_ _1832_/Q Tile_X0Y0_FrameData[24] Tile_X0Y5_FrameStrobe[4] VPWR VGND sg13cmos5l_dlhq_1
XFILLER_89_4 VPWR VGND sg13cmos5l_fill_1
XANTENNA__2017__GATE Tile_X0Y5_FrameStrobe[1] VPWR VGND sg13cmos5l_antennanp
XFILLER_237_14 VPWR VGND sg13cmos5l_fill_1
X_1763_ _1763_/Q Tile_X0Y0_FrameData[29] Tile_X0Y5_FrameStrobe[2] VPWR VGND sg13cmos5l_dlhq_1
XANTENNA__2647__GATE Tile_X0Y5_FrameStrobe[4] VPWR VGND sg13cmos5l_antennanp
X_3502_ Tile_X0Y1_E2BEG[2] _3502_/A VPWR VGND sg13cmos5l_buf_1
X_1694_ _3893_/A Tile_X0Y5_W1END[2] Tile_X0Y5_W6END[10] _0694_/X _0991_/Y _3288_/Q
+ _3287_/Q VPWR VGND sg13cmos5l_mux4_1
X_0714_ _0716_/B Tile_X0Y1_W6END[3] _1970_/Q VPWR VGND sg13cmos5l_nor2b_1
XANTENNA__1139__A0 Tile_X0Y2_W1END[1] VPWR VGND sg13cmos5l_antennanp
X_3433_ Tile_X0Y1_FrameData_O[1] Tile_X0Y1_FrameData[1] VPWR VGND sg13cmos5l_buf_1
X_0645_ _0645_/X Tile_X0Y5_N1END[1] Tile_X0Y5_N4END[1] _1021_/B _0644_/X _3086_/Q
+ _3085_/Q VPWR VGND sg13cmos5l_mux4_1
X_3364_ Tile_X0Y2_E2BEGb[2] _3364_/A VPWR VGND sg13cmos5l_buf_1
X_0576_ _0578_/B Tile_X0Y2_W6END[0] _2248_/Q VPWR VGND sg13cmos5l_nor2b_1
XFILLER_32_0 VPWR VGND sg13cmos5l_fill_1
XFILLER_111_141 VPWR VGND sg13cmos5l_decap_4
X_3295_ _3295_/Q Tile_X0Y5_FrameData[17] Tile_X0Y5_FrameStrobe[7] VPWR VGND sg13cmos5l_dlhq_1
X_2315_ _2315_/Q Tile_X0Y2_FrameData[21] Tile_X0Y5_FrameStrobe[2] VPWR VGND sg13cmos5l_dlhq_1
X_2246_ _2246_/Q Tile_X0Y2_FrameData[26] Tile_X0Y5_FrameStrobe[0] VPWR VGND sg13cmos5l_dlhq_1
XANTENNA__2485__D Tile_X0Y2_FrameData[11] VPWR VGND sg13cmos5l_antennanp
XANTENNA__1311__A0 Tile_X0Y1_W2MID[5] VPWR VGND sg13cmos5l_antennanp
XANTENNA__3511__X Tile_X0Y1_E1BEG[3] VPWR VGND sg13cmos5l_antennanp
X_2177_ _2177_/Q Tile_X0Y1_FrameData[15] Tile_X0Y5_FrameStrobe[6] VPWR VGND sg13cmos5l_dlhq_1
XFILLER_65_261 VPWR VGND sg13cmos5l_decap_4
XANTENNA__0854__Y AXI_M_SOC_ARLEN1 VPWR VGND sg13cmos5l_antennanp
XFILLER_202_50 VPWR VGND sg13cmos5l_decap_8
X_1128_ _1128_/X Tile_X0Y2_W2MID[4] Tile_X0Y2_W2END[4] Tile_X0Y2_W6END[11] _1187_/X
+ _2462_/Q _2461_/Q VPWR VGND sg13cmos5l_mux4_1
XANTENNA__1841__GATE Tile_X0Y5_FrameStrobe[4] VPWR VGND sg13cmos5l_antennanp
XFILLER_202_72 VPWR VGND sg13cmos5l_fill_1
X_1059_ _1059_/X Tile_X0Y0_W6END[4] _1074_/X _1075_/X _1078_/X _1906_/Q _1908_/Q VPWR
+ VGND sg13cmos5l_mux4_1
XFILLER_15_59 VPWR VGND sg13cmos5l_decap_8
XANTENNA__0968__A3 Tile_X0Y0_S4END[7] VPWR VGND sg13cmos5l_antennanp
XANTENNA__1829__D Tile_X0Y0_FrameData[27] VPWR VGND sg13cmos5l_antennanp
XFILLER_278_76 VPWR VGND sg13cmos5l_decap_4
XANTENNA__1090__A2 Tile_X0Y1_W6END[4] VPWR VGND sg13cmos5l_antennanp
XFILLER_31_25 VPWR VGND sg13cmos5l_fill_1
XANTENNA__1856__GATE Tile_X0Y5_FrameStrobe[4] VPWR VGND sg13cmos5l_antennanp
XFILLER_31_36 VPWR VGND sg13cmos5l_decap_8
XFILLER_134_211 VPWR VGND sg13cmos5l_decap_8
XFILLER_31_69 VPWR VGND sg13cmos5l_decap_4
XANTENNA__1145__A3 Tile_X0Y0_S2END[0] VPWR VGND sg13cmos5l_antennanp
XANTENNA__1206__X AXI_M_SOC_AWADDR29 VPWR VGND sg13cmos5l_antennanp
XANTENNA__1550__A0 Tile_X0Y3_WW4END[2] VPWR VGND sg13cmos5l_antennanp
XANTENNA__2395__D Tile_X0Y2_FrameData[5] VPWR VGND sg13cmos5l_antennanp
XANTENNA__1302__A0 AXI_M_SOC_RDATA29 VPWR VGND sg13cmos5l_antennanp
XANTENNA__3421__X Tile_X0Y2_FrameData_O[23] VPWR VGND sg13cmos5l_antennanp
XFILLER_263_159 VPWR VGND sg13cmos5l_fill_1
XFILLER_56_272 VPWR VGND sg13cmos5l_fill_1
XANTENNA__1809__GATE Tile_X0Y5_FrameStrobe[3] VPWR VGND sg13cmos5l_antennanp
XFILLER_112_83 VPWR VGND sg13cmos5l_decap_8
XFILLER_204_248 VPWR VGND sg13cmos5l_fill_2
XFILLER_169_130 VPWR VGND sg13cmos5l_fill_1
XFILLER_72_54 VPWR VGND sg13cmos5l_decap_4
XFILLER_71_286 VPWR VGND sg13cmos5l_fill_1
XANTENNA__0959__A3 Tile_X0Y0_S4END[4] VPWR VGND sg13cmos5l_antennanp
XANTENNA__1739__D Tile_X0Y0_FrameData[21] VPWR VGND sg13cmos5l_antennanp
XFILLER_234_0 VPWR VGND sg13cmos5l_decap_8
XFILLER_72_98 VPWR VGND sg13cmos5l_decap_8
XANTENNA__1081__A2 Tile_X0Y0_W2END[1] VPWR VGND sg13cmos5l_antennanp
XFILLER_184_122 VPWR VGND sg13cmos5l_fill_1
XFILLER_184_144 VPWR VGND sg13cmos5l_decap_8
XFILLER_21_80 VPWR VGND sg13cmos5l_decap_8
XANTENNA__0592__A1 Tile_X0Y4_W6END[8] VPWR VGND sg13cmos5l_antennanp
XFILLER_98_128 VPWR VGND sg13cmos5l_decap_8
XANTENNA__0668__A Tile_X0Y1_W6END[2] VPWR VGND sg13cmos5l_antennanp
XANTENNA__1136__A3 Tile_X0Y0_S2END[7] VPWR VGND sg13cmos5l_antennanp
XANTENNA__1541__A0 AXI_M_SOC_RDATA9 VPWR VGND sg13cmos5l_antennanp
XANTENNA__3300__GATE Tile_X0Y5_FrameStrobe[7] VPWR VGND sg13cmos5l_antennanp
XFILLER_239_112 VPWR VGND sg13cmos5l_fill_1
X_3080_ _3080_/Q Tile_X0Y5_FrameData[8] Tile_X0Y5_FrameStrobe[0] VPWR VGND sg13cmos5l_dlhq_1
X_2100_ _2100_/Q Tile_X0Y1_FrameData[28] Tile_X0Y5_FrameStrobe[4] VPWR VGND sg13cmos5l_dlhq_1
XFILLER_254_115 VPWR VGND sg13cmos5l_decap_8
X_2031_ _2031_/Q Tile_X0Y1_FrameData[1] Tile_X0Y5_FrameStrobe[1] VPWR VGND sg13cmos5l_dlhq_1
XANTENNA__3315__GATE Tile_X0Y5_FrameStrobe[8] VPWR VGND sg13cmos5l_antennanp
XFILLER_62_220 VPWR VGND sg13cmos5l_decap_8
XANTENNA__2571__GATE Tile_X0Y5_FrameStrobe[1] VPWR VGND sg13cmos5l_antennanp
XFILLER_22_117 VPWR VGND sg13cmos5l_decap_8
X_2933_ _2933_/Q Tile_X0Y4_FrameData[11] Tile_X0Y5_FrameStrobe[4] VPWR VGND sg13cmos5l_dlhq_1
XFILLER_210_229 VPWR VGND sg13cmos5l_fill_1
XANTENNA__1072__A2 Tile_X0Y5_W6END[7] VPWR VGND sg13cmos5l_antennanp
XFILLER_30_172 VPWR VGND sg13cmos5l_decap_8
X_2864_ _2864_/Q Tile_X0Y4_FrameData[16] Tile_X0Y5_FrameStrobe[2] VPWR VGND sg13cmos5l_dlhq_1
X_2795_ _2795_/Q Tile_X0Y4_FrameData[21] Tile_X0Y5_FrameStrobe[0] VPWR VGND sg13cmos5l_dlhq_1
X_1815_ _1815_/Q Tile_X0Y0_FrameData[9] Tile_X0Y5_FrameStrobe[3] VPWR VGND sg13cmos5l_dlhq_1
XANTENNA__2586__GATE Tile_X0Y5_FrameStrobe[2] VPWR VGND sg13cmos5l_antennanp
X_1746_ _1746_/Q Tile_X0Y0_FrameData[14] Tile_X0Y5_FrameStrobe[1] VPWR VGND sg13cmos5l_dlhq_1
XFILLER_324_119 VPWR VGND sg13cmos5l_decap_4
XFILLER_317_182 VPWR VGND sg13cmos5l_fill_1
XANTENNA__3506__X Tile_X0Y1_E2BEG[6] VPWR VGND sg13cmos5l_antennanp
X_1677_ _3744_/A Tile_X0Y4_W2END[5] AXI_M_SOC_RDATA3 _1016_/X _1318_/X _2956_/Q _2955_/Q
+ VPWR VGND sg13cmos5l_mux4_1
XFILLER_89_128 VPWR VGND sg13cmos5l_decap_8
XANTENNA__0849__Y AXI_M_SOC_ARLEN0 VPWR VGND sg13cmos5l_antennanp
XFILLER_131_236 VPWR VGND sg13cmos5l_fill_1
X_3416_ Tile_X0Y2_FrameData_O[18] Tile_X0Y2_FrameData[18] VPWR VGND sg13cmos5l_buf_1
X_0628_ _0628_/X _0623_/X _0624_/Y _0627_/Y VPWR VGND sg13cmos5l_a21o_1
XANTENNA__1532__A0 Tile_X0Y3_WW4END[6] VPWR VGND sg13cmos5l_antennanp
X_3347_ _3347_/Q Tile_X0Y5_FrameData[13] Tile_X0Y5_FrameStrobe[8] VPWR VGND sg13cmos5l_dlhq_1
X_0559_ _0559_/X Tile_X0Y5_N2MID[6] Tile_X0Y5_N2END[6] _3909_/A _0558_/X _3068_/Q
+ _3067_/Q VPWR VGND sg13cmos5l_mux4_1
XANTENNA__0886__A2 Tile_X0Y3_WW4END[5] VPWR VGND sg13cmos5l_antennanp
XANTENNA__2524__GATE Tile_X0Y5_FrameStrobe[0] VPWR VGND sg13cmos5l_antennanp
XANTENNA__3889__A Tile_X0Y5_FrameData[30] VPWR VGND sg13cmos5l_antennanp
XFILLER_245_137 VPWR VGND sg13cmos5l_decap_8
XFILLER_280_55 VPWR VGND sg13cmos5l_decap_4
X_3278_ _3278_/Q Tile_X0Y5_FrameData[2] Tile_X0Y5_FrameStrobe[6] VPWR VGND sg13cmos5l_dlhq_1
XANTENNA__3104__D Tile_X0Y5_FrameData[16] VPWR VGND sg13cmos5l_antennanp
XFILLER_245_148 VPWR VGND sg13cmos5l_fill_1
X_2229_ _2229_/Q Tile_X0Y1_FrameData[27] Tile_X0Y5_FrameStrobe[8] VPWR VGND sg13cmos5l_dlhq_1
XANTENNA__1780__GATE Tile_X0Y5_FrameStrobe[2] VPWR VGND sg13cmos5l_antennanp
XFILLER_289_20 VPWR VGND sg13cmos5l_fill_1
XFILLER_53_231 VPWR VGND sg13cmos5l_fill_2
XFILLER_53_220 VPWR VGND sg13cmos5l_decap_8
XANTENNA__2943__D Tile_X0Y4_FrameData[1] VPWR VGND sg13cmos5l_antennanp
XFILLER_53_275 VPWR VGND sg13cmos5l_fill_1
XANTENNA__2539__GATE Tile_X0Y5_FrameStrobe[0] VPWR VGND sg13cmos5l_antennanp
XFILLER_201_207 VPWR VGND sg13cmos5l_fill_2
XFILLER_289_97 VPWR VGND sg13cmos5l_fill_2
XANTENNA__1063__A2 Tile_X0Y5_N4END[4] VPWR VGND sg13cmos5l_antennanp
XANTENNA__1795__GATE Tile_X0Y5_FrameStrobe[3] VPWR VGND sg13cmos5l_antennanp
XFILLER_166_133 VPWR VGND sg13cmos5l_fill_1
XFILLER_21_150 VPWR VGND sg13cmos5l_fill_1
XFILLER_42_68 VPWR VGND sg13cmos5l_decap_8
XANTENNA__3416__X Tile_X0Y2_FrameData_O[18] VPWR VGND sg13cmos5l_antennanp
XFILLER_323_174 VPWR VGND sg13cmos5l_decap_8
XANTENNA__1733__GATE Tile_X0Y5_FrameStrobe[1] VPWR VGND sg13cmos5l_antennanp
XFILLER_122_258 VPWR VGND sg13cmos5l_decap_4
XFILLER_88_183 VPWR VGND sg13cmos5l_decap_8
XANTENNA__3799__A Tile_X0Y4_FrameData[21] VPWR VGND sg13cmos5l_antennanp
XFILLER_184_0 VPWR VGND sg13cmos5l_fill_2
XFILLER_67_98 VPWR VGND sg13cmos5l_decap_4
XANTENNA__3014__D Tile_X0Y4_FrameData[26] VPWR VGND sg13cmos5l_antennanp
XANTENNA__1748__GATE Tile_X0Y5_FrameStrobe[1] VPWR VGND sg13cmos5l_antennanp
XFILLER_83_42 VPWR VGND sg13cmos5l_decap_8
XANTENNA__2853__D Tile_X0Y4_FrameData[27] VPWR VGND sg13cmos5l_antennanp
XFILLER_189_258 VPWR VGND sg13cmos5l_fill_2
XFILLER_199_86 VPWR VGND sg13cmos5l_decap_4
XANTENNA__0801__A2 AXI_M_SOC_RVALID VPWR VGND sg13cmos5l_antennanp
XFILLER_218_27 VPWR VGND sg13cmos5l_decap_8
X_1600_ _1600_/Y _2717_/Q _1599_/X _2716_/Q VPWR VGND sg13cmos5l_o21ai_1
XANTENNA__1357__A3 Tile_X0Y0_S4END[8] VPWR VGND sg13cmos5l_antennanp
X_2580_ _2580_/Q Tile_X0Y3_FrameData[28] Tile_X0Y5_FrameStrobe[2] VPWR VGND sg13cmos5l_dlhq_1
X_1531_ _3695_/A Tile_X0Y3_WW4END[1] _1530_/X AXI_M_SOC_RDATA7 _1219_/X _2643_/Q _2644_/Q
+ VPWR VGND sg13cmos5l_mux4_1
X_1462_ _3368_/A Tile_X0Y2_W2END[1] AXI_M_SOC_RDATA15 _1143_/X _1175_/X _2404_/Q _2403_/Q
+ VPWR VGND sg13cmos5l_mux4_1
XANTENNA__1932__D Tile_X0Y0_FrameData[20] VPWR VGND sg13cmos5l_antennanp
X_3201_ _3201_/Q Tile_X0Y5_FrameData[15] Tile_X0Y5_FrameStrobe[4] VPWR VGND sg13cmos5l_dlhq_1
XANTENNA__1514__A0 Tile_X0Y3_WW4END[12] VPWR VGND sg13cmos5l_antennanp
X_3132_ _3132_/Q Tile_X0Y5_FrameData[20] Tile_X0Y5_FrameStrobe[2] VPWR VGND sg13cmos5l_dlhq_1
X_1393_ _1393_/X _1315_/X _1369_/X _2485_/Q VPWR VGND sg13cmos5l_mux2_1
XFILLER_267_273 VPWR VGND sg13cmos5l_decap_4
XFILLER_94_131 VPWR VGND sg13cmos5l_decap_8
XANTENNA__3254__GATE Tile_X0Y5_FrameStrobe[6] VPWR VGND sg13cmos5l_antennanp
XFILLER_227_148 VPWR VGND sg13cmos5l_fill_1
XFILLER_250_14 VPWR VGND sg13cmos5l_fill_1
X_3063_ _3063_/Q Tile_X0Y5_FrameData[25] Tile_X0Y5_FrameStrobe[0] VPWR VGND sg13cmos5l_dlhq_1
XFILLER_94_186 VPWR VGND sg13cmos5l_decap_8
XFILLER_282_265 VPWR VGND sg13cmos5l_fill_2
X_2014_ _2014_/Q Tile_X0Y1_FrameData[18] Tile_X0Y5_FrameStrobe[1] VPWR VGND sg13cmos5l_dlhq_1
XANTENNA__2763__D Tile_X0Y3_FrameData[5] VPWR VGND sg13cmos5l_antennanp
XANTENNA__1293__A2 Tile_X0Y0_S4END[7] VPWR VGND sg13cmos5l_antennanp
XFILLER_330_91 VPWR VGND sg13cmos5l_fill_1
XANTENNA__3269__GATE Tile_X0Y5_FrameStrobe[6] VPWR VGND sg13cmos5l_antennanp
XFILLER_250_173 VPWR VGND sg13cmos5l_decap_8
XANTENNA__1045__A2 Tile_X0Y0_S2MID[5] VPWR VGND sg13cmos5l_antennanp
X_2916_ _2916_/Q Tile_X0Y4_FrameData[28] Tile_X0Y5_FrameStrobe[4] VPWR VGND sg13cmos5l_dlhq_1
X_3896_ Tile_X0Y5_S2BEG[1] _3896_/A VPWR VGND sg13cmos5l_buf_1
XFILLER_12_16 VPWR VGND sg13cmos5l_fill_2
XFILLER_148_166 VPWR VGND sg13cmos5l_fill_2
X_2847_ _2847_/Q Tile_X0Y4_FrameData[1] Tile_X0Y5_FrameStrobe[1] VPWR VGND sg13cmos5l_dlhq_1
XFILLER_337_244 VPWR VGND sg13cmos5l_decap_4
XFILLER_128_27 VPWR VGND sg13cmos5l_fill_2
XFILLER_12_38 VPWR VGND sg13cmos5l_fill_2
XFILLER_163_125 VPWR VGND sg13cmos5l_decap_8
XFILLER_337_277 VPWR VGND sg13cmos5l_fill_1
XFILLER_163_136 VPWR VGND sg13cmos5l_fill_2
X_2778_ _2778_/Q Tile_X0Y3_FrameData[22] Tile_X0Y5_FrameStrobe[8] VPWR VGND sg13cmos5l_dlhq_1
X_1729_ _1729_/Q Tile_X0Y0_FrameData[31] Tile_X0Y5_FrameStrobe[1] VPWR VGND sg13cmos5l_dlhq_1
XANTENNA__2003__D Tile_X0Y1_FrameData[29] VPWR VGND sg13cmos5l_antennanp
XANTENNA__3207__GATE Tile_X0Y5_FrameStrobe[4] VPWR VGND sg13cmos5l_antennanp
XFILLER_144_15 VPWR VGND sg13cmos5l_decap_8
XANTENNA__2938__D Tile_X0Y4_FrameData[6] VPWR VGND sg13cmos5l_antennanp
XANTENNA__1505__A0 Tile_X0Y3_W2MID[1] VPWR VGND sg13cmos5l_antennanp
XANTENNA__1842__D Tile_X0Y0_FrameData[14] VPWR VGND sg13cmos5l_antennanp
XANTENNA__2463__GATE Tile_X0Y5_FrameStrobe[6] VPWR VGND sg13cmos5l_antennanp
XFILLER_291_76 VPWR VGND sg13cmos5l_decap_4
XFILLER_218_137 VPWR VGND sg13cmos5l_fill_2
XANTENNA__3412__A Tile_X0Y2_FrameData[14] VPWR VGND sg13cmos5l_antennanp
XFILLER_160_47 VPWR VGND sg13cmos5l_decap_8
XFILLER_160_58 VPWR VGND sg13cmos5l_fill_1
XFILLER_160_69 VPWR VGND sg13cmos5l_decap_4
XANTENNA__2478__GATE Tile_X0Y5_FrameStrobe[7] VPWR VGND sg13cmos5l_antennanp
XANTENNA__2673__D Tile_X0Y3_FrameData[31] VPWR VGND sg13cmos5l_antennanp
XFILLER_226_181 VPWR VGND sg13cmos5l_decap_8
XFILLER_310_17 VPWR VGND sg13cmos5l_fill_2
XFILLER_53_56 VPWR VGND sg13cmos5l_decap_8
XANTENNA__2401__GATE Tile_X0Y5_FrameStrobe[5] VPWR VGND sg13cmos5l_antennanp
XFILLER_319_15 VPWR VGND sg13cmos5l_fill_1
XFILLER_328_266 VPWR VGND sg13cmos5l_fill_2
XANTENNA__2416__GATE Tile_X0Y5_FrameStrobe[5] VPWR VGND sg13cmos5l_antennanp
XFILLER_185_44 VPWR VGND sg13cmos5l_decap_8
XFILLER_5_146 VPWR VGND sg13cmos5l_decap_8
XANTENNA__3009__D Tile_X0Y4_FrameData[31] VPWR VGND sg13cmos5l_antennanp
XFILLER_118_60 VPWR VGND sg13cmos5l_decap_4
XFILLER_162_180 VPWR VGND sg13cmos5l_decap_8
XFILLER_311_122 VPWR VGND sg13cmos5l_decap_8
XANTENNA__2848__D Tile_X0Y4_FrameData[0] VPWR VGND sg13cmos5l_antennanp
XFILLER_78_53 VPWR VGND sg13cmos5l_fill_1
XANTENNA__1752__D Tile_X0Y0_FrameData[8] VPWR VGND sg13cmos5l_antennanp
XFILLER_110_217 VPWR VGND sg13cmos5l_decap_8
XFILLER_264_221 VPWR VGND sg13cmos5l_fill_2
XFILLER_76_142 VPWR VGND sg13cmos5l_fill_1
XANTENNA__2583__D Tile_X0Y3_FrameData[25] VPWR VGND sg13cmos5l_antennanp
XFILLER_17_231 VPWR VGND sg13cmos5l_fill_1
XFILLER_17_253 VPWR VGND sg13cmos5l_decap_4
XANTENNA__0952__Y AXI_M_SOC_AWLEN1 VPWR VGND sg13cmos5l_antennanp
XFILLER_177_206 VPWR VGND sg13cmos5l_decap_8
X_3750_ Tile_X0Y4_E6BEG[0] _3750_/A VPWR VGND sg13cmos5l_buf_1
X_0962_ _0962_/X _1139_/X _0617_/X _0926_/X Tile_X0Y0_S4END[5] _1997_/Q _1998_/Q VPWR
+ VGND sg13cmos5l_mux4_1
XFILLER_192_209 VPWR VGND sg13cmos5l_fill_2
X_2701_ _2701_/Q Tile_X0Y3_FrameData[3] Tile_X0Y5_FrameStrobe[5] VPWR VGND sg13cmos5l_dlhq_1
XFILLER_319_255 VPWR VGND sg13cmos5l_fill_1
XANTENNA__0786__A1 Tile_X0Y5_N2END[1] VPWR VGND sg13cmos5l_antennanp
XANTENNA__1927__D Tile_X0Y0_FrameData[25] VPWR VGND sg13cmos5l_antennanp
X_3681_ Tile_X0Y3_EE4BEG[0] _3681_/A VPWR VGND sg13cmos5l_buf_1
X_0893_ AXI_M_SOC_WSTRB3 _3334_/Q _0893_/B VPWR VGND sg13cmos5l_or2_1
XFILLER_334_203 VPWR VGND sg13cmos5l_decap_4
X_2632_ _2632_/Q Tile_X0Y3_FrameData[8] Tile_X0Y5_FrameStrobe[3] VPWR VGND sg13cmos5l_dlhq_1
XFILLER_334_225 VPWR VGND sg13cmos5l_fill_1
XFILLER_245_25 VPWR VGND sg13cmos5l_decap_8
X_2563_ _2563_/Q Tile_X0Y3_FrameData[13] Tile_X0Y5_FrameStrobe[1] VPWR VGND sg13cmos5l_dlhq_1
XFILLER_299_162 VPWR VGND sg13cmos5l_fill_2
X_1514_ _3684_/A Tile_X0Y3_WW4END[12] AXI_M_SOC_RDATA9 _0882_/X _1271_/X _2666_/Q
+ _2665_/Q VPWR VGND sg13cmos5l_mux4_1
XANTENNA__2758__D Tile_X0Y3_FrameData[10] VPWR VGND sg13cmos5l_antennanp
X_2494_ _2494_/Q Tile_X0Y2_FrameData[2] Tile_X0Y5_FrameStrobe[7] VPWR VGND sg13cmos5l_dlhq_1
XFILLER_99_256 VPWR VGND sg13cmos5l_fill_2
XFILLER_4_190 VPWR VGND sg13cmos5l_decap_4
XFILLER_101_228 VPWR VGND sg13cmos5l_decap_4
X_1445_ _3382_/A Tile_X0Y2_WW4END[15] _1121_/X AXI_M_SOC_RDATA14 _1179_/X _2399_/Q
+ _2400_/Q VPWR VGND sg13cmos5l_mux4_1
XFILLER_4_83 VPWR VGND sg13cmos5l_fill_1
XANTENNA__3193__GATE Tile_X0Y5_FrameStrobe[4] VPWR VGND sg13cmos5l_antennanp
X_1376_ _1376_/X _1314_/X _1370_/X _2479_/Q VPWR VGND sg13cmos5l_mux2_1
XFILLER_67_120 VPWR VGND sg13cmos5l_decap_8
XFILLER_255_221 VPWR VGND sg13cmos5l_decap_8
XFILLER_255_254 VPWR VGND sg13cmos5l_fill_2
X_3115_ _3115_/Q Tile_X0Y5_FrameData[5] Tile_X0Y5_FrameStrobe[1] VPWR VGND sg13cmos5l_dlhq_1
X_3046_ _3046_/Q Tile_X0Y4_FrameData[26] Tile_X0Y5_FrameStrobe[8] VPWR VGND sg13cmos5l_dlhq_1
XFILLER_82_134 VPWR VGND sg13cmos5l_decap_8
XANTENNA__2493__D Tile_X0Y2_FrameData[3] VPWR VGND sg13cmos5l_antennanp
XFILLER_270_279 VPWR VGND sg13cmos5l_fill_1
XANTENNA__3131__GATE Tile_X0Y5_FrameStrobe[2] VPWR VGND sg13cmos5l_antennanp
XFILLER_139_15 VPWR VGND sg13cmos5l_decap_8
XFILLER_210_94 VPWR VGND sg13cmos5l_fill_2
XFILLER_286_21 VPWR VGND sg13cmos5l_decap_8
XANTENNA__1837__D Tile_X0Y0_FrameData[19] VPWR VGND sg13cmos5l_antennanp
XFILLER_128_8 VPWR VGND sg13cmos5l_fill_1
XFILLER_136_103 VPWR VGND sg13cmos5l_decap_8
XFILLER_176_261 VPWR VGND sg13cmos5l_decap_8
X_3879_ Tile_X0Y5_FrameData_O[20] Tile_X0Y5_FrameData[20] VPWR VGND sg13cmos5l_buf_1
XANTENNA__3146__GATE Tile_X0Y5_FrameStrobe[2] VPWR VGND sg13cmos5l_antennanp
XFILLER_219_92 VPWR VGND sg13cmos5l_fill_1
XANTENNA__3407__A Tile_X0Y2_FrameData[9] VPWR VGND sg13cmos5l_antennanp
XANTENNA__2668__D Tile_X0Y3_FrameData[4] VPWR VGND sg13cmos5l_antennanp
XFILLER_48_56 VPWR VGND sg13cmos5l_decap_4
XANTENNA__0701__A1 Tile_X0Y5_WW4END[14] VPWR VGND sg13cmos5l_antennanp
XANTENNA__1214__X AXI_M_SOC_AWADDR30 VPWR VGND sg13cmos5l_antennanp
XFILLER_321_27 VPWR VGND sg13cmos5l_fill_1
XFILLER_64_22 VPWR VGND sg13cmos5l_decap_8
XANTENNA__2340__GATE Tile_X0Y5_FrameStrobe[3] VPWR VGND sg13cmos5l_antennanp
XFILLER_64_99 VPWR VGND sg13cmos5l_decap_8
XANTENNA__1009__A2 Tile_X0Y1_W6END[1] VPWR VGND sg13cmos5l_antennanp
XANTENNA__2970__GATE Tile_X0Y5_FrameStrobe[5] VPWR VGND sg13cmos5l_antennanp
XFILLER_147_0 VPWR VGND sg13cmos5l_decap_4
XFILLER_80_21 VPWR VGND sg13cmos5l_decap_8
XANTENNA__0768__A1 Tile_X0Y5_WW4END[15] VPWR VGND sg13cmos5l_antennanp
XANTENNA__1747__D Tile_X0Y0_FrameData[13] VPWR VGND sg13cmos5l_antennanp
XFILLER_167_261 VPWR VGND sg13cmos5l_decap_8
XFILLER_196_54 VPWR VGND sg13cmos5l_decap_8
XFILLER_314_0 VPWR VGND sg13cmos5l_fill_2
XFILLER_80_98 VPWR VGND sg13cmos5l_decap_8
XANTENNA__2355__GATE Tile_X0Y5_FrameStrobe[3] VPWR VGND sg13cmos5l_antennanp
XANTENNA__2985__GATE Tile_X0Y5_FrameStrobe[6] VPWR VGND sg13cmos5l_antennanp
XFILLER_129_70 VPWR VGND sg13cmos5l_decap_4
XANTENNA__1193__A1 Tile_X0Y0_WW4END[15] VPWR VGND sg13cmos5l_antennanp
XANTENNA__2578__D Tile_X0Y3_FrameData[30] VPWR VGND sg13cmos5l_antennanp
XANTENNA__3604__X Tile_X0Y0_EE4BEG[3] VPWR VGND sg13cmos5l_antennanp
XFILLER_215_39 VPWR VGND sg13cmos5l_decap_8
XFILLER_296_165 VPWR VGND sg13cmos5l_fill_1
XFILLER_145_91 VPWR VGND sg13cmos5l_fill_1
X_1230_ _3615_/A Tile_X0Y0_WW4END[1] AXI_M_SOC_RDATA31 _1042_/X _1140_/X _1828_/Q
+ _1827_/Q VPWR VGND sg13cmos5l_mux4_1
XFILLER_96_259 VPWR VGND sg13cmos5l_decap_8
XFILLER_237_221 VPWR VGND sg13cmos5l_decap_8
XFILLER_237_232 VPWR VGND sg13cmos5l_fill_2
X_1161_ _1161_/X Tile_X0Y0_W1END[3] Tile_X0Y0_WW4END[3] _0985_/X _1137_/X _1935_/Q
+ _1933_/Q VPWR VGND sg13cmos5l_mux4_1
XANTENNA__1496__A2 AXI_M_SOC_RDATA8 VPWR VGND sg13cmos5l_antennanp
XANTENNA__2923__GATE Tile_X0Y5_FrameStrobe[4] VPWR VGND sg13cmos5l_antennanp
XFILLER_231_38 VPWR VGND sg13cmos5l_decap_8
XFILLER_252_213 VPWR VGND sg13cmos5l_decap_8
X_1092_ _1092_/X Tile_X0Y2_W2MID[4] Tile_X0Y2_W2END[4] Tile_X0Y2_W6END[4] _1187_/X
+ _2498_/Q _2497_/Q VPWR VGND sg13cmos5l_mux4_1
XFILLER_64_156 VPWR VGND sg13cmos5l_decap_4
XANTENNA__1248__A2 Tile_X0Y0_S1END[2] VPWR VGND sg13cmos5l_antennanp
XANTENNA__3202__D Tile_X0Y5_FrameData[14] VPWR VGND sg13cmos5l_antennanp
XANTENNA__2308__GATE Tile_X0Y5_FrameStrobe[2] VPWR VGND sg13cmos5l_antennanp
XANTENNA__2938__GATE Tile_X0Y5_FrameStrobe[4] VPWR VGND sg13cmos5l_antennanp
X_3802_ Tile_X0Y4_FrameData_O[24] Tile_X0Y4_FrameData[24] VPWR VGND sg13cmos5l_buf_1
X_1994_ _1994_/Q Tile_X0Y1_FrameData[6] Tile_X0Y5_FrameStrobe[0] VPWR VGND sg13cmos5l_dlhq_1
X_3733_ Tile_X0Y4_E1BEG[3] _3733_/A VPWR VGND sg13cmos5l_buf_1
X_0945_ _0945_/X Tile_X0Y1_WW4END[7] Tile_X0Y1_WW4END[15] Tile_X0Y1_W6END[7] _0944_/X
+ _2058_/Q _2057_/Q VPWR VGND sg13cmos5l_mux4_1
XANTENNA__1420__A2 Tile_X0Y2_W6END[9] VPWR VGND sg13cmos5l_antennanp
XFILLER_109_29 VPWR VGND sg13cmos5l_decap_4
XFILLER_118_125 VPWR VGND sg13cmos5l_decap_8
X_3664_ Tile_X0Y3_E2BEGb[3] _3664_/A VPWR VGND sg13cmos5l_buf_1
X_0876_ AXI_M_SOC_ARLEN6 _3115_/Q _0873_/Y _0874_/Y _0875_/Y _3332_/Q VPWR VGND sg13cmos5l_a221oi_1
XFILLER_9_293 VPWR VGND sg13cmos5l_fill_2
XFILLER_173_253 VPWR VGND sg13cmos5l_decap_8
X_2615_ _2615_/Q Tile_X0Y3_FrameData[25] Tile_X0Y5_FrameStrobe[3] VPWR VGND sg13cmos5l_dlhq_1
XFILLER_62_0 VPWR VGND sg13cmos5l_decap_8
XFILLER_133_139 VPWR VGND sg13cmos5l_decap_8
XFILLER_173_286 VPWR VGND sg13cmos5l_fill_1
X_3595_ Tile_X0Y0_FrameData_O[26] Tile_X0Y0_FrameData[26] VPWR VGND sg13cmos5l_buf_1
XANTENNA__1184__A1 Tile_X0Y0_W2END[3] VPWR VGND sg13cmos5l_antennanp
XANTENNA__2488__D Tile_X0Y2_FrameData[8] VPWR VGND sg13cmos5l_antennanp
XFILLER_126_191 VPWR VGND sg13cmos5l_decap_8
X_2546_ _2546_/Q Tile_X0Y3_FrameData[30] Tile_X0Y5_FrameStrobe[1] VPWR VGND sg13cmos5l_dlhq_1
XANTENNA__3514__X Tile_X0Y0_N4BEG[1] VPWR VGND sg13cmos5l_antennanp
XFILLER_287_165 VPWR VGND sg13cmos5l_decap_4
X_2477_ _2477_/Q Tile_X0Y2_FrameData[19] Tile_X0Y5_FrameStrobe[7] VPWR VGND sg13cmos5l_dlhq_1
X_1428_ AXI_M_SOC_WDATA30 Tile_X0Y2_W2MID[6] Tile_X0Y2_W2END[6] Tile_X0Y2_W6END[6]
+ _1175_/X _2300_/Q _2299_/Q VPWR VGND sg13cmos5l_mux4_1
XFILLER_87_237 VPWR VGND sg13cmos5l_decap_8
XANTENNA__0695__A0 Tile_X0Y5_N1END[2] VPWR VGND sg13cmos5l_antennanp
X_1359_ _3517_/A _1358_/X _1356_/X _2486_/Q VPWR VGND sg13cmos5l_mux2_1
XFILLER_55_112 VPWR VGND sg13cmos5l_decap_8
XANTENNA__1239__A2 Tile_X0Y0_W6END[0] VPWR VGND sg13cmos5l_antennanp
XANTENNA__3112__D Tile_X0Y5_FrameData[8] VPWR VGND sg13cmos5l_antennanp
X_3029_ _3029_/Q Tile_X0Y4_FrameData[11] Tile_X0Y5_FrameStrobe[7] VPWR VGND sg13cmos5l_dlhq_1
XFILLER_55_189 VPWR VGND sg13cmos5l_decap_8
XFILLER_34_36 VPWR VGND sg13cmos5l_decap_8
XANTENNA__2951__D Tile_X0Y4_FrameData[25] VPWR VGND sg13cmos5l_antennanp
XANTENNA__3070__GATE Tile_X0Y5_FrameStrobe[0] VPWR VGND sg13cmos5l_antennanp
XFILLER_140_7 VPWR VGND sg13cmos5l_decap_4
XFILLER_211_154 VPWR VGND sg13cmos5l_fill_1
XFILLER_149_272 VPWR VGND sg13cmos5l_fill_1
XANTENNA__1411__A2 Tile_X0Y2_W6END[2] VPWR VGND sg13cmos5l_antennanp
XFILLER_50_46 VPWR VGND sg13cmos5l_decap_8
XANTENNA__3085__GATE Tile_X0Y5_FrameStrobe[0] VPWR VGND sg13cmos5l_antennanp
XFILLER_109_158 VPWR VGND sg13cmos5l_decap_8
XFILLER_164_264 VPWR VGND sg13cmos5l_fill_2
XFILLER_164_275 VPWR VGND sg13cmos5l_fill_1
XFILLER_50_68 VPWR VGND sg13cmos5l_fill_2
XANTENNA__1209__X AXI_M_SOC_AWADDR21 VPWR VGND sg13cmos5l_antennanp
XFILLER_313_228 VPWR VGND sg13cmos5l_fill_1
XFILLER_306_280 VPWR VGND sg13cmos5l_fill_1
XANTENNA__2398__D Tile_X0Y2_FrameData[2] VPWR VGND sg13cmos5l_antennanp
XANTENNA__3424__X Tile_X0Y2_FrameData_O[26] VPWR VGND sg13cmos5l_antennanp
XFILLER_59_88 VPWR VGND sg13cmos5l_decap_4
XFILLER_115_72 VPWR VGND sg13cmos5l_decap_8
XFILLER_182_89 VPWR VGND sg13cmos5l_decap_8
XANTENNA__3023__GATE Tile_X0Y5_FrameStrobe[7] VPWR VGND sg13cmos5l_antennanp
XFILLER_115_83 VPWR VGND sg13cmos5l_fill_1
XFILLER_219_254 VPWR VGND sg13cmos5l_fill_1
XFILLER_293_168 VPWR VGND sg13cmos5l_decap_4
XFILLER_86_281 VPWR VGND sg13cmos5l_fill_1
XFILLER_75_32 VPWR VGND sg13cmos5l_decap_4
XFILLER_46_123 VPWR VGND sg13cmos5l_fill_1
XFILLER_46_112 VPWR VGND sg13cmos5l_decap_8
XFILLER_75_65 VPWR VGND sg13cmos5l_decap_8
XANTENNA__3022__D Tile_X0Y4_FrameData[18] VPWR VGND sg13cmos5l_antennanp
XFILLER_264_0 VPWR VGND sg13cmos5l_fill_2
XANTENNA__3600__A Tile_X0Y0_FrameData[31] VPWR VGND sg13cmos5l_antennanp
XFILLER_234_279 VPWR VGND sg13cmos5l_fill_1
XFILLER_91_31 VPWR VGND sg13cmos5l_decap_8
XFILLER_61_148 VPWR VGND sg13cmos5l_decap_8
XANTENNA__0989__A1 Tile_X0Y5_W6END[2] VPWR VGND sg13cmos5l_antennanp
XANTENNA__2861__D Tile_X0Y4_FrameData[19] VPWR VGND sg13cmos5l_antennanp
XANTENNA__3038__GATE Tile_X0Y5_FrameStrobe[7] VPWR VGND sg13cmos5l_antennanp
XANTENNA__1650__A2 Tile_X0Y4_W6END[0] VPWR VGND sg13cmos5l_antennanp
XFILLER_202_143 VPWR VGND sg13cmos5l_decap_8
XFILLER_202_154 VPWR VGND sg13cmos5l_fill_2
XANTENNA__2294__GATE Tile_X0Y5_FrameStrobe[1] VPWR VGND sg13cmos5l_antennanp
XFILLER_24_91 VPWR VGND sg13cmos5l_decap_8
X_0730_ _0730_/X Tile_X0Y3_W1END[3] Tile_X0Y3_W6END[11] _1586_/B _0729_/X _2742_/Q
+ _2741_/Q VPWR VGND sg13cmos5l_mux4_1
XFILLER_115_139 VPWR VGND sg13cmos5l_decap_8
XFILLER_170_223 VPWR VGND sg13cmos5l_decap_8
X_2400_ _2400_/Q Tile_X0Y2_FrameData[0] Tile_X0Y5_FrameStrobe[4] VPWR VGND sg13cmos5l_dlhq_1
X_0661_ _0661_/Y _3264_/Q _0657_/X _0660_/Y VPWR VGND sg13cmos5l_a21oi_1
XFILLER_6_285 VPWR VGND sg13cmos5l_fill_2
XFILLER_6_274 VPWR VGND sg13cmos5l_fill_2
XANTENNA__1166__A1 AXI_M_SOC_BVALID VPWR VGND sg13cmos5l_antennanp
X_3380_ Tile_X0Y2_E6BEG[10] _3380_/A VPWR VGND sg13cmos5l_buf_1
X_0592_ _1054_/B Tile_X0Y4_W1END[0] Tile_X0Y4_W6END[8] _1070_/X _0591_/X _3020_/Q
+ _3019_/Q VPWR VGND sg13cmos5l_mux4_1
XFILLER_170_278 VPWR VGND sg13cmos5l_fill_2
X_2331_ _2331_/Q Tile_X0Y2_FrameData[5] Tile_X0Y5_FrameStrobe[2] VPWR VGND sg13cmos5l_dlhq_1
XFILLER_69_226 VPWR VGND sg13cmos5l_fill_2
XANTENNA__2101__D Tile_X0Y1_FrameData[27] VPWR VGND sg13cmos5l_antennanp
XANTENNA__2232__GATE Tile_X0Y5_FrameStrobe[8] VPWR VGND sg13cmos5l_antennanp
X_2262_ _2262_/Q Tile_X0Y2_FrameData[10] Tile_X0Y5_FrameStrobe[0] VPWR VGND sg13cmos5l_dlhq_1
XANTENNA__2862__GATE Tile_X0Y5_FrameStrobe[2] VPWR VGND sg13cmos5l_antennanp
X_1213_ AXI_M_SOC_AWADDR31 Tile_X0Y0_W2MID[7] Tile_X0Y0_W2END[7] Tile_X0Y0_W6END[7]
+ _1136_/X _1754_/Q _1753_/Q VPWR VGND sg13cmos5l_mux4_1
XANTENNA__1940__D Tile_X0Y0_FrameData[12] VPWR VGND sg13cmos5l_antennanp
X_2193_ _2193_/Q Tile_X0Y1_FrameData[31] Tile_X0Y5_FrameStrobe[7] VPWR VGND sg13cmos5l_dlhq_1
XFILLER_1_51 VPWR VGND sg13cmos5l_fill_2
XFILLER_225_213 VPWR VGND sg13cmos5l_fill_2
X_1144_ _3538_/A Tile_X0Y0_W2MID[6] Tile_X0Y0_W2END[6] Tile_X0Y0_W6END[6] _1140_/X
+ _1958_/Q _1957_/Q VPWR VGND sg13cmos5l_mux4_1
XFILLER_92_251 VPWR VGND sg13cmos5l_decap_8
XANTENNA__2247__GATE Tile_X0Y5_FrameStrobe[0] VPWR VGND sg13cmos5l_antennanp
XFILLER_225_246 VPWR VGND sg13cmos5l_fill_2
X_1075_ _1075_/X _1079_/X _1067_/X Tile_X0Y0_S1END[0] Tile_X0Y0_S4END[0] _1752_/Q
+ _1751_/Q VPWR VGND sg13cmos5l_mux4_1
XFILLER_37_167 VPWR VGND sg13cmos5l_decap_4
XANTENNA__2877__GATE Tile_X0Y5_FrameStrobe[2] VPWR VGND sg13cmos5l_antennanp
XFILLER_52_137 VPWR VGND sg13cmos5l_decap_8
XANTENNA__2771__D Tile_X0Y3_FrameData[29] VPWR VGND sg13cmos5l_antennanp
XANTENNA__1641__A2 Tile_X0Y4_W6END[4] VPWR VGND sg13cmos5l_antennanp
XANTENNA__2800__GATE Tile_X0Y5_FrameStrobe[0] VPWR VGND sg13cmos5l_antennanp
XANTENNA__3509__X Tile_X0Y1_E1BEG[1] VPWR VGND sg13cmos5l_antennanp
X_3716_ Tile_X0Y3_FrameData_O[19] Tile_X0Y3_FrameData[19] VPWR VGND sg13cmos5l_buf_1
X_1977_ _1977_/Q Tile_X0Y1_FrameData[23] Tile_X0Y5_FrameStrobe[0] VPWR VGND sg13cmos5l_dlhq_1
X_0928_ _0928_/X Tile_X0Y1_WW4END[5] Tile_X0Y1_WW4END[13] Tile_X0Y1_W6END[5] _0927_/X
+ _2062_/Q _2061_/Q VPWR VGND sg13cmos5l_mux4_1
XANTENNA__2815__GATE Tile_X0Y5_FrameStrobe[0] VPWR VGND sg13cmos5l_antennanp
XFILLER_106_117 VPWR VGND sg13cmos5l_decap_8
XFILLER_146_275 VPWR VGND sg13cmos5l_decap_4
XFILLER_283_22 VPWR VGND sg13cmos5l_fill_1
X_3647_ Tile_X0Y0_E1BEG[2] _3647_/A VPWR VGND sg13cmos5l_buf_1
X_0859_ _0859_/Y _3122_/Q Tile_X0Y5_W2MID[3] VPWR VGND sg13cmos5l_nand2b_1
XFILLER_136_49 VPWR VGND sg13cmos5l_decap_8
XFILLER_161_234 VPWR VGND sg13cmos5l_decap_8
X_3578_ Tile_X0Y0_FrameData_O[9] Tile_X0Y0_FrameData[9] VPWR VGND sg13cmos5l_buf_1
XANTENNA__3107__D Tile_X0Y5_FrameData[13] VPWR VGND sg13cmos5l_antennanp
XFILLER_114_161 VPWR VGND sg13cmos5l_decap_8
X_2529_ _2529_/Q Tile_X0Y3_FrameData[15] Tile_X0Y5_FrameStrobe[0] VPWR VGND sg13cmos5l_dlhq_1
XANTENNA__2011__D Tile_X0Y1_FrameData[21] VPWR VGND sg13cmos5l_antennanp
XFILLER_216_82 VPWR VGND sg13cmos5l_decap_8
XFILLER_275_102 VPWR VGND sg13cmos5l_fill_1
XANTENNA__2946__D Tile_X0Y4_FrameData[30] VPWR VGND sg13cmos5l_antennanp
XANTENNA__1850__D Tile_X0Y0_FrameData[6] VPWR VGND sg13cmos5l_antennanp
XFILLER_216_213 VPWR VGND sg13cmos5l_decap_8
XFILLER_216_235 VPWR VGND sg13cmos5l_decap_8
XFILLER_216_246 VPWR VGND sg13cmos5l_fill_1
XFILLER_45_35 VPWR VGND sg13cmos5l_decap_8
XANTENNA__3420__A Tile_X0Y2_FrameData[22] VPWR VGND sg13cmos5l_antennanp
XFILLER_43_159 VPWR VGND sg13cmos5l_decap_8
XANTENNA__1093__A0 Tile_X0Y0_W2MID[4] VPWR VGND sg13cmos5l_antennanp
XANTENNA__2681__D Tile_X0Y3_FrameData[23] VPWR VGND sg13cmos5l_antennanp
XFILLER_101_52 VPWR VGND sg13cmos5l_decap_8
XANTENNA__1632__A2 Tile_X0Y4_WW4END[8] VPWR VGND sg13cmos5l_antennanp
XFILLER_101_74 VPWR VGND sg13cmos5l_decap_8
XANTENNA__0840__A0 Tile_X0Y5_W1END[0] VPWR VGND sg13cmos5l_antennanp
XANTENNA__3419__X Tile_X0Y2_FrameData_O[21] VPWR VGND sg13cmos5l_antennanp
XFILLER_137_231 VPWR VGND sg13cmos5l_fill_1
XFILLER_196_197 VPWR VGND sg13cmos5l_decap_8
XFILLER_61_78 VPWR VGND sg13cmos5l_decap_8
XFILLER_137_286 VPWR VGND sg13cmos5l_fill_1
XFILLER_193_11 VPWR VGND sg13cmos5l_fill_1
XFILLER_298_227 VPWR VGND sg13cmos5l_fill_2
XFILLER_193_88 VPWR VGND sg13cmos5l_decap_8
XFILLER_3_266 VPWR VGND sg13cmos5l_fill_1
XANTENNA__3017__D Tile_X0Y4_FrameData[23] VPWR VGND sg13cmos5l_antennanp
XANTENNA__2856__D Tile_X0Y4_FrameData[24] VPWR VGND sg13cmos5l_antennanp
XFILLER_266_124 VPWR VGND sg13cmos5l_decap_8
XANTENNA__1760__D Tile_X0Y0_FrameData[0] VPWR VGND sg13cmos5l_antennanp
XFILLER_222_205 VPWR VGND sg13cmos5l_decap_4
XFILLER_34_137 VPWR VGND sg13cmos5l_decap_8
XANTENNA__2591__D Tile_X0Y3_FrameData[17] VPWR VGND sg13cmos5l_antennanp
XANTENNA__1084__A0 Tile_X0Y0_W1END[1] VPWR VGND sg13cmos5l_antennanp
XFILLER_187_142 VPWR VGND sg13cmos5l_fill_2
X_2880_ _2880_/Q Tile_X0Y4_FrameData[0] Tile_X0Y5_FrameStrobe[2] VPWR VGND sg13cmos5l_dlhq_1
X_1900_ _1900_/Q Tile_X0Y0_FrameData[20] Tile_X0Y5_FrameStrobe[6] VPWR VGND sg13cmos5l_dlhq_1
XFILLER_230_293 VPWR VGND sg13cmos5l_fill_2
X_1831_ _1831_/Q Tile_X0Y0_FrameData[25] Tile_X0Y5_FrameStrobe[4] VPWR VGND sg13cmos5l_dlhq_1
XFILLER_336_128 VPWR VGND sg13cmos5l_decap_8
XFILLER_336_117 VPWR VGND sg13cmos5l_fill_1
X_1762_ _1762_/Q Tile_X0Y0_FrameData[30] Tile_X0Y5_FrameStrobe[2] VPWR VGND sg13cmos5l_dlhq_1
XANTENNA__1935__D Tile_X0Y0_FrameData[17] VPWR VGND sg13cmos5l_antennanp
XFILLER_143_201 VPWR VGND sg13cmos5l_fill_2
X_3501_ Tile_X0Y1_E2BEG[1] _3501_/A VPWR VGND sg13cmos5l_buf_1
X_1693_ _3894_/A Tile_X0Y5_W1END[3] Tile_X0Y5_W6END[11] _0740_/X _1134_/Y _3286_/Q
+ _3285_/Q VPWR VGND sg13cmos5l_mux4_1
X_0713_ _0713_/Y _1970_/Q _2241_/Q VPWR VGND sg13cmos5l_nor2b_1
XANTENNA__1139__A1 Tile_X0Y2_W6END[5] VPWR VGND sg13cmos5l_antennanp
XFILLER_289_249 VPWR VGND sg13cmos5l_decap_8
X_3432_ Tile_X0Y1_FrameData_O[0] Tile_X0Y1_FrameData[0] VPWR VGND sg13cmos5l_buf_1
X_0644_ _0644_/X _0643_/X _0642_/X _2176_/Q VPWR VGND sg13cmos5l_mux2_1
X_3363_ Tile_X0Y2_E2BEGb[1] _3363_/A VPWR VGND sg13cmos5l_buf_1
XANTENNA__2171__GATE Tile_X0Y5_FrameStrobe[6] VPWR VGND sg13cmos5l_antennanp
X_0575_ _0575_/Y _2248_/Q _2247_/Q VPWR VGND sg13cmos5l_nor2b_1
XFILLER_25_0 VPWR VGND sg13cmos5l_fill_2
X_3294_ _3294_/Q Tile_X0Y5_FrameData[18] Tile_X0Y5_FrameStrobe[7] VPWR VGND sg13cmos5l_dlhq_1
X_2314_ _2314_/Q Tile_X0Y2_FrameData[22] Tile_X0Y5_FrameStrobe[2] VPWR VGND sg13cmos5l_dlhq_1
XFILLER_57_207 VPWR VGND sg13cmos5l_decap_8
XANTENNA__2766__D Tile_X0Y3_FrameData[2] VPWR VGND sg13cmos5l_antennanp
XFILLER_111_164 VPWR VGND sg13cmos5l_decap_8
XFILLER_111_175 VPWR VGND sg13cmos5l_fill_1
XFILLER_257_179 VPWR VGND sg13cmos5l_decap_8
X_2245_ _2245_/Q Tile_X0Y2_FrameData[27] Tile_X0Y5_FrameStrobe[0] VPWR VGND sg13cmos5l_dlhq_1
XFILLER_333_80 VPWR VGND sg13cmos5l_decap_4
XANTENNA__2186__GATE Tile_X0Y5_FrameStrobe[6] VPWR VGND sg13cmos5l_antennanp
X_2176_ _2176_/Q Tile_X0Y1_FrameData[16] Tile_X0Y5_FrameStrobe[6] VPWR VGND sg13cmos5l_dlhq_1
XFILLER_65_240 VPWR VGND sg13cmos5l_decap_8
XANTENNA__1311__A1 Tile_X0Y1_W2END[5] VPWR VGND sg13cmos5l_antennanp
X_1127_ _1127_/X _1135_/X _0730_/X Tile_X0Y5_N4END[7] _0980_/X _2809_/Q _2810_/Q VPWR
+ VGND sg13cmos5l_mux4_1
XFILLER_65_251 VPWR VGND sg13cmos5l_fill_2
XFILLER_213_205 VPWR VGND sg13cmos5l_fill_2
XFILLER_25_137 VPWR VGND sg13cmos5l_decap_8
XFILLER_15_27 VPWR VGND sg13cmos5l_fill_1
XFILLER_206_290 VPWR VGND sg13cmos5l_decap_4
X_1058_ _1058_/X _1051_/X _0574_/X Tile_X0Y5_N4END[12] Tile_X0Y0_S4END[8] _2271_/Q
+ _2272_/Q VPWR VGND sg13cmos5l_mux4_1
XANTENNA__1614__A2 AXI_M_SOC_RDATA3 VPWR VGND sg13cmos5l_antennanp
XANTENNA__0822__A0 Tile_X0Y5_WW4END[1] VPWR VGND sg13cmos5l_antennanp
XFILLER_221_293 VPWR VGND sg13cmos5l_fill_2
XANTENNA__2006__D Tile_X0Y1_FrameData[26] VPWR VGND sg13cmos5l_antennanp
XFILLER_278_99 VPWR VGND sg13cmos5l_decap_4
XANTENNA__2124__GATE Tile_X0Y5_FrameStrobe[4] VPWR VGND sg13cmos5l_antennanp
XFILLER_119_242 VPWR VGND sg13cmos5l_decap_8
XFILLER_119_253 VPWR VGND sg13cmos5l_fill_2
XFILLER_147_15 VPWR VGND sg13cmos5l_decap_8
XANTENNA__1845__D Tile_X0Y0_FrameData[11] VPWR VGND sg13cmos5l_antennanp
XANTENNA__2754__GATE Tile_X0Y5_FrameStrobe[7] VPWR VGND sg13cmos5l_antennanp
XFILLER_147_59 VPWR VGND sg13cmos5l_decap_8
XFILLER_193_189 VPWR VGND sg13cmos5l_decap_4
XFILLER_335_183 VPWR VGND sg13cmos5l_fill_1
XANTENNA__2139__GATE Tile_X0Y5_FrameStrobe[5] VPWR VGND sg13cmos5l_antennanp
XANTENNA__0889__A0 Tile_X0Y3_W1END[2] VPWR VGND sg13cmos5l_antennanp
XANTENNA__2769__GATE Tile_X0Y5_FrameStrobe[8] VPWR VGND sg13cmos5l_antennanp
XANTENNA__3415__A Tile_X0Y2_FrameData[17] VPWR VGND sg13cmos5l_antennanp
XANTENNA__1550__A1 Tile_X0Y3_WW4END[10] VPWR VGND sg13cmos5l_antennanp
XFILLER_288_293 VPWR VGND sg13cmos5l_fill_2
XANTENNA__2676__D Tile_X0Y3_FrameData[28] VPWR VGND sg13cmos5l_antennanp
XFILLER_248_168 VPWR VGND sg13cmos5l_decap_8
XANTENNA__3702__X Tile_X0Y3_FrameData_O[5] VPWR VGND sg13cmos5l_antennanp
XFILLER_186_4 VPWR VGND sg13cmos5l_fill_2
XFILLER_243_91 VPWR VGND sg13cmos5l_fill_2
XFILLER_56_45 VPWR VGND sg13cmos5l_decap_4
XFILLER_56_89 VPWR VGND sg13cmos5l_decap_4
XFILLER_112_62 VPWR VGND sg13cmos5l_decap_8
XFILLER_72_33 VPWR VGND sg13cmos5l_decap_8
XANTENNA__1066__A0 Tile_X0Y4_W1END[0] VPWR VGND sg13cmos5l_antennanp
XANTENNA__2707__GATE Tile_X0Y5_FrameStrobe[6] VPWR VGND sg13cmos5l_antennanp
XANTENNA__3300__D Tile_X0Y5_FrameData[12] VPWR VGND sg13cmos5l_antennanp
XFILLER_188_22 VPWR VGND sg13cmos5l_decap_4
XANTENNA__0813__A0 Tile_X0Y5_WW4END[10] VPWR VGND sg13cmos5l_antennanp
XFILLER_169_175 VPWR VGND sg13cmos5l_fill_1
XFILLER_72_88 VPWR VGND sg13cmos5l_decap_4
XANTENNA__1963__GATE Tile_X0Y5_FrameStrobe[8] VPWR VGND sg13cmos5l_antennanp
XFILLER_212_293 VPWR VGND sg13cmos5l_fill_2
XFILLER_227_0 VPWR VGND sg13cmos5l_fill_2
XFILLER_338_47 VPWR VGND sg13cmos5l_fill_2
XANTENNA__1755__D Tile_X0Y0_FrameData[5] VPWR VGND sg13cmos5l_antennanp
XANTENNA__1978__GATE Tile_X0Y5_FrameStrobe[0] VPWR VGND sg13cmos5l_antennanp
XFILLER_125_256 VPWR VGND sg13cmos5l_decap_8
XFILLER_140_204 VPWR VGND sg13cmos5l_fill_1
XFILLER_98_107 VPWR VGND sg13cmos5l_decap_8
XFILLER_279_260 VPWR VGND sg13cmos5l_fill_1
XANTENNA__1901__GATE Tile_X0Y5_FrameStrobe[6] VPWR VGND sg13cmos5l_antennanp
XANTENNA__2586__D Tile_X0Y3_FrameData[22] VPWR VGND sg13cmos5l_antennanp
XANTENNA__3612__X Tile_X0Y0_EE4BEG[11] VPWR VGND sg13cmos5l_antennanp
X_2030_ _2030_/Q Tile_X0Y1_FrameData[2] Tile_X0Y5_FrameStrobe[1] VPWR VGND sg13cmos5l_dlhq_1
XANTENNA__0955__Y AXI_M_SOC_AWLEN2 VPWR VGND sg13cmos5l_antennanp
XFILLER_47_273 VPWR VGND sg13cmos5l_fill_1
XANTENNA__1916__GATE Tile_X0Y5_FrameStrobe[6] VPWR VGND sg13cmos5l_antennanp
XFILLER_262_160 VPWR VGND sg13cmos5l_fill_2
XANTENNA__1057__A0 Tile_X0Y1_W1END[1] VPWR VGND sg13cmos5l_antennanp
XANTENNA__3210__D Tile_X0Y5_FrameData[6] VPWR VGND sg13cmos5l_antennanp
X_2932_ _2932_/Q Tile_X0Y4_FrameData[12] Tile_X0Y5_FrameStrobe[4] VPWR VGND sg13cmos5l_dlhq_1
XANTENNA__0804__A0 Tile_X0Y5_W2END[3] VPWR VGND sg13cmos5l_antennanp
XFILLER_15_192 VPWR VGND sg13cmos5l_decap_8
XFILLER_203_293 VPWR VGND sg13cmos5l_fill_2
XFILLER_248_14 VPWR VGND sg13cmos5l_fill_2
XFILLER_309_128 VPWR VGND sg13cmos5l_decap_8
XFILLER_30_151 VPWR VGND sg13cmos5l_decap_8
X_2863_ _2863_/Q Tile_X0Y4_FrameData[17] Tile_X0Y5_FrameStrobe[2] VPWR VGND sg13cmos5l_dlhq_1
XFILLER_248_47 VPWR VGND sg13cmos5l_decap_8
X_2794_ _2794_/Q Tile_X0Y4_FrameData[22] Tile_X0Y5_FrameStrobe[0] VPWR VGND sg13cmos5l_dlhq_1
X_1814_ _1814_/Q Tile_X0Y0_FrameData[10] Tile_X0Y5_FrameStrobe[3] VPWR VGND sg13cmos5l_dlhq_1
XFILLER_175_189 VPWR VGND sg13cmos5l_decap_8
X_1745_ _1745_/Q Tile_X0Y0_FrameData[15] Tile_X0Y5_FrameStrobe[1] VPWR VGND sg13cmos5l_dlhq_1
XFILLER_117_18 VPWR VGND sg13cmos5l_fill_1
X_1676_ _3763_/A Tile_X0Y4_WW4END[14] _1013_/X AXI_M_SOC_RRESP1 _1360_/X _2941_/Q
+ _2942_/Q VPWR VGND sg13cmos5l_mux4_1
XFILLER_89_107 VPWR VGND sg13cmos5l_decap_8
XANTENNA__1307__X AXI_M_SOC_AWADDR3 VPWR VGND sg13cmos5l_antennanp
X_3415_ Tile_X0Y2_FrameData_O[17] Tile_X0Y2_FrameData[17] VPWR VGND sg13cmos5l_buf_1
X_0627_ _0627_/Y _2245_/Q _0627_/B _0627_/C VPWR VGND sg13cmos5l_nor3_1
X_3346_ _3346_/Q Tile_X0Y5_FrameData[12] Tile_X0Y5_FrameStrobe[8] VPWR VGND sg13cmos5l_dlhq_1
X_0558_ _0558_/X Tile_X0Y3_W1END[2] Tile_X0Y3_W2MID[1] Tile_X0Y3_W2END[1] _1348_/X
+ _2728_/Q _2727_/Q VPWR VGND sg13cmos5l_mux4_1
XANTENNA__1532__A1 AXI_M_SOC_RDATA12 VPWR VGND sg13cmos5l_antennanp
XANTENNA__2496__D Tile_X0Y2_FrameData[0] VPWR VGND sg13cmos5l_antennanp
XFILLER_280_12 VPWR VGND sg13cmos5l_fill_1
XFILLER_97_195 VPWR VGND sg13cmos5l_decap_8
XANTENNA__3522__X Tile_X0Y0_N4BEG[9] VPWR VGND sg13cmos5l_antennanp
XFILLER_280_67 VPWR VGND sg13cmos5l_decap_8
X_3277_ _3277_/Q Tile_X0Y5_FrameData[3] Tile_X0Y5_FrameStrobe[6] VPWR VGND sg13cmos5l_dlhq_1
X_2228_ _2228_/Q Tile_X0Y1_FrameData[28] Tile_X0Y5_FrameStrobe[8] VPWR VGND sg13cmos5l_dlhq_1
X_2159_ _2159_/Q Tile_X0Y1_FrameData[1] Tile_X0Y5_FrameStrobe[5] VPWR VGND sg13cmos5l_dlhq_1
XFILLER_38_284 VPWR VGND sg13cmos5l_fill_2
XANTENNA__1048__A0 Tile_X0Y5_W2MID[6] VPWR VGND sg13cmos5l_antennanp
XANTENNA__3120__D Tile_X0Y5_FrameData[0] VPWR VGND sg13cmos5l_antennanp
XANTENNA__2063__GATE Tile_X0Y5_FrameStrobe[2] VPWR VGND sg13cmos5l_antennanp
XFILLER_42_47 VPWR VGND sg13cmos5l_decap_8
XANTENNA__2693__GATE Tile_X0Y5_FrameStrobe[5] VPWR VGND sg13cmos5l_antennanp
XFILLER_181_148 VPWR VGND sg13cmos5l_decap_8
XANTENNA__0574__A2 Tile_X0Y1_W6END[8] VPWR VGND sg13cmos5l_antennanp
XANTENNA__2078__GATE Tile_X0Y5_FrameStrobe[3] VPWR VGND sg13cmos5l_antennanp
XFILLER_122_237 VPWR VGND sg13cmos5l_decap_8
XANTENNA__2001__GATE Tile_X0Y5_FrameStrobe[1] VPWR VGND sg13cmos5l_antennanp
XFILLER_67_22 VPWR VGND sg13cmos5l_decap_4
XANTENNA__2631__GATE Tile_X0Y5_FrameStrobe[3] VPWR VGND sg13cmos5l_antennanp
XANTENNA__3432__X Tile_X0Y1_FrameData_O[0] VPWR VGND sg13cmos5l_antennanp
XFILLER_130_281 VPWR VGND sg13cmos5l_fill_2
XANTENNA__1287__A0 Tile_X0Y1_WW4END[4] VPWR VGND sg13cmos5l_antennanp
XANTENNA__2016__GATE Tile_X0Y5_FrameStrobe[1] VPWR VGND sg13cmos5l_antennanp
XFILLER_177_0 VPWR VGND sg13cmos5l_fill_1
XFILLER_291_277 VPWR VGND sg13cmos5l_fill_1
XFILLER_83_21 VPWR VGND sg13cmos5l_decap_8
XFILLER_44_232 VPWR VGND sg13cmos5l_fill_1
XANTENNA__2646__GATE Tile_X0Y5_FrameStrobe[4] VPWR VGND sg13cmos5l_antennanp
XFILLER_199_32 VPWR VGND sg13cmos5l_decap_8
XANTENNA__3030__D Tile_X0Y4_FrameData[10] VPWR VGND sg13cmos5l_antennanp
XFILLER_200_230 VPWR VGND sg13cmos5l_fill_2
XFILLER_200_252 VPWR VGND sg13cmos5l_fill_1
XFILLER_73_8 VPWR VGND sg13cmos5l_decap_8
XFILLER_172_126 VPWR VGND sg13cmos5l_decap_8
XANTENNA__1211__A0 Tile_X0Y0_W2MID[4] VPWR VGND sg13cmos5l_antennanp
XANTENNA__3607__X Tile_X0Y0_EE4BEG[6] VPWR VGND sg13cmos5l_antennanp
XFILLER_314_153 VPWR VGND sg13cmos5l_fill_1
X_1530_ _1530_/X _1017_/X _0629_/X Tile_X0Y5_N4END[9] Tile_X0Y0_S4END[13] _2565_/Q
+ _2566_/Q VPWR VGND sg13cmos5l_mux4_1
XFILLER_113_215 VPWR VGND sg13cmos5l_decap_4
X_1461_ _3367_/A Tile_X0Y2_W2END[2] AXI_M_SOC_RDATA16 _1151_/X _1183_/X _2406_/Q _2405_/Q
+ VPWR VGND sg13cmos5l_mux4_1
XANTENNA__1840__GATE Tile_X0Y5_FrameStrobe[4] VPWR VGND sg13cmos5l_antennanp
XFILLER_113_248 VPWR VGND sg13cmos5l_decap_8
X_3200_ _3200_/Q Tile_X0Y5_FrameData[16] Tile_X0Y5_FrameStrobe[4] VPWR VGND sg13cmos5l_dlhq_1
X_1392_ _1392_/Y _2485_/Q _1143_/X _1391_/Y VPWR VGND sg13cmos5l_a21oi_1
XANTENNA__1514__A1 AXI_M_SOC_RDATA9 VPWR VGND sg13cmos5l_antennanp
X_3131_ _3131_/Q Tile_X0Y5_FrameData[21] Tile_X0Y5_FrameStrobe[2] VPWR VGND sg13cmos5l_dlhq_1
XFILLER_94_110 VPWR VGND sg13cmos5l_decap_8
XANTENNA__3205__D Tile_X0Y5_FrameData[11] VPWR VGND sg13cmos5l_antennanp
XFILLER_121_281 VPWR VGND sg13cmos5l_fill_1
XFILLER_121_292 VPWR VGND sg13cmos5l_fill_2
XANTENNA__1855__GATE Tile_X0Y5_FrameStrobe[4] VPWR VGND sg13cmos5l_antennanp
XFILLER_282_244 VPWR VGND sg13cmos5l_fill_2
X_3062_ _3062_/Q Tile_X0Y5_FrameData[26] Tile_X0Y5_FrameStrobe[0] VPWR VGND sg13cmos5l_dlhq_1
XANTENNA__1278__A0 Tile_X0Y1_W2END[0] VPWR VGND sg13cmos5l_antennanp
XFILLER_282_277 VPWR VGND sg13cmos5l_fill_1
X_2013_ _2013_/Q Tile_X0Y1_FrameData[19] Tile_X0Y5_FrameStrobe[1] VPWR VGND sg13cmos5l_dlhq_1
XFILLER_50_202 VPWR VGND sg13cmos5l_fill_1
XFILLER_35_276 VPWR VGND sg13cmos5l_fill_1
XFILLER_330_81 VPWR VGND sg13cmos5l_fill_1
XFILLER_92_0 VPWR VGND sg13cmos5l_decap_8
XANTENNA__1045__A3 Tile_X0Y0_S2END[5] VPWR VGND sg13cmos5l_antennanp
X_2915_ _2915_/Q Tile_X0Y4_FrameData[29] Tile_X0Y5_FrameStrobe[4] VPWR VGND sg13cmos5l_dlhq_1
X_3895_ Tile_X0Y5_S2BEG[0] _3895_/A VPWR VGND sg13cmos5l_buf_1
XANTENNA__1450__A0 Tile_X0Y2_WW4END[14] VPWR VGND sg13cmos5l_antennanp
XFILLER_148_145 VPWR VGND sg13cmos5l_decap_8
X_2846_ _2846_/Q Tile_X0Y4_FrameData[2] Tile_X0Y5_FrameStrobe[1] VPWR VGND sg13cmos5l_dlhq_1
XANTENNA__1202__A0 Tile_X0Y0_WW4END[0] VPWR VGND sg13cmos5l_antennanp
XANTENNA__3517__X Tile_X0Y0_N4BEG[4] VPWR VGND sg13cmos5l_antennanp
X_2777_ _2777_/Q Tile_X0Y3_FrameData[23] Tile_X0Y5_FrameStrobe[8] VPWR VGND sg13cmos5l_dlhq_1
X_1728_ _1728_/Q Tile_X0Y0_FrameData[0] Tile_X0Y5_FrameStrobe[0] VPWR VGND sg13cmos5l_dlhq_1
XANTENNA__1808__GATE Tile_X0Y5_FrameStrobe[3] VPWR VGND sg13cmos5l_antennanp
X_1659_ _3742_/A Tile_X0Y4_W2END[7] AXI_M_SOC_RDATA5 _1073_/X _1361_/X _2960_/Q _2959_/Q
+ VPWR VGND sg13cmos5l_mux4_1
XFILLER_104_248 VPWR VGND sg13cmos5l_decap_8
XANTENNA__1505__A1 AXI_M_SOC_RDATA12 VPWR VGND sg13cmos5l_antennanp
XANTENNA__3115__D Tile_X0Y5_FrameData[5] VPWR VGND sg13cmos5l_antennanp
XFILLER_258_285 VPWR VGND sg13cmos5l_fill_2
XFILLER_291_99 VPWR VGND sg13cmos5l_decap_8
X_3329_ _3329_/Q Tile_X0Y5_FrameData[31] Tile_X0Y5_FrameStrobe[0] VPWR VGND sg13cmos5l_dlhq_1
XFILLER_37_58 VPWR VGND sg13cmos5l_decap_8
XANTENNA__1269__A0 Tile_X0Y5_W2MID[3] VPWR VGND sg13cmos5l_antennanp
XANTENNA__2954__D Tile_X0Y4_FrameData[22] VPWR VGND sg13cmos5l_antennanp
XFILLER_53_35 VPWR VGND sg13cmos5l_decap_8
XFILLER_41_213 VPWR VGND sg13cmos5l_fill_2
XFILLER_169_24 VPWR VGND sg13cmos5l_fill_1
XFILLER_169_35 VPWR VGND sg13cmos5l_fill_1
XFILLER_241_163 VPWR VGND sg13cmos5l_decap_8
XFILLER_149_4 VPWR VGND sg13cmos5l_fill_1
XFILLER_169_57 VPWR VGND sg13cmos5l_fill_2
XFILLER_186_229 VPWR VGND sg13cmos5l_decap_8
XFILLER_241_196 VPWR VGND sg13cmos5l_fill_1
XFILLER_328_256 VPWR VGND sg13cmos5l_fill_2
XFILLER_139_178 VPWR VGND sg13cmos5l_decap_8
XFILLER_185_23 VPWR VGND sg13cmos5l_decap_8
XANTENNA__3427__X Tile_X0Y2_FrameData_O[29] VPWR VGND sg13cmos5l_antennanp
XANTENNA__3314__GATE Tile_X0Y5_FrameStrobe[8] VPWR VGND sg13cmos5l_antennanp
XFILLER_118_83 VPWR VGND sg13cmos5l_decap_8
XFILLER_335_26 VPWR VGND sg13cmos5l_decap_4
XANTENNA__2570__GATE Tile_X0Y5_FrameStrobe[1] VPWR VGND sg13cmos5l_antennanp
XANTENNA__3025__D Tile_X0Y4_FrameData[15] VPWR VGND sg13cmos5l_antennanp
XANTENNA__3329__GATE Tile_X0Y5_FrameStrobe[0] VPWR VGND sg13cmos5l_antennanp
XFILLER_264_211 VPWR VGND sg13cmos5l_decap_4
XFILLER_134_93 VPWR VGND sg13cmos5l_fill_2
XFILLER_209_127 VPWR VGND sg13cmos5l_fill_1
XFILLER_209_149 VPWR VGND sg13cmos5l_decap_8
XANTENNA__2585__GATE Tile_X0Y5_FrameStrobe[2] VPWR VGND sg13cmos5l_antennanp
XANTENNA__2864__D Tile_X0Y4_FrameData[16] VPWR VGND sg13cmos5l_antennanp
XFILLER_220_29 VPWR VGND sg13cmos5l_fill_1
XANTENNA__1410__X AXI_M_SOC_WDATA13 VPWR VGND sg13cmos5l_antennanp
XANTENNA__1680__A0 Tile_X0Y4_W2END[4] VPWR VGND sg13cmos5l_antennanp
XFILLER_32_246 VPWR VGND sg13cmos5l_decap_8
XFILLER_300_62 VPWR VGND sg13cmos5l_decap_4
X_0961_ AXI_M_SOC_AWLEN4 _3337_/Q _0960_/X VPWR VGND sg13cmos5l_nor2b_1
XANTENNA__1432__A0 Tile_X0Y2_W2MID[2] VPWR VGND sg13cmos5l_antennanp
X_2700_ _2700_/Q Tile_X0Y3_FrameData[4] Tile_X0Y5_FrameStrobe[5] VPWR VGND sg13cmos5l_dlhq_1
X_3680_ Tile_X0Y3_E6BEG[11] _3680_/A VPWR VGND sg13cmos5l_buf_1
X_0892_ _0893_/B Tile_X0Y3_W1END[3] Tile_X0Y3_WW4END[15] Tile_X0Y3_WW4END[7] _1586_/B
+ _2585_/Q _2586_/Q VPWR VGND sg13cmos5l_mux4_1
XANTENNA__2104__D Tile_X0Y1_FrameData[24] VPWR VGND sg13cmos5l_antennanp
XANTENNA__2523__GATE Tile_X0Y5_FrameStrobe[0] VPWR VGND sg13cmos5l_antennanp
X_2631_ _2631_/Q Tile_X0Y3_FrameData[9] Tile_X0Y5_FrameStrobe[3] VPWR VGND sg13cmos5l_dlhq_1
XFILLER_64_4 VPWR VGND sg13cmos5l_fill_1
XFILLER_309_71 VPWR VGND sg13cmos5l_decap_8
XFILLER_309_82 VPWR VGND sg13cmos5l_fill_1
X_2562_ _2562_/Q Tile_X0Y3_FrameData[14] Tile_X0Y5_FrameStrobe[1] VPWR VGND sg13cmos5l_dlhq_1
XFILLER_334_259 VPWR VGND sg13cmos5l_decap_4
XANTENNA__1943__D Tile_X0Y0_FrameData[9] VPWR VGND sg13cmos5l_antennanp
X_1513_ _3685_/A Tile_X0Y3_WW4END[11] AXI_M_SOC_RDATA10 _0971_/X _1587_/B _2664_/Q
+ _2663_/Q VPWR VGND sg13cmos5l_mux4_1
XFILLER_99_224 VPWR VGND sg13cmos5l_decap_4
XANTENNA__2538__GATE Tile_X0Y5_FrameStrobe[0] VPWR VGND sg13cmos5l_antennanp
X_2493_ _2493_/Q Tile_X0Y2_FrameData[3] Tile_X0Y5_FrameStrobe[7] VPWR VGND sg13cmos5l_dlhq_1
XANTENNA__1499__A0 Tile_X0Y3_W2MID[7] VPWR VGND sg13cmos5l_antennanp
XFILLER_302_178 VPWR VGND sg13cmos5l_fill_1
X_1444_ _3912_/A _1441_/Y _1443_/Y _1439_/Y VPWR VGND sg13cmos5l_o21ai_1
XANTENNA__1794__GATE Tile_X0Y5_FrameStrobe[3] VPWR VGND sg13cmos5l_antennanp
X_1375_ _1375_/Y _2479_/Q _1187_/X _1374_/Y VPWR VGND sg13cmos5l_a21oi_1
X_3114_ _3114_/Q Tile_X0Y5_FrameData[6] Tile_X0Y5_FrameStrobe[1] VPWR VGND sg13cmos5l_dlhq_1
XFILLER_67_154 VPWR VGND sg13cmos5l_decap_8
XANTENNA__2774__D Tile_X0Y3_FrameData[26] VPWR VGND sg13cmos5l_antennanp
X_3045_ _3045_/Q Tile_X0Y4_FrameData[27] Tile_X0Y5_FrameStrobe[8] VPWR VGND sg13cmos5l_dlhq_1
XFILLER_67_187 VPWR VGND sg13cmos5l_decap_8
XANTENNA__3800__X Tile_X0Y4_FrameData_O[22] VPWR VGND sg13cmos5l_antennanp
XFILLER_23_213 VPWR VGND sg13cmos5l_fill_1
XFILLER_223_163 VPWR VGND sg13cmos5l_fill_1
XFILLER_23_235 VPWR VGND sg13cmos5l_fill_2
XFILLER_210_62 VPWR VGND sg13cmos5l_decap_8
XANTENNA__1423__A0 Tile_X0Y2_W1END[3] VPWR VGND sg13cmos5l_antennanp
XANTENNA__1732__GATE Tile_X0Y5_FrameStrobe[1] VPWR VGND sg13cmos5l_antennanp
XFILLER_176_240 VPWR VGND sg13cmos5l_decap_8
X_3878_ Tile_X0Y5_FrameData_O[19] Tile_X0Y5_FrameData[19] VPWR VGND sg13cmos5l_buf_1
XANTENNA__2014__D Tile_X0Y1_FrameData[18] VPWR VGND sg13cmos5l_antennanp
X_2829_ _2829_/Q Tile_X0Y4_FrameData[19] Tile_X0Y5_FrameStrobe[1] VPWR VGND sg13cmos5l_dlhq_1
XANTENNA__1747__GATE Tile_X0Y5_FrameStrobe[1] VPWR VGND sg13cmos5l_antennanp
XANTENNA__1853__D Tile_X0Y0_FrameData[3] VPWR VGND sg13cmos5l_antennanp
XANTENNA__2949__D Tile_X0Y4_FrameData[27] VPWR VGND sg13cmos5l_antennanp
XFILLER_2_117 VPWR VGND sg13cmos5l_fill_1
XFILLER_305_18 VPWR VGND sg13cmos5l_fill_2
XANTENNA__3423__A Tile_X0Y2_FrameData[25] VPWR VGND sg13cmos5l_antennanp
XFILLER_171_14 VPWR VGND sg13cmos5l_decap_4
XFILLER_48_35 VPWR VGND sg13cmos5l_decap_8
XANTENNA__2684__D Tile_X0Y3_FrameData[20] VPWR VGND sg13cmos5l_antennanp
XANTENNA__3710__X Tile_X0Y3_FrameData_O[13] VPWR VGND sg13cmos5l_antennanp
XFILLER_321_39 VPWR VGND sg13cmos5l_fill_2
XFILLER_64_78 VPWR VGND sg13cmos5l_decap_8
XANTENNA__1662__A0 Tile_X0Y4_W2MID[3] VPWR VGND sg13cmos5l_antennanp
XFILLER_14_235 VPWR VGND sg13cmos5l_fill_2
XFILLER_214_174 VPWR VGND sg13cmos5l_decap_8
XFILLER_214_185 VPWR VGND sg13cmos5l_fill_1
XANTENNA__1414__A0 Tile_X0Y2_WW4END[4] VPWR VGND sg13cmos5l_antennanp
XFILLER_196_33 VPWR VGND sg13cmos5l_decap_8
XANTENNA__0768__A2 Tile_X0Y5_W6END[7] VPWR VGND sg13cmos5l_antennanp
XFILLER_167_251 VPWR VGND sg13cmos5l_decap_4
XFILLER_182_221 VPWR VGND sg13cmos5l_fill_1
XFILLER_182_243 VPWR VGND sg13cmos5l_decap_4
XANTENNA__3253__GATE Tile_X0Y5_FrameStrobe[6] VPWR VGND sg13cmos5l_antennanp
XFILLER_307_0 VPWR VGND sg13cmos5l_fill_2
XANTENNA__2859__D Tile_X0Y4_FrameData[21] VPWR VGND sg13cmos5l_antennanp
XFILLER_89_64 VPWR VGND sg13cmos5l_decap_4
XANTENNA__1193__A2 Tile_X0Y0_W6END[7] VPWR VGND sg13cmos5l_antennanp
XANTENNA__1763__D Tile_X0Y0_FrameData[29] VPWR VGND sg13cmos5l_antennanp
XFILLER_135_192 VPWR VGND sg13cmos5l_decap_4
XANTENNA__3268__GATE Tile_X0Y5_FrameStrobe[6] VPWR VGND sg13cmos5l_antennanp
XFILLER_215_18 VPWR VGND sg13cmos5l_decap_8
XFILLER_96_216 VPWR VGND sg13cmos5l_fill_2
XFILLER_1_194 VPWR VGND sg13cmos5l_fill_1
X_1160_ _1160_/X Tile_X0Y0_W6END[11] _1124_/X _1080_/X _1148_/X _1933_/Q _1935_/Q
+ VPWR VGND sg13cmos5l_mux4_1
XANTENNA__1496__A3 AXI_M_SOC_RDATA12 VPWR VGND sg13cmos5l_antennanp
XANTENNA__2594__D Tile_X0Y3_FrameData[14] VPWR VGND sg13cmos5l_antennanp
XFILLER_231_17 VPWR VGND sg13cmos5l_fill_1
XFILLER_237_255 VPWR VGND sg13cmos5l_fill_1
XFILLER_64_124 VPWR VGND sg13cmos5l_fill_1
XFILLER_64_113 VPWR VGND sg13cmos5l_decap_4
XANTENNA__3620__X Tile_X0Y0_E6BEG[3] VPWR VGND sg13cmos5l_antennanp
X_1091_ _1091_/X Tile_X0Y3_W2MID[4] Tile_X0Y3_W2END[4] Tile_X0Y3_W6END[4] _1587_/B
+ _2770_/Q _2769_/Q VPWR VGND sg13cmos5l_mux4_1
XFILLER_64_135 VPWR VGND sg13cmos5l_decap_8
XANTENNA__1248__A3 AXI_M_SOC_BRESP1 VPWR VGND sg13cmos5l_antennanp
XFILLER_252_258 VPWR VGND sg13cmos5l_fill_1
XANTENNA__1653__A0 Tile_X0Y4_W1END[1] VPWR VGND sg13cmos5l_antennanp
XFILLER_220_100 VPWR VGND sg13cmos5l_fill_2
XFILLER_311_94 VPWR VGND sg13cmos5l_decap_8
XANTENNA__3206__GATE Tile_X0Y5_FrameStrobe[4] VPWR VGND sg13cmos5l_antennanp
X_3801_ Tile_X0Y4_FrameData_O[23] Tile_X0Y4_FrameData[23] VPWR VGND sg13cmos5l_buf_1
XANTENNA__1405__A0 AXI_M_SOC_RDATA20 VPWR VGND sg13cmos5l_antennanp
XANTENNA__1938__D Tile_X0Y0_FrameData[14] VPWR VGND sg13cmos5l_antennanp
X_1993_ _1993_/Q Tile_X0Y1_FrameData[7] Tile_X0Y5_FrameStrobe[0] VPWR VGND sg13cmos5l_dlhq_1
XANTENNA__2462__GATE Tile_X0Y5_FrameStrobe[6] VPWR VGND sg13cmos5l_antennanp
XFILLER_13_290 VPWR VGND sg13cmos5l_decap_4
XFILLER_158_251 VPWR VGND sg13cmos5l_decap_4
X_3732_ Tile_X0Y4_E1BEG[2] _3732_/A VPWR VGND sg13cmos5l_buf_1
X_0944_ _0944_/X _1123_/X _0712_/X _0904_/Y Tile_X0Y0_S4END[7] _2009_/Q _2010_/Q VPWR
+ VGND sg13cmos5l_mux4_1
XFILLER_173_210 VPWR VGND sg13cmos5l_fill_1
XFILLER_173_232 VPWR VGND sg13cmos5l_decap_8
XFILLER_256_14 VPWR VGND sg13cmos5l_fill_1
XFILLER_256_25 VPWR VGND sg13cmos5l_fill_1
X_3663_ Tile_X0Y3_E2BEGb[2] _3663_/A VPWR VGND sg13cmos5l_buf_1
X_0875_ _0875_/Y Tile_X0Y5_W2END[6] _3116_/Q _3115_/Q VPWR VGND sg13cmos5l_a21oi_1
X_2614_ _2614_/Q Tile_X0Y3_FrameData[26] Tile_X0Y5_FrameStrobe[3] VPWR VGND sg13cmos5l_dlhq_1
XANTENNA__2769__D Tile_X0Y3_FrameData[31] VPWR VGND sg13cmos5l_antennanp
X_3594_ Tile_X0Y0_FrameData_O[25] Tile_X0Y0_FrameData[25] VPWR VGND sg13cmos5l_buf_1
XFILLER_55_0 VPWR VGND sg13cmos5l_decap_8
XANTENNA__1184__A2 Tile_X0Y0_W6END[3] VPWR VGND sg13cmos5l_antennanp
XANTENNA__2477__GATE Tile_X0Y5_FrameStrobe[7] VPWR VGND sg13cmos5l_antennanp
X_2545_ _2545_/Q Tile_X0Y3_FrameData[31] Tile_X0Y5_FrameStrobe[1] VPWR VGND sg13cmos5l_dlhq_1
XFILLER_272_46 VPWR VGND sg13cmos5l_fill_1
X_2476_ _2476_/Q Tile_X0Y2_FrameData[20] Tile_X0Y5_FrameStrobe[7] VPWR VGND sg13cmos5l_dlhq_1
XFILLER_87_216 VPWR VGND sg13cmos5l_decap_8
XANTENNA__2400__GATE Tile_X0Y5_FrameStrobe[4] VPWR VGND sg13cmos5l_antennanp
X_1427_ AXI_M_SOC_WDATA31 Tile_X0Y2_W2MID[7] Tile_X0Y2_W2END[7] Tile_X0Y2_W6END[7]
+ _1179_/X _2298_/Q _2297_/Q VPWR VGND sg13cmos5l_mux4_1
XFILLER_205_51 VPWR VGND sg13cmos5l_decap_8
XFILLER_205_62 VPWR VGND sg13cmos5l_fill_1
XANTENNA__0695__A1 Tile_X0Y5_N4END[2] VPWR VGND sg13cmos5l_antennanp
XFILLER_141_28 VPWR VGND sg13cmos5l_decap_8
XFILLER_18_27 VPWR VGND sg13cmos5l_fill_1
XFILLER_205_84 VPWR VGND sg13cmos5l_decap_8
X_1358_ _1358_/X Tile_X0Y2_W1END[0] Tile_X0Y2_W6END[8] Tile_X0Y2_WW4END[0] _1357_/X
+ _2487_/Q _2488_/Q VPWR VGND sg13cmos5l_mux4_1
XANTENNA__3530__X Tile_X0Y0_N2BEGb[1] VPWR VGND sg13cmos5l_antennanp
X_1289_ _3473_/A Tile_X0Y1_WW4END[6] AXI_M_SOC_RDATA28 _0941_/X _1083_/X _2110_/Q
+ _2109_/Q VPWR VGND sg13cmos5l_mux4_1
XANTENNA__2415__GATE Tile_X0Y5_FrameStrobe[5] VPWR VGND sg13cmos5l_antennanp
X_3028_ _3028_/Q Tile_X0Y4_FrameData[12] Tile_X0Y5_FrameStrobe[7] VPWR VGND sg13cmos5l_dlhq_1
XFILLER_70_105 VPWR VGND sg13cmos5l_fill_2
XFILLER_55_168 VPWR VGND sg13cmos5l_decap_8
XANTENNA__1644__A0 Tile_X0Y4_WW4END[2] VPWR VGND sg13cmos5l_antennanp
XANTENNA__2009__D Tile_X0Y1_FrameData[23] VPWR VGND sg13cmos5l_antennanp
XFILLER_221_94 VPWR VGND sg13cmos5l_decap_4
XFILLER_70_138 VPWR VGND sg13cmos5l_decap_4
XFILLER_251_280 VPWR VGND sg13cmos5l_fill_1
XANTENNA__1848__D Tile_X0Y0_FrameData[8] VPWR VGND sg13cmos5l_antennanp
XFILLER_166_14 VPWR VGND sg13cmos5l_fill_2
XFILLER_166_25 VPWR VGND sg13cmos5l_fill_1
XFILLER_50_36 VPWR VGND sg13cmos5l_decap_4
XANTENNA__3418__A Tile_X0Y2_FrameData[20] VPWR VGND sg13cmos5l_antennanp
XFILLER_166_47 VPWR VGND sg13cmos5l_fill_2
XANTENNA__2679__D Tile_X0Y3_FrameData[25] VPWR VGND sg13cmos5l_antennanp
XANTENNA__3705__X Tile_X0Y3_FrameData_O[8] VPWR VGND sg13cmos5l_antennanp
XFILLER_132_173 VPWR VGND sg13cmos5l_fill_2
XFILLER_278_144 VPWR VGND sg13cmos5l_fill_1
XFILLER_59_67 VPWR VGND sg13cmos5l_decap_8
XFILLER_182_68 VPWR VGND sg13cmos5l_decap_8
XFILLER_278_177 VPWR VGND sg13cmos5l_decap_4
XFILLER_293_114 VPWR VGND sg13cmos5l_fill_1
XFILLER_115_51 VPWR VGND sg13cmos5l_decap_4
XFILLER_293_136 VPWR VGND sg13cmos5l_fill_1
XFILLER_332_16 VPWR VGND sg13cmos5l_decap_4
XFILLER_86_293 VPWR VGND sg13cmos5l_fill_2
XFILLER_75_44 VPWR VGND sg13cmos5l_fill_2
XANTENNA__3303__D Tile_X0Y5_FrameData[9] VPWR VGND sg13cmos5l_antennanp
XANTENNA__3440__X Tile_X0Y1_FrameData_O[8] VPWR VGND sg13cmos5l_antennanp
XFILLER_234_203 VPWR VGND sg13cmos5l_fill_2
XFILLER_234_225 VPWR VGND sg13cmos5l_fill_1
XFILLER_46_157 VPWR VGND sg13cmos5l_decap_8
XANTENNA__1635__A0 Tile_X0Y4_WW4END[1] VPWR VGND sg13cmos5l_antennanp
XFILLER_199_151 VPWR VGND sg13cmos5l_decap_4
XFILLER_61_127 VPWR VGND sg13cmos5l_fill_2
XFILLER_199_173 VPWR VGND sg13cmos5l_decap_8
XANTENNA__1758__D Tile_X0Y0_FrameData[2] VPWR VGND sg13cmos5l_antennanp
XANTENNA__3192__GATE Tile_X0Y5_FrameStrobe[4] VPWR VGND sg13cmos5l_antennanp
XFILLER_10_293 VPWR VGND sg13cmos5l_fill_2
XANTENNA__2589__D Tile_X0Y3_FrameData[19] VPWR VGND sg13cmos5l_antennanp
X_0660_ _0660_/Y _3264_/Q _0659_/Y _3263_/Q VPWR VGND sg13cmos5l_o21ai_1
XANTENNA__1166__A2 Tile_X0Y0_S1END[0] VPWR VGND sg13cmos5l_antennanp
XANTENNA__3615__X Tile_X0Y0_EE4BEG[14] VPWR VGND sg13cmos5l_antennanp
XFILLER_170_268 VPWR VGND sg13cmos5l_decap_4
X_0591_ _0591_/X _0586_/X _0587_/Y _0590_/Y VPWR VGND sg13cmos5l_a21o_1
XANTENNA__0958__Y AXI_M_SOC_AWLEN3 VPWR VGND sg13cmos5l_antennanp
XFILLER_312_251 VPWR VGND sg13cmos5l_decap_8
X_2330_ _2330_/Q Tile_X0Y2_FrameData[6] Tile_X0Y5_FrameStrobe[2] VPWR VGND sg13cmos5l_dlhq_1
X_2261_ _2261_/Q Tile_X0Y2_FrameData[11] Tile_X0Y5_FrameStrobe[0] VPWR VGND sg13cmos5l_dlhq_1
XANTENNA__3130__GATE Tile_X0Y5_FrameStrobe[2] VPWR VGND sg13cmos5l_antennanp
X_1212_ AXI_M_SOC_AWADDR27 Tile_X0Y0_W2MID[3] Tile_X0Y0_W2END[3] Tile_X0Y0_W6END[3]
+ _1148_/X _1762_/Q _1761_/Q VPWR VGND sg13cmos5l_mux4_1
XFILLER_1_41 VPWR VGND sg13cmos5l_fill_1
XFILLER_284_158 VPWR VGND sg13cmos5l_fill_2
X_2192_ _2192_/Q Tile_X0Y1_FrameData[0] Tile_X0Y5_FrameStrobe[6] VPWR VGND sg13cmos5l_dlhq_1
XFILLER_77_282 VPWR VGND sg13cmos5l_fill_2
XANTENNA__3213__D Tile_X0Y5_FrameData[3] VPWR VGND sg13cmos5l_antennanp
XANTENNA__3350__X Tile_X0Y2_E1BEG[0] VPWR VGND sg13cmos5l_antennanp
X_1143_ _1143_/X _1102_/X _1141_/X _1142_/X _1104_/X _2261_/Q _2262_/Q VPWR VGND sg13cmos5l_mux4_1
XFILLER_37_146 VPWR VGND sg13cmos5l_decap_8
X_1074_ _1074_/X _1079_/X _1067_/X Tile_X0Y0_S1END[0] Tile_X0Y0_S4END[0] _1728_/Q
+ _1727_/Q VPWR VGND sg13cmos5l_mux4_1
XANTENNA__1626__A0 AXI_M_SOC_RDATA1 VPWR VGND sg13cmos5l_antennanp
XANTENNA__3145__GATE Tile_X0Y5_FrameStrobe[2] VPWR VGND sg13cmos5l_antennanp
X_1976_ _1976_/Q Tile_X0Y1_FrameData[24] Tile_X0Y5_FrameStrobe[0] VPWR VGND sg13cmos5l_dlhq_1
XFILLER_267_68 VPWR VGND sg13cmos5l_decap_4
X_3715_ Tile_X0Y3_FrameData_O[18] Tile_X0Y3_FrameData[18] VPWR VGND sg13cmos5l_buf_1
X_0927_ _0927_/X _1139_/X _0617_/X _0926_/X Tile_X0Y0_S4END[5] _2013_/Q _2014_/Q VPWR
+ VGND sg13cmos5l_mux4_1
XANTENNA__2499__D Tile_X0Y2_FrameData[29] VPWR VGND sg13cmos5l_antennanp
XFILLER_161_213 VPWR VGND sg13cmos5l_decap_8
X_3646_ Tile_X0Y0_E1BEG[1] _3646_/A VPWR VGND sg13cmos5l_buf_1
X_0858_ _0858_/Y _3122_/Q _0794_/X _0857_/Y VPWR VGND sg13cmos5l_a21oi_1
XANTENNA__3525__X Tile_X0Y0_N4BEG[12] VPWR VGND sg13cmos5l_antennanp
XFILLER_136_28 VPWR VGND sg13cmos5l_decap_8
X_3577_ Tile_X0Y0_FrameData_O[8] Tile_X0Y0_FrameData[8] VPWR VGND sg13cmos5l_buf_1
X_0789_ _3905_/A Tile_X0Y4_W2MID[5] Tile_X0Y4_W2END[5] Tile_X0Y4_W6END[10] _1016_/X
+ _3008_/Q _3007_/Q VPWR VGND sg13cmos5l_mux4_1
XFILLER_114_140 VPWR VGND sg13cmos5l_decap_8
X_2528_ _2528_/Q Tile_X0Y3_FrameData[16] Tile_X0Y5_FrameStrobe[0] VPWR VGND sg13cmos5l_dlhq_1
XFILLER_303_273 VPWR VGND sg13cmos5l_fill_1
XFILLER_275_136 VPWR VGND sg13cmos5l_decap_4
X_2459_ _2459_/Q Tile_X0Y2_FrameData[5] Tile_X0Y5_FrameStrobe[6] VPWR VGND sg13cmos5l_dlhq_1
XFILLER_152_38 VPWR VGND sg13cmos5l_fill_2
XANTENNA__0884__X AXI_M_SOC_WSTRB0 VPWR VGND sg13cmos5l_antennanp
XANTENNA__2354__GATE Tile_X0Y5_FrameStrobe[3] VPWR VGND sg13cmos5l_antennanp
XANTENNA__3123__D Tile_X0Y5_FrameData[29] VPWR VGND sg13cmos5l_antennanp
XFILLER_290_117 VPWR VGND sg13cmos5l_decap_8
XFILLER_68_293 VPWR VGND sg13cmos5l_fill_2
XANTENNA__2984__GATE Tile_X0Y5_FrameStrobe[6] VPWR VGND sg13cmos5l_antennanp
XANTENNA__3701__A Tile_X0Y3_FrameData[4] VPWR VGND sg13cmos5l_antennanp
XFILLER_232_71 VPWR VGND sg13cmos5l_decap_4
XFILLER_232_93 VPWR VGND sg13cmos5l_decap_8
XFILLER_83_274 VPWR VGND sg13cmos5l_fill_1
XFILLER_45_14 VPWR VGND sg13cmos5l_decap_4
XANTENNA__1617__A0 Tile_X0Y5_N4END[7] VPWR VGND sg13cmos5l_antennanp
XANTENNA__2962__D Tile_X0Y4_FrameData[14] VPWR VGND sg13cmos5l_antennanp
XFILLER_43_127 VPWR VGND sg13cmos5l_decap_8
XFILLER_101_31 VPWR VGND sg13cmos5l_decap_8
XANTENNA__1093__A1 Tile_X0Y0_W2END[4] VPWR VGND sg13cmos5l_antennanp
XANTENNA__2369__GATE Tile_X0Y5_FrameStrobe[4] VPWR VGND sg13cmos5l_antennanp
XANTENNA__0840__A1 Tile_X0Y5_WW4END[12] VPWR VGND sg13cmos5l_antennanp
XANTENNA__2999__GATE Tile_X0Y5_FrameStrobe[6] VPWR VGND sg13cmos5l_antennanp
XFILLER_196_176 VPWR VGND sg13cmos5l_decap_8
XFILLER_61_57 VPWR VGND sg13cmos5l_decap_8
XFILLER_177_35 VPWR VGND sg13cmos5l_fill_2
XFILLER_338_181 VPWR VGND sg13cmos5l_fill_1
XANTENNA__1396__A2 Tile_X0Y0_S4END[11] VPWR VGND sg13cmos5l_antennanp
XANTENNA__2922__GATE Tile_X0Y5_FrameStrobe[4] VPWR VGND sg13cmos5l_antennanp
XFILLER_152_202 VPWR VGND sg13cmos5l_fill_1
XANTENNA__3435__X Tile_X0Y1_FrameData_O[3] VPWR VGND sg13cmos5l_antennanp
XFILLER_3_234 VPWR VGND sg13cmos5l_decap_4
XFILLER_3_223 VPWR VGND sg13cmos5l_fill_1
XANTENNA__1148__A2 Tile_X0Y0_S2MID[3] VPWR VGND sg13cmos5l_antennanp
XANTENNA__2202__D Tile_X0Y1_FrameData[22] VPWR VGND sg13cmos5l_antennanp
XANTENNA__2307__GATE Tile_X0Y5_FrameStrobe[2] VPWR VGND sg13cmos5l_antennanp
XANTENNA__2937__GATE Tile_X0Y5_FrameStrobe[4] VPWR VGND sg13cmos5l_antennanp
XFILLER_105_184 VPWR VGND sg13cmos5l_decap_8
XFILLER_10_83 VPWR VGND sg13cmos5l_decap_8
XFILLER_10_94 VPWR VGND sg13cmos5l_fill_1
XFILLER_120_154 VPWR VGND sg13cmos5l_decap_4
XFILLER_126_83 VPWR VGND sg13cmos5l_decap_8
XFILLER_86_65 VPWR VGND sg13cmos5l_decap_8
XFILLER_59_260 VPWR VGND sg13cmos5l_fill_1
XANTENNA__3033__D Tile_X0Y4_FrameData[7] VPWR VGND sg13cmos5l_antennanp
XFILLER_281_117 VPWR VGND sg13cmos5l_fill_2
XFILLER_59_293 VPWR VGND sg13cmos5l_fill_2
XANTENNA__1320__A2 AXI_M_SOC_RDATA22 VPWR VGND sg13cmos5l_antennanp
XANTENNA__1608__A0 Tile_X0Y4_WW4END[5] VPWR VGND sg13cmos5l_antennanp
XANTENNA__2872__D Tile_X0Y4_FrameData[8] VPWR VGND sg13cmos5l_antennanp
XFILLER_34_116 VPWR VGND sg13cmos5l_decap_8
XFILLER_27_190 VPWR VGND sg13cmos5l_decap_8
XANTENNA__1084__A1 Tile_X0Y0_W2MID[2] VPWR VGND sg13cmos5l_antennanp
XFILLER_230_250 VPWR VGND sg13cmos5l_fill_2
X_1830_ _1830_/Q Tile_X0Y0_FrameData[26] Tile_X0Y5_FrameStrobe[4] VPWR VGND sg13cmos5l_dlhq_1
XFILLER_128_221 VPWR VGND sg13cmos5l_decap_4
X_3500_ Tile_X0Y1_E2BEG[0] _3500_/A VPWR VGND sg13cmos5l_buf_1
X_1761_ _1761_/Q Tile_X0Y0_FrameData[31] Tile_X0Y5_FrameStrobe[2] VPWR VGND sg13cmos5l_dlhq_1
X_1692_ _3895_/A Tile_X0Y5_W2MID[7] Tile_X0Y5_W2END[7] Tile_X0Y5_W6END[8] _0782_/X
+ _3284_/Q _3283_/Q VPWR VGND sg13cmos5l_mux4_1
X_0712_ _0712_/X Tile_X0Y0_W1END[3] Tile_X0Y0_W6END[11] _1124_/X _0711_/Y _1926_/Q
+ _1925_/Q VPWR VGND sg13cmos5l_mux4_1
XANTENNA__3208__D Tile_X0Y5_FrameData[8] VPWR VGND sg13cmos5l_antennanp
X_3431_ Tile_X0Y1_UserCLKo Tile_X0Y1_UserCLK VPWR VGND sg13cmos5l_buf_1
X_0643_ _0643_/X Tile_X0Y1_W1END[1] _0927_/X Tile_X0Y1_WW4END[13] _0950_/X _2175_/Q
+ _2177_/Q VPWR VGND sg13cmos5l_mux4_1
XANTENNA__2112__D Tile_X0Y1_FrameData[16] VPWR VGND sg13cmos5l_antennanp
X_3362_ Tile_X0Y2_E2BEGb[0] _3362_/A VPWR VGND sg13cmos5l_buf_1
XFILLER_317_93 VPWR VGND sg13cmos5l_decap_8
X_2313_ _2313_/Q Tile_X0Y2_FrameData[23] Tile_X0Y5_FrameStrobe[2] VPWR VGND sg13cmos5l_dlhq_1
X_0574_ _0574_/X Tile_X0Y1_W1END[0] _0959_/X Tile_X0Y1_W6END[8] _0573_/X _2203_/Q
+ _2204_/Q VPWR VGND sg13cmos5l_mux4_1
XANTENNA__1951__D Tile_X0Y0_FrameData[1] VPWR VGND sg13cmos5l_antennanp
X_3293_ _3293_/Q Tile_X0Y5_FrameData[19] Tile_X0Y5_FrameStrobe[7] VPWR VGND sg13cmos5l_dlhq_1
XFILLER_257_147 VPWR VGND sg13cmos5l_fill_1
X_2244_ _2244_/Q Tile_X0Y2_FrameData[28] Tile_X0Y5_FrameStrobe[0] VPWR VGND sg13cmos5l_dlhq_1
XFILLER_18_0 VPWR VGND sg13cmos5l_fill_2
X_2175_ _2175_/Q Tile_X0Y1_FrameData[17] Tile_X0Y5_FrameStrobe[6] VPWR VGND sg13cmos5l_dlhq_1
XANTENNA__1311__A2 Tile_X0Y1_W6END[5] VPWR VGND sg13cmos5l_antennanp
XANTENNA__3084__GATE Tile_X0Y5_FrameStrobe[0] VPWR VGND sg13cmos5l_antennanp
XFILLER_265_191 VPWR VGND sg13cmos5l_fill_2
X_1126_ _1126_/X _1135_/X _0730_/X Tile_X0Y5_N4END[7] _0980_/X _2817_/Q _2818_/Q VPWR
+ VGND sg13cmos5l_mux4_1
XANTENNA__0864__B Tile_X0Y5_W2MID[4] VPWR VGND sg13cmos5l_antennanp
XANTENNA__2782__D Tile_X0Y3_FrameData[18] VPWR VGND sg13cmos5l_antennanp
XFILLER_280_150 VPWR VGND sg13cmos5l_fill_2
XFILLER_80_222 VPWR VGND sg13cmos5l_decap_8
XFILLER_65_285 VPWR VGND sg13cmos5l_fill_1
XFILLER_280_172 VPWR VGND sg13cmos5l_decap_8
XFILLER_280_183 VPWR VGND sg13cmos5l_fill_1
XFILLER_280_194 VPWR VGND sg13cmos5l_fill_2
X_1057_ _1057_/X Tile_X0Y1_W1END[1] _0962_/X Tile_X0Y1_W6END[5] _0622_/X _2237_/Q
+ _2238_/Q VPWR VGND sg13cmos5l_mux4_1
XFILLER_278_23 VPWR VGND sg13cmos5l_fill_1
XANTENNA__3099__GATE Tile_X0Y5_FrameStrobe[1] VPWR VGND sg13cmos5l_antennanp
XFILLER_193_102 VPWR VGND sg13cmos5l_fill_2
XFILLER_278_45 VPWR VGND sg13cmos5l_fill_2
XFILLER_278_67 VPWR VGND sg13cmos5l_decap_4
XFILLER_119_221 VPWR VGND sg13cmos5l_decap_8
X_1959_ _1959_/Q Tile_X0Y0_FrameData[25] Tile_X0Y5_FrameStrobe[8] VPWR VGND sg13cmos5l_dlhq_1
XANTENNA__0586__A0 Tile_X0Y3_W1END[0] VPWR VGND sg13cmos5l_antennanp
XANTENNA__3022__GATE Tile_X0Y5_FrameStrobe[7] VPWR VGND sg13cmos5l_antennanp
XFILLER_119_265 VPWR VGND sg13cmos5l_decap_8
XANTENNA__3118__D Tile_X0Y5_FrameData[2] VPWR VGND sg13cmos5l_antennanp
XFILLER_103_8 VPWR VGND sg13cmos5l_decap_8
X_3629_ Tile_X0Y0_E2BEGb[0] _3629_/A VPWR VGND sg13cmos5l_buf_1
XANTENNA__2022__D Tile_X0Y1_FrameData[10] VPWR VGND sg13cmos5l_antennanp
XANTENNA__2957__D Tile_X0Y4_FrameData[19] VPWR VGND sg13cmos5l_antennanp
XANTENNA__3037__GATE Tile_X0Y5_FrameStrobe[7] VPWR VGND sg13cmos5l_antennanp
XFILLER_227_93 VPWR VGND sg13cmos5l_decap_8
XANTENNA__0889__A1 Tile_X0Y3_WW4END[14] VPWR VGND sg13cmos5l_antennanp
XANTENNA__1861__D Tile_X0Y0_FrameData[27] VPWR VGND sg13cmos5l_antennanp
XFILLER_0_248 VPWR VGND sg13cmos5l_decap_4
XFILLER_102_132 VPWR VGND sg13cmos5l_fill_2
XANTENNA__1550__A2 Tile_X0Y3_W6END[2] VPWR VGND sg13cmos5l_antennanp
XANTENNA__2293__GATE Tile_X0Y5_FrameStrobe[1] VPWR VGND sg13cmos5l_antennanp
XFILLER_102_198 VPWR VGND sg13cmos5l_decap_8
XANTENNA__3431__A Tile_X0Y1_UserCLK VPWR VGND sg13cmos5l_antennanp
XFILLER_263_139 VPWR VGND sg13cmos5l_fill_1
XFILLER_56_68 VPWR VGND sg13cmos5l_fill_2
XFILLER_56_263 VPWR VGND sg13cmos5l_decap_8
XFILLER_56_241 VPWR VGND sg13cmos5l_fill_2
XANTENNA__2692__D Tile_X0Y3_FrameData[12] VPWR VGND sg13cmos5l_antennanp
XFILLER_204_217 VPWR VGND sg13cmos5l_decap_4
XFILLER_71_233 VPWR VGND sg13cmos5l_fill_2
XFILLER_72_12 VPWR VGND sg13cmos5l_decap_4
XANTENNA__1066__A1 Tile_X0Y4_WW4END[0] VPWR VGND sg13cmos5l_antennanp
XFILLER_169_143 VPWR VGND sg13cmos5l_decap_8
XFILLER_188_67 VPWR VGND sg13cmos5l_decap_4
XFILLER_212_250 VPWR VGND sg13cmos5l_fill_2
XFILLER_24_193 VPWR VGND sg13cmos5l_decap_8
XANTENNA__2231__GATE Tile_X0Y5_FrameStrobe[8] VPWR VGND sg13cmos5l_antennanp
XFILLER_318_129 VPWR VGND sg13cmos5l_decap_8
XANTENNA__1369__A2 Tile_X0Y5_N4END[13] VPWR VGND sg13cmos5l_antennanp
XANTENNA__2861__GATE Tile_X0Y5_FrameStrobe[2] VPWR VGND sg13cmos5l_antennanp
XFILLER_122_0 VPWR VGND sg13cmos5l_fill_2
XFILLER_125_202 VPWR VGND sg13cmos5l_decap_8
XFILLER_184_179 VPWR VGND sg13cmos5l_decap_8
XANTENNA__3028__D Tile_X0Y4_FrameData[12] VPWR VGND sg13cmos5l_antennanp
XFILLER_125_235 VPWR VGND sg13cmos5l_decap_8
XFILLER_326_195 VPWR VGND sg13cmos5l_fill_1
XANTENNA__2246__GATE Tile_X0Y5_FrameStrobe[0] VPWR VGND sg13cmos5l_antennanp
XANTENNA__2876__GATE Tile_X0Y5_FrameStrobe[2] VPWR VGND sg13cmos5l_antennanp
XFILLER_97_20 VPWR VGND sg13cmos5l_decap_8
XANTENNA__2867__D Tile_X0Y4_FrameData[13] VPWR VGND sg13cmos5l_antennanp
XFILLER_286_209 VPWR VGND sg13cmos5l_decap_4
XANTENNA__1771__D Tile_X0Y0_FrameData[21] VPWR VGND sg13cmos5l_antennanp
XFILLER_239_158 VPWR VGND sg13cmos5l_fill_1
XFILLER_294_253 VPWR VGND sg13cmos5l_decap_4
XANTENNA__1413__X AXI_M_SOC_WDATA8 VPWR VGND sg13cmos5l_antennanp
XANTENNA__2814__GATE Tile_X0Y5_FrameStrobe[0] VPWR VGND sg13cmos5l_antennanp
XFILLER_62_266 VPWR VGND sg13cmos5l_decap_4
XFILLER_15_171 VPWR VGND sg13cmos5l_decap_8
X_2931_ _2931_/Q Tile_X0Y4_FrameData[13] Tile_X0Y5_FrameStrobe[4] VPWR VGND sg13cmos5l_dlhq_1
XANTENNA__2107__D Tile_X0Y1_FrameData[21] VPWR VGND sg13cmos5l_antennanp
XFILLER_175_102 VPWR VGND sg13cmos5l_decap_4
XFILLER_248_26 VPWR VGND sg13cmos5l_decap_8
X_2862_ _2862_/Q Tile_X0Y4_FrameData[18] Tile_X0Y5_FrameStrobe[2] VPWR VGND sg13cmos5l_dlhq_1
XANTENNA__1946__D Tile_X0Y0_FrameData[6] VPWR VGND sg13cmos5l_antennanp
XANTENNA__2829__GATE Tile_X0Y5_FrameStrobe[1] VPWR VGND sg13cmos5l_antennanp
XFILLER_175_146 VPWR VGND sg13cmos5l_decap_8
X_2793_ _2793_/Q Tile_X0Y4_FrameData[23] Tile_X0Y5_FrameStrobe[0] VPWR VGND sg13cmos5l_dlhq_1
X_1813_ _1813_/Q Tile_X0Y0_FrameData[11] Tile_X0Y5_FrameStrobe[3] VPWR VGND sg13cmos5l_dlhq_1
XANTENNA__0568__A0 Tile_X0Y0_W1END[0] VPWR VGND sg13cmos5l_antennanp
XFILLER_190_127 VPWR VGND sg13cmos5l_fill_1
X_1744_ _1744_/Q Tile_X0Y0_FrameData[16] Tile_X0Y5_FrameStrobe[1] VPWR VGND sg13cmos5l_dlhq_1
XFILLER_116_279 VPWR VGND sg13cmos5l_decap_4
X_3414_ Tile_X0Y2_FrameData_O[16] Tile_X0Y2_FrameData[16] VPWR VGND sg13cmos5l_buf_1
X_1675_ _3762_/A Tile_X0Y4_WW4END[15] _1127_/X AXI_M_SOC_RRESP0 _1361_/X _2943_/Q
+ _2944_/Q VPWR VGND sg13cmos5l_mux4_1
XANTENNA__0859__B Tile_X0Y5_W2MID[3] VPWR VGND sg13cmos5l_antennanp
XANTENNA__2777__D Tile_X0Y3_FrameData[23] VPWR VGND sg13cmos5l_antennanp
X_0626_ _0627_/C _2246_/Q _1018_/X VPWR VGND sg13cmos5l_nor2_1
XANTENNA__3803__X Tile_X0Y4_FrameData_O[25] VPWR VGND sg13cmos5l_antennanp
X_3345_ _3345_/Q Tile_X0Y5_FrameData[11] Tile_X0Y5_FrameStrobe[8] VPWR VGND sg13cmos5l_dlhq_1
X_0557_ _3909_/A Tile_X0Y4_W1END[2] Tile_X0Y4_W2MID[1] Tile_X0Y4_W2END[1] _1360_/X
+ _3000_/Q _2999_/Q VPWR VGND sg13cmos5l_mux4_1
XANTENNA__0740__A0 Tile_X0Y5_N1END[3] VPWR VGND sg13cmos5l_antennanp
XFILLER_133_29 VPWR VGND sg13cmos5l_decap_8
XFILLER_285_231 VPWR VGND sg13cmos5l_fill_1
X_3276_ _3276_/Q Tile_X0Y5_FrameData[4] Tile_X0Y5_FrameStrobe[6] VPWR VGND sg13cmos5l_dlhq_1
XFILLER_97_174 VPWR VGND sg13cmos5l_decap_8
X_2227_ _2227_/Q Tile_X0Y1_FrameData[29] Tile_X0Y5_FrameStrobe[8] VPWR VGND sg13cmos5l_dlhq_1
XFILLER_213_40 VPWR VGND sg13cmos5l_fill_1
XFILLER_38_241 VPWR VGND sg13cmos5l_decap_8
XFILLER_213_84 VPWR VGND sg13cmos5l_decap_8
XFILLER_213_95 VPWR VGND sg13cmos5l_fill_1
XFILLER_253_161 VPWR VGND sg13cmos5l_decap_4
XFILLER_26_16 VPWR VGND sg13cmos5l_fill_2
XFILLER_289_11 VPWR VGND sg13cmos5l_fill_1
X_2158_ _2158_/Q Tile_X0Y1_FrameData[2] Tile_X0Y5_FrameStrobe[5] VPWR VGND sg13cmos5l_dlhq_1
XFILLER_53_200 VPWR VGND sg13cmos5l_decap_8
XFILLER_198_216 VPWR VGND sg13cmos5l_decap_8
XFILLER_198_227 VPWR VGND sg13cmos5l_fill_2
XFILLER_253_194 VPWR VGND sg13cmos5l_decap_8
X_2089_ _2089_/Q Tile_X0Y1_FrameData[7] Tile_X0Y5_FrameStrobe[3] VPWR VGND sg13cmos5l_dlhq_1
X_1109_ _1109_/X Tile_X0Y2_W2MID[7] Tile_X0Y2_W2END[7] Tile_X0Y2_W6END[7] _1157_/X
+ _2504_/Q _2503_/Q VPWR VGND sg13cmos5l_mux4_1
XANTENNA__0881__Y AXI_M_SOC_ARLEN7 VPWR VGND sg13cmos5l_antennanp
XANTENNA__1048__A1 Tile_X0Y5_W2END[6] VPWR VGND sg13cmos5l_antennanp
XFILLER_201_209 VPWR VGND sg13cmos5l_fill_1
XANTENNA__2017__D Tile_X0Y1_FrameData[15] VPWR VGND sg13cmos5l_antennanp
XFILLER_289_99 VPWR VGND sg13cmos5l_fill_1
XFILLER_42_15 VPWR VGND sg13cmos5l_decap_4
XANTENNA__1856__D Tile_X0Y0_FrameData[0] VPWR VGND sg13cmos5l_antennanp
XFILLER_21_196 VPWR VGND sg13cmos5l_fill_2
XANTENNA__0559__A0 Tile_X0Y5_N2MID[6] VPWR VGND sg13cmos5l_antennanp
XFILLER_107_224 VPWR VGND sg13cmos5l_decap_8
XFILLER_174_14 VPWR VGND sg13cmos5l_fill_2
XANTENNA__3426__A Tile_X0Y2_FrameData[28] VPWR VGND sg13cmos5l_antennanp
XFILLER_174_36 VPWR VGND sg13cmos5l_decap_8
XFILLER_323_132 VPWR VGND sg13cmos5l_fill_1
XFILLER_122_216 VPWR VGND sg13cmos5l_decap_8
XANTENNA__2687__D Tile_X0Y3_FrameData[17] VPWR VGND sg13cmos5l_antennanp
XFILLER_107_63 VPWR VGND sg13cmos5l_decap_8
XANTENNA__1523__A2 Tile_X0Y5_N4END[9] VPWR VGND sg13cmos5l_antennanp
XANTENNA__3713__X Tile_X0Y3_FrameData_O[16] VPWR VGND sg13cmos5l_antennanp
XFILLER_67_45 VPWR VGND sg13cmos5l_decap_8
XFILLER_190_35 VPWR VGND sg13cmos5l_decap_4
XFILLER_276_286 VPWR VGND sg13cmos5l_fill_1
XFILLER_184_2 VPWR VGND sg13cmos5l_fill_1
XANTENNA__1287__A1 AXI_M_SOC_RDATA26 VPWR VGND sg13cmos5l_antennanp
XFILLER_199_11 VPWR VGND sg13cmos5l_decap_4
XFILLER_44_211 VPWR VGND sg13cmos5l_decap_8
XANTENNA__3311__D Tile_X0Y5_FrameData[1] VPWR VGND sg13cmos5l_antennanp
XFILLER_244_194 VPWR VGND sg13cmos5l_fill_1
XANTENNA__2170__GATE Tile_X0Y5_FrameStrobe[6] VPWR VGND sg13cmos5l_antennanp
XFILLER_337_0 VPWR VGND sg13cmos5l_fill_2
XANTENNA__0798__A0 Tile_X0Y5_W2MID[1] VPWR VGND sg13cmos5l_antennanp
XFILLER_12_163 VPWR VGND sg13cmos5l_decap_8
XANTENNA__1766__D Tile_X0Y0_FrameData[26] VPWR VGND sg13cmos5l_antennanp
XFILLER_157_135 VPWR VGND sg13cmos5l_decap_8
XANTENNA__1211__A1 Tile_X0Y0_W2END[4] VPWR VGND sg13cmos5l_antennanp
XANTENNA__2185__GATE Tile_X0Y5_FrameStrobe[6] VPWR VGND sg13cmos5l_antennanp
XFILLER_66_8 VPWR VGND sg13cmos5l_decap_8
XFILLER_59_7 VPWR VGND sg13cmos5l_decap_8
X_1460_ _3366_/A Tile_X0Y2_W2END[3] AXI_M_SOC_RDATA17 _1187_/X _1191_/X _2408_/Q _2407_/Q
+ VPWR VGND sg13cmos5l_mux4_1
XANTENNA__2597__D Tile_X0Y3_FrameData[11] VPWR VGND sg13cmos5l_antennanp
X_1391_ _1391_/Y _2485_/Q _0550_/Y _2484_/Q VPWR VGND sg13cmos5l_o21ai_1
XFILLER_79_141 VPWR VGND sg13cmos5l_decap_8
XANTENNA__3623__X Tile_X0Y0_E6BEG[6] VPWR VGND sg13cmos5l_antennanp
X_3130_ _3130_/Q Tile_X0Y5_FrameData[22] Tile_X0Y5_FrameStrobe[2] VPWR VGND sg13cmos5l_dlhq_1
XANTENNA__2123__GATE Tile_X0Y5_FrameStrobe[4] VPWR VGND sg13cmos5l_antennanp
XFILLER_250_27 VPWR VGND sg13cmos5l_fill_1
XFILLER_282_223 VPWR VGND sg13cmos5l_fill_2
XFILLER_314_94 VPWR VGND sg13cmos5l_fill_1
X_3061_ _3061_/Q Tile_X0Y5_FrameData[27] Tile_X0Y5_FrameStrobe[0] VPWR VGND sg13cmos5l_dlhq_1
XANTENNA__1278__A1 AXI_M_SOC_RDATA22 VPWR VGND sg13cmos5l_antennanp
XANTENNA__2753__GATE Tile_X0Y5_FrameStrobe[7] VPWR VGND sg13cmos5l_antennanp
XFILLER_250_49 VPWR VGND sg13cmos5l_fill_2
X_2012_ _2012_/Q Tile_X0Y1_FrameData[20] Tile_X0Y5_FrameStrobe[1] VPWR VGND sg13cmos5l_dlhq_1
XANTENNA__3221__D Tile_X0Y5_FrameData[27] VPWR VGND sg13cmos5l_antennanp
XFILLER_330_71 VPWR VGND sg13cmos5l_fill_2
XANTENNA__2138__GATE Tile_X0Y5_FrameStrobe[5] VPWR VGND sg13cmos5l_antennanp
XANTENNA__0789__A0 Tile_X0Y4_W2MID[5] VPWR VGND sg13cmos5l_antennanp
XANTENNA__2768__GATE Tile_X0Y5_FrameStrobe[7] VPWR VGND sg13cmos5l_antennanp
XFILLER_259_47 VPWR VGND sg13cmos5l_fill_2
X_2914_ _2914_/Q Tile_X0Y4_FrameData[30] Tile_X0Y5_FrameStrobe[4] VPWR VGND sg13cmos5l_dlhq_1
X_3894_ Tile_X0Y5_S1BEG[3] _3894_/A VPWR VGND sg13cmos5l_buf_1
XFILLER_85_0 VPWR VGND sg13cmos5l_fill_2
XFILLER_188_293 VPWR VGND sg13cmos5l_fill_2
X_2845_ _2845_/Q Tile_X0Y4_FrameData[3] Tile_X0Y5_FrameStrobe[1] VPWR VGND sg13cmos5l_dlhq_1
XFILLER_275_24 VPWR VGND sg13cmos5l_fill_2
XANTENNA__1202__A1 Tile_X0Y0_WW4END[8] VPWR VGND sg13cmos5l_antennanp
XFILLER_128_29 VPWR VGND sg13cmos5l_fill_1
XFILLER_275_35 VPWR VGND sg13cmos5l_fill_2
X_2776_ _2776_/Q Tile_X0Y3_FrameData[24] Tile_X0Y5_FrameStrobe[8] VPWR VGND sg13cmos5l_dlhq_1
X_1727_ _1727_/Q Tile_X0Y0_FrameData[1] Tile_X0Y5_FrameStrobe[0] VPWR VGND sg13cmos5l_dlhq_1
XFILLER_104_227 VPWR VGND sg13cmos5l_decap_8
XFILLER_171_182 VPWR VGND sg13cmos5l_fill_1
X_1658_ _3741_/A Tile_X0Y4_W2MID[0] AXI_M_SOC_RDATA5 _1073_/X _1361_/X _2962_/Q _2961_/Q
+ VPWR VGND sg13cmos5l_mux4_1
XANTENNA__2706__GATE Tile_X0Y5_FrameStrobe[6] VPWR VGND sg13cmos5l_antennanp
XFILLER_291_23 VPWR VGND sg13cmos5l_fill_2
X_0609_ _0609_/Y _0598_/X _3268_/Q VPWR VGND sg13cmos5l_nand2b_1
XANTENNA__2300__D Tile_X0Y2_FrameData[4] VPWR VGND sg13cmos5l_antennanp
XANTENNA__3533__X Tile_X0Y0_N2BEGb[4] VPWR VGND sg13cmos5l_antennanp
X_3328_ _3328_/Q Tile_X0Y5_FrameData[16] Tile_X0Y5_FrameStrobe[8] VPWR VGND sg13cmos5l_dlhq_1
X_1589_ _1589_/Y _2749_/Q _1589_/B _1589_/C VPWR VGND sg13cmos5l_nand3_1
XANTENNA__0876__Y AXI_M_SOC_ARLEN6 VPWR VGND sg13cmos5l_antennanp
XANTENNA__1962__GATE Tile_X0Y5_FrameStrobe[8] VPWR VGND sg13cmos5l_antennanp
XFILLER_112_293 VPWR VGND sg13cmos5l_fill_2
XFILLER_224_72 VPWR VGND sg13cmos5l_decap_8
XFILLER_224_83 VPWR VGND sg13cmos5l_fill_2
XFILLER_273_245 VPWR VGND sg13cmos5l_decap_8
X_3259_ _3259_/Q Tile_X0Y5_FrameData[21] Tile_X0Y5_FrameStrobe[6] VPWR VGND sg13cmos5l_dlhq_1
XFILLER_85_144 VPWR VGND sg13cmos5l_decap_8
XFILLER_37_37 VPWR VGND sg13cmos5l_decap_8
XANTENNA__1269__A1 Tile_X0Y5_W2END[3] VPWR VGND sg13cmos5l_antennanp
XFILLER_273_267 VPWR VGND sg13cmos5l_fill_2
XANTENNA__3131__D Tile_X0Y5_FrameData[21] VPWR VGND sg13cmos5l_antennanp
XFILLER_268_8 VPWR VGND sg13cmos5l_fill_2
XFILLER_26_255 VPWR VGND sg13cmos5l_decap_4
XANTENNA__1977__GATE Tile_X0Y5_FrameStrobe[0] VPWR VGND sg13cmos5l_antennanp
XFILLER_26_277 VPWR VGND sg13cmos5l_fill_1
XFILLER_53_14 VPWR VGND sg13cmos5l_decap_8
XANTENNA__2970__D Tile_X0Y4_FrameData[6] VPWR VGND sg13cmos5l_antennanp
XFILLER_139_113 VPWR VGND sg13cmos5l_decap_8
XFILLER_179_260 VPWR VGND sg13cmos5l_decap_8
XANTENNA__1900__GATE Tile_X0Y5_FrameStrobe[6] VPWR VGND sg13cmos5l_antennanp
XFILLER_328_224 VPWR VGND sg13cmos5l_decap_4
XANTENNA__3708__X Tile_X0Y3_FrameData_O[11] VPWR VGND sg13cmos5l_antennanp
XFILLER_194_285 VPWR VGND sg13cmos5l_fill_2
XFILLER_154_149 VPWR VGND sg13cmos5l_decap_8
XANTENNA__1915__GATE Tile_X0Y5_FrameStrobe[6] VPWR VGND sg13cmos5l_antennanp
XFILLER_335_49 VPWR VGND sg13cmos5l_fill_1
XFILLER_335_38 VPWR VGND sg13cmos5l_fill_2
XANTENNA__2210__D Tile_X0Y1_FrameData[14] VPWR VGND sg13cmos5l_antennanp
XANTENNA__3306__D Tile_X0Y5_FrameData[6] VPWR VGND sg13cmos5l_antennanp
XANTENNA__3443__X Tile_X0Y1_FrameData_O[11] VPWR VGND sg13cmos5l_antennanp
XFILLER_311_157 VPWR VGND sg13cmos5l_decap_8
XFILLER_78_99 VPWR VGND sg13cmos5l_fill_2
XFILLER_76_100 VPWR VGND sg13cmos5l_fill_2
XFILLER_103_293 VPWR VGND sg13cmos5l_fill_2
XFILLER_264_223 VPWR VGND sg13cmos5l_fill_1
XFILLER_287_0 VPWR VGND sg13cmos5l_decap_8
XFILLER_217_150 VPWR VGND sg13cmos5l_fill_2
XFILLER_224_109 VPWR VGND sg13cmos5l_decap_8
XANTENNA__3041__D Tile_X0Y4_FrameData[31] VPWR VGND sg13cmos5l_antennanp
XFILLER_91_158 VPWR VGND sg13cmos5l_decap_8
XFILLER_150_71 VPWR VGND sg13cmos5l_fill_2
XANTENNA__1680__A1 AXI_M_SOC_RDATA2 VPWR VGND sg13cmos5l_antennanp
XANTENNA__2880__D Tile_X0Y4_FrameData[0] VPWR VGND sg13cmos5l_antennanp
X_0960_ _0960_/X Tile_X0Y1_W1END[0] Tile_X0Y1_WW4END[12] Tile_X0Y1_WW4END[4] _0959_/X
+ _2047_/Q _2048_/Q VPWR VGND sg13cmos5l_mux4_1
XANTENNA__1432__A1 Tile_X0Y2_W2END[2] VPWR VGND sg13cmos5l_antennanp
XFILLER_229_28 VPWR VGND sg13cmos5l_fill_2
XFILLER_43_80 VPWR VGND sg13cmos5l_fill_1
XANTENNA__3618__X Tile_X0Y0_E6BEG[1] VPWR VGND sg13cmos5l_antennanp
XFILLER_185_274 VPWR VGND sg13cmos5l_fill_2
X_2630_ _2630_/Q Tile_X0Y3_FrameData[10] Tile_X0Y5_FrameStrobe[3] VPWR VGND sg13cmos5l_dlhq_1
X_0891_ _1586_/B _1119_/X _0724_/X Tile_X0Y5_N4END[11] Tile_X0Y0_S4END[15] _2537_/Q
+ _2538_/Q VPWR VGND sg13cmos5l_mux4_1
XFILLER_309_50 VPWR VGND sg13cmos5l_decap_8
XFILLER_334_216 VPWR VGND sg13cmos5l_fill_1
XANTENNA__1196__A0 Tile_X0Y0_WW4END[4] VPWR VGND sg13cmos5l_antennanp
X_2561_ _2561_/Q Tile_X0Y3_FrameData[15] Tile_X0Y5_FrameStrobe[1] VPWR VGND sg13cmos5l_dlhq_1
XFILLER_153_171 VPWR VGND sg13cmos5l_fill_2
XFILLER_299_164 VPWR VGND sg13cmos5l_fill_1
X_2492_ _2492_/Q Tile_X0Y2_FrameData[4] Tile_X0Y5_FrameStrobe[7] VPWR VGND sg13cmos5l_dlhq_1
X_1512_ _1512_/X _0987_/X _0678_/X Tile_X0Y5_N4END[10] Tile_X0Y0_S4END[14] _2547_/Q
+ _2548_/Q VPWR VGND sg13cmos5l_mux4_1
XFILLER_99_203 VPWR VGND sg13cmos5l_decap_4
X_1443_ _1443_/Y _2448_/Q _1442_/X _2447_/Q VPWR VGND sg13cmos5l_o21ai_1
XFILLER_99_247 VPWR VGND sg13cmos5l_decap_4
XFILLER_4_41 VPWR VGND sg13cmos5l_decap_8
XANTENNA__2120__D Tile_X0Y1_FrameData[8] VPWR VGND sg13cmos5l_antennanp
XANTENNA__3216__D Tile_X0Y5_FrameData[0] VPWR VGND sg13cmos5l_antennanp
XANTENNA__3353__X Tile_X0Y2_E1BEG[3] VPWR VGND sg13cmos5l_antennanp
XFILLER_325_82 VPWR VGND sg13cmos5l_fill_1
XANTENNA__1499__A1 AXI_M_SOC_RDATA6 VPWR VGND sg13cmos5l_antennanp
XFILLER_255_201 VPWR VGND sg13cmos5l_fill_2
XFILLER_261_26 VPWR VGND sg13cmos5l_fill_2
X_1374_ _1374_/Y _2479_/Q _0552_/Y _2478_/Q VPWR VGND sg13cmos5l_o21ai_1
XFILLER_67_133 VPWR VGND sg13cmos5l_decap_4
XFILLER_67_111 VPWR VGND sg13cmos5l_fill_1
XANTENNA__2062__GATE Tile_X0Y5_FrameStrobe[2] VPWR VGND sg13cmos5l_antennanp
XANTENNA__2692__GATE Tile_X0Y5_FrameStrobe[5] VPWR VGND sg13cmos5l_antennanp
X_3113_ _3113_/Q Tile_X0Y5_FrameData[7] Tile_X0Y5_FrameStrobe[1] VPWR VGND sg13cmos5l_dlhq_1
X_3044_ _3044_/Q Tile_X0Y4_FrameData[28] Tile_X0Y5_FrameStrobe[8] VPWR VGND sg13cmos5l_dlhq_1
XFILLER_208_183 VPWR VGND sg13cmos5l_decap_4
XFILLER_82_169 VPWR VGND sg13cmos5l_fill_2
XANTENNA__1120__A0 Tile_X0Y3_W1END[3] VPWR VGND sg13cmos5l_antennanp
XANTENNA__2077__GATE Tile_X0Y5_FrameStrobe[3] VPWR VGND sg13cmos5l_antennanp
XFILLER_270_259 VPWR VGND sg13cmos5l_fill_1
XANTENNA__2790__D Tile_X0Y4_FrameData[26] VPWR VGND sg13cmos5l_antennanp
XFILLER_90_180 VPWR VGND sg13cmos5l_fill_1
XFILLER_23_17 VPWR VGND sg13cmos5l_decap_4
XANTENNA__1423__A1 Tile_X0Y2_WW4END[7] VPWR VGND sg13cmos5l_antennanp
XANTENNA__2000__GATE Tile_X0Y5_FrameStrobe[0] VPWR VGND sg13cmos5l_antennanp
XFILLER_210_96 VPWR VGND sg13cmos5l_fill_1
XANTENNA__2630__GATE Tile_X0Y5_FrameStrobe[3] VPWR VGND sg13cmos5l_antennanp
XANTENNA__3528__X Tile_X0Y0_N4BEG[15] VPWR VGND sg13cmos5l_antennanp
X_3877_ Tile_X0Y5_FrameData_O[18] Tile_X0Y5_FrameData[18] VPWR VGND sg13cmos5l_buf_1
XFILLER_286_89 VPWR VGND sg13cmos5l_fill_2
X_2828_ _2828_/Q Tile_X0Y4_FrameData[20] Tile_X0Y5_FrameStrobe[1] VPWR VGND sg13cmos5l_dlhq_1
X_2759_ _2759_/Q Tile_X0Y3_FrameData[9] Tile_X0Y5_FrameStrobe[7] VPWR VGND sg13cmos5l_dlhq_1
XANTENNA__2015__GATE Tile_X0Y5_FrameStrobe[1] VPWR VGND sg13cmos5l_antennanp
XFILLER_333_260 VPWR VGND sg13cmos5l_fill_1
XANTENNA__0887__X AXI_M_SOC_WSTRB1 VPWR VGND sg13cmos5l_antennanp
XANTENNA__2645__GATE Tile_X0Y5_FrameStrobe[4] VPWR VGND sg13cmos5l_antennanp
XANTENNA__2030__D Tile_X0Y1_FrameData[2] VPWR VGND sg13cmos5l_antennanp
XANTENNA__3126__D Tile_X0Y5_FrameData[26] VPWR VGND sg13cmos5l_antennanp
XANTENNA__3704__A Tile_X0Y3_FrameData[7] VPWR VGND sg13cmos5l_antennanp
XFILLER_48_14 VPWR VGND sg13cmos5l_decap_8
XFILLER_58_122 VPWR VGND sg13cmos5l_fill_1
XFILLER_58_111 VPWR VGND sg13cmos5l_decap_8
XANTENNA__2965__D Tile_X0Y4_FrameData[11] VPWR VGND sg13cmos5l_antennanp
XFILLER_100_230 VPWR VGND sg13cmos5l_decap_8
XFILLER_100_252 VPWR VGND sg13cmos5l_fill_1
XFILLER_100_274 VPWR VGND sg13cmos5l_decap_4
XFILLER_246_245 VPWR VGND sg13cmos5l_decap_8
XFILLER_58_177 VPWR VGND sg13cmos5l_decap_8
XFILLER_104_86 VPWR VGND sg13cmos5l_decap_8
XFILLER_104_97 VPWR VGND sg13cmos5l_fill_1
XFILLER_73_147 VPWR VGND sg13cmos5l_decap_8
XANTENNA__1111__A0 Tile_X0Y1_W2MID[0] VPWR VGND sg13cmos5l_antennanp
XFILLER_64_57 VPWR VGND sg13cmos5l_decap_8
XANTENNA__1662__A1 AXI_M_SOC_RDATA2 VPWR VGND sg13cmos5l_antennanp
XFILLER_120_74 VPWR VGND sg13cmos5l_decap_4
XANTENNA__1414__A1 Tile_X0Y2_WW4END[12] VPWR VGND sg13cmos5l_antennanp
XFILLER_167_230 VPWR VGND sg13cmos5l_decap_4
XFILLER_196_12 VPWR VGND sg13cmos5l_decap_8
XFILLER_80_56 VPWR VGND sg13cmos5l_decap_8
XANTENNA__2205__D Tile_X0Y1_FrameData[19] VPWR VGND sg13cmos5l_antennanp
XANTENNA__3438__X Tile_X0Y1_FrameData_O[6] VPWR VGND sg13cmos5l_antennanp
XFILLER_127_105 VPWR VGND sg13cmos5l_decap_4
XFILLER_316_227 VPWR VGND sg13cmos5l_decap_4
XANTENNA__1178__A0 Tile_X0Y4_W2MID[0] VPWR VGND sg13cmos5l_antennanp
XANTENNA__1854__GATE Tile_X0Y5_FrameStrobe[4] VPWR VGND sg13cmos5l_antennanp
XFILLER_202_0 VPWR VGND sg13cmos5l_fill_2
XFILLER_89_43 VPWR VGND sg13cmos5l_decap_8
XFILLER_89_87 VPWR VGND sg13cmos5l_fill_2
XFILLER_324_293 VPWR VGND sg13cmos5l_fill_2
XANTENNA__1869__GATE Tile_X0Y5_FrameStrobe[5] VPWR VGND sg13cmos5l_antennanp
XANTENNA__3036__D Tile_X0Y4_FrameData[4] VPWR VGND sg13cmos5l_antennanp
XFILLER_145_60 VPWR VGND sg13cmos5l_fill_1
XFILLER_296_156 VPWR VGND sg13cmos5l_decap_8
XFILLER_145_82 VPWR VGND sg13cmos5l_decap_8
XFILLER_237_201 VPWR VGND sg13cmos5l_fill_2
XANTENNA__1350__A0 Tile_X0Y2_W1END[3] VPWR VGND sg13cmos5l_antennanp
XANTENNA__2875__D Tile_X0Y4_FrameData[5] VPWR VGND sg13cmos5l_antennanp
XFILLER_49_155 VPWR VGND sg13cmos5l_fill_1
XANTENNA__3901__X Tile_X0Y5_S2BEG[6] VPWR VGND sg13cmos5l_antennanp
X_1090_ _3532_/A Tile_X0Y1_W2MID[4] Tile_X0Y1_W2END[4] Tile_X0Y1_W6END[4] _1094_/X
+ _2226_/Q _2225_/Q VPWR VGND sg13cmos5l_mux4_1
XANTENNA__1102__A0 Tile_X0Y3_W2MID[6] VPWR VGND sg13cmos5l_antennanp
XANTENNA__1421__X AXI_M_SOC_WDATA16 VPWR VGND sg13cmos5l_antennanp
XFILLER_205_120 VPWR VGND sg13cmos5l_decap_8
XANTENNA__1653__A1 Tile_X0Y4_WW4END[5] VPWR VGND sg13cmos5l_antennanp
XFILLER_72_180 VPWR VGND sg13cmos5l_fill_1
XANTENNA__1807__GATE Tile_X0Y5_FrameStrobe[3] VPWR VGND sg13cmos5l_antennanp
X_3800_ Tile_X0Y4_FrameData_O[22] Tile_X0Y4_FrameData[22] VPWR VGND sg13cmos5l_buf_1
XFILLER_220_167 VPWR VGND sg13cmos5l_decap_8
X_3731_ Tile_X0Y4_E1BEG[1] _3731_/A VPWR VGND sg13cmos5l_buf_1
X_1992_ _1992_/Q Tile_X0Y1_FrameData[8] Tile_X0Y5_FrameStrobe[0] VPWR VGND sg13cmos5l_dlhq_1
XANTENNA__2115__D Tile_X0Y1_FrameData[13] VPWR VGND sg13cmos5l_antennanp
XFILLER_13_280 VPWR VGND sg13cmos5l_decap_4
X_0943_ AXI_M_SOC_AWSIZE1 _3336_/Q _0943_/B VPWR VGND sg13cmos5l_or2_1
X_3662_ Tile_X0Y3_E2BEGb[1] _3662_/A VPWR VGND sg13cmos5l_buf_1
X_0874_ _0874_/Y _3116_/Q Tile_X0Y5_W2MID[6] VPWR VGND sg13cmos5l_nand2b_1
XANTENNA__1954__D Tile_X0Y0_FrameData[30] VPWR VGND sg13cmos5l_antennanp
X_2613_ _2613_/Q Tile_X0Y3_FrameData[27] Tile_X0Y5_FrameStrobe[3] VPWR VGND sg13cmos5l_dlhq_1
X_3593_ Tile_X0Y0_FrameData_O[24] Tile_X0Y0_FrameData[24] VPWR VGND sg13cmos5l_buf_1
X_2544_ _2544_/Q Tile_X0Y3_FrameData[0] Tile_X0Y5_FrameStrobe[0] VPWR VGND sg13cmos5l_dlhq_1
XFILLER_141_130 VPWR VGND sg13cmos5l_decap_8
XFILLER_48_0 VPWR VGND sg13cmos5l_decap_8
XFILLER_315_293 VPWR VGND sg13cmos5l_fill_2
XFILLER_315_282 VPWR VGND sg13cmos5l_fill_2
XFILLER_272_25 VPWR VGND sg13cmos5l_decap_4
X_2475_ _2475_/Q Tile_X0Y2_FrameData[21] Tile_X0Y5_FrameStrobe[7] VPWR VGND sg13cmos5l_dlhq_1
XFILLER_336_92 VPWR VGND sg13cmos5l_fill_1
XFILLER_141_185 VPWR VGND sg13cmos5l_fill_2
X_1426_ AXI_M_SOC_WDATA21 Tile_X0Y2_W1END[1] Tile_X0Y2_WW4END[13] Tile_X0Y2_WW4END[5]
+ _1025_/X _2317_/Q _2318_/Q VPWR VGND sg13cmos5l_mux4_1
XANTENNA__1341__A0 Tile_X0Y1_W2MID[2] VPWR VGND sg13cmos5l_antennanp
XANTENNA__2785__D Tile_X0Y3_FrameData[31] VPWR VGND sg13cmos5l_antennanp
X_1357_ _1357_/X _1051_/X _0574_/X Tile_X0Y5_N4END[12] Tile_X0Y0_S4END[8] _2295_/Q
+ _2296_/Q VPWR VGND sg13cmos5l_mux4_1
XANTENNA__3811__X Tile_X0Y5_E1BEG[0] VPWR VGND sg13cmos5l_antennanp
X_1288_ _3474_/A Tile_X0Y1_WW4END[5] AXI_M_SOC_RDATA27 _0927_/X _1086_/X _2108_/Q
+ _2107_/Q VPWR VGND sg13cmos5l_mux4_1
X_3027_ _3027_/Q Tile_X0Y4_FrameData[13] Tile_X0Y5_FrameStrobe[7] VPWR VGND sg13cmos5l_dlhq_1
XANTENNA__1644__A1 Tile_X0Y4_WW4END[10] VPWR VGND sg13cmos5l_antennanp
XANTENNA__3313__GATE Tile_X0Y5_FrameStrobe[8] VPWR VGND sg13cmos5l_antennanp
XFILLER_221_62 VPWR VGND sg13cmos5l_fill_1
XFILLER_297_11 VPWR VGND sg13cmos5l_fill_2
XFILLER_149_230 VPWR VGND sg13cmos5l_fill_2
XANTENNA__2025__D Tile_X0Y1_FrameData[7] VPWR VGND sg13cmos5l_antennanp
XFILLER_133_8 VPWR VGND sg13cmos5l_decap_8
XFILLER_149_263 VPWR VGND sg13cmos5l_decap_8
XFILLER_297_99 VPWR VGND sg13cmos5l_fill_2
XFILLER_50_15 VPWR VGND sg13cmos5l_decap_8
XANTENNA__3328__GATE Tile_X0Y5_FrameStrobe[8] VPWR VGND sg13cmos5l_antennanp
XFILLER_109_116 VPWR VGND sg13cmos5l_decap_8
XFILLER_164_222 VPWR VGND sg13cmos5l_decap_8
XANTENNA__1864__D Tile_X0Y0_FrameData[24] VPWR VGND sg13cmos5l_antennanp
XFILLER_164_266 VPWR VGND sg13cmos5l_fill_1
XANTENNA__2584__GATE Tile_X0Y5_FrameStrobe[2] VPWR VGND sg13cmos5l_antennanp
XFILLER_124_119 VPWR VGND sg13cmos5l_decap_8
XFILLER_313_219 VPWR VGND sg13cmos5l_decap_8
XFILLER_306_293 VPWR VGND sg13cmos5l_fill_2
XFILLER_316_29 VPWR VGND sg13cmos5l_decap_4
XANTENNA__1580__A0 Tile_X0Y3_W1END[2] VPWR VGND sg13cmos5l_antennanp
XANTENNA__3434__A Tile_X0Y1_FrameData[2] VPWR VGND sg13cmos5l_antennanp
XFILLER_182_25 VPWR VGND sg13cmos5l_decap_8
XFILLER_278_134 VPWR VGND sg13cmos5l_decap_4
XFILLER_59_35 VPWR VGND sg13cmos5l_decap_8
XANTENNA__2599__GATE Tile_X0Y5_FrameStrobe[2] VPWR VGND sg13cmos5l_antennanp
XANTENNA__2695__D Tile_X0Y3_FrameData[9] VPWR VGND sg13cmos5l_antennanp
XANTENNA__3721__X Tile_X0Y3_FrameData_O[24] VPWR VGND sg13cmos5l_antennanp
XFILLER_75_23 VPWR VGND sg13cmos5l_decap_4
XFILLER_46_103 VPWR VGND sg13cmos5l_decap_4
XANTENNA__2522__GATE Tile_X0Y5_FrameStrobe[0] VPWR VGND sg13cmos5l_antennanp
XFILLER_46_136 VPWR VGND sg13cmos5l_decap_8
XFILLER_61_106 VPWR VGND sg13cmos5l_decap_8
XANTENNA__1635__A1 Tile_X0Y4_WW4END[9] VPWR VGND sg13cmos5l_antennanp
XFILLER_131_73 VPWR VGND sg13cmos5l_decap_4
XFILLER_131_95 VPWR VGND sg13cmos5l_decap_8
XFILLER_152_0 VPWR VGND sg13cmos5l_fill_2
XFILLER_242_270 VPWR VGND sg13cmos5l_decap_8
XANTENNA__2537__GATE Tile_X0Y5_FrameStrobe[0] VPWR VGND sg13cmos5l_antennanp
XANTENNA__1399__A0 AXI_M_SOC_RDATA16 VPWR VGND sg13cmos5l_antennanp
XANTENNA__1793__GATE Tile_X0Y5_FrameStrobe[3] VPWR VGND sg13cmos5l_antennanp
XANTENNA__1774__D Tile_X0Y0_FrameData[18] VPWR VGND sg13cmos5l_antennanp
XFILLER_155_255 VPWR VGND sg13cmos5l_fill_2
XFILLER_6_232 VPWR VGND sg13cmos5l_fill_1
X_0590_ _0590_/Y _2791_/Q _0590_/B _0590_/C VPWR VGND sg13cmos5l_nor3_1
XANTENNA__1166__A3 AXI_M_SOC_AWREADY VPWR VGND sg13cmos5l_antennanp
XANTENNA__1416__X AXI_M_SOC_WDATA24 VPWR VGND sg13cmos5l_antennanp
XFILLER_41_7 VPWR VGND sg13cmos5l_fill_2
XFILLER_306_51 VPWR VGND sg13cmos5l_decap_4
XFILLER_306_73 VPWR VGND sg13cmos5l_fill_2
X_2260_ _2260_/Q Tile_X0Y2_FrameData[12] Tile_X0Y5_FrameStrobe[0] VPWR VGND sg13cmos5l_dlhq_1
XFILLER_69_228 VPWR VGND sg13cmos5l_fill_1
XFILLER_284_115 VPWR VGND sg13cmos5l_decap_4
X_1211_ AXI_M_SOC_AWADDR28 Tile_X0Y0_W2MID[4] Tile_X0Y0_W2END[4] Tile_X0Y0_W6END[4]
+ _1078_/X _1760_/Q _1759_/Q VPWR VGND sg13cmos5l_mux4_1
XANTENNA__1323__A0 Tile_X0Y1_W2MID[5] VPWR VGND sg13cmos5l_antennanp
XANTENNA__1731__GATE Tile_X0Y5_FrameStrobe[1] VPWR VGND sg13cmos5l_antennanp
XANTENNA__3631__X Tile_X0Y0_E2BEGb[2] VPWR VGND sg13cmos5l_antennanp
XFILLER_172_80 VPWR VGND sg13cmos5l_decap_8
X_2191_ _2191_/Q Tile_X0Y1_FrameData[1] Tile_X0Y5_FrameStrobe[6] VPWR VGND sg13cmos5l_dlhq_1
XFILLER_225_215 VPWR VGND sg13cmos5l_fill_1
X_1142_ _1142_/X Tile_X0Y4_W2MID[6] Tile_X0Y4_W2END[6] Tile_X0Y4_W6END[6] _1049_/X
+ _3046_/Q _3045_/Q VPWR VGND sg13cmos5l_mux4_1
XFILLER_77_294 VPWR VGND sg13cmos5l_fill_1
XFILLER_37_125 VPWR VGND sg13cmos5l_decap_8
X_1073_ _1073_/X _1072_/X _0780_/X Tile_X0Y5_N2MID[0] _1071_/X _2807_/Q _2808_/Q VPWR
+ VGND sg13cmos5l_mux4_1
XFILLER_322_94 VPWR VGND sg13cmos5l_decap_4
XANTENNA__1746__GATE Tile_X0Y5_FrameStrobe[1] VPWR VGND sg13cmos5l_antennanp
XANTENNA__1949__D Tile_X0Y0_FrameData[3] VPWR VGND sg13cmos5l_antennanp
XFILLER_267_14 VPWR VGND sg13cmos5l_fill_2
X_1975_ _1975_/Q Tile_X0Y1_FrameData[25] Tile_X0Y5_FrameStrobe[0] VPWR VGND sg13cmos5l_dlhq_1
X_3714_ Tile_X0Y3_FrameData_O[17] Tile_X0Y3_FrameData[17] VPWR VGND sg13cmos5l_buf_1
X_0926_ _0926_/X _0923_/X _0925_/X _0922_/X _0924_/X _3299_/Q _3300_/Q VPWR VGND sg13cmos5l_mux4_1
XANTENNA__3806__X Tile_X0Y4_FrameData_O[28] VPWR VGND sg13cmos5l_antennanp
X_3645_ Tile_X0Y0_E1BEG[0] _3645_/A VPWR VGND sg13cmos5l_buf_1
X_0857_ _0857_/Y _3122_/Q Tile_X0Y5_W6END[3] VPWR VGND sg13cmos5l_nor2b_1
XFILLER_283_35 VPWR VGND sg13cmos5l_fill_2
X_3576_ Tile_X0Y0_FrameData_O[7] Tile_X0Y0_FrameData[7] VPWR VGND sg13cmos5l_buf_1
X_0788_ _0788_/X Tile_X0Y3_W2MID[5] Tile_X0Y3_W2END[5] Tile_X0Y3_W6END[10] _1216_/X
+ _2736_/Q _2735_/Q VPWR VGND sg13cmos5l_mux4_1
XANTENNA__1562__A0 Tile_X0Y3_WW4END[1] VPWR VGND sg13cmos5l_antennanp
XFILLER_283_68 VPWR VGND sg13cmos5l_fill_2
XFILLER_303_252 VPWR VGND sg13cmos5l_decap_8
X_2527_ _2527_/Q Tile_X0Y3_FrameData[17] Tile_X0Y5_FrameStrobe[0] VPWR VGND sg13cmos5l_dlhq_1
XFILLER_114_196 VPWR VGND sg13cmos5l_decap_8
XFILLER_303_285 VPWR VGND sg13cmos5l_fill_2
X_2458_ _2458_/Q Tile_X0Y2_FrameData[6] Tile_X0Y5_FrameStrobe[6] VPWR VGND sg13cmos5l_dlhq_1
X_1409_ _3377_/A AXI_M_SOC_RDATA17 _1312_/X _1355_/X _1187_/X _2354_/Q _2353_/Q VPWR
+ VGND sg13cmos5l_mux4_1
XANTENNA__3541__X Tile_X0Y0_N2BEG[4] VPWR VGND sg13cmos5l_antennanp
X_2389_ _2389_/Q Tile_X0Y2_FrameData[11] Tile_X0Y5_FrameStrobe[4] VPWR VGND sg13cmos5l_dlhq_1
XFILLER_68_283 VPWR VGND sg13cmos5l_fill_1
XFILLER_68_272 VPWR VGND sg13cmos5l_fill_2
XANTENNA__3252__GATE Tile_X0Y5_FrameStrobe[6] VPWR VGND sg13cmos5l_antennanp
XFILLER_28_169 VPWR VGND sg13cmos5l_fill_1
XANTENNA__1859__D Tile_X0Y0_FrameData[29] VPWR VGND sg13cmos5l_antennanp
XANTENNA__1093__A2 Tile_X0Y0_W6END[11] VPWR VGND sg13cmos5l_antennanp
XANTENNA__0840__A2 Tile_X0Y5_WW4END[4] VPWR VGND sg13cmos5l_antennanp
XANTENNA__3267__GATE Tile_X0Y5_FrameStrobe[6] VPWR VGND sg13cmos5l_antennanp
XFILLER_196_155 VPWR VGND sg13cmos5l_decap_8
XFILLER_61_36 VPWR VGND sg13cmos5l_decap_8
XANTENNA__3429__A Tile_X0Y2_FrameData[31] VPWR VGND sg13cmos5l_antennanp
XFILLER_177_47 VPWR VGND sg13cmos5l_decap_8
XFILLER_177_58 VPWR VGND sg13cmos5l_fill_2
XFILLER_177_69 VPWR VGND sg13cmos5l_decap_4
XANTENNA__3716__X Tile_X0Y3_FrameData_O[19] VPWR VGND sg13cmos5l_antennanp
XFILLER_137_277 VPWR VGND sg13cmos5l_decap_4
XFILLER_193_46 VPWR VGND sg13cmos5l_decap_4
XFILLER_298_218 VPWR VGND sg13cmos5l_decap_4
XANTENNA__1148__A3 Tile_X0Y0_S2END[3] VPWR VGND sg13cmos5l_antennanp
XANTENNA__1553__A0 Tile_X0Y3_WW4END[5] VPWR VGND sg13cmos5l_antennanp
XFILLER_152_258 VPWR VGND sg13cmos5l_decap_4
XFILLER_3_257 VPWR VGND sg13cmos5l_decap_4
XANTENNA__3205__GATE Tile_X0Y5_FrameStrobe[4] VPWR VGND sg13cmos5l_antennanp
XFILLER_105_163 VPWR VGND sg13cmos5l_decap_8
XFILLER_126_62 VPWR VGND sg13cmos5l_decap_8
XFILLER_86_22 VPWR VGND sg13cmos5l_decap_8
XFILLER_86_11 VPWR VGND sg13cmos5l_fill_2
XANTENNA__1305__A0 AXI_M_SOC_RDATA26 VPWR VGND sg13cmos5l_antennanp
XANTENNA__2461__GATE Tile_X0Y5_FrameStrobe[6] VPWR VGND sg13cmos5l_antennanp
XANTENNA__3314__D Tile_X0Y5_FrameData[30] VPWR VGND sg13cmos5l_antennanp
XANTENNA__3451__X Tile_X0Y1_FrameData_O[19] VPWR VGND sg13cmos5l_antennanp
XANTENNA__1320__A3 AXI_M_SOC_RDATA26 VPWR VGND sg13cmos5l_antennanp
XFILLER_207_226 VPWR VGND sg13cmos5l_fill_2
XFILLER_74_275 VPWR VGND sg13cmos5l_fill_1
XANTENNA__1608__A1 AXI_M_SOC_RDATA3 VPWR VGND sg13cmos5l_antennanp
XANTENNA__1769__D Tile_X0Y0_FrameData[23] VPWR VGND sg13cmos5l_antennanp
XANTENNA__2476__GATE Tile_X0Y5_FrameStrobe[7] VPWR VGND sg13cmos5l_antennanp
XANTENNA__1084__A2 Tile_X0Y0_W2END[2] VPWR VGND sg13cmos5l_antennanp
XFILLER_42_150 VPWR VGND sg13cmos5l_fill_1
XFILLER_187_144 VPWR VGND sg13cmos5l_fill_1
XFILLER_187_177 VPWR VGND sg13cmos5l_decap_4
XFILLER_128_200 VPWR VGND sg13cmos5l_decap_8
X_1760_ _1760_/Q Tile_X0Y0_FrameData[0] Tile_X0Y5_FrameStrobe[1] VPWR VGND sg13cmos5l_dlhq_1
XFILLER_128_244 VPWR VGND sg13cmos5l_decap_8
X_0711_ _0711_/Y _0540_/Y _1969_/Q _1698_/Q _0709_/Y _0710_/Y VPWR VGND sg13cmos5l_a221oi_1
XANTENNA__3626__X Tile_X0Y0_E6BEG[9] VPWR VGND sg13cmos5l_antennanp
XFILLER_167_91 VPWR VGND sg13cmos5l_decap_8
X_1691_ _3921_/A _1690_/X _1689_/X _2988_/Q VPWR VGND sg13cmos5l_mux2_1
XFILLER_289_207 VPWR VGND sg13cmos5l_decap_4
X_3430_ Tile_X0Y2_UserCLKo Tile_X0Y2_UserCLK VPWR VGND sg13cmos5l_buf_1
X_0642_ _0642_/X Tile_X0Y1_W6END[5] _0962_/X _1218_/X _1086_/X _2175_/Q _2177_/Q VPWR
+ VGND sg13cmos5l_mux4_1
XANTENNA__1544__A0 AXI_M_SOC_RDATA12 VPWR VGND sg13cmos5l_antennanp
XANTENNA__2414__GATE Tile_X0Y5_FrameStrobe[5] VPWR VGND sg13cmos5l_antennanp
X_3361_ Tile_X0Y2_E2BEG[7] _3361_/A VPWR VGND sg13cmos5l_buf_1
X_0573_ _0573_/X _0568_/X _0569_/Y _0572_/Y VPWR VGND sg13cmos5l_a21o_1
XFILLER_151_280 VPWR VGND sg13cmos5l_fill_1
XFILLER_253_27 VPWR VGND sg13cmos5l_fill_2
X_2312_ _2312_/Q Tile_X0Y2_FrameData[24] Tile_X0Y5_FrameStrobe[2] VPWR VGND sg13cmos5l_dlhq_1
XFILLER_300_222 VPWR VGND sg13cmos5l_fill_1
X_3292_ _3292_/Q Tile_X0Y5_FrameData[20] Tile_X0Y5_FrameStrobe[7] VPWR VGND sg13cmos5l_dlhq_1
XANTENNA__2429__GATE Tile_X0Y5_FrameStrobe[5] VPWR VGND sg13cmos5l_antennanp
XANTENNA__3224__D Tile_X0Y5_FrameData[24] VPWR VGND sg13cmos5l_antennanp
XANTENNA__3361__X Tile_X0Y2_E2BEG[7] VPWR VGND sg13cmos5l_antennanp
XANTENNA__3802__A Tile_X0Y4_FrameData[24] VPWR VGND sg13cmos5l_antennanp
X_2243_ _2243_/Q Tile_X0Y2_FrameData[29] Tile_X0Y5_FrameStrobe[0] VPWR VGND sg13cmos5l_dlhq_1
X_2174_ _2174_/Q Tile_X0Y1_FrameData[18] Tile_X0Y5_FrameStrobe[6] VPWR VGND sg13cmos5l_dlhq_1
X_1125_ _1125_/X _1135_/X _0730_/X Tile_X0Y5_N4END[7] _0980_/X _2825_/Q _2826_/Q VPWR
+ VGND sg13cmos5l_mux4_1
XFILLER_213_207 VPWR VGND sg13cmos5l_fill_1
XFILLER_280_162 VPWR VGND sg13cmos5l_fill_2
X_1056_ _1056_/X Tile_X0Y5_W1END[0] _0596_/X Tile_X0Y5_W6END[4] _1055_/Y _3327_/Q
+ _3328_/Q VPWR VGND sg13cmos5l_mux4_1
XANTENNA__1075__A2 Tile_X0Y0_S1END[0] VPWR VGND sg13cmos5l_antennanp
XFILLER_178_122 VPWR VGND sg13cmos5l_decap_8
XFILLER_33_172 VPWR VGND sg13cmos5l_decap_8
XFILLER_193_125 VPWR VGND sg13cmos5l_fill_1
X_1958_ _1958_/Q Tile_X0Y0_FrameData[26] Tile_X0Y5_FrameStrobe[8] VPWR VGND sg13cmos5l_dlhq_1
XANTENNA__0586__A1 Tile_X0Y3_W6END[8] VPWR VGND sg13cmos5l_antennanp
XANTENNA__2303__D Tile_X0Y2_FrameData[1] VPWR VGND sg13cmos5l_antennanp
XANTENNA__3536__X Tile_X0Y0_N2BEGb[7] VPWR VGND sg13cmos5l_antennanp
X_1889_ _1889_/Q Tile_X0Y0_FrameData[31] Tile_X0Y5_FrameStrobe[6] VPWR VGND sg13cmos5l_dlhq_1
X_0909_ _0909_/Y _0909_/A VPWR VGND sg13cmos5l_inv_1
XFILLER_227_50 VPWR VGND sg13cmos5l_fill_2
X_3628_ Tile_X0Y0_E6BEG[11] _3628_/A VPWR VGND sg13cmos5l_buf_1
XFILLER_227_83 VPWR VGND sg13cmos5l_fill_2
XANTENNA__1535__A0 Tile_X0Y5_N4END[11] VPWR VGND sg13cmos5l_antennanp
XFILLER_102_111 VPWR VGND sg13cmos5l_decap_4
X_3559_ Tile_X0Y0_FrameStrobe_O[10] Tile_X0Y5_FrameStrobe[10] VPWR VGND sg13cmos5l_buf_1
XANTENNA__0889__A2 Tile_X0Y3_WW4END[6] VPWR VGND sg13cmos5l_antennanp
XFILLER_298_8 VPWR VGND sg13cmos5l_fill_1
XANTENNA__3134__D Tile_X0Y5_FrameData[18] VPWR VGND sg13cmos5l_antennanp
XANTENNA__3712__A Tile_X0Y3_FrameData[15] VPWR VGND sg13cmos5l_antennanp
XFILLER_102_155 VPWR VGND sg13cmos5l_decap_4
XFILLER_56_14 VPWR VGND sg13cmos5l_decap_8
XANTENNA__3191__GATE Tile_X0Y5_FrameStrobe[4] VPWR VGND sg13cmos5l_antennanp
XANTENNA__2973__D Tile_X0Y4_FrameData[3] VPWR VGND sg13cmos5l_antennanp
XFILLER_72_24 VPWR VGND sg13cmos5l_decap_4
XFILLER_71_267 VPWR VGND sg13cmos5l_decap_8
XANTENNA__1066__A2 Tile_X0Y4_W6END[8] VPWR VGND sg13cmos5l_antennanp
XFILLER_24_172 VPWR VGND sg13cmos5l_decap_8
XFILLER_184_158 VPWR VGND sg13cmos5l_decap_4
XANTENNA__1369__A3 Tile_X0Y0_S4END[9] VPWR VGND sg13cmos5l_antennanp
XANTENNA__3309__D Tile_X0Y5_FrameData[3] VPWR VGND sg13cmos5l_antennanp
XANTENNA__3446__X Tile_X0Y1_FrameData_O[14] VPWR VGND sg13cmos5l_antennanp
XANTENNA__2213__D Tile_X0Y1_FrameData[11] VPWR VGND sg13cmos5l_antennanp
XFILLER_21_94 VPWR VGND sg13cmos5l_decap_8
XANTENNA__3144__GATE Tile_X0Y5_FrameStrobe[2] VPWR VGND sg13cmos5l_antennanp
XFILLER_137_94 VPWR VGND sg13cmos5l_decap_8
XFILLER_294_221 VPWR VGND sg13cmos5l_decap_4
XANTENNA__3044__D Tile_X0Y4_FrameData[28] VPWR VGND sg13cmos5l_antennanp
XANTENNA__3159__GATE Tile_X0Y5_FrameStrobe[3] VPWR VGND sg13cmos5l_antennanp
XFILLER_254_129 VPWR VGND sg13cmos5l_decap_8
XFILLER_47_220 VPWR VGND sg13cmos5l_fill_2
XANTENNA__2883__D Tile_X0Y4_FrameData[29] VPWR VGND sg13cmos5l_antennanp
XFILLER_303_41 VPWR VGND sg13cmos5l_fill_1
XFILLER_262_162 VPWR VGND sg13cmos5l_fill_1
XFILLER_62_245 VPWR VGND sg13cmos5l_fill_1
XFILLER_62_234 VPWR VGND sg13cmos5l_decap_8
XANTENNA__1057__A2 Tile_X0Y1_W6END[5] VPWR VGND sg13cmos5l_antennanp
X_2930_ _2930_/Q Tile_X0Y4_FrameData[14] Tile_X0Y5_FrameStrobe[4] VPWR VGND sg13cmos5l_dlhq_1
XFILLER_175_125 VPWR VGND sg13cmos5l_decap_8
X_2861_ _2861_/Q Tile_X0Y4_FrameData[19] Tile_X0Y5_FrameStrobe[2] VPWR VGND sg13cmos5l_dlhq_1
XFILLER_30_186 VPWR VGND sg13cmos5l_decap_8
X_2792_ _2792_/Q Tile_X0Y4_FrameData[24] Tile_X0Y5_FrameStrobe[0] VPWR VGND sg13cmos5l_dlhq_1
X_1812_ _1812_/Q Tile_X0Y0_FrameData[12] Tile_X0Y5_FrameStrobe[3] VPWR VGND sg13cmos5l_dlhq_1
XANTENNA__0568__A1 Tile_X0Y0_W6END[8] VPWR VGND sg13cmos5l_antennanp
XANTENNA__3219__D Tile_X0Y5_FrameData[29] VPWR VGND sg13cmos5l_antennanp
XANTENNA__3356__X Tile_X0Y2_E2BEG[2] VPWR VGND sg13cmos5l_antennanp
X_1743_ _1743_/Q Tile_X0Y0_FrameData[17] Tile_X0Y5_FrameStrobe[1] VPWR VGND sg13cmos5l_dlhq_1
XFILLER_7_52 VPWR VGND sg13cmos5l_fill_2
XANTENNA__2123__D Tile_X0Y1_FrameData[5] VPWR VGND sg13cmos5l_antennanp
XANTENNA__2353__GATE Tile_X0Y5_FrameStrobe[3] VPWR VGND sg13cmos5l_antennanp
X_1674_ _3765_/A Tile_X0Y4_WW4END[12] _1070_/X AXI_M_SOC_RDATA1 _1319_/X _2937_/Q
+ _2938_/Q VPWR VGND sg13cmos5l_mux4_1
XANTENNA__2983__GATE Tile_X0Y5_FrameStrobe[6] VPWR VGND sg13cmos5l_antennanp
XFILLER_264_48 VPWR VGND sg13cmos5l_decap_4
X_3413_ Tile_X0Y2_FrameData_O[15] Tile_X0Y2_FrameData[15] VPWR VGND sg13cmos5l_buf_1
X_0625_ _0627_/B Tile_X0Y2_W6END[1] _2246_/Q VPWR VGND sg13cmos5l_nor2b_1
XANTENNA__1517__A0 Tile_X0Y3_WW4END[15] VPWR VGND sg13cmos5l_antennanp
XANTENNA__1962__D Tile_X0Y0_FrameData[22] VPWR VGND sg13cmos5l_antennanp
XFILLER_131_228 VPWR VGND sg13cmos5l_fill_1
XANTENNA__2368__GATE Tile_X0Y5_FrameStrobe[3] VPWR VGND sg13cmos5l_antennanp
XFILLER_124_280 VPWR VGND sg13cmos5l_fill_1
XFILLER_30_0 VPWR VGND sg13cmos5l_fill_2
X_3344_ _3344_/Q Tile_X0Y5_FrameData[10] Tile_X0Y5_FrameStrobe[8] VPWR VGND sg13cmos5l_dlhq_1
X_0556_ _0556_/Y _1435_/X VPWR VGND sg13cmos5l_inv_1
XFILLER_332_199 VPWR VGND sg13cmos5l_decap_8
XANTENNA__2998__GATE Tile_X0Y5_FrameStrobe[6] VPWR VGND sg13cmos5l_antennanp
X_3275_ _3275_/Q Tile_X0Y5_FrameData[5] Tile_X0Y5_FrameStrobe[6] VPWR VGND sg13cmos5l_dlhq_1
XANTENNA__0740__A1 Tile_X0Y5_N4END[3] VPWR VGND sg13cmos5l_antennanp
X_2226_ _2226_/Q Tile_X0Y1_FrameData[30] Tile_X0Y5_FrameStrobe[8] VPWR VGND sg13cmos5l_dlhq_1
XANTENNA__2793__D Tile_X0Y4_FrameData[23] VPWR VGND sg13cmos5l_antennanp
XANTENNA__1296__A2 Tile_X0Y0_S4END[5] VPWR VGND sg13cmos5l_antennanp
XANTENNA__2921__GATE Tile_X0Y5_FrameStrobe[4] VPWR VGND sg13cmos5l_antennanp
XFILLER_26_28 VPWR VGND sg13cmos5l_decap_8
X_2157_ _2157_/Q Tile_X0Y1_FrameData[3] Tile_X0Y5_FrameStrobe[5] VPWR VGND sg13cmos5l_dlhq_1
X_2088_ _2088_/Q Tile_X0Y1_FrameData[8] Tile_X0Y5_FrameStrobe[3] VPWR VGND sg13cmos5l_dlhq_1
X_1108_ _1108_/X Tile_X0Y0_W2MID[7] Tile_X0Y0_W2END[7] Tile_X0Y0_W6END[8] _1145_/X
+ _1924_/Q _1923_/Q VPWR VGND sg13cmos5l_mux4_1
XANTENNA__1048__A2 Tile_X0Y5_W6END[6] VPWR VGND sg13cmos5l_antennanp
XFILLER_289_56 VPWR VGND sg13cmos5l_fill_1
XFILLER_289_67 VPWR VGND sg13cmos5l_decap_8
X_1039_ _1039_/X _1023_/X _0635_/X Tile_X0Y5_N4END[5] _1028_/X _2829_/Q _2830_/Q VPWR
+ VGND sg13cmos5l_mux4_1
XANTENNA__2306__GATE Tile_X0Y5_FrameStrobe[2] VPWR VGND sg13cmos5l_antennanp
XANTENNA__2936__GATE Tile_X0Y5_FrameStrobe[4] VPWR VGND sg13cmos5l_antennanp
XANTENNA__0559__A1 Tile_X0Y5_N2END[6] VPWR VGND sg13cmos5l_antennanp
XANTENNA__3129__D Tile_X0Y5_FrameData[23] VPWR VGND sg13cmos5l_antennanp
XFILLER_107_203 VPWR VGND sg13cmos5l_decap_8
XANTENNA__1220__A2 Tile_X0Y0_S4END[1] VPWR VGND sg13cmos5l_antennanp
XANTENNA__2033__D Tile_X0Y1_FrameData[31] VPWR VGND sg13cmos5l_antennanp
XANTENNA__3707__A Tile_X0Y3_FrameData[10] VPWR VGND sg13cmos5l_antennanp
XFILLER_308_174 VPWR VGND sg13cmos5l_decap_8
XANTENNA__2968__D Tile_X0Y4_FrameData[8] VPWR VGND sg13cmos5l_antennanp
XFILLER_107_258 VPWR VGND sg13cmos5l_decap_8
XANTENNA__1508__A0 Tile_X0Y3_W2END[3] VPWR VGND sg13cmos5l_antennanp
XANTENNA__1872__D Tile_X0Y0_FrameData[16] VPWR VGND sg13cmos5l_antennanp
XFILLER_107_42 VPWR VGND sg13cmos5l_decap_8
XANTENNA__1523__A3 Tile_X0Y0_S4END[13] VPWR VGND sg13cmos5l_antennanp
XFILLER_190_14 VPWR VGND sg13cmos5l_decap_8
XFILLER_276_221 VPWR VGND sg13cmos5l_decap_4
XFILLER_88_164 VPWR VGND sg13cmos5l_fill_2
XFILLER_88_153 VPWR VGND sg13cmos5l_decap_8
XANTENNA__3442__A Tile_X0Y1_FrameData[10] VPWR VGND sg13cmos5l_antennanp
XFILLER_130_272 VPWR VGND sg13cmos5l_fill_2
XFILLER_236_107 VPWR VGND sg13cmos5l_decap_8
XFILLER_276_265 VPWR VGND sg13cmos5l_fill_1
XFILLER_88_197 VPWR VGND sg13cmos5l_decap_8
XFILLER_67_68 VPWR VGND sg13cmos5l_decap_8
XFILLER_123_30 VPWR VGND sg13cmos5l_decap_4
XFILLER_123_41 VPWR VGND sg13cmos5l_decap_8
XFILLER_123_52 VPWR VGND sg13cmos5l_fill_1
XFILLER_123_74 VPWR VGND sg13cmos5l_decap_8
XFILLER_83_56 VPWR VGND sg13cmos5l_decap_8
XANTENNA__1039__A2 Tile_X0Y5_N4END[5] VPWR VGND sg13cmos5l_antennanp
XANTENNA__2208__D Tile_X0Y1_FrameData[16] VPWR VGND sg13cmos5l_antennanp
XFILLER_44_267 VPWR VGND sg13cmos5l_decap_8
XFILLER_12_142 VPWR VGND sg13cmos5l_decap_8
XFILLER_200_232 VPWR VGND sg13cmos5l_fill_1
XFILLER_232_0 VPWR VGND sg13cmos5l_fill_1
XANTENNA__3039__D Tile_X0Y4_FrameData[1] VPWR VGND sg13cmos5l_antennanp
XFILLER_32_71 VPWR VGND sg13cmos5l_decap_4
XANTENNA__1211__A2 Tile_X0Y0_W6END[4] VPWR VGND sg13cmos5l_antennanp
XANTENNA__2878__D Tile_X0Y4_FrameData[2] VPWR VGND sg13cmos5l_antennanp
XANTENNA__3083__GATE Tile_X0Y5_FrameStrobe[0] VPWR VGND sg13cmos5l_antennanp
XANTENNA__1782__D Tile_X0Y0_FrameData[10] VPWR VGND sg13cmos5l_antennanp
XANTENNA__3904__X Tile_X0Y5_S2BEGb[1] VPWR VGND sg13cmos5l_antennanp
X_1390_ _1390_/Y _2483_/Q _1390_/B VPWR VGND sg13cmos5l_nand2b_1
XFILLER_79_120 VPWR VGND sg13cmos5l_decap_8
XANTENNA__3098__GATE Tile_X0Y5_FrameStrobe[1] VPWR VGND sg13cmos5l_antennanp
XANTENNA__1424__X AXI_M_SOC_WDATA14 VPWR VGND sg13cmos5l_antennanp
XFILLER_121_294 VPWR VGND sg13cmos5l_fill_1
XFILLER_227_118 VPWR VGND sg13cmos5l_decap_4
XFILLER_282_213 VPWR VGND sg13cmos5l_fill_2
X_3060_ _3060_/Q Tile_X0Y5_FrameData[28] Tile_X0Y5_FrameStrobe[0] VPWR VGND sg13cmos5l_dlhq_1
X_2011_ _2011_/Q Tile_X0Y1_FrameData[21] Tile_X0Y5_FrameStrobe[1] VPWR VGND sg13cmos5l_dlhq_1
XFILLER_94_145 VPWR VGND sg13cmos5l_fill_2
XANTENNA__3021__GATE Tile_X0Y5_FrameStrobe[7] VPWR VGND sg13cmos5l_antennanp
XFILLER_180_80 VPWR VGND sg13cmos5l_decap_8
XANTENNA__2118__D Tile_X0Y1_FrameData[10] VPWR VGND sg13cmos5l_antennanp
XFILLER_250_143 VPWR VGND sg13cmos5l_fill_2
XFILLER_195_209 VPWR VGND sg13cmos5l_fill_2
XANTENNA__0789__A1 Tile_X0Y4_W2END[5] VPWR VGND sg13cmos5l_antennanp
XANTENNA__1957__D Tile_X0Y0_FrameData[27] VPWR VGND sg13cmos5l_antennanp
XANTENNA__3036__GATE Tile_X0Y5_FrameStrobe[7] VPWR VGND sg13cmos5l_antennanp
X_2913_ _2913_/Q Tile_X0Y4_FrameData[31] Tile_X0Y5_FrameStrobe[4] VPWR VGND sg13cmos5l_dlhq_1
X_3893_ Tile_X0Y5_S1BEG[2] _3893_/A VPWR VGND sg13cmos5l_buf_1
XFILLER_337_203 VPWR VGND sg13cmos5l_fill_2
XANTENNA__1450__A2 AXI_M_SOC_RDATA15 VPWR VGND sg13cmos5l_antennanp
X_2844_ _2844_/Q Tile_X0Y4_FrameData[4] Tile_X0Y5_FrameStrobe[1] VPWR VGND sg13cmos5l_dlhq_1
XANTENNA__2292__GATE Tile_X0Y5_FrameStrobe[1] VPWR VGND sg13cmos5l_antennanp
X_2775_ _2775_/Q Tile_X0Y3_FrameData[25] Tile_X0Y5_FrameStrobe[8] VPWR VGND sg13cmos5l_dlhq_1
XANTENNA__1202__A2 Tile_X0Y0_W6END[8] VPWR VGND sg13cmos5l_antennanp
XANTENNA__2788__D Tile_X0Y4_FrameData[28] VPWR VGND sg13cmos5l_antennanp
XFILLER_275_69 VPWR VGND sg13cmos5l_fill_2
XFILLER_305_144 VPWR VGND sg13cmos5l_decap_8
X_1726_ _1726_/Q Tile_X0Y0_FrameData[2] Tile_X0Y5_FrameStrobe[0] VPWR VGND sg13cmos5l_dlhq_1
XANTENNA__3814__X Tile_X0Y5_E1BEG[3] VPWR VGND sg13cmos5l_antennanp
XFILLER_171_161 VPWR VGND sg13cmos5l_decap_8
X_1657_ _3740_/A Tile_X0Y4_W2MID[1] AXI_M_SOC_RDATA4 _1049_/X _1360_/X _2964_/Q _2963_/Q
+ VPWR VGND sg13cmos5l_mux4_1
XFILLER_320_103 VPWR VGND sg13cmos5l_fill_1
XFILLER_144_29 VPWR VGND sg13cmos5l_fill_2
X_1588_ _1589_/C _2750_/Q _1588_/B _1588_/C VPWR VGND sg13cmos5l_nand3_1
X_0608_ _0608_/X _0596_/X _0607_/X _3268_/Q VPWR VGND sg13cmos5l_mux2_1
XFILLER_112_250 VPWR VGND sg13cmos5l_decap_4
X_3327_ _3327_/Q Tile_X0Y5_FrameData[17] Tile_X0Y5_FrameStrobe[8] VPWR VGND sg13cmos5l_dlhq_1
X_0539_ _0539_/Y Tile_X0Y0_S1END[0] VPWR VGND sg13cmos5l_inv_1
XFILLER_85_123 VPWR VGND sg13cmos5l_decap_8
XANTENNA__2230__GATE Tile_X0Y5_FrameStrobe[8] VPWR VGND sg13cmos5l_antennanp
XANTENNA__2860__GATE Tile_X0Y5_FrameStrobe[2] VPWR VGND sg13cmos5l_antennanp
XFILLER_273_213 VPWR VGND sg13cmos5l_decap_8
X_3258_ _3258_/Q Tile_X0Y5_FrameData[22] Tile_X0Y5_FrameStrobe[6] VPWR VGND sg13cmos5l_dlhq_1
XANTENNA__1269__A2 Tile_X0Y5_W6END[3] VPWR VGND sg13cmos5l_antennanp
X_3189_ _3189_/Q Tile_X0Y5_FrameData[27] Tile_X0Y5_FrameStrobe[4] VPWR VGND sg13cmos5l_dlhq_1
X_2209_ _2209_/Q Tile_X0Y1_FrameData[15] Tile_X0Y5_FrameStrobe[7] VPWR VGND sg13cmos5l_dlhq_1
XANTENNA__2028__D Tile_X0Y1_FrameData[4] VPWR VGND sg13cmos5l_antennanp
XANTENNA__2245__GATE Tile_X0Y5_FrameStrobe[0] VPWR VGND sg13cmos5l_antennanp
XFILLER_226_195 VPWR VGND sg13cmos5l_decap_8
XANTENNA__2875__GATE Tile_X0Y5_FrameStrobe[2] VPWR VGND sg13cmos5l_antennanp
XANTENNA__1867__D Tile_X0Y0_FrameData[21] VPWR VGND sg13cmos5l_antennanp
XFILLER_241_187 VPWR VGND sg13cmos5l_decap_8
XFILLER_194_220 VPWR VGND sg13cmos5l_fill_2
XFILLER_328_258 VPWR VGND sg13cmos5l_fill_1
XANTENNA__3437__A Tile_X0Y1_FrameData[5] VPWR VGND sg13cmos5l_antennanp
XFILLER_154_128 VPWR VGND sg13cmos5l_decap_8
XANTENNA__2698__D Tile_X0Y3_FrameData[6] VPWR VGND sg13cmos5l_antennanp
XANTENNA__3724__X Tile_X0Y3_FrameData_O[27] VPWR VGND sg13cmos5l_antennanp
XFILLER_162_150 VPWR VGND sg13cmos5l_fill_2
XFILLER_78_12 VPWR VGND sg13cmos5l_decap_8
XANTENNA__2813__GATE Tile_X0Y5_FrameStrobe[0] VPWR VGND sg13cmos5l_antennanp
XANTENNA__2828__GATE Tile_X0Y5_FrameStrobe[1] VPWR VGND sg13cmos5l_antennanp
XANTENNA__3322__D Tile_X0Y5_FrameData[22] VPWR VGND sg13cmos5l_antennanp
XFILLER_94_77 VPWR VGND sg13cmos5l_decap_8
XFILLER_91_126 VPWR VGND sg13cmos5l_decap_8
XFILLER_76_178 VPWR VGND sg13cmos5l_decap_4
XFILLER_94_88 VPWR VGND sg13cmos5l_fill_1
XFILLER_232_132 VPWR VGND sg13cmos5l_decap_8
XFILLER_32_204 VPWR VGND sg13cmos5l_decap_4
XFILLER_32_226 VPWR VGND sg13cmos5l_fill_2
XANTENNA__1777__D Tile_X0Y0_FrameData[15] VPWR VGND sg13cmos5l_antennanp
XANTENNA__1432__A2 Tile_X0Y2_W6END[2] VPWR VGND sg13cmos5l_antennanp
X_0890_ AXI_M_SOC_WSTRB2 _3334_/Q _0890_/B VPWR VGND sg13cmos5l_or2_1
XFILLER_71_7 VPWR VGND sg13cmos5l_decap_8
XANTENNA__1419__X AXI_M_SOC_WDATA18 VPWR VGND sg13cmos5l_antennanp
XANTENNA__1196__A1 Tile_X0Y0_W6END[4] VPWR VGND sg13cmos5l_antennanp
X_2560_ _2560_/Q Tile_X0Y3_FrameData[16] Tile_X0Y5_FrameStrobe[1] VPWR VGND sg13cmos5l_dlhq_1
XFILLER_153_150 VPWR VGND sg13cmos5l_fill_2
XFILLER_245_17 VPWR VGND sg13cmos5l_fill_2
XFILLER_245_39 VPWR VGND sg13cmos5l_decap_8
X_2491_ _2491_/Q Tile_X0Y2_FrameData[5] Tile_X0Y5_FrameStrobe[7] VPWR VGND sg13cmos5l_dlhq_1
X_1511_ _3686_/A Tile_X0Y3_WW4END[10] _1512_/X AXI_M_SOC_RDATA11 _1216_/X _2661_/Q
+ _2662_/Q VPWR VGND sg13cmos5l_mux4_1
XANTENNA__2401__D Tile_X0Y2_FrameData[31] VPWR VGND sg13cmos5l_antennanp
XANTENNA__3634__X Tile_X0Y0_E2BEGb[5] VPWR VGND sg13cmos5l_antennanp
X_1442_ _1442_/X _1315_/X _1369_/X _2449_/Q VPWR VGND sg13cmos5l_mux2_1
XFILLER_101_209 VPWR VGND sg13cmos5l_decap_8
XFILLER_325_50 VPWR VGND sg13cmos5l_fill_1
X_1373_ _1373_/Y _2477_/Q _1373_/B VPWR VGND sg13cmos5l_nand2b_1
X_3112_ _3112_/Q Tile_X0Y5_FrameData[8] Tile_X0Y5_FrameStrobe[1] VPWR VGND sg13cmos5l_dlhq_1
XANTENNA__3232__D Tile_X0Y5_FrameData[16] VPWR VGND sg13cmos5l_antennanp
X_3043_ _3043_/Q Tile_X0Y4_FrameData[29] Tile_X0Y5_FrameStrobe[8] VPWR VGND sg13cmos5l_dlhq_1
XANTENNA__3810__A Tile_X0Y4_UserCLK VPWR VGND sg13cmos5l_antennanp
XFILLER_82_148 VPWR VGND sg13cmos5l_decap_8
XANTENNA__1120__A1 Tile_X0Y3_W6END[7] VPWR VGND sg13cmos5l_antennanp
XANTENNA__1671__A2 AXI_M_SOC_RRESP1 VPWR VGND sg13cmos5l_antennanp
XFILLER_23_237 VPWR VGND sg13cmos5l_fill_1
XFILLER_23_259 VPWR VGND sg13cmos5l_decap_4
XANTENNA__1423__A2 Tile_X0Y2_WW4END[15] VPWR VGND sg13cmos5l_antennanp
XANTENNA__3809__X Tile_X0Y4_FrameData_O[31] VPWR VGND sg13cmos5l_antennanp
XFILLER_176_275 VPWR VGND sg13cmos5l_fill_2
X_3876_ Tile_X0Y5_FrameData_O[17] Tile_X0Y5_FrameData[17] VPWR VGND sg13cmos5l_buf_1
XFILLER_191_234 VPWR VGND sg13cmos5l_decap_8
X_2827_ _2827_/Q Tile_X0Y4_FrameData[21] Tile_X0Y5_FrameStrobe[1] VPWR VGND sg13cmos5l_dlhq_1
X_2758_ _2758_/Q Tile_X0Y3_FrameData[10] Tile_X0Y5_FrameStrobe[7] VPWR VGND sg13cmos5l_dlhq_1
XFILLER_318_280 VPWR VGND sg13cmos5l_fill_1
XFILLER_2_108 VPWR VGND sg13cmos5l_decap_8
X_1709_ _1709_/Q Tile_X0Y0_FrameData[19] Tile_X0Y5_FrameStrobe[0] VPWR VGND sg13cmos5l_dlhq_1
XANTENNA__2311__D Tile_X0Y2_FrameData[25] VPWR VGND sg13cmos5l_antennanp
XANTENNA__3544__X Tile_X0Y0_N2BEG[7] VPWR VGND sg13cmos5l_antennanp
XFILLER_144_194 VPWR VGND sg13cmos5l_fill_2
X_2689_ _2689_/Q Tile_X0Y3_FrameData[15] Tile_X0Y5_FrameStrobe[5] VPWR VGND sg13cmos5l_dlhq_1
XFILLER_246_224 VPWR VGND sg13cmos5l_decap_4
XFILLER_280_8 VPWR VGND sg13cmos5l_fill_1
XANTENNA__3142__D Tile_X0Y5_FrameData[10] VPWR VGND sg13cmos5l_antennanp
XFILLER_73_104 VPWR VGND sg13cmos5l_decap_4
XANTENNA__2184__GATE Tile_X0Y5_FrameStrobe[6] VPWR VGND sg13cmos5l_antennanp
XANTENNA__3720__A Tile_X0Y3_FrameData[23] VPWR VGND sg13cmos5l_antennanp
XFILLER_64_36 VPWR VGND sg13cmos5l_decap_8
XANTENNA__1111__A1 Tile_X0Y1_W2END[0] VPWR VGND sg13cmos5l_antennanp
XANTENNA__2981__D Tile_X0Y4_FrameData[27] VPWR VGND sg13cmos5l_antennanp
XFILLER_254_290 VPWR VGND sg13cmos5l_decap_4
XFILLER_14_215 VPWR VGND sg13cmos5l_fill_2
XFILLER_214_143 VPWR VGND sg13cmos5l_decap_8
XFILLER_81_181 VPWR VGND sg13cmos5l_decap_8
XANTENNA__1414__A2 Tile_X0Y2_W6END[4] VPWR VGND sg13cmos5l_antennanp
XANTENNA__2199__GATE Tile_X0Y5_FrameStrobe[7] VPWR VGND sg13cmos5l_antennanp
XANTENNA__3719__X Tile_X0Y3_FrameData_O[22] VPWR VGND sg13cmos5l_antennanp
XFILLER_80_35 VPWR VGND sg13cmos5l_decap_8
XANTENNA__1239__X AXI_M_SOC_AWADDR8 VPWR VGND sg13cmos5l_antennanp
XFILLER_127_128 VPWR VGND sg13cmos5l_decap_4
XFILLER_196_68 VPWR VGND sg13cmos5l_decap_8
XFILLER_316_217 VPWR VGND sg13cmos5l_decap_4
XANTENNA__1178__A1 Tile_X0Y4_W2END[0] VPWR VGND sg13cmos5l_antennanp
XANTENNA__2122__GATE Tile_X0Y5_FrameStrobe[4] VPWR VGND sg13cmos5l_antennanp
XFILLER_129_84 VPWR VGND sg13cmos5l_decap_8
XFILLER_89_22 VPWR VGND sg13cmos5l_decap_8
XANTENNA__2752__GATE Tile_X0Y5_FrameStrobe[7] VPWR VGND sg13cmos5l_antennanp
XANTENNA__3317__D Tile_X0Y5_FrameData[27] VPWR VGND sg13cmos5l_antennanp
XFILLER_129_95 VPWR VGND sg13cmos5l_fill_1
XFILLER_135_172 VPWR VGND sg13cmos5l_fill_2
XANTENNA__2221__D Tile_X0Y1_FrameData[3] VPWR VGND sg13cmos5l_antennanp
XANTENNA__3454__X Tile_X0Y1_FrameData_O[22] VPWR VGND sg13cmos5l_antennanp
XANTENNA__2137__GATE Tile_X0Y5_FrameStrobe[5] VPWR VGND sg13cmos5l_antennanp
XFILLER_150_142 VPWR VGND sg13cmos5l_decap_4
XANTENNA__2767__GATE Tile_X0Y5_FrameStrobe[7] VPWR VGND sg13cmos5l_antennanp
XFILLER_1_174 VPWR VGND sg13cmos5l_fill_1
XFILLER_1_185 VPWR VGND sg13cmos5l_decap_8
XANTENNA__1350__A1 Tile_X0Y2_W2MID[0] VPWR VGND sg13cmos5l_antennanp
XANTENNA__3052__D Tile_X0Y4_FrameData[20] VPWR VGND sg13cmos5l_antennanp
XANTENNA__1102__A1 Tile_X0Y3_W2END[6] VPWR VGND sg13cmos5l_antennanp
XANTENNA__2891__D Tile_X0Y4_FrameData[21] VPWR VGND sg13cmos5l_antennanp
XANTENNA__1653__A2 Tile_X0Y4_WW4END[13] VPWR VGND sg13cmos5l_antennanp
XFILLER_205_187 VPWR VGND sg13cmos5l_decap_4
XFILLER_220_102 VPWR VGND sg13cmos5l_fill_1
XFILLER_220_113 VPWR VGND sg13cmos5l_decap_8
XFILLER_220_124 VPWR VGND sg13cmos5l_fill_1
XFILLER_260_293 VPWR VGND sg13cmos5l_fill_2
XANTENNA__2705__GATE Tile_X0Y5_FrameStrobe[6] VPWR VGND sg13cmos5l_antennanp
XANTENNA__3629__X Tile_X0Y0_E2BEGb[0] VPWR VGND sg13cmos5l_antennanp
XFILLER_220_135 VPWR VGND sg13cmos5l_decap_8
XFILLER_220_146 VPWR VGND sg13cmos5l_decap_8
X_3730_ Tile_X0Y4_E1BEG[0] _3730_/A VPWR VGND sg13cmos5l_buf_1
X_1991_ _1991_/Q Tile_X0Y1_FrameData[9] Tile_X0Y5_FrameStrobe[0] VPWR VGND sg13cmos5l_dlhq_1
X_0942_ _0943_/B Tile_X0Y1_WW4END[6] Tile_X0Y1_W6END[6] Tile_X0Y1_WW4END[14] _0941_/X
+ _2059_/Q _2060_/Q VPWR VGND sg13cmos5l_mux4_1
XFILLER_9_241 VPWR VGND sg13cmos5l_fill_2
XANTENNA__1961__GATE Tile_X0Y5_FrameStrobe[8] VPWR VGND sg13cmos5l_antennanp
XFILLER_118_139 VPWR VGND sg13cmos5l_decap_8
XFILLER_173_201 VPWR VGND sg13cmos5l_decap_8
XFILLER_307_217 VPWR VGND sg13cmos5l_decap_8
X_3661_ Tile_X0Y3_E2BEGb[0] _3661_/A VPWR VGND sg13cmos5l_buf_1
X_0873_ _0873_/Y _3116_/Q _0559_/X _0872_/Y VPWR VGND sg13cmos5l_a21oi_1
XFILLER_173_267 VPWR VGND sg13cmos5l_fill_2
XFILLER_256_49 VPWR VGND sg13cmos5l_decap_4
X_2612_ _2612_/Q Tile_X0Y3_FrameData[28] Tile_X0Y5_FrameStrobe[3] VPWR VGND sg13cmos5l_dlhq_1
X_3592_ Tile_X0Y0_FrameData_O[23] Tile_X0Y0_FrameData[23] VPWR VGND sg13cmos5l_buf_1
XFILLER_133_109 VPWR VGND sg13cmos5l_decap_8
XFILLER_173_278 VPWR VGND sg13cmos5l_fill_1
X_2543_ _2543_/Q Tile_X0Y3_FrameData[1] Tile_X0Y5_FrameStrobe[0] VPWR VGND sg13cmos5l_dlhq_1
XANTENNA__2131__D Tile_X0Y1_FrameData[29] VPWR VGND sg13cmos5l_antennanp
XANTENNA__3227__D Tile_X0Y5_FrameData[21] VPWR VGND sg13cmos5l_antennanp
XANTENNA__3364__X Tile_X0Y2_E2BEGb[2] VPWR VGND sg13cmos5l_antennanp
XANTENNA__3805__A Tile_X0Y4_FrameData[27] VPWR VGND sg13cmos5l_antennanp
XFILLER_287_113 VPWR VGND sg13cmos5l_fill_1
XFILLER_315_272 VPWR VGND sg13cmos5l_fill_1
XANTENNA__1976__GATE Tile_X0Y5_FrameStrobe[0] VPWR VGND sg13cmos5l_antennanp
X_2474_ _2474_/Q Tile_X0Y2_FrameData[22] Tile_X0Y5_FrameStrobe[7] VPWR VGND sg13cmos5l_dlhq_1
XANTENNA__1970__D Tile_X0Y1_FrameData[30] VPWR VGND sg13cmos5l_antennanp
X_1425_ AXI_M_SOC_WDATA22 Tile_X0Y2_W1END[2] Tile_X0Y2_WW4END[6] Tile_X0Y2_WW4END[14]
+ _0976_/X _2316_/Q _2315_/Q VPWR VGND sg13cmos5l_mux4_1
X_1356_ _1356_/X _1312_/X _1355_/X _1058_/X _1157_/X _2488_/Q _2487_/Q VPWR VGND sg13cmos5l_mux4_1
XFILLER_95_251 VPWR VGND sg13cmos5l_fill_2
XANTENNA__1341__A1 AXI_M_SOC_RDATA27 VPWR VGND sg13cmos5l_antennanp
XFILLER_228_246 VPWR VGND sg13cmos5l_decap_4
XFILLER_228_268 VPWR VGND sg13cmos5l_decap_4
XFILLER_95_284 VPWR VGND sg13cmos5l_fill_2
XFILLER_243_216 VPWR VGND sg13cmos5l_fill_1
X_1287_ _3475_/A Tile_X0Y1_WW4END[4] AXI_M_SOC_RDATA26 _0919_/X _1089_/X _2106_/Q
+ _2105_/Q VPWR VGND sg13cmos5l_mux4_1
XFILLER_221_41 VPWR VGND sg13cmos5l_fill_2
XFILLER_243_249 VPWR VGND sg13cmos5l_decap_8
X_3026_ _3026_/Q Tile_X0Y4_FrameData[14] Tile_X0Y5_FrameStrobe[7] VPWR VGND sg13cmos5l_dlhq_1
XANTENNA__1644__A2 Tile_X0Y4_W6END[10] VPWR VGND sg13cmos5l_antennanp
XANTENNA__1914__GATE Tile_X0Y5_FrameStrobe[6] VPWR VGND sg13cmos5l_antennanp
XFILLER_34_17 VPWR VGND sg13cmos5l_decap_8
XFILLER_251_293 VPWR VGND sg13cmos5l_fill_2
XANTENNA__2306__D Tile_X0Y2_FrameData[30] VPWR VGND sg13cmos5l_antennanp
XANTENNA__3539__X Tile_X0Y0_N2BEG[2] VPWR VGND sg13cmos5l_antennanp
XFILLER_11_229 VPWR VGND sg13cmos5l_decap_8
XANTENNA__1929__GATE Tile_X0Y5_FrameStrobe[7] VPWR VGND sg13cmos5l_antennanp
XFILLER_164_201 VPWR VGND sg13cmos5l_decap_8
X_3859_ Tile_X0Y5_FrameData_O[0] Tile_X0Y5_FrameData[0] VPWR VGND sg13cmos5l_buf_1
XFILLER_306_250 VPWR VGND sg13cmos5l_decap_8
XANTENNA__2041__D Tile_X0Y1_FrameData[23] VPWR VGND sg13cmos5l_antennanp
XANTENNA__3137__D Tile_X0Y5_FrameData[15] VPWR VGND sg13cmos5l_antennanp
XANTENNA__3715__A Tile_X0Y3_FrameData[18] VPWR VGND sg13cmos5l_antennanp
XFILLER_59_14 VPWR VGND sg13cmos5l_decap_8
XANTENNA__1580__A1 Tile_X0Y3_W6END[10] VPWR VGND sg13cmos5l_antennanp
XFILLER_78_207 VPWR VGND sg13cmos5l_decap_8
XANTENNA__1880__D Tile_X0Y0_FrameData[8] VPWR VGND sg13cmos5l_antennanp
XANTENNA__2976__D Tile_X0Y4_FrameData[0] VPWR VGND sg13cmos5l_antennanp
XFILLER_132_175 VPWR VGND sg13cmos5l_fill_1
XFILLER_132_186 VPWR VGND sg13cmos5l_fill_1
XANTENNA__3450__A Tile_X0Y1_FrameData[18] VPWR VGND sg13cmos5l_antennanp
XFILLER_219_268 VPWR VGND sg13cmos5l_fill_2
XFILLER_234_205 VPWR VGND sg13cmos5l_fill_1
XFILLER_75_79 VPWR VGND sg13cmos5l_fill_1
XFILLER_131_30 VPWR VGND sg13cmos5l_fill_1
XANTENNA__1096__A0 Tile_X0Y1_W2MID[5] VPWR VGND sg13cmos5l_antennanp
XANTENNA__1635__A2 Tile_X0Y4_W6END[9] VPWR VGND sg13cmos5l_antennanp
XFILLER_91_12 VPWR VGND sg13cmos5l_fill_2
XFILLER_54_181 VPWR VGND sg13cmos5l_fill_2
XFILLER_242_293 VPWR VGND sg13cmos5l_fill_2
XFILLER_91_45 VPWR VGND sg13cmos5l_decap_8
XANTENNA__2216__D Tile_X0Y1_FrameData[8] VPWR VGND sg13cmos5l_antennanp
XANTENNA__3449__X Tile_X0Y1_FrameData_O[17] VPWR VGND sg13cmos5l_antennanp
XFILLER_145_0 VPWR VGND sg13cmos5l_fill_2
XANTENNA__2061__GATE Tile_X0Y5_FrameStrobe[2] VPWR VGND sg13cmos5l_antennanp
XFILLER_312_0 VPWR VGND sg13cmos5l_fill_2
XANTENNA__2691__GATE Tile_X0Y5_FrameStrobe[5] VPWR VGND sg13cmos5l_antennanp
XFILLER_155_278 VPWR VGND sg13cmos5l_fill_2
XANTENNA__3047__D Tile_X0Y4_FrameData[25] VPWR VGND sg13cmos5l_antennanp
XFILLER_108_172 VPWR VGND sg13cmos5l_decap_4
XFILLER_40_93 VPWR VGND sg13cmos5l_fill_2
XFILLER_40_82 VPWR VGND sg13cmos5l_decap_8
XANTENNA__0988__B_N Tile_X0Y5_N1END[2] VPWR VGND sg13cmos5l_antennanp
XANTENNA__2076__GATE Tile_X0Y5_FrameStrobe[3] VPWR VGND sg13cmos5l_antennanp
XFILLER_306_30 VPWR VGND sg13cmos5l_decap_8
XFILLER_312_231 VPWR VGND sg13cmos5l_fill_2
XANTENNA__1790__D Tile_X0Y0_FrameData[2] VPWR VGND sg13cmos5l_antennanp
XANTENNA__2886__D Tile_X0Y4_FrameData[26] VPWR VGND sg13cmos5l_antennanp
XANTENNA__3912__X Tile_X0Y5_S4BEG[1] VPWR VGND sg13cmos5l_antennanp
X_2190_ _2190_/Q Tile_X0Y1_FrameData[2] Tile_X0Y5_FrameStrobe[6] VPWR VGND sg13cmos5l_dlhq_1
X_1210_ AXI_M_SOC_AWADDR20 Tile_X0Y0_W1END[0] Tile_X0Y0_WW4END[12] Tile_X0Y0_WW4END[4]
+ _1074_/X _1775_/Q _1776_/Q VPWR VGND sg13cmos5l_mux4_1
XANTENNA__1323__A1 AXI_M_SOC_RDATA24 VPWR VGND sg13cmos5l_antennanp
XFILLER_1_32 VPWR VGND sg13cmos5l_fill_1
X_1141_ _1141_/X Tile_X0Y1_W2MID[6] Tile_X0Y1_W2END[6] Tile_X0Y1_W6END[9] _1105_/X
+ _2194_/Q _2193_/Q VPWR VGND sg13cmos5l_mux4_1
XANTENNA__1432__X AXI_M_SOC_WDATA26 VPWR VGND sg13cmos5l_antennanp
XFILLER_292_171 VPWR VGND sg13cmos5l_fill_1
XFILLER_225_238 VPWR VGND sg13cmos5l_fill_2
X_1072_ _1072_/X Tile_X0Y5_W2MID[7] Tile_X0Y5_W2END[7] Tile_X0Y5_W6END[7] _0782_/X
+ _3320_/Q _3319_/Q VPWR VGND sg13cmos5l_mux4_1
XFILLER_92_276 VPWR VGND sg13cmos5l_fill_2
XFILLER_92_265 VPWR VGND sg13cmos5l_decap_8
XANTENNA__1087__A0 Tile_X0Y3_W2MID[3] VPWR VGND sg13cmos5l_antennanp
XANTENNA__2014__GATE Tile_X0Y5_FrameStrobe[1] VPWR VGND sg13cmos5l_antennanp
XFILLER_45_181 VPWR VGND sg13cmos5l_decap_8
XANTENNA__0834__A0 AXI_M_SOC_RVALID VPWR VGND sg13cmos5l_antennanp
XANTENNA__2644__GATE Tile_X0Y5_FrameStrobe[4] VPWR VGND sg13cmos5l_antennanp
XFILLER_45_192 VPWR VGND sg13cmos5l_fill_1
XANTENNA__2126__D Tile_X0Y1_FrameData[2] VPWR VGND sg13cmos5l_antennanp
XANTENNA__3359__X Tile_X0Y2_E2BEG[5] VPWR VGND sg13cmos5l_antennanp
XFILLER_233_293 VPWR VGND sg13cmos5l_fill_2
X_1974_ _1974_/Q Tile_X0Y1_FrameData[26] Tile_X0Y5_FrameStrobe[0] VPWR VGND sg13cmos5l_dlhq_1
XANTENNA__1965__D Tile_X0Y0_FrameData[19] VPWR VGND sg13cmos5l_antennanp
XANTENNA__2029__GATE Tile_X0Y5_FrameStrobe[1] VPWR VGND sg13cmos5l_antennanp
X_3713_ Tile_X0Y3_FrameData_O[16] Tile_X0Y3_FrameData[16] VPWR VGND sg13cmos5l_buf_1
X_0925_ _0925_/X _0646_/X _0647_/X _3301_/Q VPWR VGND sg13cmos5l_mux2_1
XANTENNA__2659__GATE Tile_X0Y5_FrameStrobe[4] VPWR VGND sg13cmos5l_antennanp
X_3644_ Tile_X0Y0_E2BEG[7] _3644_/A VPWR VGND sg13cmos5l_buf_1
X_0856_ AXI_M_SOC_ARLEN2 _3332_/Q _0855_/X VPWR VGND sg13cmos5l_nor2b_1
XFILLER_60_0 VPWR VGND sg13cmos5l_decap_4
XFILLER_161_248 VPWR VGND sg13cmos5l_decap_8
X_3575_ Tile_X0Y0_FrameData_O[6] Tile_X0Y0_FrameData[6] VPWR VGND sg13cmos5l_buf_1
X_0787_ _3816_/A Tile_X0Y5_W2MID[6] _0771_/X _0786_/X _0559_/X _3246_/Q _3245_/Q VPWR
+ VGND sg13cmos5l_mux4_1
XANTENNA__1562__A1 Tile_X0Y3_WW4END[9] VPWR VGND sg13cmos5l_antennanp
XFILLER_161_259 VPWR VGND sg13cmos5l_fill_2
XFILLER_216_30 VPWR VGND sg13cmos5l_fill_2
X_2526_ _2526_/Q Tile_X0Y3_FrameData[18] Tile_X0Y5_FrameStrobe[0] VPWR VGND sg13cmos5l_dlhq_1
XANTENNA__2796__D Tile_X0Y4_FrameData[20] VPWR VGND sg13cmos5l_antennanp
XFILLER_114_175 VPWR VGND sg13cmos5l_decap_8
X_2457_ _2457_/Q Tile_X0Y2_FrameData[7] Tile_X0Y5_FrameStrobe[6] VPWR VGND sg13cmos5l_dlhq_1
XANTENNA__3822__X Tile_X0Y5_E2BEG[7] VPWR VGND sg13cmos5l_antennanp
XFILLER_216_96 VPWR VGND sg13cmos5l_decap_8
X_1408_ _3381_/A AXI_M_SOC_RDATA21 _1312_/X _1357_/X _1179_/X _2345_/Q _2346_/Q VPWR
+ VGND sg13cmos5l_mux4_1
X_2388_ _2388_/Q Tile_X0Y2_FrameData[12] Tile_X0Y5_FrameStrobe[4] VPWR VGND sg13cmos5l_dlhq_1
XFILLER_232_51 VPWR VGND sg13cmos5l_decap_8
X_1339_ _3507_/A Tile_X0Y1_W2MID[0] AXI_M_SOC_RDATA29 _1110_/X _1115_/X _2146_/Q _2145_/Q
+ VPWR VGND sg13cmos5l_mux4_1
XANTENNA__1853__GATE Tile_X0Y5_FrameStrobe[4] VPWR VGND sg13cmos5l_antennanp
X_3009_ _3009_/Q Tile_X0Y4_FrameData[31] Tile_X0Y5_FrameStrobe[7] VPWR VGND sg13cmos5l_dlhq_1
XFILLER_45_49 VPWR VGND sg13cmos5l_decap_8
XFILLER_36_170 VPWR VGND sg13cmos5l_decap_8
XANTENNA__0825__A0 Tile_X0Y5_N4END[1] VPWR VGND sg13cmos5l_antennanp
XFILLER_36_181 VPWR VGND sg13cmos5l_fill_2
XANTENNA__2036__D Tile_X0Y1_FrameData[28] VPWR VGND sg13cmos5l_antennanp
XFILLER_224_293 VPWR VGND sg13cmos5l_fill_2
XFILLER_243_8 VPWR VGND sg13cmos5l_fill_1
XFILLER_61_15 VPWR VGND sg13cmos5l_decap_8
XANTENNA__1868__GATE Tile_X0Y5_FrameStrobe[5] VPWR VGND sg13cmos5l_antennanp
XFILLER_101_88 VPWR VGND sg13cmos5l_decap_4
XANTENNA__1875__D Tile_X0Y0_FrameData[13] VPWR VGND sg13cmos5l_antennanp
XFILLER_177_37 VPWR VGND sg13cmos5l_fill_1
XFILLER_338_161 VPWR VGND sg13cmos5l_decap_4
XANTENNA__1250__A0 Tile_X0Y0_W2MID[7] VPWR VGND sg13cmos5l_antennanp
XANTENNA__3445__A Tile_X0Y1_FrameData[13] VPWR VGND sg13cmos5l_antennanp
XFILLER_193_25 VPWR VGND sg13cmos5l_decap_4
XANTENNA__1553__A1 Tile_X0Y3_WW4END[13] VPWR VGND sg13cmos5l_antennanp
XANTENNA__1806__GATE Tile_X0Y5_FrameStrobe[3] VPWR VGND sg13cmos5l_antennanp
XFILLER_120_101 VPWR VGND sg13cmos5l_fill_1
XANTENNA__3732__X Tile_X0Y4_E1BEG[2] VPWR VGND sg13cmos5l_antennanp
XFILLER_59_273 VPWR VGND sg13cmos5l_fill_1
XFILLER_59_251 VPWR VGND sg13cmos5l_decap_8
XFILLER_207_205 VPWR VGND sg13cmos5l_decap_8
XFILLER_274_160 VPWR VGND sg13cmos5l_decap_8
XFILLER_281_119 VPWR VGND sg13cmos5l_fill_1
XANTENNA__3330__D Tile_X0Y5_FrameData[28] VPWR VGND sg13cmos5l_antennanp
XFILLER_262_0 VPWR VGND sg13cmos5l_fill_1
XANTENNA__0816__A0 Tile_X0Y5_WW4END[7] VPWR VGND sg13cmos5l_antennanp
XFILLER_215_293 VPWR VGND sg13cmos5l_fill_2
XFILLER_35_71 VPWR VGND sg13cmos5l_decap_8
XFILLER_230_252 VPWR VGND sg13cmos5l_fill_1
XANTENNA__1785__D Tile_X0Y0_FrameData[7] VPWR VGND sg13cmos5l_antennanp
XFILLER_89_8 VPWR VGND sg13cmos5l_decap_8
XANTENNA__1241__A0 AXI_M_SOC_WREADY VPWR VGND sg13cmos5l_antennanp
XANTENNA__3907__X Tile_X0Y5_S2BEGb[4] VPWR VGND sg13cmos5l_antennanp
X_0710_ _0710_/Y _1969_/Q _1698_/Q _0986_/X VPWR VGND sg13cmos5l_nor3_1
XFILLER_51_70 VPWR VGND sg13cmos5l_fill_1
XFILLER_329_183 VPWR VGND sg13cmos5l_fill_1
XFILLER_128_267 VPWR VGND sg13cmos5l_fill_1
XFILLER_167_70 VPWR VGND sg13cmos5l_decap_8
X_1690_ _1690_/X Tile_X0Y4_W1END[2] Tile_X0Y4_W6END[6] Tile_X0Y4_WW4END[14] _0996_/X
+ _2989_/Q _2990_/Q VPWR VGND sg13cmos5l_mux4_1
XANTENNA__1427__X AXI_M_SOC_WDATA31 VPWR VGND sg13cmos5l_antennanp
X_0641_ _1021_/B Tile_X0Y4_W1END[1] _1046_/X Tile_X0Y4_W6END[9] _0640_/X _3017_/Q
+ _3018_/Q VPWR VGND sg13cmos5l_mux4_1
X_3360_ Tile_X0Y2_E2BEG[6] _3360_/A VPWR VGND sg13cmos5l_buf_1
X_0572_ _0572_/Y _1975_/Q _0572_/B _0572_/C VPWR VGND sg13cmos5l_nor3_1
XANTENNA__3312__GATE Tile_X0Y5_FrameStrobe[7] VPWR VGND sg13cmos5l_antennanp
XFILLER_111_101 VPWR VGND sg13cmos5l_fill_2
X_2311_ _2311_/Q Tile_X0Y2_FrameData[25] Tile_X0Y5_FrameStrobe[2] VPWR VGND sg13cmos5l_dlhq_1
XANTENNA__3642__X Tile_X0Y0_E2BEG[5] VPWR VGND sg13cmos5l_antennanp
XFILLER_111_145 VPWR VGND sg13cmos5l_fill_2
X_3291_ _3291_/Q Tile_X0Y5_FrameData[21] Tile_X0Y5_FrameStrobe[7] VPWR VGND sg13cmos5l_dlhq_1
X_2242_ _2242_/Q Tile_X0Y2_FrameData[30] Tile_X0Y5_FrameStrobe[0] VPWR VGND sg13cmos5l_dlhq_1
XANTENNA__3327__GATE Tile_X0Y5_FrameStrobe[8] VPWR VGND sg13cmos5l_antennanp
X_2173_ _2173_/Q Tile_X0Y1_FrameData[19] Tile_X0Y5_FrameStrobe[6] VPWR VGND sg13cmos5l_dlhq_1
XFILLER_265_193 VPWR VGND sg13cmos5l_fill_1
X_1124_ _1124_/X _0986_/X _0984_/X Tile_X0Y0_S1END[3] Tile_X0Y0_S4END[3] _1722_/Q
+ _1721_/Q VPWR VGND sg13cmos5l_mux4_1
XFILLER_65_265 VPWR VGND sg13cmos5l_fill_2
XANTENNA__2583__GATE Tile_X0Y5_FrameStrobe[2] VPWR VGND sg13cmos5l_antennanp
XANTENNA__3240__D Tile_X0Y5_FrameData[8] VPWR VGND sg13cmos5l_antennanp
X_1055_ _1055_/Y _3063_/Q _1053_/Y _1054_/Y VPWR VGND sg13cmos5l_o21ai_1
XFILLER_80_202 VPWR VGND sg13cmos5l_fill_2
XANTENNA__0807__A0 Tile_X0Y5_W2END[0] VPWR VGND sg13cmos5l_antennanp
XFILLER_18_192 VPWR VGND sg13cmos5l_decap_4
XFILLER_206_271 VPWR VGND sg13cmos5l_decap_8
XANTENNA__1075__A3 Tile_X0Y0_S4END[0] VPWR VGND sg13cmos5l_antennanp
XFILLER_33_151 VPWR VGND sg13cmos5l_decap_8
XFILLER_278_47 VPWR VGND sg13cmos5l_fill_1
XANTENNA__2598__GATE Tile_X0Y5_FrameStrobe[2] VPWR VGND sg13cmos5l_antennanp
XANTENNA__1232__A0 Tile_X0Y0_WW4END[8] VPWR VGND sg13cmos5l_antennanp
XANTENNA__3817__X Tile_X0Y5_E2BEG[2] VPWR VGND sg13cmos5l_antennanp
X_1957_ _1957_/Q Tile_X0Y0_FrameData[27] Tile_X0Y5_FrameStrobe[8] VPWR VGND sg13cmos5l_dlhq_1
XFILLER_31_29 VPWR VGND sg13cmos5l_decap_8
XFILLER_147_29 VPWR VGND sg13cmos5l_fill_2
X_1888_ _1888_/Q Tile_X0Y0_FrameData[0] Tile_X0Y5_FrameStrobe[5] VPWR VGND sg13cmos5l_dlhq_1
X_0908_ _0909_/A _3304_/Q Tile_X0Y5_W6END[8] _3303_/Q VPWR VGND sg13cmos5l_o21ai_1
XFILLER_335_142 VPWR VGND sg13cmos5l_decap_8
XANTENNA__2521__GATE Tile_X0Y5_FrameStrobe[0] VPWR VGND sg13cmos5l_antennanp
XFILLER_294_68 VPWR VGND sg13cmos5l_decap_4
X_3627_ Tile_X0Y0_E6BEG[10] _3627_/A VPWR VGND sg13cmos5l_buf_1
X_0839_ AXI_M_SOC_ARBURST0 _3330_/Q _0839_/B VPWR VGND sg13cmos5l_or2_1
XFILLER_227_62 VPWR VGND sg13cmos5l_fill_2
X_3558_ Tile_X0Y0_FrameStrobe_O[9] Tile_X0Y5_FrameStrobe[9] VPWR VGND sg13cmos5l_buf_1
XFILLER_288_230 VPWR VGND sg13cmos5l_fill_1
X_2509_ _2509_/Q Tile_X0Y2_FrameData[19] Tile_X0Y5_FrameStrobe[8] VPWR VGND sg13cmos5l_dlhq_1
XANTENNA__2536__GATE Tile_X0Y5_FrameStrobe[0] VPWR VGND sg13cmos5l_antennanp
XANTENNA__3552__X Tile_X0Y0_FrameStrobe_O[3] VPWR VGND sg13cmos5l_antennanp
X_3489_ Tile_X0Y1_E6BEG[9] _3489_/A VPWR VGND sg13cmos5l_buf_1
XFILLER_248_149 VPWR VGND sg13cmos5l_fill_2
XANTENNA__1299__A0 Tile_X0Y1_W2MID[4] VPWR VGND sg13cmos5l_antennanp
XFILLER_56_210 VPWR VGND sg13cmos5l_decap_4
XANTENNA__1792__GATE Tile_X0Y5_FrameStrobe[2] VPWR VGND sg13cmos5l_antennanp
XFILLER_56_276 VPWR VGND sg13cmos5l_fill_2
XANTENNA__3150__D Tile_X0Y5_FrameData[2] VPWR VGND sg13cmos5l_antennanp
XFILLER_112_76 VPWR VGND sg13cmos5l_decap_8
XFILLER_72_58 VPWR VGND sg13cmos5l_fill_2
XFILLER_72_47 VPWR VGND sg13cmos5l_decap_8
XANTENNA__1471__A0 Tile_X0Y2_WW4END[7] VPWR VGND sg13cmos5l_antennanp
XFILLER_184_115 VPWR VGND sg13cmos5l_decap_8
XFILLER_338_28 VPWR VGND sg13cmos5l_fill_1
XANTENNA__1223__A0 Tile_X0Y0_WW4END[14] VPWR VGND sg13cmos5l_antennanp
XANTENNA__1730__GATE Tile_X0Y5_FrameStrobe[1] VPWR VGND sg13cmos5l_antennanp
XANTENNA__3727__X Tile_X0Y3_FrameData_O[30] VPWR VGND sg13cmos5l_antennanp
XFILLER_137_40 VPWR VGND sg13cmos5l_fill_2
XFILLER_192_181 VPWR VGND sg13cmos5l_decap_8
XFILLER_21_73 VPWR VGND sg13cmos5l_decap_8
XFILLER_108_0 VPWR VGND sg13cmos5l_fill_2
XANTENNA__1745__GATE Tile_X0Y5_FrameStrobe[1] VPWR VGND sg13cmos5l_antennanp
XFILLER_97_55 VPWR VGND sg13cmos5l_decap_8
XANTENNA__3325__D Tile_X0Y5_FrameData[19] VPWR VGND sg13cmos5l_antennanp
XANTENNA__3462__X Tile_X0Y1_FrameData_O[30] VPWR VGND sg13cmos5l_antennanp
XFILLER_153_83 VPWR VGND sg13cmos5l_decap_4
XFILLER_247_160 VPWR VGND sg13cmos5l_decap_8
XFILLER_47_243 VPWR VGND sg13cmos5l_decap_8
XFILLER_62_213 VPWR VGND sg13cmos5l_decap_8
XANTENNA__3060__D Tile_X0Y5_FrameData[28] VPWR VGND sg13cmos5l_antennanp
XANTENNA__1462__A0 Tile_X0Y2_W2END[1] VPWR VGND sg13cmos5l_antennanp
XFILLER_30_121 VPWR VGND sg13cmos5l_decap_8
X_2860_ _2860_/Q Tile_X0Y4_FrameData[20] Tile_X0Y5_FrameStrobe[2] VPWR VGND sg13cmos5l_dlhq_1
X_1811_ _1811_/Q Tile_X0Y0_FrameData[13] Tile_X0Y5_FrameStrobe[3] VPWR VGND sg13cmos5l_dlhq_1
XFILLER_62_91 VPWR VGND sg13cmos5l_decap_4
XANTENNA__1214__A0 Tile_X0Y0_W2MID[6] VPWR VGND sg13cmos5l_antennanp
XANTENNA__2404__D Tile_X0Y2_FrameData[28] VPWR VGND sg13cmos5l_antennanp
XANTENNA__3637__X Tile_X0Y0_E2BEG[0] VPWR VGND sg13cmos5l_antennanp
XFILLER_30_165 VPWR VGND sg13cmos5l_decap_8
X_2791_ _2791_/Q Tile_X0Y4_FrameData[25] Tile_X0Y5_FrameStrobe[0] VPWR VGND sg13cmos5l_dlhq_1
XFILLER_7_20 VPWR VGND sg13cmos5l_fill_2
X_1742_ _1742_/Q Tile_X0Y0_FrameData[18] Tile_X0Y5_FrameStrobe[1] VPWR VGND sg13cmos5l_dlhq_1
XFILLER_7_64 VPWR VGND sg13cmos5l_fill_2
X_1673_ _3764_/A Tile_X0Y4_WW4END[13] _1046_/X AXI_M_SOC_RDATA0 _1318_/X _2939_/Q
+ _2940_/Q VPWR VGND sg13cmos5l_mux4_1
XFILLER_328_61 VPWR VGND sg13cmos5l_decap_8
XANTENNA__3251__GATE Tile_X0Y5_FrameStrobe[6] VPWR VGND sg13cmos5l_antennanp
XFILLER_264_38 VPWR VGND sg13cmos5l_fill_2
X_3412_ Tile_X0Y2_FrameData_O[14] Tile_X0Y2_FrameData[14] VPWR VGND sg13cmos5l_buf_1
X_0624_ _0624_/Y _2246_/Q _2245_/Q VPWR VGND sg13cmos5l_nor2b_1
XFILLER_328_94 VPWR VGND sg13cmos5l_fill_1
XANTENNA__1517__A1 AXI_M_SOC_RDATA6 VPWR VGND sg13cmos5l_antennanp
XANTENNA__3235__D Tile_X0Y5_FrameData[13] VPWR VGND sg13cmos5l_antennanp
XANTENNA__3372__X Tile_X0Y2_E6BEG[2] VPWR VGND sg13cmos5l_antennanp
X_3343_ _3343_/Q Tile_X0Y5_FrameData[9] Tile_X0Y5_FrameStrobe[8] VPWR VGND sg13cmos5l_dlhq_1
X_0555_ _0555_/Y _0888_/X VPWR VGND sg13cmos5l_inv_1
XANTENNA__3266__GATE Tile_X0Y5_FrameStrobe[6] VPWR VGND sg13cmos5l_antennanp
XFILLER_23_0 VPWR VGND sg13cmos5l_fill_2
XFILLER_285_222 VPWR VGND sg13cmos5l_decap_4
X_3274_ _3274_/Q Tile_X0Y5_FrameData[6] Tile_X0Y5_FrameStrobe[6] VPWR VGND sg13cmos5l_dlhq_1
X_2225_ _2225_/Q Tile_X0Y1_FrameData[31] Tile_X0Y5_FrameStrobe[8] VPWR VGND sg13cmos5l_dlhq_1
XFILLER_38_221 VPWR VGND sg13cmos5l_fill_2
XFILLER_238_160 VPWR VGND sg13cmos5l_decap_8
XFILLER_26_18 VPWR VGND sg13cmos5l_fill_1
X_2156_ _2156_/Q Tile_X0Y1_FrameData[4] Tile_X0Y5_FrameStrobe[5] VPWR VGND sg13cmos5l_dlhq_1
XFILLER_38_276 VPWR VGND sg13cmos5l_fill_2
X_2087_ _2087_/Q Tile_X0Y1_FrameData[9] Tile_X0Y5_FrameStrobe[3] VPWR VGND sg13cmos5l_dlhq_1
X_1107_ _1107_/X Tile_X0Y3_W2MID[7] Tile_X0Y3_W2END[7] Tile_X0Y3_W6END[7] _1267_/X
+ _2776_/Q _2775_/Q VPWR VGND sg13cmos5l_mux4_1
X_1038_ _1038_/X _1057_/X _1036_/X Tile_X0Y0_S1END[1] Tile_X0Y0_S4END[1] _1734_/Q
+ _1733_/Q VPWR VGND sg13cmos5l_mux4_1
XANTENNA__1453__A0 Tile_X0Y2_W2MID[7] VPWR VGND sg13cmos5l_antennanp
XANTENNA__3204__GATE Tile_X0Y5_FrameStrobe[4] VPWR VGND sg13cmos5l_antennanp
XANTENNA__1205__A0 Tile_X0Y0_W2MID[0] VPWR VGND sg13cmos5l_antennanp
XANTENNA__2314__D Tile_X0Y2_FrameData[22] VPWR VGND sg13cmos5l_antennanp
XANTENNA__3547__X Tile_X0Y0_N1BEG[2] VPWR VGND sg13cmos5l_antennanp
X_2989_ _2989_/Q Tile_X0Y4_FrameData[19] Tile_X0Y5_FrameStrobe[6] VPWR VGND sg13cmos5l_dlhq_1
XANTENNA__2460__GATE Tile_X0Y5_FrameStrobe[6] VPWR VGND sg13cmos5l_antennanp
XFILLER_21_198 VPWR VGND sg13cmos5l_fill_1
XANTENNA__3219__GATE Tile_X0Y5_FrameStrobe[5] VPWR VGND sg13cmos5l_antennanp
XANTENNA__1508__A1 AXI_M_SOC_RDATA9 VPWR VGND sg13cmos5l_antennanp
XFILLER_107_32 VPWR VGND sg13cmos5l_decap_8
XANTENNA__2475__GATE Tile_X0Y5_FrameStrobe[7] VPWR VGND sg13cmos5l_antennanp
XANTENNA__3145__D Tile_X0Y5_FrameData[7] VPWR VGND sg13cmos5l_antennanp
XANTENNA__3723__A Tile_X0Y3_FrameData[26] VPWR VGND sg13cmos5l_antennanp
XFILLER_115_270 VPWR VGND sg13cmos5l_decap_4
XFILLER_115_292 VPWR VGND sg13cmos5l_fill_2
XFILLER_254_71 VPWR VGND sg13cmos5l_decap_4
XFILLER_130_262 VPWR VGND sg13cmos5l_fill_2
XANTENNA__2984__D Tile_X0Y4_FrameData[24] VPWR VGND sg13cmos5l_antennanp
XFILLER_229_193 VPWR VGND sg13cmos5l_decap_8
XFILLER_83_35 VPWR VGND sg13cmos5l_decap_8
XANTENNA__1692__A0 Tile_X0Y5_W2MID[7] VPWR VGND sg13cmos5l_antennanp
XFILLER_244_152 VPWR VGND sg13cmos5l_decap_8
XANTENNA__2413__GATE Tile_X0Y5_FrameStrobe[5] VPWR VGND sg13cmos5l_antennanp
XFILLER_199_57 VPWR VGND sg13cmos5l_decap_4
XFILLER_12_110 VPWR VGND sg13cmos5l_fill_1
XFILLER_199_79 VPWR VGND sg13cmos5l_decap_8
XANTENNA__0798__A2 AXI_M_SOC_RVALID VPWR VGND sg13cmos5l_antennanp
XANTENNA__2224__D Tile_X0Y1_FrameData[0] VPWR VGND sg13cmos5l_antennanp
XANTENNA__3457__X Tile_X0Y1_FrameData_O[25] VPWR VGND sg13cmos5l_antennanp
XFILLER_225_0 VPWR VGND sg13cmos5l_fill_2
XANTENNA__2428__GATE Tile_X0Y5_FrameStrobe[5] VPWR VGND sg13cmos5l_antennanp
XANTENNA__3055__D Tile_X0Y4_FrameData[17] VPWR VGND sg13cmos5l_antennanp
XFILLER_234_19 VPWR VGND sg13cmos5l_decap_4
XANTENNA__1699__GATE Tile_X0Y5_FrameStrobe[0] VPWR VGND sg13cmos5l_antennanp
XANTENNA__2894__D Tile_X0Y4_FrameData[18] VPWR VGND sg13cmos5l_antennanp
XFILLER_267_266 VPWR VGND sg13cmos5l_decap_8
XFILLER_94_124 VPWR VGND sg13cmos5l_decap_8
XANTENNA__3920__X Tile_X0Y5_S4BEG[9] VPWR VGND sg13cmos5l_antennanp
XFILLER_282_225 VPWR VGND sg13cmos5l_fill_1
X_2010_ _2010_/Q Tile_X0Y1_FrameData[22] Tile_X0Y5_FrameStrobe[1] VPWR VGND sg13cmos5l_dlhq_1
XFILLER_235_196 VPWR VGND sg13cmos5l_fill_2
XFILLER_330_73 VPWR VGND sg13cmos5l_fill_1
XFILLER_250_166 VPWR VGND sg13cmos5l_decap_8
X_2912_ _2912_/Q Tile_X0Y4_FrameData[0] Tile_X0Y5_FrameStrobe[3] VPWR VGND sg13cmos5l_dlhq_1
XFILLER_73_90 VPWR VGND sg13cmos5l_decap_8
XFILLER_330_95 VPWR VGND sg13cmos5l_fill_2
XANTENNA__0789__A2 Tile_X0Y4_W6END[10] VPWR VGND sg13cmos5l_antennanp
X_3892_ Tile_X0Y5_S1BEG[1] _3892_/A VPWR VGND sg13cmos5l_buf_1
XANTENNA__3367__X Tile_X0Y2_E2BEGb[5] VPWR VGND sg13cmos5l_antennanp
X_2843_ _2843_/Q Tile_X0Y4_FrameData[5] Tile_X0Y5_FrameStrobe[1] VPWR VGND sg13cmos5l_dlhq_1
XFILLER_339_60 VPWR VGND sg13cmos5l_fill_1
XFILLER_337_248 VPWR VGND sg13cmos5l_fill_1
XFILLER_337_226 VPWR VGND sg13cmos5l_decap_4
XANTENNA__2134__D Tile_X0Y1_FrameData[26] VPWR VGND sg13cmos5l_antennanp
XANTENNA__3808__A Tile_X0Y4_FrameData[30] VPWR VGND sg13cmos5l_antennanp
XFILLER_148_159 VPWR VGND sg13cmos5l_decap_8
X_2774_ _2774_/Q Tile_X0Y3_FrameData[26] Tile_X0Y5_FrameStrobe[8] VPWR VGND sg13cmos5l_dlhq_1
XANTENNA__1973__D Tile_X0Y1_FrameData[27] VPWR VGND sg13cmos5l_antennanp
XANTENNA__3190__GATE Tile_X0Y5_FrameStrobe[4] VPWR VGND sg13cmos5l_antennanp
XFILLER_163_118 VPWR VGND sg13cmos5l_decap_8
X_1725_ _1725_/Q Tile_X0Y0_FrameData[3] Tile_X0Y5_FrameStrobe[0] VPWR VGND sg13cmos5l_dlhq_1
XFILLER_208_31 VPWR VGND sg13cmos5l_decap_8
XFILLER_208_42 VPWR VGND sg13cmos5l_fill_1
XFILLER_305_123 VPWR VGND sg13cmos5l_decap_4
X_1656_ _3736_/A Tile_X0Y4_W2MID[5] AXI_M_SOC_RDATA0 _1016_/X _1318_/X _2972_/Q _2971_/Q
+ VPWR VGND sg13cmos5l_mux4_1
X_1587_ _1588_/C _2751_/Q _1587_/B VPWR VGND sg13cmos5l_nand2_1
X_0607_ _0607_/X Tile_X0Y5_N2MID[4] Tile_X0Y5_N2END[4] _3907_/A _0606_/X _3072_/Q
+ _3071_/Q VPWR VGND sg13cmos5l_mux4_1
XFILLER_291_69 VPWR VGND sg13cmos5l_decap_4
X_3326_ _3326_/Q Tile_X0Y5_FrameData[18] Tile_X0Y5_FrameStrobe[8] VPWR VGND sg13cmos5l_dlhq_1
X_0538_ _0538_/Y _3027_/Q VPWR VGND sg13cmos5l_inv_1
XFILLER_258_277 VPWR VGND sg13cmos5l_fill_2
XFILLER_85_102 VPWR VGND sg13cmos5l_decap_8
XANTENNA__3830__X Tile_X0Y5_E2BEGb[7] VPWR VGND sg13cmos5l_antennanp
X_3257_ _3257_/Q Tile_X0Y5_FrameData[23] Tile_X0Y5_FrameStrobe[6] VPWR VGND sg13cmos5l_dlhq_1
XFILLER_226_141 VPWR VGND sg13cmos5l_decap_4
X_3188_ _3188_/Q Tile_X0Y5_FrameData[28] Tile_X0Y5_FrameStrobe[4] VPWR VGND sg13cmos5l_dlhq_1
X_2208_ _2208_/Q Tile_X0Y1_FrameData[16] Tile_X0Y5_FrameStrobe[7] VPWR VGND sg13cmos5l_dlhq_1
XANTENNA__1674__A0 Tile_X0Y4_WW4END[12] VPWR VGND sg13cmos5l_antennanp
XANTENNA__2309__D Tile_X0Y2_FrameData[27] VPWR VGND sg13cmos5l_antennanp
XFILLER_226_163 VPWR VGND sg13cmos5l_fill_1
XFILLER_226_174 VPWR VGND sg13cmos5l_decap_8
X_2139_ _2139_/Q Tile_X0Y1_FrameData[21] Tile_X0Y5_FrameStrobe[5] VPWR VGND sg13cmos5l_dlhq_1
XFILLER_240_51 VPWR VGND sg13cmos5l_fill_1
XANTENNA__1426__A0 Tile_X0Y2_W1END[1] VPWR VGND sg13cmos5l_antennanp
XANTENNA__3143__GATE Tile_X0Y5_FrameStrobe[2] VPWR VGND sg13cmos5l_antennanp
XFILLER_53_49 VPWR VGND sg13cmos5l_decap_8
XFILLER_330_9 VPWR VGND sg13cmos5l_fill_1
XANTENNA__2044__D Tile_X0Y1_FrameData[20] VPWR VGND sg13cmos5l_antennanp
XANTENNA__3718__A Tile_X0Y3_FrameData[21] VPWR VGND sg13cmos5l_antennanp
XFILLER_249_82 VPWR VGND sg13cmos5l_fill_2
XANTENNA__2979__D Tile_X0Y4_FrameData[29] VPWR VGND sg13cmos5l_antennanp
XANTENNA__3158__GATE Tile_X0Y5_FrameStrobe[3] VPWR VGND sg13cmos5l_antennanp
XFILLER_185_37 VPWR VGND sg13cmos5l_decap_8
XANTENNA__1883__D Tile_X0Y0_FrameData[5] VPWR VGND sg13cmos5l_antennanp
XFILLER_118_42 VPWR VGND sg13cmos5l_fill_1
XFILLER_5_139 VPWR VGND sg13cmos5l_decap_8
XFILLER_162_173 VPWR VGND sg13cmos5l_decap_8
XFILLER_78_46 VPWR VGND sg13cmos5l_decap_8
XANTENNA__3453__A Tile_X0Y1_FrameData[21] VPWR VGND sg13cmos5l_antennanp
XANTENNA__3740__X Tile_X0Y4_E2BEG[6] VPWR VGND sg13cmos5l_antennanp
XFILLER_281_80 VPWR VGND sg13cmos5l_fill_2
XFILLER_94_34 VPWR VGND sg13cmos5l_decap_4
XANTENNA__1665__A0 Tile_X0Y4_W1END[3] VPWR VGND sg13cmos5l_antennanp
XANTENNA__2219__D Tile_X0Y1_FrameData[5] VPWR VGND sg13cmos5l_antennanp
XANTENNA__2352__GATE Tile_X0Y5_FrameStrobe[3] VPWR VGND sg13cmos5l_antennanp
XFILLER_150_40 VPWR VGND sg13cmos5l_decap_8
XFILLER_17_224 VPWR VGND sg13cmos5l_decap_8
XFILLER_232_100 VPWR VGND sg13cmos5l_decap_8
XANTENNA__2982__GATE Tile_X0Y5_FrameStrobe[6] VPWR VGND sg13cmos5l_antennanp
XFILLER_150_73 VPWR VGND sg13cmos5l_fill_1
XFILLER_17_257 VPWR VGND sg13cmos5l_fill_2
XANTENNA__1417__A0 Tile_X0Y2_W1END[0] VPWR VGND sg13cmos5l_antennanp
XFILLER_232_188 VPWR VGND sg13cmos5l_decap_4
XANTENNA__2367__GATE Tile_X0Y5_FrameStrobe[3] VPWR VGND sg13cmos5l_antennanp
XFILLER_185_210 VPWR VGND sg13cmos5l_fill_2
XFILLER_229_19 VPWR VGND sg13cmos5l_fill_2
XFILLER_43_71 VPWR VGND sg13cmos5l_decap_8
XFILLER_43_60 VPWR VGND sg13cmos5l_fill_1
XANTENNA__2997__GATE Tile_X0Y5_FrameStrobe[6] VPWR VGND sg13cmos5l_antennanp
XFILLER_159_71 VPWR VGND sg13cmos5l_decap_8
XFILLER_159_82 VPWR VGND sg13cmos5l_fill_1
XFILLER_40_293 VPWR VGND sg13cmos5l_fill_2
XANTENNA__2889__D Tile_X0Y4_FrameData[23] VPWR VGND sg13cmos5l_antennanp
XFILLER_185_276 VPWR VGND sg13cmos5l_fill_1
XFILLER_334_229 VPWR VGND sg13cmos5l_fill_2
XFILLER_334_207 VPWR VGND sg13cmos5l_fill_1
XANTENNA__1196__A2 Tile_X0Y0_WW4END[12] VPWR VGND sg13cmos5l_antennanp
XANTENNA__1793__D Tile_X0Y0_FrameData[31] VPWR VGND sg13cmos5l_antennanp
XANTENNA__3915__X Tile_X0Y5_S4BEG[4] VPWR VGND sg13cmos5l_antennanp
XFILLER_299_100 VPWR VGND sg13cmos5l_decap_8
XANTENNA__2920__GATE Tile_X0Y5_FrameStrobe[4] VPWR VGND sg13cmos5l_antennanp
X_2490_ _2490_/Q Tile_X0Y2_FrameData[6] Tile_X0Y5_FrameStrobe[7] VPWR VGND sg13cmos5l_dlhq_1
X_1510_ _3689_/A Tile_X0Y3_WW4END[7] AXI_M_SOC_RDATA13 _1435_/X _1351_/X _2656_/Q
+ _2655_/Q VPWR VGND sg13cmos5l_mux4_1
XFILLER_175_81 VPWR VGND sg13cmos5l_decap_8
XFILLER_302_104 VPWR VGND sg13cmos5l_fill_1
X_1441_ _1441_/Y _2449_/Q _1183_/X _1440_/Y VPWR VGND sg13cmos5l_a21oi_1
XFILLER_4_194 VPWR VGND sg13cmos5l_fill_1
XFILLER_4_183 VPWR VGND sg13cmos5l_decap_8
XANTENNA__2305__GATE Tile_X0Y5_FrameStrobe[2] VPWR VGND sg13cmos5l_antennanp
XFILLER_4_54 VPWR VGND sg13cmos5l_fill_1
XFILLER_325_40 VPWR VGND sg13cmos5l_fill_2
XANTENNA__2935__GATE Tile_X0Y5_FrameStrobe[4] VPWR VGND sg13cmos5l_antennanp
X_3111_ _3111_/Q Tile_X0Y5_FrameData[9] Tile_X0Y5_FrameStrobe[1] VPWR VGND sg13cmos5l_dlhq_1
X_1372_ _1373_/B Tile_X0Y2_W1END[3] Tile_X0Y2_W6END[11] Tile_X0Y2_WW4END[3] _1371_/X
+ _2478_/Q _2479_/Q VPWR VGND sg13cmos5l_mux4_1
XFILLER_4_98 VPWR VGND sg13cmos5l_decap_8
XANTENNA__3650__X Tile_X0Y3_E1BEG[1] VPWR VGND sg13cmos5l_antennanp
XFILLER_191_80 VPWR VGND sg13cmos5l_decap_8
XFILLER_255_203 VPWR VGND sg13cmos5l_fill_1
XFILLER_261_28 VPWR VGND sg13cmos5l_fill_1
X_3042_ _3042_/Q Tile_X0Y4_FrameData[30] Tile_X0Y5_FrameStrobe[8] VPWR VGND sg13cmos5l_dlhq_1
XANTENNA__1656__A0 Tile_X0Y4_W2MID[5] VPWR VGND sg13cmos5l_antennanp
XANTENNA__2129__D Tile_X0Y1_FrameData[31] VPWR VGND sg13cmos5l_antennanp
XFILLER_82_127 VPWR VGND sg13cmos5l_decap_8
XANTENNA__1408__A0 AXI_M_SOC_RDATA21 VPWR VGND sg13cmos5l_antennanp
XANTENNA__1671__A3 AXI_M_SOC_RDATA3 VPWR VGND sg13cmos5l_antennanp
XANTENNA__1968__D Tile_X0Y0_FrameData[16] VPWR VGND sg13cmos5l_antennanp
XFILLER_90_171 VPWR VGND sg13cmos5l_decap_8
XFILLER_90_0 VPWR VGND sg13cmos5l_fill_2
XFILLER_210_76 VPWR VGND sg13cmos5l_fill_1
XFILLER_286_14 VPWR VGND sg13cmos5l_decap_8
X_3875_ Tile_X0Y5_FrameData_O[16] Tile_X0Y5_FrameData[16] VPWR VGND sg13cmos5l_buf_1
XFILLER_176_254 VPWR VGND sg13cmos5l_decap_8
X_2826_ _2826_/Q Tile_X0Y4_FrameData[22] Tile_X0Y5_FrameStrobe[1] VPWR VGND sg13cmos5l_dlhq_1
XFILLER_31_293 VPWR VGND sg13cmos5l_fill_2
XANTENNA__2799__D Tile_X0Y4_FrameData[17] VPWR VGND sg13cmos5l_antennanp
XFILLER_219_41 VPWR VGND sg13cmos5l_fill_2
XFILLER_286_69 VPWR VGND sg13cmos5l_fill_2
XANTENNA__3825__X Tile_X0Y5_E2BEGb[2] VPWR VGND sg13cmos5l_antennanp
XFILLER_219_85 VPWR VGND sg13cmos5l_decap_8
X_2757_ _2757_/Q Tile_X0Y3_FrameData[11] Tile_X0Y5_FrameStrobe[7] VPWR VGND sg13cmos5l_dlhq_1
X_2688_ _2688_/Q Tile_X0Y3_FrameData[16] Tile_X0Y5_FrameStrobe[5] VPWR VGND sg13cmos5l_dlhq_1
X_1708_ _1708_/Q Tile_X0Y0_FrameData[20] Tile_X0Y5_FrameStrobe[0] VPWR VGND sg13cmos5l_dlhq_1
X_1639_ AXI_M_SOC_ARADDR6 Tile_X0Y4_WW4END[6] Tile_X0Y4_WW4END[14] Tile_X0Y4_W6END[6]
+ _1011_/X _2876_/Q _2875_/Q VPWR VGND sg13cmos5l_mux4_1
XFILLER_48_49 VPWR VGND sg13cmos5l_decap_8
XANTENNA__3560__X Tile_X0Y0_FrameStrobe_O[11] VPWR VGND sg13cmos5l_antennanp
XFILLER_104_11 VPWR VGND sg13cmos5l_decap_8
X_3309_ _3309_/Q Tile_X0Y5_FrameData[3] Tile_X0Y5_FrameStrobe[7] VPWR VGND sg13cmos5l_dlhq_1
XFILLER_98_293 VPWR VGND sg13cmos5l_fill_2
XANTENNA__1647__A0 Tile_X0Y4_W2MID[3] VPWR VGND sg13cmos5l_antennanp
XANTENNA__2039__D Tile_X0Y1_FrameData[25] VPWR VGND sg13cmos5l_antennanp
XFILLER_64_15 VPWR VGND sg13cmos5l_decap_8
XANTENNA__1111__A2 Tile_X0Y1_W6END[0] VPWR VGND sg13cmos5l_antennanp
XANTENNA__3082__GATE Tile_X0Y5_FrameStrobe[0] VPWR VGND sg13cmos5l_antennanp
XANTENNA__1878__D Tile_X0Y0_FrameData[10] VPWR VGND sg13cmos5l_antennanp
XANTENNA__0870__A1 Tile_X0Y5_W2END[5] VPWR VGND sg13cmos5l_antennanp
XFILLER_80_14 VPWR VGND sg13cmos5l_decap_8
XFILLER_147_4 VPWR VGND sg13cmos5l_fill_1
XANTENNA__3097__GATE Tile_X0Y5_FrameStrobe[1] VPWR VGND sg13cmos5l_antennanp
XANTENNA__3448__A Tile_X0Y1_FrameData[16] VPWR VGND sg13cmos5l_antennanp
XFILLER_196_47 VPWR VGND sg13cmos5l_decap_8
XFILLER_22_293 VPWR VGND sg13cmos5l_fill_2
XANTENNA__1178__A2 Tile_X0Y4_W6END[0] VPWR VGND sg13cmos5l_antennanp
XANTENNA__3735__X Tile_X0Y4_E2BEG[1] VPWR VGND sg13cmos5l_antennanp
XFILLER_129_63 VPWR VGND sg13cmos5l_decap_8
XFILLER_309_270 VPWR VGND sg13cmos5l_decap_8
XANTENNA__2502__D Tile_X0Y2_FrameData[26] VPWR VGND sg13cmos5l_antennanp
XANTENNA__3020__GATE Tile_X0Y5_FrameStrobe[7] VPWR VGND sg13cmos5l_antennanp
XFILLER_89_89 VPWR VGND sg13cmos5l_fill_1
XFILLER_145_51 VPWR VGND sg13cmos5l_decap_8
XANTENNA__3035__GATE Tile_X0Y5_FrameStrobe[7] VPWR VGND sg13cmos5l_antennanp
XFILLER_150_176 VPWR VGND sg13cmos5l_fill_2
XFILLER_292_0 VPWR VGND sg13cmos5l_fill_2
XANTENNA__3333__D Tile_X0Y5_FrameData[31] VPWR VGND sg13cmos5l_antennanp
XANTENNA__3470__X Tile_X0Y1_EE4BEG[6] VPWR VGND sg13cmos5l_antennanp
XFILLER_237_203 VPWR VGND sg13cmos5l_fill_1
XFILLER_89_293 VPWR VGND sg13cmos5l_fill_2
XFILLER_49_135 VPWR VGND sg13cmos5l_decap_4
XANTENNA__1350__A2 Tile_X0Y2_W2END[0] VPWR VGND sg13cmos5l_antennanp
XFILLER_38_60 VPWR VGND sg13cmos5l_decap_8
XANTENNA__1638__A0 Tile_X0Y4_W1END[0] VPWR VGND sg13cmos5l_antennanp
XANTENNA__2291__GATE Tile_X0Y5_FrameStrobe[1] VPWR VGND sg13cmos5l_antennanp
XFILLER_161_72 VPWR VGND sg13cmos5l_decap_4
XFILLER_252_206 VPWR VGND sg13cmos5l_decap_8
XFILLER_64_149 VPWR VGND sg13cmos5l_decap_8
XANTENNA__1102__A2 Tile_X0Y3_W6END[6] VPWR VGND sg13cmos5l_antennanp
XANTENNA__1788__D Tile_X0Y0_FrameData[4] VPWR VGND sg13cmos5l_antennanp
XFILLER_311_75 VPWR VGND sg13cmos5l_fill_2
XFILLER_260_261 VPWR VGND sg13cmos5l_fill_1
X_1990_ _1990_/Q Tile_X0Y1_FrameData[10] Tile_X0Y5_FrameStrobe[0] VPWR VGND sg13cmos5l_dlhq_1
XFILLER_54_81 VPWR VGND sg13cmos5l_fill_2
XFILLER_158_210 VPWR VGND sg13cmos5l_fill_2
X_0941_ _0941_/X _1122_/X _0666_/X _0940_/Y Tile_X0Y0_S4END[6] _2011_/Q _2012_/Q VPWR
+ VGND sg13cmos5l_mux4_1
XFILLER_118_118 VPWR VGND sg13cmos5l_decap_8
X_3660_ Tile_X0Y3_E2BEG[7] _3660_/A VPWR VGND sg13cmos5l_buf_1
X_0872_ _0872_/Y _3116_/Q Tile_X0Y5_W6END[6] VPWR VGND sg13cmos5l_nor2b_1
XANTENNA__3645__X Tile_X0Y0_E1BEG[0] VPWR VGND sg13cmos5l_antennanp
XFILLER_173_246 VPWR VGND sg13cmos5l_decap_8
X_2611_ _2611_/Q Tile_X0Y3_FrameData[29] Tile_X0Y5_FrameStrobe[3] VPWR VGND sg13cmos5l_dlhq_1
X_3591_ Tile_X0Y0_FrameData_O[22] Tile_X0Y0_FrameData[22] VPWR VGND sg13cmos5l_buf_1
XANTENNA__2412__D Tile_X0Y2_FrameData[20] VPWR VGND sg13cmos5l_antennanp
X_2542_ _2542_/Q Tile_X0Y3_FrameData[2] Tile_X0Y5_FrameStrobe[0] VPWR VGND sg13cmos5l_dlhq_1
XFILLER_126_184 VPWR VGND sg13cmos5l_decap_8
XANTENNA__2244__GATE Tile_X0Y5_FrameStrobe[0] VPWR VGND sg13cmos5l_antennanp
X_2473_ _2473_/Q Tile_X0Y2_FrameData[23] Tile_X0Y5_FrameStrobe[7] VPWR VGND sg13cmos5l_dlhq_1
XANTENNA__2874__GATE Tile_X0Y5_FrameStrobe[2] VPWR VGND sg13cmos5l_antennanp
XFILLER_141_187 VPWR VGND sg13cmos5l_fill_1
XFILLER_272_38 VPWR VGND sg13cmos5l_fill_2
X_1424_ AXI_M_SOC_WDATA14 Tile_X0Y2_WW4END[6] Tile_X0Y2_WW4END[14] Tile_X0Y2_W6END[6]
+ _1313_/X _2332_/Q _2331_/Q VPWR VGND sg13cmos5l_mux4_1
XFILLER_330_276 VPWR VGND sg13cmos5l_fill_1
XANTENNA__3243__D Tile_X0Y5_FrameData[5] VPWR VGND sg13cmos5l_antennanp
XANTENNA__3380__X Tile_X0Y2_E6BEG[10] VPWR VGND sg13cmos5l_antennanp
X_1355_ _1355_/X _1051_/X _0574_/X Tile_X0Y5_N4END[12] Tile_X0Y0_S4END[8] _2279_/Q
+ _2280_/Q VPWR VGND sg13cmos5l_mux4_1
XANTENNA__2259__GATE Tile_X0Y5_FrameStrobe[0] VPWR VGND sg13cmos5l_antennanp
XFILLER_55_105 VPWR VGND sg13cmos5l_decap_8
XANTENNA__1629__A0 AXI_M_SOC_RRESP0 VPWR VGND sg13cmos5l_antennanp
XANTENNA__2889__GATE Tile_X0Y5_FrameStrobe[3] VPWR VGND sg13cmos5l_antennanp
X_3025_ _3025_/Q Tile_X0Y4_FrameData[15] Tile_X0Y5_FrameStrobe[7] VPWR VGND sg13cmos5l_dlhq_1
X_1286_ _3476_/A Tile_X0Y1_WW4END[3] AXI_M_SOC_RDATA25 _0905_/X _1094_/X _2104_/Q
+ _2103_/Q VPWR VGND sg13cmos5l_mux4_1
XANTENNA__1698__D Tile_X0Y0_FrameData[30] VPWR VGND sg13cmos5l_antennanp
XFILLER_63_160 VPWR VGND sg13cmos5l_decap_8
XANTENNA__2812__GATE Tile_X0Y5_FrameStrobe[0] VPWR VGND sg13cmos5l_antennanp
XFILLER_34_29 VPWR VGND sg13cmos5l_decap_8
X_3927_ Tile_X0Y5_UserCLKo Tile_X0Y5_UserCLK VPWR VGND sg13cmos5l_buf_1
X_3858_ Tile_X0Y5_EE4BEG[15] _3858_/A VPWR VGND sg13cmos5l_buf_1
XANTENNA__2827__GATE Tile_X0Y5_FrameStrobe[1] VPWR VGND sg13cmos5l_antennanp
X_2809_ _2809_/Q Tile_X0Y4_FrameData[7] Tile_X0Y5_FrameStrobe[0] VPWR VGND sg13cmos5l_dlhq_1
X_3789_ Tile_X0Y4_FrameData_O[11] Tile_X0Y4_FrameData[11] VPWR VGND sg13cmos5l_buf_1
XANTENNA__2322__D Tile_X0Y2_FrameData[14] VPWR VGND sg13cmos5l_antennanp
XANTENNA__3555__X Tile_X0Y0_FrameStrobe_O[6] VPWR VGND sg13cmos5l_antennanp
XFILLER_117_140 VPWR VGND sg13cmos5l_decap_8
XFILLER_117_173 VPWR VGND sg13cmos5l_fill_1
XFILLER_246_72 VPWR VGND sg13cmos5l_fill_2
XANTENNA__1580__A2 Tile_X0Y3_WW4END[2] VPWR VGND sg13cmos5l_antennanp
XANTENNA__3153__D Tile_X0Y5_FrameData[31] VPWR VGND sg13cmos5l_antennanp
XANTENNA__1332__A2 AXI_M_SOC_RDATA25 VPWR VGND sg13cmos5l_antennanp
XFILLER_219_258 VPWR VGND sg13cmos5l_decap_4
XFILLER_75_36 VPWR VGND sg13cmos5l_fill_1
XFILLER_75_14 VPWR VGND sg13cmos5l_decap_4
XANTENNA__2992__D Tile_X0Y4_FrameData[16] VPWR VGND sg13cmos5l_antennanp
XANTENNA__1096__A1 Tile_X0Y1_W2END[5] VPWR VGND sg13cmos5l_antennanp
XFILLER_199_198 VPWR VGND sg13cmos5l_decap_8
XFILLER_202_136 VPWR VGND sg13cmos5l_decap_8
XFILLER_138_0 VPWR VGND sg13cmos5l_decap_8
XFILLER_24_73 VPWR VGND sg13cmos5l_fill_1
XANTENNA__3328__D Tile_X0Y5_FrameData[16] VPWR VGND sg13cmos5l_antennanp
XANTENNA__2232__D Tile_X0Y1_FrameData[24] VPWR VGND sg13cmos5l_antennanp
XANTENNA__3465__X Tile_X0Y1_EE4BEG[1] VPWR VGND sg13cmos5l_antennanp
XFILLER_170_216 VPWR VGND sg13cmos5l_decap_8
XFILLER_6_267 VPWR VGND sg13cmos5l_decap_4
XFILLER_40_61 VPWR VGND sg13cmos5l_decap_8
XANTENNA__1020__A1 Tile_X0Y5_W6END[1] VPWR VGND sg13cmos5l_antennanp
XFILLER_312_221 VPWR VGND sg13cmos5l_fill_2
XFILLER_41_9 VPWR VGND sg13cmos5l_fill_1
XANTENNA__3063__D Tile_X0Y5_FrameData[25] VPWR VGND sg13cmos5l_antennanp
XFILLER_123_198 VPWR VGND sg13cmos5l_decap_8
X_1140_ _1140_/X _3530_/A _1103_/X Tile_X0Y0_S2MID[1] Tile_X0Y0_S2END[1] _1718_/Q
+ _1717_/Q VPWR VGND sg13cmos5l_mux4_1
XFILLER_225_206 VPWR VGND sg13cmos5l_decap_8
XFILLER_92_211 VPWR VGND sg13cmos5l_decap_4
XFILLER_322_52 VPWR VGND sg13cmos5l_fill_1
X_1071_ _1071_/X Tile_X0Y2_W2MID[7] Tile_X0Y2_W2END[7] Tile_X0Y2_W6END[8] _1157_/X
+ _2468_/Q _2467_/Q VPWR VGND sg13cmos5l_mux4_1
XANTENNA__1087__A1 Tile_X0Y3_W2END[3] VPWR VGND sg13cmos5l_antennanp
XFILLER_240_209 VPWR VGND sg13cmos5l_fill_1
XFILLER_45_160 VPWR VGND sg13cmos5l_decap_8
XANTENNA__2407__D Tile_X0Y2_FrameData[25] VPWR VGND sg13cmos5l_antennanp
X_1973_ _1973_/Q Tile_X0Y1_FrameData[27] Tile_X0Y5_FrameStrobe[0] VPWR VGND sg13cmos5l_dlhq_1
XANTENNA__0598__A0 Tile_X0Y5_N1END[0] VPWR VGND sg13cmos5l_antennanp
XFILLER_267_38 VPWR VGND sg13cmos5l_fill_2
X_3712_ Tile_X0Y3_FrameData_O[15] Tile_X0Y3_FrameData[15] VPWR VGND sg13cmos5l_buf_1
X_0924_ _0924_/X _0645_/X _0786_/X _3301_/Q VPWR VGND sg13cmos5l_mux2_1
XANTENNA__3238__D Tile_X0Y5_FrameData[10] VPWR VGND sg13cmos5l_antennanp
X_3643_ Tile_X0Y0_E2BEG[6] _3643_/A VPWR VGND sg13cmos5l_buf_1
X_0855_ _0855_/X Tile_X0Y5_W2MID[2] Tile_X0Y5_W2END[2] Tile_X0Y5_W6END[2] _0790_/X
+ _3124_/Q _3123_/Q VPWR VGND sg13cmos5l_mux4_1
XANTENNA__2142__D Tile_X0Y1_FrameData[18] VPWR VGND sg13cmos5l_antennanp
XANTENNA__3375__X Tile_X0Y2_E6BEG[5] VPWR VGND sg13cmos5l_antennanp
XFILLER_146_268 VPWR VGND sg13cmos5l_decap_8
XFILLER_146_279 VPWR VGND sg13cmos5l_fill_2
XANTENNA__2183__GATE Tile_X0Y5_FrameStrobe[6] VPWR VGND sg13cmos5l_antennanp
XFILLER_161_227 VPWR VGND sg13cmos5l_decap_8
XFILLER_283_15 VPWR VGND sg13cmos5l_decap_8
X_3574_ Tile_X0Y0_FrameData_O[5] Tile_X0Y0_FrameData[5] VPWR VGND sg13cmos5l_buf_1
X_0786_ _0786_/X Tile_X0Y5_N2MID[1] Tile_X0Y5_N2END[1] _3904_/A _0784_/X _3078_/Q
+ _3077_/Q VPWR VGND sg13cmos5l_mux4_1
XFILLER_53_0 VPWR VGND sg13cmos5l_decap_8
XANTENNA__1981__D Tile_X0Y1_FrameData[19] VPWR VGND sg13cmos5l_antennanp
XFILLER_114_154 VPWR VGND sg13cmos5l_decap_8
X_2525_ _2525_/Q Tile_X0Y3_FrameData[19] Tile_X0Y5_FrameStrobe[0] VPWR VGND sg13cmos5l_dlhq_1
XANTENNA__0770__A0 Tile_X0Y1_WW4END[0] VPWR VGND sg13cmos5l_antennanp
XANTENNA__1562__A2 Tile_X0Y3_W6END[9] VPWR VGND sg13cmos5l_antennanp
X_2456_ _2456_/Q Tile_X0Y2_FrameData[8] Tile_X0Y5_FrameStrobe[6] VPWR VGND sg13cmos5l_dlhq_1
XANTENNA__2198__GATE Tile_X0Y5_FrameStrobe[7] VPWR VGND sg13cmos5l_antennanp
XFILLER_216_75 VPWR VGND sg13cmos5l_decap_8
XFILLER_275_106 VPWR VGND sg13cmos5l_decap_4
XFILLER_275_128 VPWR VGND sg13cmos5l_fill_2
X_1407_ _3378_/A AXI_M_SOC_RDATA18 _1314_/X _1371_/X _1191_/X _2351_/Q _2352_/Q VPWR
+ VGND sg13cmos5l_mux4_1
XFILLER_68_230 VPWR VGND sg13cmos5l_decap_4
XANTENNA__1314__A2 Tile_X0Y5_N4END[15] VPWR VGND sg13cmos5l_antennanp
XANTENNA__3551__A Tile_X0Y5_FrameStrobe[2] VPWR VGND sg13cmos5l_antennanp
XFILLER_268_191 VPWR VGND sg13cmos5l_decap_8
X_2387_ _2387_/Q Tile_X0Y2_FrameData[13] Tile_X0Y5_FrameStrobe[4] VPWR VGND sg13cmos5l_dlhq_1
XFILLER_68_274 VPWR VGND sg13cmos5l_fill_1
XFILLER_216_206 VPWR VGND sg13cmos5l_decap_8
X_1338_ _3506_/A Tile_X0Y1_W2MID[1] AXI_M_SOC_RDATA28 _1105_/X _1083_/X _2148_/Q _2147_/Q
+ VPWR VGND sg13cmos5l_mux4_1
XANTENNA__2121__GATE Tile_X0Y5_FrameStrobe[4] VPWR VGND sg13cmos5l_antennanp
XFILLER_209_280 VPWR VGND sg13cmos5l_fill_1
XFILLER_216_228 VPWR VGND sg13cmos5l_decap_8
X_1269_ _1269_/X Tile_X0Y5_W2MID[3] Tile_X0Y5_W2END[3] Tile_X0Y5_W6END[3] _0607_/X
+ _3312_/Q _3311_/Q VPWR VGND sg13cmos5l_mux4_1
XFILLER_45_28 VPWR VGND sg13cmos5l_decap_8
XANTENNA__2751__GATE Tile_X0Y5_FrameStrobe[7] VPWR VGND sg13cmos5l_antennanp
X_3008_ _3008_/Q Tile_X0Y4_FrameData[0] Tile_X0Y5_FrameStrobe[6] VPWR VGND sg13cmos5l_dlhq_1
XANTENNA__2317__D Tile_X0Y2_FrameData[19] VPWR VGND sg13cmos5l_antennanp
XFILLER_101_45 VPWR VGND sg13cmos5l_decap_8
XFILLER_101_67 VPWR VGND sg13cmos5l_decap_8
XANTENNA__2136__GATE Tile_X0Y5_FrameStrobe[5] VPWR VGND sg13cmos5l_antennanp
XFILLER_177_16 VPWR VGND sg13cmos5l_fill_1
XFILLER_51_196 VPWR VGND sg13cmos5l_fill_2
XANTENNA__2766__GATE Tile_X0Y5_FrameStrobe[7] VPWR VGND sg13cmos5l_antennanp
XANTENNA__1250__A1 AXI_M_SOC_RDATA30 VPWR VGND sg13cmos5l_antennanp
XFILLER_338_195 VPWR VGND sg13cmos5l_fill_2
XANTENNA__2052__D Tile_X0Y1_FrameData[12] VPWR VGND sg13cmos5l_antennanp
XANTENNA__3148__D Tile_X0Y5_FrameData[4] VPWR VGND sg13cmos5l_antennanp
XANTENNA__3726__A Tile_X0Y3_FrameData[29] VPWR VGND sg13cmos5l_antennanp
XANTENNA__2987__D Tile_X0Y4_FrameData[21] VPWR VGND sg13cmos5l_antennanp
XFILLER_105_110 VPWR VGND sg13cmos5l_decap_8
XFILLER_257_93 VPWR VGND sg13cmos5l_decap_4
XANTENNA__1891__D Tile_X0Y0_FrameData[29] VPWR VGND sg13cmos5l_antennanp
XFILLER_10_42 VPWR VGND sg13cmos5l_fill_2
XANTENNA__0761__A0 Tile_X0Y5_WW4END[2] VPWR VGND sg13cmos5l_antennanp
XANTENNA__1553__A2 Tile_X0Y3_W6END[5] VPWR VGND sg13cmos5l_antennanp
XANTENNA__2704__GATE Tile_X0Y5_FrameStrobe[5] VPWR VGND sg13cmos5l_antennanp
XFILLER_105_198 VPWR VGND sg13cmos5l_decap_8
XFILLER_126_97 VPWR VGND sg13cmos5l_decap_8
XFILLER_160_293 VPWR VGND sg13cmos5l_fill_2
XFILLER_273_92 VPWR VGND sg13cmos5l_fill_1
XFILLER_59_230 VPWR VGND sg13cmos5l_decap_8
XANTENNA__3461__A Tile_X0Y1_FrameData[29] VPWR VGND sg13cmos5l_antennanp
XFILLER_120_168 VPWR VGND sg13cmos5l_fill_2
XANTENNA__1960__GATE Tile_X0Y5_FrameStrobe[8] VPWR VGND sg13cmos5l_antennanp
XANTENNA__2719__GATE Tile_X0Y5_FrameStrobe[6] VPWR VGND sg13cmos5l_antennanp
XANTENNA__2227__D Tile_X0Y1_FrameData[29] VPWR VGND sg13cmos5l_antennanp
XFILLER_215_250 VPWR VGND sg13cmos5l_decap_4
XFILLER_255_0 VPWR VGND sg13cmos5l_fill_1
XFILLER_35_50 VPWR VGND sg13cmos5l_decap_8
XANTENNA__1975__GATE Tile_X0Y5_FrameStrobe[0] VPWR VGND sg13cmos5l_antennanp
XFILLER_187_102 VPWR VGND sg13cmos5l_fill_2
XFILLER_42_141 VPWR VGND sg13cmos5l_decap_8
XFILLER_230_286 VPWR VGND sg13cmos5l_fill_1
XANTENNA__3058__D Tile_X0Y5_FrameData[30] VPWR VGND sg13cmos5l_antennanp
XFILLER_143_227 VPWR VGND sg13cmos5l_fill_2
X_0640_ _0640_/X _0635_/X _0636_/Y _0639_/Y VPWR VGND sg13cmos5l_a21o_1
XANTENNA__2897__D Tile_X0Y4_FrameData[15] VPWR VGND sg13cmos5l_antennanp
X_0571_ _0572_/C _1976_/Q _1138_/X VPWR VGND sg13cmos5l_nor2_1
XANTENNA__1913__GATE Tile_X0Y5_FrameStrobe[6] VPWR VGND sg13cmos5l_antennanp
XANTENNA__3923__X Tile_X0Y5_S4BEG[12] VPWR VGND sg13cmos5l_antennanp
X_3290_ _3290_/Q Tile_X0Y5_FrameData[22] Tile_X0Y5_FrameStrobe[7] VPWR VGND sg13cmos5l_dlhq_1
X_2310_ _2310_/Q Tile_X0Y2_FrameData[26] Tile_X0Y5_FrameStrobe[2] VPWR VGND sg13cmos5l_dlhq_1
XFILLER_151_293 VPWR VGND sg13cmos5l_fill_2
X_2241_ _2241_/Q Tile_X0Y1_FrameData[31] Tile_X0Y5_FrameStrobe[0] VPWR VGND sg13cmos5l_dlhq_1
XFILLER_333_62 VPWR VGND sg13cmos5l_fill_2
XFILLER_333_51 VPWR VGND sg13cmos5l_fill_1
XANTENNA__1928__GATE Tile_X0Y5_FrameStrobe[7] VPWR VGND sg13cmos5l_antennanp
X_2172_ _2172_/Q Tile_X0Y1_FrameData[20] Tile_X0Y5_FrameStrobe[6] VPWR VGND sg13cmos5l_dlhq_1
X_1123_ _1123_/X Tile_X0Y2_W1END[3] Tile_X0Y2_W6END[7] _1121_/X _0723_/X _2506_/Q
+ _2505_/Q VPWR VGND sg13cmos5l_mux4_1
XFILLER_65_233 VPWR VGND sg13cmos5l_decap_8
XFILLER_202_11 VPWR VGND sg13cmos5l_fill_1
X_1054_ _1054_/Y _3064_/Q _1054_/B _3063_/Q VPWR VGND sg13cmos5l_nand3b_1
XANTENNA__2137__D Tile_X0Y1_FrameData[23] VPWR VGND sg13cmos5l_antennanp
XFILLER_206_261 VPWR VGND sg13cmos5l_decap_4
XFILLER_206_294 VPWR VGND sg13cmos5l_fill_1
XANTENNA__1976__D Tile_X0Y1_FrameData[24] VPWR VGND sg13cmos5l_antennanp
XFILLER_221_275 VPWR VGND sg13cmos5l_fill_2
X_1956_ _1956_/Q Tile_X0Y0_FrameData[28] Tile_X0Y5_FrameStrobe[8] VPWR VGND sg13cmos5l_dlhq_1
XFILLER_119_235 VPWR VGND sg13cmos5l_decap_8
X_0907_ AXI_M_SOC_AWBURST0 _3335_/Q _0907_/B VPWR VGND sg13cmos5l_or2_1
XFILLER_294_14 VPWR VGND sg13cmos5l_fill_1
X_1887_ _1887_/Q Tile_X0Y0_FrameData[1] Tile_X0Y5_FrameStrobe[5] VPWR VGND sg13cmos5l_dlhq_1
X_3626_ Tile_X0Y0_E6BEG[9] _3626_/A VPWR VGND sg13cmos5l_buf_1
X_0838_ _0839_/B Tile_X0Y5_WW4END[3] Tile_X0Y5_W6END[11] Tile_X0Y5_WW4END[11] _0742_/X
+ _3137_/Q _3138_/Q VPWR VGND sg13cmos5l_mux4_1
XFILLER_335_176 VPWR VGND sg13cmos5l_fill_2
X_3557_ Tile_X0Y0_FrameStrobe_O[8] Tile_X0Y5_FrameStrobe[8] VPWR VGND sg13cmos5l_buf_1
X_0769_ _0769_/X Tile_X0Y5_WW4END[4] Tile_X0Y5_WW4END[12] Tile_X0Y5_W6END[4] _0597_/X
+ _3152_/Q _3151_/Q VPWR VGND sg13cmos5l_mux4_1
XANTENNA__0743__A0 Tile_X0Y5_N1END[3] VPWR VGND sg13cmos5l_antennanp
XANTENNA__1535__A2 Tile_X0Y0_S4END[15] VPWR VGND sg13cmos5l_antennanp
XANTENNA__2600__D Tile_X0Y3_FrameData[8] VPWR VGND sg13cmos5l_antennanp
XANTENNA__3833__X Tile_X0Y5_E6BEG[2] VPWR VGND sg13cmos5l_antennanp
XFILLER_227_85 VPWR VGND sg13cmos5l_fill_1
X_2508_ _2508_/Q Tile_X0Y2_FrameData[20] Tile_X0Y5_FrameStrobe[8] VPWR VGND sg13cmos5l_dlhq_1
XFILLER_142_293 VPWR VGND sg13cmos5l_fill_2
XFILLER_248_106 VPWR VGND sg13cmos5l_decap_8
XFILLER_248_117 VPWR VGND sg13cmos5l_decap_4
XFILLER_288_286 VPWR VGND sg13cmos5l_fill_1
X_3488_ Tile_X0Y1_E6BEG[8] _3488_/A VPWR VGND sg13cmos5l_buf_1
X_2439_ _2439_/Q Tile_X0Y2_FrameData[25] Tile_X0Y5_FrameStrobe[6] VPWR VGND sg13cmos5l_dlhq_1
XANTENNA__1299__A1 Tile_X0Y1_W2END[4] VPWR VGND sg13cmos5l_antennanp
XFILLER_243_84 VPWR VGND sg13cmos5l_decap_8
XFILLER_56_38 VPWR VGND sg13cmos5l_decap_8
XANTENNA__2060__GATE Tile_X0Y5_FrameStrobe[2] VPWR VGND sg13cmos5l_antennanp
XFILLER_256_194 VPWR VGND sg13cmos5l_decap_8
XANTENNA__2690__GATE Tile_X0Y5_FrameStrobe[5] VPWR VGND sg13cmos5l_antennanp
XANTENNA__2047__D Tile_X0Y1_FrameData[17] VPWR VGND sg13cmos5l_antennanp
XFILLER_112_55 VPWR VGND sg13cmos5l_decap_8
XANTENNA__2075__GATE Tile_X0Y5_FrameStrobe[3] VPWR VGND sg13cmos5l_antennanp
XFILLER_188_15 VPWR VGND sg13cmos5l_decap_8
XFILLER_24_141 VPWR VGND sg13cmos5l_decap_8
XANTENNA__1886__D Tile_X0Y0_FrameData[2] VPWR VGND sg13cmos5l_antennanp
XFILLER_338_18 VPWR VGND sg13cmos5l_fill_2
XANTENNA__1223__A1 AXI_M_SOC_RDATA31 VPWR VGND sg13cmos5l_antennanp
XANTENNA__3456__A Tile_X0Y1_FrameData[24] VPWR VGND sg13cmos5l_antennanp
XFILLER_125_216 VPWR VGND sg13cmos5l_fill_2
XFILLER_125_249 VPWR VGND sg13cmos5l_decap_8
XANTENNA__1526__A2 Tile_X0Y5_N4END[11] VPWR VGND sg13cmos5l_antennanp
XANTENNA__2013__GATE Tile_X0Y5_FrameStrobe[1] VPWR VGND sg13cmos5l_antennanp
XANTENNA__2510__D Tile_X0Y2_FrameData[18] VPWR VGND sg13cmos5l_antennanp
XANTENNA__3743__X Tile_X0Y4_E2BEGb[1] VPWR VGND sg13cmos5l_antennanp
XANTENNA__2643__GATE Tile_X0Y5_FrameStrobe[4] VPWR VGND sg13cmos5l_antennanp
XFILLER_133_293 VPWR VGND sg13cmos5l_fill_2
XFILLER_279_264 VPWR VGND sg13cmos5l_fill_1
XFILLER_279_275 VPWR VGND sg13cmos5l_fill_2
XANTENNA__2028__GATE Tile_X0Y5_FrameStrobe[1] VPWR VGND sg13cmos5l_antennanp
XFILLER_153_62 VPWR VGND sg13cmos5l_decap_8
XANTENNA__2658__GATE Tile_X0Y5_FrameStrobe[4] VPWR VGND sg13cmos5l_antennanp
XANTENNA__3341__D Tile_X0Y5_FrameData[7] VPWR VGND sg13cmos5l_antennanp
XFILLER_46_60 VPWR VGND sg13cmos5l_decap_8
XFILLER_262_153 VPWR VGND sg13cmos5l_decap_8
XANTENNA__1462__A1 AXI_M_SOC_RDATA15 VPWR VGND sg13cmos5l_antennanp
XANTENNA__1796__D Tile_X0Y0_FrameData[28] VPWR VGND sg13cmos5l_antennanp
XFILLER_15_185 VPWR VGND sg13cmos5l_decap_8
XANTENNA__3918__X Tile_X0Y5_S4BEG[7] VPWR VGND sg13cmos5l_antennanp
X_1810_ _1810_/Q Tile_X0Y0_FrameData[14] Tile_X0Y5_FrameStrobe[3] VPWR VGND sg13cmos5l_dlhq_1
XFILLER_62_70 VPWR VGND sg13cmos5l_decap_8
XANTENNA__1214__A1 Tile_X0Y0_W2END[6] VPWR VGND sg13cmos5l_antennanp
XFILLER_178_81 VPWR VGND sg13cmos5l_decap_8
XFILLER_178_92 VPWR VGND sg13cmos5l_fill_2
X_2790_ _2790_/Q Tile_X0Y4_FrameData[26] Tile_X0Y5_FrameStrobe[0] VPWR VGND sg13cmos5l_dlhq_1
X_1741_ _1741_/Q Tile_X0Y0_FrameData[19] Tile_X0Y5_FrameStrobe[1] VPWR VGND sg13cmos5l_dlhq_1
XFILLER_7_54 VPWR VGND sg13cmos5l_fill_1
XANTENNA__0973__A0 Tile_X0Y5_W2MID[4] VPWR VGND sg13cmos5l_antennanp
XFILLER_116_227 VPWR VGND sg13cmos5l_decap_4
X_1672_ _3731_/A _1023_/X _0635_/X AXI_M_SOC_RDATA0 AXI_M_SOC_RDATA4 _2982_/Q _2981_/Q
+ VPWR VGND sg13cmos5l_mux4_1
XFILLER_7_76 VPWR VGND sg13cmos5l_fill_2
XANTENNA__1852__GATE Tile_X0Y5_FrameStrobe[4] VPWR VGND sg13cmos5l_antennanp
XFILLER_264_28 VPWR VGND sg13cmos5l_fill_1
X_3411_ Tile_X0Y2_FrameData_O[13] Tile_X0Y2_FrameData[13] VPWR VGND sg13cmos5l_buf_1
X_0623_ _0623_/X Tile_X0Y1_W1END[1] _0962_/X Tile_X0Y1_W6END[9] _0622_/X _2201_/Q
+ _2202_/Q VPWR VGND sg13cmos5l_mux4_1
XFILLER_332_124 VPWR VGND sg13cmos5l_fill_2
XANTENNA__2420__D Tile_X0Y2_FrameData[12] VPWR VGND sg13cmos5l_antennanp
XANTENNA__3653__X Tile_X0Y3_E2BEG[0] VPWR VGND sg13cmos5l_antennanp
X_3342_ _3342_/Q Tile_X0Y5_FrameData[8] Tile_X0Y5_FrameStrobe[8] VPWR VGND sg13cmos5l_dlhq_1
XFILLER_285_201 VPWR VGND sg13cmos5l_fill_1
X_0554_ _0554_/Y _0885_/X VPWR VGND sg13cmos5l_inv_1
XFILLER_280_16 VPWR VGND sg13cmos5l_fill_2
X_3273_ _3273_/Q Tile_X0Y5_FrameData[7] Tile_X0Y5_FrameStrobe[6] VPWR VGND sg13cmos5l_dlhq_1
XANTENNA__1867__GATE Tile_X0Y5_FrameStrobe[5] VPWR VGND sg13cmos5l_antennanp
X_2224_ _2224_/Q Tile_X0Y1_FrameData[0] Tile_X0Y5_FrameStrobe[7] VPWR VGND sg13cmos5l_dlhq_1
XFILLER_97_188 VPWR VGND sg13cmos5l_decap_8
XANTENNA__3251__D Tile_X0Y5_FrameData[29] VPWR VGND sg13cmos5l_antennanp
XFILLER_16_0 VPWR VGND sg13cmos5l_fill_2
X_2155_ _2155_/Q Tile_X0Y1_FrameData[5] Tile_X0Y5_FrameStrobe[5] VPWR VGND sg13cmos5l_dlhq_1
XANTENNA__1150__A0 Tile_X0Y4_W2MID[5] VPWR VGND sg13cmos5l_antennanp
XFILLER_213_65 VPWR VGND sg13cmos5l_fill_2
X_1106_ _3529_/A Tile_X0Y1_W2MID[7] Tile_X0Y1_W2END[7] Tile_X0Y1_W6END[7] _1110_/X
+ _2232_/Q _2231_/Q VPWR VGND sg13cmos5l_mux4_1
XFILLER_53_214 VPWR VGND sg13cmos5l_fill_2
X_2086_ _2086_/Q Tile_X0Y1_FrameData[10] Tile_X0Y5_FrameStrobe[3] VPWR VGND sg13cmos5l_dlhq_1
X_1037_ _1037_/X _1057_/X _1036_/X Tile_X0Y0_S1END[1] Tile_X0Y0_S4END[1] _1742_/Q
+ _1741_/Q VPWR VGND sg13cmos5l_mux4_1
XANTENNA__1453__A1 AXI_M_SOC_RDATA14 VPWR VGND sg13cmos5l_antennanp
XANTENNA__1805__GATE Tile_X0Y5_FrameStrobe[3] VPWR VGND sg13cmos5l_antennanp
XANTENNA__3828__X Tile_X0Y5_E2BEGb[5] VPWR VGND sg13cmos5l_antennanp
XANTENNA__1205__A1 Tile_X0Y0_W2END[0] VPWR VGND sg13cmos5l_antennanp
X_2988_ _2988_/Q Tile_X0Y4_FrameData[20] Tile_X0Y5_FrameStrobe[6] VPWR VGND sg13cmos5l_dlhq_1
X_1939_ _1939_/Q Tile_X0Y0_FrameData[13] Tile_X0Y5_FrameStrobe[7] VPWR VGND sg13cmos5l_dlhq_1
XFILLER_238_84 VPWR VGND sg13cmos5l_decap_8
XFILLER_107_238 VPWR VGND sg13cmos5l_decap_4
X_3609_ Tile_X0Y0_EE4BEG[8] _3609_/A VPWR VGND sg13cmos5l_buf_1
XANTENNA__2330__D Tile_X0Y2_FrameData[6] VPWR VGND sg13cmos5l_antennanp
XANTENNA__3563__X Tile_X0Y0_FrameStrobe_O[14] VPWR VGND sg13cmos5l_antennanp
XFILLER_107_11 VPWR VGND sg13cmos5l_decap_8
XFILLER_107_77 VPWR VGND sg13cmos5l_fill_1
XFILLER_67_26 VPWR VGND sg13cmos5l_fill_2
XFILLER_67_15 VPWR VGND sg13cmos5l_fill_1
XFILLER_229_150 VPWR VGND sg13cmos5l_decap_4
XANTENNA__3161__D Tile_X0Y5_FrameData[23] VPWR VGND sg13cmos5l_antennanp
XANTENNA__1141__A0 Tile_X0Y1_W2MID[6] VPWR VGND sg13cmos5l_antennanp
XFILLER_83_14 VPWR VGND sg13cmos5l_decap_8
XANTENNA__1692__A1 Tile_X0Y5_W2END[7] VPWR VGND sg13cmos5l_antennanp
XFILLER_189_208 VPWR VGND sg13cmos5l_decap_4
XFILLER_44_225 VPWR VGND sg13cmos5l_fill_2
XANTENNA__3311__GATE Tile_X0Y5_FrameStrobe[7] VPWR VGND sg13cmos5l_antennanp
XANTENNA__2505__D Tile_X0Y2_FrameData[23] VPWR VGND sg13cmos5l_antennanp
XANTENNA__3738__X Tile_X0Y4_E2BEG[4] VPWR VGND sg13cmos5l_antennanp
XFILLER_12_177 VPWR VGND sg13cmos5l_decap_4
XFILLER_157_149 VPWR VGND sg13cmos5l_decap_8
XFILLER_200_256 VPWR VGND sg13cmos5l_fill_1
XFILLER_148_40 VPWR VGND sg13cmos5l_decap_8
XFILLER_200_278 VPWR VGND sg13cmos5l_fill_2
XANTENNA__3326__GATE Tile_X0Y5_FrameStrobe[8] VPWR VGND sg13cmos5l_antennanp
XFILLER_172_119 VPWR VGND sg13cmos5l_decap_8
XFILLER_218_0 VPWR VGND sg13cmos5l_fill_2
XANTENNA__2240__D Tile_X0Y1_FrameData[16] VPWR VGND sg13cmos5l_antennanp
XANTENNA__2582__GATE Tile_X0Y5_FrameStrobe[2] VPWR VGND sg13cmos5l_antennanp
XANTENNA__3336__D Tile_X0Y5_FrameData[2] VPWR VGND sg13cmos5l_antennanp
XANTENNA__3473__X Tile_X0Y1_EE4BEG[9] VPWR VGND sg13cmos5l_antennanp
XFILLER_113_208 VPWR VGND sg13cmos5l_decap_8
XFILLER_113_219 VPWR VGND sg13cmos5l_fill_1
XFILLER_314_146 VPWR VGND sg13cmos5l_decap_8
XFILLER_267_201 VPWR VGND sg13cmos5l_fill_2
XFILLER_79_155 VPWR VGND sg13cmos5l_fill_2
XANTENNA__2597__GATE Tile_X0Y5_FrameStrobe[2] VPWR VGND sg13cmos5l_antennanp
XFILLER_94_147 VPWR VGND sg13cmos5l_fill_1
XFILLER_57_70 VPWR VGND sg13cmos5l_decap_8
XANTENNA__3071__D Tile_X0Y5_FrameData[17] VPWR VGND sg13cmos5l_antennanp
XANTENNA__2520__GATE Tile_X0Y5_FrameStrobe[0] VPWR VGND sg13cmos5l_antennanp
XFILLER_35_236 VPWR VGND sg13cmos5l_fill_2
XFILLER_330_63 VPWR VGND sg13cmos5l_fill_1
X_2911_ _2911_/Q Tile_X0Y4_FrameData[1] Tile_X0Y5_FrameStrobe[3] VPWR VGND sg13cmos5l_dlhq_1
XANTENNA__2415__D Tile_X0Y2_FrameData[17] VPWR VGND sg13cmos5l_antennanp
XANTENNA__3648__X Tile_X0Y0_E1BEG[3] VPWR VGND sg13cmos5l_antennanp
X_3891_ Tile_X0Y5_S1BEG[0] _3891_/A VPWR VGND sg13cmos5l_buf_1
XANTENNA__2535__GATE Tile_X0Y5_FrameStrobe[0] VPWR VGND sg13cmos5l_antennanp
XFILLER_148_138 VPWR VGND sg13cmos5l_decap_8
X_2842_ _2842_/Q Tile_X0Y4_FrameData[6] Tile_X0Y5_FrameStrobe[1] VPWR VGND sg13cmos5l_dlhq_1
XANTENNA__1199__A0 Tile_X0Y0_WW4END[2] VPWR VGND sg13cmos5l_antennanp
X_2773_ _2773_/Q Tile_X0Y3_FrameData[27] Tile_X0Y5_FrameStrobe[8] VPWR VGND sg13cmos5l_dlhq_1
XANTENNA__1791__GATE Tile_X0Y5_FrameStrobe[2] VPWR VGND sg13cmos5l_antennanp
XFILLER_275_16 VPWR VGND sg13cmos5l_fill_2
X_1724_ _1724_/Q Tile_X0Y0_FrameData[4] Tile_X0Y5_FrameStrobe[0] VPWR VGND sg13cmos5l_dlhq_1
XFILLER_156_193 VPWR VGND sg13cmos5l_decap_8
XFILLER_208_21 VPWR VGND sg13cmos5l_decap_4
XFILLER_275_49 VPWR VGND sg13cmos5l_fill_1
XANTENNA__2150__D Tile_X0Y1_FrameData[10] VPWR VGND sg13cmos5l_antennanp
XANTENNA__3246__D Tile_X0Y5_FrameData[2] VPWR VGND sg13cmos5l_antennanp
XANTENNA__3383__X Tile_X0Y2_EE4BEG[1] VPWR VGND sg13cmos5l_antennanp
X_1655_ AXI_M_SOC_ARADDR21 Tile_X0Y4_W2MID[5] Tile_X0Y4_W2END[5] Tile_X0Y4_W6END[5]
+ _1318_/X _2846_/Q _2845_/Q VPWR VGND sg13cmos5l_mux4_1
X_1586_ _1588_/B _2751_/Q _1586_/B VPWR VGND sg13cmos5l_nand2b_1
X_0606_ _0606_/X Tile_X0Y3_W1END[0] Tile_X0Y3_W2MID[3] Tile_X0Y3_W2END[3] _1271_/X
+ _2732_/Q _2731_/Q VPWR VGND sg13cmos5l_mux4_1
X_3325_ _3325_/Q Tile_X0Y5_FrameData[19] Tile_X0Y5_FrameStrobe[8] VPWR VGND sg13cmos5l_dlhq_1
X_0537_ _0537_/Y _3024_/Q VPWR VGND sg13cmos5l_inv_1
X_3256_ _3256_/Q Tile_X0Y5_FrameData[24] Tile_X0Y5_FrameStrobe[6] VPWR VGND sg13cmos5l_dlhq_1
X_2207_ _2207_/Q Tile_X0Y1_FrameData[17] Tile_X0Y5_FrameStrobe[7] VPWR VGND sg13cmos5l_dlhq_1
XANTENNA__1123__A0 Tile_X0Y2_W1END[3] VPWR VGND sg13cmos5l_antennanp
XANTENNA__1631__X AXI_M_SOC_ARADDR1 VPWR VGND sg13cmos5l_antennanp
X_3187_ _3187_/Q Tile_X0Y5_FrameData[29] Tile_X0Y5_FrameStrobe[4] VPWR VGND sg13cmos5l_dlhq_1
XFILLER_240_30 VPWR VGND sg13cmos5l_decap_4
X_2138_ _2138_/Q Tile_X0Y1_FrameData[22] Tile_X0Y5_FrameStrobe[5] VPWR VGND sg13cmos5l_dlhq_1
XFILLER_93_191 VPWR VGND sg13cmos5l_decap_4
X_2069_ _2069_/Q Tile_X0Y1_FrameData[27] Tile_X0Y5_FrameStrobe[3] VPWR VGND sg13cmos5l_dlhq_1
XANTENNA__1426__A1 Tile_X0Y2_WW4END[13] VPWR VGND sg13cmos5l_antennanp
XANTENNA__1744__GATE Tile_X0Y5_FrameStrobe[1] VPWR VGND sg13cmos5l_antennanp
XFILLER_169_17 VPWR VGND sg13cmos5l_decap_8
XFILLER_53_28 VPWR VGND sg13cmos5l_decap_8
XANTENNA__2325__D Tile_X0Y2_FrameData[11] VPWR VGND sg13cmos5l_antennanp
XANTENNA__3558__X Tile_X0Y0_FrameStrobe_O[9] VPWR VGND sg13cmos5l_antennanp
XFILLER_149_8 VPWR VGND sg13cmos5l_decap_8
XFILLER_328_249 VPWR VGND sg13cmos5l_decap_8
XANTENNA__1759__GATE Tile_X0Y5_FrameStrobe[1] VPWR VGND sg13cmos5l_antennanp
XFILLER_147_171 VPWR VGND sg13cmos5l_decap_8
XFILLER_185_16 VPWR VGND sg13cmos5l_decap_8
XFILLER_336_293 VPWR VGND sg13cmos5l_fill_2
XANTENNA__2060__D Tile_X0Y1_FrameData[4] VPWR VGND sg13cmos5l_antennanp
XANTENNA__3156__D Tile_X0Y5_FrameData[28] VPWR VGND sg13cmos5l_antennanp
XFILLER_265_71 VPWR VGND sg13cmos5l_decap_8
XFILLER_118_76 VPWR VGND sg13cmos5l_decap_8
XANTENNA__1362__A0 Tile_X0Y2_W1END[0] VPWR VGND sg13cmos5l_antennanp
XANTENNA__2995__D Tile_X0Y4_FrameData[13] VPWR VGND sg13cmos5l_antennanp
XFILLER_134_86 VPWR VGND sg13cmos5l_decap_8
XFILLER_249_278 VPWR VGND sg13cmos5l_fill_2
XFILLER_264_215 VPWR VGND sg13cmos5l_fill_2
XFILLER_76_147 VPWR VGND sg13cmos5l_fill_2
XANTENNA__1114__A0 Tile_X0Y0_W1END[3] VPWR VGND sg13cmos5l_antennanp
XFILLER_217_120 VPWR VGND sg13cmos5l_decap_8
XFILLER_264_248 VPWR VGND sg13cmos5l_decap_4
XANTENNA__1665__A1 Tile_X0Y4_W6END[7] VPWR VGND sg13cmos5l_antennanp
XFILLER_27_40 VPWR VGND sg13cmos5l_decap_8
XANTENNA__3250__GATE Tile_X0Y5_FrameStrobe[6] VPWR VGND sg13cmos5l_antennanp
XFILLER_217_197 VPWR VGND sg13cmos5l_fill_2
XANTENNA__1417__A1 Tile_X0Y2_WW4END[12] VPWR VGND sg13cmos5l_antennanp
XFILLER_32_228 VPWR VGND sg13cmos5l_fill_1
XANTENNA__2235__D Tile_X0Y1_FrameData[21] VPWR VGND sg13cmos5l_antennanp
XANTENNA__3468__X Tile_X0Y1_EE4BEG[4] VPWR VGND sg13cmos5l_antennanp
XFILLER_335_0 VPWR VGND sg13cmos5l_fill_2
XFILLER_319_227 VPWR VGND sg13cmos5l_fill_2
XANTENNA__3265__GATE Tile_X0Y5_FrameStrobe[6] VPWR VGND sg13cmos5l_antennanp
XANTENNA__0928__A0 Tile_X0Y1_WW4END[5] VPWR VGND sg13cmos5l_antennanp
XFILLER_309_64 VPWR VGND sg13cmos5l_decap_8
XFILLER_64_8 VPWR VGND sg13cmos5l_decap_8
XFILLER_327_293 VPWR VGND sg13cmos5l_fill_2
XFILLER_327_271 VPWR VGND sg13cmos5l_fill_2
XANTENNA__3066__D Tile_X0Y5_FrameData[22] VPWR VGND sg13cmos5l_antennanp
XFILLER_153_152 VPWR VGND sg13cmos5l_fill_1
XFILLER_99_217 VPWR VGND sg13cmos5l_decap_8
XFILLER_57_7 VPWR VGND sg13cmos5l_decap_8
X_1440_ _1440_/Y _2449_/Q _0550_/Y _2448_/Q VPWR VGND sg13cmos5l_o21ai_1
XFILLER_99_228 VPWR VGND sg13cmos5l_fill_2
X_1371_ _1371_/X _1120_/X _0718_/X Tile_X0Y5_N4END[15] Tile_X0Y0_S4END[11] _2289_/Q
+ _2290_/Q VPWR VGND sg13cmos5l_mux4_1
XFILLER_4_77 VPWR VGND sg13cmos5l_fill_2
XFILLER_325_63 VPWR VGND sg13cmos5l_fill_2
XANTENNA__1353__A0 Tile_X0Y1_W1END[1] VPWR VGND sg13cmos5l_antennanp
XANTENNA__3203__GATE Tile_X0Y5_FrameStrobe[4] VPWR VGND sg13cmos5l_antennanp
X_3110_ _3110_/Q Tile_X0Y5_FrameData[10] Tile_X0Y5_FrameStrobe[1] VPWR VGND sg13cmos5l_dlhq_1
XFILLER_325_74 VPWR VGND sg13cmos5l_fill_1
X_3041_ _3041_/Q Tile_X0Y4_FrameData[31] Tile_X0Y5_FrameStrobe[8] VPWR VGND sg13cmos5l_dlhq_1
XFILLER_82_106 VPWR VGND sg13cmos5l_decap_4
XANTENNA__1656__A1 AXI_M_SOC_RDATA0 VPWR VGND sg13cmos5l_antennanp
XFILLER_208_142 VPWR VGND sg13cmos5l_decap_4
XFILLER_208_164 VPWR VGND sg13cmos5l_fill_2
XANTENNA__3218__GATE Tile_X0Y5_FrameStrobe[5] VPWR VGND sg13cmos5l_antennanp
XFILLER_223_123 VPWR VGND sg13cmos5l_fill_2
XFILLER_23_206 VPWR VGND sg13cmos5l_decap_8
XANTENNA__2145__D Tile_X0Y1_FrameData[15] VPWR VGND sg13cmos5l_antennanp
XANTENNA__2474__GATE Tile_X0Y5_FrameStrobe[7] VPWR VGND sg13cmos5l_antennanp
XANTENNA__3378__X Tile_X0Y2_E6BEG[8] VPWR VGND sg13cmos5l_antennanp
X_3874_ Tile_X0Y5_FrameData_O[15] Tile_X0Y5_FrameData[15] VPWR VGND sg13cmos5l_buf_1
XFILLER_31_261 VPWR VGND sg13cmos5l_fill_1
XANTENNA__1984__D Tile_X0Y1_FrameData[16] VPWR VGND sg13cmos5l_antennanp
XFILLER_176_233 VPWR VGND sg13cmos5l_decap_8
XFILLER_286_37 VPWR VGND sg13cmos5l_fill_1
X_2825_ _2825_/Q Tile_X0Y4_FrameData[23] Tile_X0Y5_FrameStrobe[1] VPWR VGND sg13cmos5l_dlhq_1
XFILLER_83_0 VPWR VGND sg13cmos5l_fill_2
XFILLER_325_208 VPWR VGND sg13cmos5l_decap_4
XFILLER_318_260 VPWR VGND sg13cmos5l_fill_1
XANTENNA__2489__GATE Tile_X0Y5_FrameStrobe[7] VPWR VGND sg13cmos5l_antennanp
XFILLER_129_182 VPWR VGND sg13cmos5l_decap_8
XFILLER_129_193 VPWR VGND sg13cmos5l_fill_1
X_2756_ _2756_/Q Tile_X0Y3_FrameData[12] Tile_X0Y5_FrameStrobe[7] VPWR VGND sg13cmos5l_dlhq_1
XFILLER_318_293 VPWR VGND sg13cmos5l_fill_2
XANTENNA__3554__A Tile_X0Y5_FrameStrobe[5] VPWR VGND sg13cmos5l_antennanp
X_2687_ _2687_/Q Tile_X0Y3_FrameData[17] Tile_X0Y5_FrameStrobe[5] VPWR VGND sg13cmos5l_dlhq_1
X_1707_ _1707_/Q Tile_X0Y0_FrameData[21] Tile_X0Y5_FrameStrobe[0] VPWR VGND sg13cmos5l_dlhq_1
XFILLER_333_241 VPWR VGND sg13cmos5l_fill_2
XFILLER_333_230 VPWR VGND sg13cmos5l_fill_2
X_1638_ AXI_M_SOC_ARADDR12 Tile_X0Y4_W1END[0] Tile_X0Y4_WW4END[4] Tile_X0Y4_WW4END[12]
+ _1070_/X _2864_/Q _2863_/Q VPWR VGND sg13cmos5l_mux4_1
XANTENNA__2412__GATE Tile_X0Y5_FrameStrobe[5] VPWR VGND sg13cmos5l_antennanp
XFILLER_98_250 VPWR VGND sg13cmos5l_decap_4
XANTENNA__1344__A0 Tile_X0Y1_W1END[0] VPWR VGND sg13cmos5l_antennanp
XANTENNA__3841__X Tile_X0Y5_E6BEG[10] VPWR VGND sg13cmos5l_antennanp
X_1569_ _1569_/X _1437_/X _1523_/X _2721_/Q VPWR VGND sg13cmos5l_mux2_1
XFILLER_48_28 VPWR VGND sg13cmos5l_decap_8
X_3308_ _3308_/Q Tile_X0Y5_FrameData[4] Tile_X0Y5_FrameStrobe[7] VPWR VGND sg13cmos5l_dlhq_1
XFILLER_58_147 VPWR VGND sg13cmos5l_decap_4
XANTENNA__2427__GATE Tile_X0Y5_FrameStrobe[5] VPWR VGND sg13cmos5l_antennanp
X_3239_ _3239_/Q Tile_X0Y5_FrameData[9] Tile_X0Y5_FrameStrobe[5] VPWR VGND sg13cmos5l_dlhq_1
XANTENNA__1647__A1 Tile_X0Y4_W2END[3] VPWR VGND sg13cmos5l_antennanp
XFILLER_120_22 VPWR VGND sg13cmos5l_fill_1
XFILLER_14_217 VPWR VGND sg13cmos5l_fill_1
XANTENNA__2055__D Tile_X0Y1_FrameData[9] VPWR VGND sg13cmos5l_antennanp
XANTENNA__3729__A Tile_X0Y3_UserCLK VPWR VGND sg13cmos5l_antennanp
XFILLER_120_99 VPWR VGND sg13cmos5l_fill_2
XANTENNA__1698__GATE Tile_X0Y5_FrameStrobe[0] VPWR VGND sg13cmos5l_antennanp
XANTENNA__1894__D Tile_X0Y0_FrameData[26] VPWR VGND sg13cmos5l_antennanp
XFILLER_167_255 VPWR VGND sg13cmos5l_fill_2
XFILLER_196_26 VPWR VGND sg13cmos5l_decap_8
XFILLER_182_214 VPWR VGND sg13cmos5l_fill_2
XFILLER_13_86 VPWR VGND sg13cmos5l_decap_4
XFILLER_309_293 VPWR VGND sg13cmos5l_fill_2
XFILLER_135_130 VPWR VGND sg13cmos5l_decap_8
XFILLER_89_57 VPWR VGND sg13cmos5l_decap_8
XFILLER_135_174 VPWR VGND sg13cmos5l_fill_1
XFILLER_135_196 VPWR VGND sg13cmos5l_fill_2
XFILLER_89_68 VPWR VGND sg13cmos5l_fill_2
XFILLER_324_263 VPWR VGND sg13cmos5l_fill_1
XFILLER_296_126 VPWR VGND sg13cmos5l_decap_8
XANTENNA__1335__A0 Tile_X0Y1_W2END[6] VPWR VGND sg13cmos5l_antennanp
XANTENNA__3751__X Tile_X0Y4_E6BEG[1] VPWR VGND sg13cmos5l_antennanp
XFILLER_1_165 VPWR VGND sg13cmos5l_fill_1
XFILLER_49_114 VPWR VGND sg13cmos5l_decap_4
XFILLER_1_198 VPWR VGND sg13cmos5l_fill_1
XFILLER_285_0 VPWR VGND sg13cmos5l_decap_4
XFILLER_64_106 VPWR VGND sg13cmos5l_decap_8
XANTENNA__1638__A1 Tile_X0Y4_WW4END[4] VPWR VGND sg13cmos5l_antennanp
XFILLER_64_128 VPWR VGND sg13cmos5l_decap_8
XFILLER_64_117 VPWR VGND sg13cmos5l_fill_2
XFILLER_54_60 VPWR VGND sg13cmos5l_decap_8
XFILLER_13_261 VPWR VGND sg13cmos5l_fill_2
X_0940_ _0940_/Y _0932_/Y _0934_/Y _0939_/Y VPWR VGND sg13cmos5l_a21oi_1
XFILLER_13_294 VPWR VGND sg13cmos5l_fill_1
XFILLER_9_243 VPWR VGND sg13cmos5l_fill_1
XANTENNA__3926__X Tile_X0Y5_S4BEG[15] VPWR VGND sg13cmos5l_antennanp
XFILLER_158_277 VPWR VGND sg13cmos5l_decap_4
X_0871_ AXI_M_SOC_ARLEN5 _3117_/Q _0868_/Y _0869_/Y _0870_/Y _3332_/Q VPWR VGND sg13cmos5l_a221oi_1
X_2610_ _2610_/Q Tile_X0Y3_FrameData[30] Tile_X0Y5_FrameStrobe[3] VPWR VGND sg13cmos5l_dlhq_1
X_3590_ Tile_X0Y0_FrameData_O[21] Tile_X0Y0_FrameData[21] VPWR VGND sg13cmos5l_buf_1
X_2541_ _2541_/Q Tile_X0Y3_FrameData[3] Tile_X0Y5_FrameStrobe[0] VPWR VGND sg13cmos5l_dlhq_1
XFILLER_336_40 VPWR VGND sg13cmos5l_fill_1
X_2472_ _2472_/Q Tile_X0Y2_FrameData[24] Tile_X0Y5_FrameStrobe[7] VPWR VGND sg13cmos5l_dlhq_1
X_1423_ AXI_M_SOC_WDATA23 Tile_X0Y2_W1END[3] Tile_X0Y2_WW4END[7] Tile_X0Y2_WW4END[15]
+ _1121_/X _2314_/Q _2313_/Q VPWR VGND sg13cmos5l_mux4_1
XANTENNA__1326__A0 Tile_X0Y1_W1END[2] VPWR VGND sg13cmos5l_antennanp
XANTENNA__3142__GATE Tile_X0Y5_FrameStrobe[2] VPWR VGND sg13cmos5l_antennanp
XANTENNA__3661__X Tile_X0Y3_E2BEGb[0] VPWR VGND sg13cmos5l_antennanp
XFILLER_205_11 VPWR VGND sg13cmos5l_decap_8
XFILLER_330_266 VPWR VGND sg13cmos5l_fill_1
XFILLER_205_44 VPWR VGND sg13cmos5l_decap_8
X_1354_ _3522_/A _1353_/X _1352_/X _2212_/Q VPWR VGND sg13cmos5l_mux2_1
X_1285_ _3477_/A Tile_X0Y1_WW4END[2] AXI_M_SOC_RDATA24 _1217_/X _1100_/X _2102_/Q
+ _2101_/Q VPWR VGND sg13cmos5l_mux4_1
XANTENNA__3157__GATE Tile_X0Y5_FrameStrobe[3] VPWR VGND sg13cmos5l_antennanp
X_3024_ _3024_/Q Tile_X0Y4_FrameData[16] Tile_X0Y5_FrameStrobe[7] VPWR VGND sg13cmos5l_dlhq_1
XANTENNA__1979__D Tile_X0Y1_FrameData[21] VPWR VGND sg13cmos5l_antennanp
XFILLER_221_21 VPWR VGND sg13cmos5l_decap_4
XFILLER_221_43 VPWR VGND sg13cmos5l_fill_1
XFILLER_221_87 VPWR VGND sg13cmos5l_decap_8
XFILLER_221_98 VPWR VGND sg13cmos5l_fill_2
XANTENNA__3549__A Tile_X0Y5_FrameStrobe[0] VPWR VGND sg13cmos5l_antennanp
X_3926_ Tile_X0Y5_S4BEG[15] _3926_/A VPWR VGND sg13cmos5l_buf_1
XANTENNA__2603__D Tile_X0Y3_FrameData[5] VPWR VGND sg13cmos5l_antennanp
XANTENNA__3836__X Tile_X0Y5_E6BEG[5] VPWR VGND sg13cmos5l_antennanp
X_3857_ Tile_X0Y5_EE4BEG[14] _3857_/A VPWR VGND sg13cmos5l_buf_1
XFILLER_50_29 VPWR VGND sg13cmos5l_decap_8
X_2808_ _2808_/Q Tile_X0Y4_FrameData[8] Tile_X0Y5_FrameStrobe[0] VPWR VGND sg13cmos5l_dlhq_1
X_3788_ Tile_X0Y4_FrameData_O[10] Tile_X0Y4_FrameData[10] VPWR VGND sg13cmos5l_buf_1
XANTENNA__1565__A0 Tile_X0Y3_W1END[1] VPWR VGND sg13cmos5l_antennanp
X_2739_ _2739_/Q Tile_X0Y3_FrameData[29] Tile_X0Y5_FrameStrobe[7] VPWR VGND sg13cmos5l_dlhq_1
XANTENNA__2351__GATE Tile_X0Y5_FrameStrobe[3] VPWR VGND sg13cmos5l_antennanp
XFILLER_306_285 VPWR VGND sg13cmos5l_fill_2
XANTENNA__2981__GATE Tile_X0Y5_FrameStrobe[6] VPWR VGND sg13cmos5l_antennanp
XFILLER_278_126 VPWR VGND sg13cmos5l_fill_2
XFILLER_59_49 VPWR VGND sg13cmos5l_fill_1
XANTENNA__1317__A0 Tile_X0Y5_W2MID[2] VPWR VGND sg13cmos5l_antennanp
XANTENNA__3571__X Tile_X0Y0_FrameData_O[2] VPWR VGND sg13cmos5l_antennanp
XFILLER_132_166 VPWR VGND sg13cmos5l_fill_2
XFILLER_182_39 VPWR VGND sg13cmos5l_fill_2
XFILLER_115_44 VPWR VGND sg13cmos5l_decap_8
XANTENNA__1332__A3 AXI_M_SOC_RDATA29 VPWR VGND sg13cmos5l_antennanp
XANTENNA__2366__GATE Tile_X0Y5_FrameStrobe[3] VPWR VGND sg13cmos5l_antennanp
XANTENNA__2996__GATE Tile_X0Y5_FrameStrobe[6] VPWR VGND sg13cmos5l_antennanp
XFILLER_86_286 VPWR VGND sg13cmos5l_fill_1
XANTENNA__1889__D Tile_X0Y0_FrameData[31] VPWR VGND sg13cmos5l_antennanp
XFILLER_131_21 VPWR VGND sg13cmos5l_decap_8
XANTENNA__1096__A2 Tile_X0Y1_W6END[5] VPWR VGND sg13cmos5l_antennanp
XFILLER_131_43 VPWR VGND sg13cmos5l_decap_4
XFILLER_54_161 VPWR VGND sg13cmos5l_decap_4
XFILLER_199_144 VPWR VGND sg13cmos5l_decap_8
XFILLER_199_155 VPWR VGND sg13cmos5l_fill_1
XFILLER_242_262 VPWR VGND sg13cmos5l_decap_4
XANTENNA__3459__A Tile_X0Y1_FrameData[27] VPWR VGND sg13cmos5l_antennanp
XANTENNA__2304__GATE Tile_X0Y5_FrameStrobe[1] VPWR VGND sg13cmos5l_antennanp
XANTENNA__2513__D Tile_X0Y2_FrameData[31] VPWR VGND sg13cmos5l_antennanp
XANTENNA__2934__GATE Tile_X0Y5_FrameStrobe[4] VPWR VGND sg13cmos5l_antennanp
XANTENNA__3746__X Tile_X0Y4_E2BEGb[4] VPWR VGND sg13cmos5l_antennanp
XFILLER_210_181 VPWR VGND sg13cmos5l_decap_8
XFILLER_108_152 VPWR VGND sg13cmos5l_fill_2
XANTENNA__1556__A0 Tile_X0Y3_W2MID[3] VPWR VGND sg13cmos5l_antennanp
XANTENNA__2319__GATE Tile_X0Y5_FrameStrobe[2] VPWR VGND sg13cmos5l_antennanp
XFILLER_200_0 VPWR VGND sg13cmos5l_fill_2
XANTENNA__2949__GATE Tile_X0Y5_FrameStrobe[5] VPWR VGND sg13cmos5l_antennanp
XFILLER_312_233 VPWR VGND sg13cmos5l_fill_1
XANTENNA__1308__A0 Tile_X0Y1_W2MID[2] VPWR VGND sg13cmos5l_antennanp
XANTENNA__3344__D Tile_X0Y5_FrameData[10] VPWR VGND sg13cmos5l_antennanp
XANTENNA__3481__X Tile_X0Y1_E6BEG[1] VPWR VGND sg13cmos5l_antennanp
XFILLER_172_50 VPWR VGND sg13cmos5l_decap_8
XFILLER_27_8 VPWR VGND sg13cmos5l_fill_1
XFILLER_49_82 VPWR VGND sg13cmos5l_decap_4
XFILLER_172_94 VPWR VGND sg13cmos5l_decap_8
XFILLER_1_56 VPWR VGND sg13cmos5l_decap_4
XFILLER_77_275 VPWR VGND sg13cmos5l_decap_8
XFILLER_37_139 VPWR VGND sg13cmos5l_decap_8
XANTENNA__1799__D Tile_X0Y0_FrameData[25] VPWR VGND sg13cmos5l_antennanp
X_1070_ _1070_/X _1056_/X _0586_/X Tile_X0Y5_N4END[4] _1061_/X _2815_/Q _2816_/Q VPWR
+ VGND sg13cmos5l_mux4_1
XANTENNA__1087__A2 Tile_X0Y3_W6END[3] VPWR VGND sg13cmos5l_antennanp
XFILLER_60_120 VPWR VGND sg13cmos5l_fill_1
X_1972_ _1972_/Q Tile_X0Y1_FrameData[28] Tile_X0Y5_FrameStrobe[0] VPWR VGND sg13cmos5l_dlhq_1
XFILLER_81_80 VPWR VGND sg13cmos5l_fill_2
XFILLER_60_197 VPWR VGND sg13cmos5l_decap_4
XANTENNA__0598__A1 Tile_X0Y5_N4END[0] VPWR VGND sg13cmos5l_antennanp
XANTENNA__3656__X Tile_X0Y3_E2BEG[3] VPWR VGND sg13cmos5l_antennanp
X_3711_ Tile_X0Y3_FrameData_O[14] Tile_X0Y3_FrameData[14] VPWR VGND sg13cmos5l_buf_1
X_0923_ _0923_/X Tile_X0Y5_W1END[1] Tile_X0Y5_WW4END[1] _3301_/Q VPWR VGND sg13cmos5l_mux2_1
XANTENNA__2423__D Tile_X0Y2_FrameData[9] VPWR VGND sg13cmos5l_antennanp
X_3642_ Tile_X0Y0_E2BEG[5] _3642_/A VPWR VGND sg13cmos5l_buf_1
X_0854_ AXI_M_SOC_ARLEN1 _3125_/Q _0851_/Y _0852_/Y _0853_/Y _3332_/Q VPWR VGND sg13cmos5l_a221oi_1
XFILLER_161_206 VPWR VGND sg13cmos5l_decap_8
XANTENNA__1547__A0 AXI_M_SOC_RDATA13 VPWR VGND sg13cmos5l_antennanp
X_3573_ Tile_X0Y0_FrameData_O[4] Tile_X0Y0_FrameData[4] VPWR VGND sg13cmos5l_buf_1
X_0785_ _3904_/A Tile_X0Y4_W2MID[6] Tile_X0Y4_W2END[6] Tile_X0Y4_W6END[9] _1049_/X
+ _3010_/Q _3009_/Q VPWR VGND sg13cmos5l_mux4_1
XANTENNA__1011__A2 Tile_X0Y5_N4END[6] VPWR VGND sg13cmos5l_antennanp
XANTENNA__3081__GATE Tile_X0Y5_FrameStrobe[0] VPWR VGND sg13cmos5l_antennanp
XFILLER_114_133 VPWR VGND sg13cmos5l_decap_8
X_2524_ _2524_/Q Tile_X0Y3_FrameData[20] Tile_X0Y5_FrameStrobe[0] VPWR VGND sg13cmos5l_dlhq_1
XFILLER_46_0 VPWR VGND sg13cmos5l_fill_2
XANTENNA__0770__A1 Tile_X0Y1_WW4END[8] VPWR VGND sg13cmos5l_antennanp
XANTENNA__3254__D Tile_X0Y5_FrameData[26] VPWR VGND sg13cmos5l_antennanp
XANTENNA__3391__X Tile_X0Y2_EE4BEG[9] VPWR VGND sg13cmos5l_antennanp
XFILLER_216_32 VPWR VGND sg13cmos5l_fill_1
XFILLER_216_43 VPWR VGND sg13cmos5l_fill_2
XFILLER_303_266 VPWR VGND sg13cmos5l_decap_8
X_2455_ _2455_/Q Tile_X0Y2_FrameData[9] Tile_X0Y5_FrameStrobe[6] VPWR VGND sg13cmos5l_dlhq_1
X_2386_ _2386_/Q Tile_X0Y2_FrameData[14] Tile_X0Y5_FrameStrobe[4] VPWR VGND sg13cmos5l_dlhq_1
X_1406_ _3379_/A AXI_M_SOC_RDATA19 _1313_/X _1380_/X _1183_/X _2349_/Q _2350_/Q VPWR
+ VGND sg13cmos5l_mux4_1
XANTENNA__1314__A3 Tile_X0Y0_S4END[11] VPWR VGND sg13cmos5l_antennanp
XANTENNA__3096__GATE Tile_X0Y5_FrameStrobe[1] VPWR VGND sg13cmos5l_antennanp
X_1337_ _3503_/A Tile_X0Y1_W2MID[4] AXI_M_SOC_RDATA25 _1094_/X _1089_/X _2154_/Q _2153_/Q
+ VPWR VGND sg13cmos5l_mux4_1
XFILLER_283_140 VPWR VGND sg13cmos5l_fill_1
XFILLER_28_106 VPWR VGND sg13cmos5l_decap_4
XFILLER_232_75 VPWR VGND sg13cmos5l_fill_1
XFILLER_283_195 VPWR VGND sg13cmos5l_fill_2
X_1268_ _1268_/X _1138_/X _0568_/X _0918_/Y Tile_X0Y0_S4END[4] _2023_/Q _2024_/Q VPWR
+ VGND sg13cmos5l_mux4_1
XANTENNA__1078__A2 Tile_X0Y0_S2MID[4] VPWR VGND sg13cmos5l_antennanp
X_3007_ _3007_/Q Tile_X0Y4_FrameData[1] Tile_X0Y5_FrameStrobe[6] VPWR VGND sg13cmos5l_dlhq_1
X_1199_ AXI_M_SOC_AWADDR18 Tile_X0Y0_WW4END[2] Tile_X0Y0_WW4END[10] Tile_X0Y0_W6END[10]
+ _1005_/X _1780_/Q _1779_/Q VPWR VGND sg13cmos5l_mux4_1
XFILLER_101_24 VPWR VGND sg13cmos5l_decap_8
XFILLER_224_262 VPWR VGND sg13cmos5l_fill_1
XFILLER_51_131 VPWR VGND sg13cmos5l_fill_1
XANTENNA__3034__GATE Tile_X0Y5_FrameStrobe[7] VPWR VGND sg13cmos5l_antennanp
XANTENNA__3566__X Tile_X0Y0_FrameStrobe_O[17] VPWR VGND sg13cmos5l_antennanp
XFILLER_196_169 VPWR VGND sg13cmos5l_decap_8
XFILLER_229_8 VPWR VGND sg13cmos5l_fill_2
X_3909_ Tile_X0Y5_S2BEGb[6] _3909_/A VPWR VGND sg13cmos5l_buf_1
XANTENNA__2333__D Tile_X0Y2_FrameData[3] VPWR VGND sg13cmos5l_antennanp
XANTENNA__2290__GATE Tile_X0Y5_FrameStrobe[1] VPWR VGND sg13cmos5l_antennanp
XFILLER_257_72 VPWR VGND sg13cmos5l_decap_8
XANTENNA__1538__A0 Tile_X0Y5_N4END[8] VPWR VGND sg13cmos5l_antennanp
XFILLER_10_21 VPWR VGND sg13cmos5l_fill_2
XFILLER_3_227 VPWR VGND sg13cmos5l_decap_8
XANTENNA__3049__GATE Tile_X0Y5_FrameStrobe[8] VPWR VGND sg13cmos5l_antennanp
XFILLER_10_32 VPWR VGND sg13cmos5l_fill_1
XFILLER_3_238 VPWR VGND sg13cmos5l_fill_2
XANTENNA__0761__A1 Tile_X0Y5_W6END[2] VPWR VGND sg13cmos5l_antennanp
XANTENNA__3164__D Tile_X0Y5_FrameData[20] VPWR VGND sg13cmos5l_antennanp
XFILLER_105_177 VPWR VGND sg13cmos5l_decap_8
XFILLER_126_43 VPWR VGND sg13cmos5l_fill_2
XFILLER_160_250 VPWR VGND sg13cmos5l_fill_2
XFILLER_126_76 VPWR VGND sg13cmos5l_decap_8
XFILLER_86_36 VPWR VGND sg13cmos5l_fill_1
XFILLER_120_147 VPWR VGND sg13cmos5l_decap_8
XFILLER_86_58 VPWR VGND sg13cmos5l_decap_8
XFILLER_59_264 VPWR VGND sg13cmos5l_decap_4
XFILLER_19_106 VPWR VGND sg13cmos5l_decap_4
XFILLER_142_53 VPWR VGND sg13cmos5l_fill_2
XFILLER_74_245 VPWR VGND sg13cmos5l_fill_2
XANTENNA__1069__A2 Tile_X0Y0_S1END[0] VPWR VGND sg13cmos5l_antennanp
XANTENNA__2508__D Tile_X0Y2_FrameData[20] VPWR VGND sg13cmos5l_antennanp
XFILLER_34_109 VPWR VGND sg13cmos5l_decap_8
XANTENNA__0816__A2 AXI_M_SOC_RLAST VPWR VGND sg13cmos5l_antennanp
XFILLER_27_183 VPWR VGND sg13cmos5l_decap_8
XANTENNA__2243__GATE Tile_X0Y5_FrameStrobe[0] VPWR VGND sg13cmos5l_antennanp
XFILLER_150_0 VPWR VGND sg13cmos5l_decap_4
XFILLER_248_0 VPWR VGND sg13cmos5l_fill_2
XFILLER_42_131 VPWR VGND sg13cmos5l_decap_4
XANTENNA__2873__GATE Tile_X0Y5_FrameStrobe[2] VPWR VGND sg13cmos5l_antennanp
XANTENNA__3339__D Tile_X0Y5_FrameData[5] VPWR VGND sg13cmos5l_antennanp
XANTENNA__2243__D Tile_X0Y2_FrameData[29] VPWR VGND sg13cmos5l_antennanp
XANTENNA__3476__X Tile_X0Y1_EE4BEG[12] VPWR VGND sg13cmos5l_antennanp
XFILLER_128_214 VPWR VGND sg13cmos5l_decap_8
XFILLER_128_225 VPWR VGND sg13cmos5l_fill_2
XANTENNA__2258__GATE Tile_X0Y5_FrameStrobe[0] VPWR VGND sg13cmos5l_antennanp
XFILLER_128_258 VPWR VGND sg13cmos5l_decap_4
XANTENNA__1529__A0 Tile_X0Y3_WW4END[5] VPWR VGND sg13cmos5l_antennanp
XANTENNA__2888__GATE Tile_X0Y5_FrameStrobe[3] VPWR VGND sg13cmos5l_antennanp
XFILLER_136_280 VPWR VGND sg13cmos5l_fill_1
X_0570_ _0572_/B Tile_X0Y1_W6END[0] _1976_/Q VPWR VGND sg13cmos5l_nor2b_1
XANTENNA__3074__D Tile_X0Y5_FrameData[14] VPWR VGND sg13cmos5l_antennanp
XANTENNA__2811__GATE Tile_X0Y5_FrameStrobe[0] VPWR VGND sg13cmos5l_antennanp
XFILLER_183_82 VPWR VGND sg13cmos5l_decap_8
X_2240_ _2240_/Q Tile_X0Y1_FrameData[16] Tile_X0Y5_FrameStrobe[8] VPWR VGND sg13cmos5l_dlhq_1
XFILLER_2_293 VPWR VGND sg13cmos5l_fill_2
XFILLER_265_140 VPWR VGND sg13cmos5l_decap_4
X_2171_ _2171_/Q Tile_X0Y1_FrameData[21] Tile_X0Y5_FrameStrobe[6] VPWR VGND sg13cmos5l_dlhq_1
XFILLER_65_201 VPWR VGND sg13cmos5l_decap_8
XANTENNA__2826__GATE Tile_X0Y5_FrameStrobe[1] VPWR VGND sg13cmos5l_antennanp
XFILLER_265_184 VPWR VGND sg13cmos5l_decap_8
X_1122_ _1122_/X Tile_X0Y2_W1END[2] Tile_X0Y2_W6END[6] _0976_/X _0677_/X _2508_/Q
+ _2507_/Q VPWR VGND sg13cmos5l_mux4_1
XANTENNA__2418__D Tile_X0Y2_FrameData[14] VPWR VGND sg13cmos5l_antennanp
XFILLER_18_161 VPWR VGND sg13cmos5l_decap_8
X_1053_ _1053_/Y Tile_X0Y5_W6END[0] _3064_/Q _1052_/Y VPWR VGND sg13cmos5l_a21oi_1
XFILLER_80_204 VPWR VGND sg13cmos5l_fill_1
XFILLER_33_131 VPWR VGND sg13cmos5l_fill_2
XFILLER_278_27 VPWR VGND sg13cmos5l_fill_2
XFILLER_33_186 VPWR VGND sg13cmos5l_fill_1
XANTENNA__3249__D Tile_X0Y5_FrameData[31] VPWR VGND sg13cmos5l_antennanp
X_1955_ _1955_/Q Tile_X0Y0_FrameData[29] Tile_X0Y5_FrameStrobe[8] VPWR VGND sg13cmos5l_dlhq_1
XANTENNA__1232__A2 AXI_M_SOC_AWREADY VPWR VGND sg13cmos5l_antennanp
XANTENNA__2153__D Tile_X0Y1_FrameData[7] VPWR VGND sg13cmos5l_antennanp
XANTENNA__3386__X Tile_X0Y2_EE4BEG[4] VPWR VGND sg13cmos5l_antennanp
XFILLER_119_214 VPWR VGND sg13cmos5l_decap_8
X_0906_ _0907_/B Tile_X0Y1_WW4END[3] Tile_X0Y1_W6END[3] Tile_X0Y1_WW4END[11] _0905_/X
+ _2065_/Q _2066_/Q VPWR VGND sg13cmos5l_mux4_1
X_1886_ _1886_/Q Tile_X0Y0_FrameData[2] Tile_X0Y5_FrameStrobe[5] VPWR VGND sg13cmos5l_dlhq_1
XANTENNA__1992__D Tile_X0Y1_FrameData[8] VPWR VGND sg13cmos5l_antennanp
XFILLER_227_20 VPWR VGND sg13cmos5l_fill_1
XFILLER_227_31 VPWR VGND sg13cmos5l_fill_1
X_3625_ Tile_X0Y0_E6BEG[8] _3625_/A VPWR VGND sg13cmos5l_buf_1
X_0837_ AXI_M_SOC_ARVALID Tile_X0Y5_WW4END[2] Tile_X0Y5_W6END[10] Tile_X0Y5_WW4END[10]
+ _0696_/X _3139_/Q _3140_/Q VPWR VGND sg13cmos5l_mux4_1
X_3556_ Tile_X0Y0_FrameStrobe_O[7] Tile_X0Y5_FrameStrobe[7] VPWR VGND sg13cmos5l_buf_1
X_0768_ _0768_/X Tile_X0Y5_WW4END[7] Tile_X0Y5_WW4END[15] Tile_X0Y5_W6END[7] _0741_/X
+ _3146_/Q _3145_/Q VPWR VGND sg13cmos5l_mux4_1
XFILLER_335_199 VPWR VGND sg13cmos5l_fill_2
X_2507_ _2507_/Q Tile_X0Y2_FrameData[21] Tile_X0Y5_FrameStrobe[8] VPWR VGND sg13cmos5l_dlhq_1
XANTENNA__0743__A1 Tile_X0Y5_N4END[3] VPWR VGND sg13cmos5l_antennanp
XANTENNA__1634__X AXI_M_SOC_ARADDR2 VPWR VGND sg13cmos5l_antennanp
XANTENNA__3562__A Tile_X0Y5_FrameStrobe[13] VPWR VGND sg13cmos5l_antennanp
XFILLER_142_283 VPWR VGND sg13cmos5l_fill_1
X_3487_ Tile_X0Y1_E6BEG[7] _3487_/A VPWR VGND sg13cmos5l_buf_1
X_0699_ _0699_/Y _3262_/Q Tile_X0Y5_W6END[6] _3261_/Q VPWR VGND sg13cmos5l_o21ai_1
X_2438_ _2438_/Q Tile_X0Y2_FrameData[26] Tile_X0Y5_FrameStrobe[6] VPWR VGND sg13cmos5l_dlhq_1
XANTENNA__1299__A2 Tile_X0Y1_W6END[4] VPWR VGND sg13cmos5l_antennanp
X_2369_ _2369_/Q Tile_X0Y2_FrameData[31] Tile_X0Y5_FrameStrobe[4] VPWR VGND sg13cmos5l_dlhq_1
XFILLER_186_9 VPWR VGND sg13cmos5l_decap_8
XFILLER_56_256 VPWR VGND sg13cmos5l_decap_8
XANTENNA__2328__D Tile_X0Y2_FrameData[8] VPWR VGND sg13cmos5l_antennanp
XFILLER_71_215 VPWR VGND sg13cmos5l_fill_1
XFILLER_72_16 VPWR VGND sg13cmos5l_fill_2
XFILLER_212_221 VPWR VGND sg13cmos5l_decap_4
XANTENNA__1471__A2 AXI_M_SOC_RDATA21 VPWR VGND sg13cmos5l_antennanp
XFILLER_24_186 VPWR VGND sg13cmos5l_decap_8
XANTENNA__3159__D Tile_X0Y5_FrameData[25] VPWR VGND sg13cmos5l_antennanp
XANTENNA__2063__D Tile_X0Y1_FrameData[1] VPWR VGND sg13cmos5l_antennanp
XANTENNA__2998__D Tile_X0Y4_FrameData[10] VPWR VGND sg13cmos5l_antennanp
XFILLER_21_20 VPWR VGND sg13cmos5l_decap_8
XFILLER_125_228 VPWR VGND sg13cmos5l_decap_8
XFILLER_192_172 VPWR VGND sg13cmos5l_decap_4
XFILLER_326_188 VPWR VGND sg13cmos5l_decap_8
XFILLER_118_280 VPWR VGND sg13cmos5l_fill_1
XANTENNA__1526__A3 Tile_X0Y0_S4END[15] VPWR VGND sg13cmos5l_antennanp
XFILLER_284_81 VPWR VGND sg13cmos5l_fill_2
XFILLER_153_41 VPWR VGND sg13cmos5l_decap_8
XFILLER_294_246 VPWR VGND sg13cmos5l_decap_8
XFILLER_198_0 VPWR VGND sg13cmos5l_decap_4
XANTENNA__2238__D Tile_X0Y1_FrameData[18] VPWR VGND sg13cmos5l_antennanp
XFILLER_262_132 VPWR VGND sg13cmos5l_decap_8
XANTENNA__2182__GATE Tile_X0Y5_FrameStrobe[6] VPWR VGND sg13cmos5l_antennanp
XFILLER_15_131 VPWR VGND sg13cmos5l_decap_8
XFILLER_262_187 VPWR VGND sg13cmos5l_fill_2
XFILLER_62_259 VPWR VGND sg13cmos5l_decap_8
XFILLER_15_164 VPWR VGND sg13cmos5l_decap_8
XFILLER_94_8 VPWR VGND sg13cmos5l_decap_8
XANTENNA__3069__D Tile_X0Y5_FrameData[19] VPWR VGND sg13cmos5l_antennanp
XFILLER_175_106 VPWR VGND sg13cmos5l_fill_2
XFILLER_87_7 VPWR VGND sg13cmos5l_decap_8
XANTENNA__2197__GATE Tile_X0Y5_FrameStrobe[7] VPWR VGND sg13cmos5l_antennanp
XFILLER_175_139 VPWR VGND sg13cmos5l_decap_8
XFILLER_248_19 VPWR VGND sg13cmos5l_fill_1
XFILLER_317_100 VPWR VGND sg13cmos5l_fill_1
XANTENNA__1214__A2 Tile_X0Y0_W6END[6] VPWR VGND sg13cmos5l_antennanp
X_1740_ _1740_/Q Tile_X0Y0_FrameData[20] Tile_X0Y5_FrameStrobe[1] VPWR VGND sg13cmos5l_dlhq_1
XFILLER_7_33 VPWR VGND sg13cmos5l_decap_4
XFILLER_7_22 VPWR VGND sg13cmos5l_fill_1
XANTENNA__0973__A1 Tile_X0Y5_W2END[4] VPWR VGND sg13cmos5l_antennanp
XFILLER_183_172 VPWR VGND sg13cmos5l_fill_2
X_1671_ _3732_/A _0992_/X _0684_/X AXI_M_SOC_RRESP1 AXI_M_SOC_RDATA3 _2980_/Q _2979_/Q
+ VPWR VGND sg13cmos5l_mux4_1
XANTENNA__2120__GATE Tile_X0Y5_FrameStrobe[4] VPWR VGND sg13cmos5l_antennanp
XANTENNA__2701__D Tile_X0Y3_FrameData[3] VPWR VGND sg13cmos5l_antennanp
XFILLER_264_18 VPWR VGND sg13cmos5l_decap_8
X_3410_ Tile_X0Y2_FrameData_O[12] Tile_X0Y2_FrameData[12] VPWR VGND sg13cmos5l_buf_1
X_0622_ _0622_/X _0617_/X _0618_/Y _0621_/Y VPWR VGND sg13cmos5l_a21o_1
XANTENNA__2750__GATE Tile_X0Y5_FrameStrobe[7] VPWR VGND sg13cmos5l_antennanp
X_3341_ _3341_/Q Tile_X0Y5_FrameData[7] Tile_X0Y5_FrameStrobe[8] VPWR VGND sg13cmos5l_dlhq_1
X_0553_ _0553_/Y _0882_/X VPWR VGND sg13cmos5l_inv_1
XFILLER_124_294 VPWR VGND sg13cmos5l_fill_1
X_3272_ _3272_/Q Tile_X0Y5_FrameData[8] Tile_X0Y5_FrameStrobe[6] VPWR VGND sg13cmos5l_dlhq_1
XFILLER_97_167 VPWR VGND sg13cmos5l_decap_8
XANTENNA__2135__GATE Tile_X0Y5_FrameStrobe[5] VPWR VGND sg13cmos5l_antennanp
X_2223_ _2223_/Q Tile_X0Y1_FrameData[1] Tile_X0Y5_FrameStrobe[7] VPWR VGND sg13cmos5l_dlhq_1
XFILLER_87_90 VPWR VGND sg13cmos5l_decap_8
XANTENNA__2765__GATE Tile_X0Y5_FrameStrobe[7] VPWR VGND sg13cmos5l_antennanp
XFILLER_213_22 VPWR VGND sg13cmos5l_decap_8
X_2154_ _2154_/Q Tile_X0Y1_FrameData[6] Tile_X0Y5_FrameStrobe[5] VPWR VGND sg13cmos5l_dlhq_1
XFILLER_38_223 VPWR VGND sg13cmos5l_fill_1
XANTENNA__1150__A1 Tile_X0Y4_W2END[5] VPWR VGND sg13cmos5l_antennanp
XANTENNA__2148__D Tile_X0Y1_FrameData[12] VPWR VGND sg13cmos5l_antennanp
XFILLER_238_195 VPWR VGND sg13cmos5l_decap_4
X_1105_ _1105_/X _1103_/X _1104_/X _1102_/X Tile_X0Y0_S2MID[1] _1989_/Q _1990_/Q VPWR
+ VGND sg13cmos5l_mux4_1
XFILLER_198_209 VPWR VGND sg13cmos5l_decap_8
XFILLER_253_154 VPWR VGND sg13cmos5l_decap_8
XFILLER_253_165 VPWR VGND sg13cmos5l_fill_1
XFILLER_289_15 VPWR VGND sg13cmos5l_fill_2
X_2085_ _2085_/Q Tile_X0Y1_FrameData[11] Tile_X0Y5_FrameStrobe[3] VPWR VGND sg13cmos5l_dlhq_1
XANTENNA__1987__D Tile_X0Y1_FrameData[13] VPWR VGND sg13cmos5l_antennanp
XFILLER_253_187 VPWR VGND sg13cmos5l_decap_8
X_1036_ _1036_/X _0538_/Y _1030_/X _1035_/Y VPWR VGND sg13cmos5l_a21o_1
XFILLER_21_101 VPWR VGND sg13cmos5l_decap_4
XFILLER_42_19 VPWR VGND sg13cmos5l_fill_1
XANTENNA__2703__GATE Tile_X0Y5_FrameStrobe[5] VPWR VGND sg13cmos5l_antennanp
XANTENNA__3557__A Tile_X0Y5_FrameStrobe[8] VPWR VGND sg13cmos5l_antennanp
XFILLER_308_100 VPWR VGND sg13cmos5l_fill_1
X_2987_ _2987_/Q Tile_X0Y4_FrameData[21] Tile_X0Y5_FrameStrobe[6] VPWR VGND sg13cmos5l_dlhq_1
XANTENNA__1205__A2 Tile_X0Y0_W6END[0] VPWR VGND sg13cmos5l_antennanp
XFILLER_21_189 VPWR VGND sg13cmos5l_decap_8
XFILLER_238_30 VPWR VGND sg13cmos5l_decap_8
XFILLER_308_144 VPWR VGND sg13cmos5l_decap_4
X_1938_ _1938_/Q Tile_X0Y0_FrameData[14] Tile_X0Y5_FrameStrobe[7] VPWR VGND sg13cmos5l_dlhq_1
XFILLER_107_217 VPWR VGND sg13cmos5l_decap_8
XFILLER_174_150 VPWR VGND sg13cmos5l_decap_8
X_1869_ _1869_/Q Tile_X0Y0_FrameData[19] Tile_X0Y5_FrameStrobe[5] VPWR VGND sg13cmos5l_dlhq_1
XFILLER_323_103 VPWR VGND sg13cmos5l_fill_2
XANTENNA__2611__D Tile_X0Y3_FrameData[29] VPWR VGND sg13cmos5l_antennanp
XANTENNA__3844__X Tile_X0Y5_EE4BEG[1] VPWR VGND sg13cmos5l_antennanp
XFILLER_174_29 VPWR VGND sg13cmos5l_decap_4
X_3608_ Tile_X0Y0_EE4BEG[7] _3608_/A VPWR VGND sg13cmos5l_buf_1
XANTENNA__2718__GATE Tile_X0Y5_FrameStrobe[6] VPWR VGND sg13cmos5l_antennanp
XFILLER_107_56 VPWR VGND sg13cmos5l_decap_8
XFILLER_115_294 VPWR VGND sg13cmos5l_fill_1
XFILLER_276_202 VPWR VGND sg13cmos5l_fill_2
X_3539_ Tile_X0Y0_N2BEG[2] _3539_/A VPWR VGND sg13cmos5l_buf_1
XANTENNA__1974__GATE Tile_X0Y5_FrameStrobe[0] VPWR VGND sg13cmos5l_antennanp
XFILLER_67_38 VPWR VGND sg13cmos5l_decap_8
XFILLER_190_28 VPWR VGND sg13cmos5l_decap_8
XFILLER_190_39 VPWR VGND sg13cmos5l_fill_2
XFILLER_123_11 VPWR VGND sg13cmos5l_decap_8
XFILLER_291_205 VPWR VGND sg13cmos5l_fill_2
XANTENNA__1141__A1 Tile_X0Y1_W2END[6] VPWR VGND sg13cmos5l_antennanp
XANTENNA__1989__GATE Tile_X0Y5_FrameStrobe[0] VPWR VGND sg13cmos5l_antennanp
XANTENNA__2058__D Tile_X0Y1_FrameData[6] VPWR VGND sg13cmos5l_antennanp
XFILLER_244_132 VPWR VGND sg13cmos5l_fill_2
XFILLER_29_278 VPWR VGND sg13cmos5l_fill_2
XANTENNA__1692__A2 Tile_X0Y5_W6END[8] VPWR VGND sg13cmos5l_antennanp
XFILLER_16_20 VPWR VGND sg13cmos5l_fill_1
XANTENNA__1897__D Tile_X0Y0_FrameData[23] VPWR VGND sg13cmos5l_antennanp
XFILLER_244_187 VPWR VGND sg13cmos5l_decap_8
XANTENNA__1912__GATE Tile_X0Y5_FrameStrobe[6] VPWR VGND sg13cmos5l_antennanp
XANTENNA__0652__A0 Tile_X0Y5_W1END[1] VPWR VGND sg13cmos5l_antennanp
XFILLER_12_156 VPWR VGND sg13cmos5l_decap_8
XFILLER_157_128 VPWR VGND sg13cmos5l_decap_8
XANTENNA__1927__GATE Tile_X0Y5_FrameStrobe[7] VPWR VGND sg13cmos5l_antennanp
XFILLER_165_172 VPWR VGND sg13cmos5l_fill_2
XANTENNA__2521__D Tile_X0Y3_FrameData[23] VPWR VGND sg13cmos5l_antennanp
XANTENNA__3754__X Tile_X0Y4_E6BEG[4] VPWR VGND sg13cmos5l_antennanp
XFILLER_113_0 VPWR VGND sg13cmos5l_fill_2
XFILLER_106_294 VPWR VGND sg13cmos5l_fill_1
XFILLER_267_224 VPWR VGND sg13cmos5l_decap_4
XFILLER_79_134 VPWR VGND sg13cmos5l_decap_8
XFILLER_314_32 VPWR VGND sg13cmos5l_fill_2
XFILLER_79_167 VPWR VGND sg13cmos5l_fill_2
XFILLER_314_87 VPWR VGND sg13cmos5l_decap_8
XANTENNA__1132__A1 Tile_X0Y5_W6END[3] VPWR VGND sg13cmos5l_antennanp
XFILLER_180_94 VPWR VGND sg13cmos5l_decap_8
XFILLER_35_215 VPWR VGND sg13cmos5l_decap_4
XFILLER_235_198 VPWR VGND sg13cmos5l_fill_1
XFILLER_290_293 VPWR VGND sg13cmos5l_fill_2
XFILLER_330_53 VPWR VGND sg13cmos5l_fill_1
XANTENNA__1435__A2 Tile_X0Y5_N4END[11] VPWR VGND sg13cmos5l_antennanp
X_2910_ _2910_/Q Tile_X0Y4_FrameData[2] Tile_X0Y5_FrameStrobe[3] VPWR VGND sg13cmos5l_dlhq_1
XANTENNA__0643__A0 Tile_X0Y1_W1END[1] VPWR VGND sg13cmos5l_antennanp
X_3890_ Tile_X0Y5_FrameData_O[31] Tile_X0Y5_FrameData[31] VPWR VGND sg13cmos5l_buf_1
X_2841_ _2841_/Q Tile_X0Y4_FrameData[7] Tile_X0Y5_FrameStrobe[1] VPWR VGND sg13cmos5l_dlhq_1
XANTENNA__1199__A1 Tile_X0Y0_WW4END[10] VPWR VGND sg13cmos5l_antennanp
X_2772_ _2772_/Q Tile_X0Y3_FrameData[28] Tile_X0Y5_FrameStrobe[8] VPWR VGND sg13cmos5l_dlhq_1
XFILLER_156_172 VPWR VGND sg13cmos5l_decap_8
X_1723_ _1723_/Q Tile_X0Y0_FrameData[5] Tile_X0Y5_FrameStrobe[0] VPWR VGND sg13cmos5l_dlhq_1
XANTENNA__2431__D Tile_X0Y2_FrameData[1] VPWR VGND sg13cmos5l_antennanp
XANTENNA__3664__X Tile_X0Y3_E2BEGb[3] VPWR VGND sg13cmos5l_antennanp
X_1654_ AXI_M_SOC_ARADDR22 Tile_X0Y4_W2MID[6] Tile_X0Y4_W2END[6] Tile_X0Y4_W6END[6]
+ _1360_/X _2844_/Q _2843_/Q VPWR VGND sg13cmos5l_mux4_1
XFILLER_171_175 VPWR VGND sg13cmos5l_decap_8
XFILLER_208_88 VPWR VGND sg13cmos5l_decap_4
X_1585_ _1589_/B _2751_/Q _0556_/Y _1584_/Y VPWR VGND sg13cmos5l_o21ai_1
X_0605_ _3907_/A Tile_X0Y4_W1END[0] Tile_X0Y4_W2MID[3] Tile_X0Y4_W2END[3] _1319_/X
+ _3004_/Q _3003_/Q VPWR VGND sg13cmos5l_mux4_1
XANTENNA__2074__GATE Tile_X0Y5_FrameStrobe[3] VPWR VGND sg13cmos5l_antennanp
XFILLER_258_235 VPWR VGND sg13cmos5l_fill_1
X_3324_ _3324_/Q Tile_X0Y5_FrameData[20] Tile_X0Y5_FrameStrobe[8] VPWR VGND sg13cmos5l_dlhq_1
X_0536_ _0536_/Y _3258_/Q VPWR VGND sg13cmos5l_inv_1
XANTENNA__3262__D Tile_X0Y5_FrameData[18] VPWR VGND sg13cmos5l_antennanp
XFILLER_258_257 VPWR VGND sg13cmos5l_decap_4
X_3255_ _3255_/Q Tile_X0Y5_FrameData[25] Tile_X0Y5_FrameStrobe[6] VPWR VGND sg13cmos5l_dlhq_1
XFILLER_224_65 VPWR VGND sg13cmos5l_decap_8
X_2206_ _2206_/Q Tile_X0Y1_FrameData[18] Tile_X0Y5_FrameStrobe[7] VPWR VGND sg13cmos5l_dlhq_1
XFILLER_85_137 VPWR VGND sg13cmos5l_decap_8
XANTENNA__1123__A1 Tile_X0Y2_W6END[7] VPWR VGND sg13cmos5l_antennanp
XANTENNA__2089__GATE Tile_X0Y5_FrameStrobe[3] VPWR VGND sg13cmos5l_antennanp
X_3186_ _3186_/Q Tile_X0Y5_FrameData[30] Tile_X0Y5_FrameStrobe[4] VPWR VGND sg13cmos5l_dlhq_1
XANTENNA__1674__A2 AXI_M_SOC_RDATA1 VPWR VGND sg13cmos5l_antennanp
XFILLER_281_260 VPWR VGND sg13cmos5l_fill_2
X_2137_ _2137_/Q Tile_X0Y1_FrameData[23] Tile_X0Y5_FrameStrobe[5] VPWR VGND sg13cmos5l_dlhq_1
XFILLER_26_259 VPWR VGND sg13cmos5l_fill_1
XFILLER_281_293 VPWR VGND sg13cmos5l_fill_2
X_2068_ _2068_/Q Tile_X0Y1_FrameData[28] Tile_X0Y5_FrameStrobe[3] VPWR VGND sg13cmos5l_dlhq_1
XANTENNA__1426__A2 Tile_X0Y2_WW4END[5] VPWR VGND sg13cmos5l_antennanp
XANTENNA__2012__GATE Tile_X0Y5_FrameStrobe[1] VPWR VGND sg13cmos5l_antennanp
XANTENNA__2606__D Tile_X0Y3_FrameData[2] VPWR VGND sg13cmos5l_antennanp
XANTENNA__3839__X Tile_X0Y5_E6BEG[8] VPWR VGND sg13cmos5l_antennanp
X_1019_ _1019_/Y _3062_/Q Tile_X0Y5_N1END[1] VPWR VGND sg13cmos5l_nor2b_1
XFILLER_34_270 VPWR VGND sg13cmos5l_decap_8
XANTENNA__2642__GATE Tile_X0Y5_FrameStrobe[4] VPWR VGND sg13cmos5l_antennanp
XFILLER_179_242 VPWR VGND sg13cmos5l_decap_8
XFILLER_179_253 VPWR VGND sg13cmos5l_decap_4
XFILLER_34_281 VPWR VGND sg13cmos5l_fill_2
XFILLER_328_217 VPWR VGND sg13cmos5l_decap_8
XFILLER_249_84 VPWR VGND sg13cmos5l_fill_1
XANTENNA__2027__GATE Tile_X0Y5_FrameStrobe[1] VPWR VGND sg13cmos5l_antennanp
XFILLER_211_8 VPWR VGND sg13cmos5l_fill_2
XANTENNA__2341__D Tile_X0Y2_FrameData[27] VPWR VGND sg13cmos5l_antennanp
XANTENNA__2657__GATE Tile_X0Y5_FrameStrobe[4] VPWR VGND sg13cmos5l_antennanp
XANTENNA__3574__X Tile_X0Y0_FrameData_O[5] VPWR VGND sg13cmos5l_antennanp
XFILLER_309_8 VPWR VGND sg13cmos5l_fill_1
XFILLER_78_26 VPWR VGND sg13cmos5l_fill_2
XANTENNA__1362__A1 Tile_X0Y2_W6END[4] VPWR VGND sg13cmos5l_antennanp
XANTENNA__3172__D Tile_X0Y5_FrameData[12] VPWR VGND sg13cmos5l_antennanp
XFILLER_134_21 VPWR VGND sg13cmos5l_decap_8
XANTENNA__1114__A1 Tile_X0Y0_W2MID[0] VPWR VGND sg13cmos5l_antennanp
XANTENNA__1665__A2 Tile_X0Y4_WW4END[15] VPWR VGND sg13cmos5l_antennanp
XFILLER_150_31 VPWR VGND sg13cmos5l_fill_1
XFILLER_84_181 VPWR VGND sg13cmos5l_decap_8
XFILLER_150_64 VPWR VGND sg13cmos5l_decap_8
XFILLER_272_293 VPWR VGND sg13cmos5l_fill_2
XANTENNA__1851__GATE Tile_X0Y5_FrameStrobe[4] VPWR VGND sg13cmos5l_antennanp
XANTENNA__2516__D Tile_X0Y3_FrameData[28] VPWR VGND sg13cmos5l_antennanp
XANTENNA__3749__X Tile_X0Y4_E2BEGb[7] VPWR VGND sg13cmos5l_antennanp
XFILLER_232_146 VPWR VGND sg13cmos5l_decap_4
XANTENNA__1417__A2 Tile_X0Y2_WW4END[4] VPWR VGND sg13cmos5l_antennanp
XFILLER_230_0 VPWR VGND sg13cmos5l_fill_2
XFILLER_43_51 VPWR VGND sg13cmos5l_decap_8
XANTENNA__1866__GATE Tile_X0Y5_FrameStrobe[5] VPWR VGND sg13cmos5l_antennanp
XFILLER_159_62 VPWR VGND sg13cmos5l_decap_4
XFILLER_328_0 VPWR VGND sg13cmos5l_fill_2
XFILLER_309_43 VPWR VGND sg13cmos5l_decap_8
XANTENNA__0928__A1 Tile_X0Y1_WW4END[13] VPWR VGND sg13cmos5l_antennanp
XANTENNA__1050__A0 Tile_X0Y4_W1END[0] VPWR VGND sg13cmos5l_antennanp
XANTENNA__2251__D Tile_X0Y2_FrameData[21] VPWR VGND sg13cmos5l_antennanp
XANTENNA__3347__D Tile_X0Y5_FrameData[13] VPWR VGND sg13cmos5l_antennanp
XANTENNA__3484__X Tile_X0Y1_E6BEG[4] VPWR VGND sg13cmos5l_antennanp
XFILLER_138_194 VPWR VGND sg13cmos5l_decap_8
XFILLER_153_164 VPWR VGND sg13cmos5l_decap_8
XFILLER_153_197 VPWR VGND sg13cmos5l_decap_8
XFILLER_4_34 VPWR VGND sg13cmos5l_fill_1
XFILLER_4_12 VPWR VGND sg13cmos5l_fill_1
X_1370_ _1370_/X _1120_/X _0718_/X Tile_X0Y5_N4END[15] Tile_X0Y0_S4END[11] _2273_/Q
+ _2274_/Q VPWR VGND sg13cmos5l_mux4_1
XANTENNA__3082__D Tile_X0Y5_FrameData[6] VPWR VGND sg13cmos5l_antennanp
XFILLER_67_115 VPWR VGND sg13cmos5l_fill_2
XFILLER_325_86 VPWR VGND sg13cmos5l_fill_1
XANTENNA__1804__GATE Tile_X0Y5_FrameStrobe[3] VPWR VGND sg13cmos5l_antennanp
XFILLER_67_148 VPWR VGND sg13cmos5l_fill_1
XFILLER_67_137 VPWR VGND sg13cmos5l_fill_1
XFILLER_208_110 VPWR VGND sg13cmos5l_decap_8
X_3040_ _3040_/Q Tile_X0Y4_FrameData[0] Tile_X0Y5_FrameStrobe[7] VPWR VGND sg13cmos5l_dlhq_1
XANTENNA__1819__GATE Tile_X0Y5_FrameStrobe[3] VPWR VGND sg13cmos5l_antennanp
XFILLER_208_187 VPWR VGND sg13cmos5l_fill_1
XFILLER_223_102 VPWR VGND sg13cmos5l_decap_8
XFILLER_263_293 VPWR VGND sg13cmos5l_fill_2
XFILLER_75_192 VPWR VGND sg13cmos5l_decap_8
XANTENNA__2426__D Tile_X0Y2_FrameData[6] VPWR VGND sg13cmos5l_antennanp
XANTENNA__3659__X Tile_X0Y3_E2BEG[6] VPWR VGND sg13cmos5l_antennanp
X_3873_ Tile_X0Y5_FrameData_O[14] Tile_X0Y5_FrameData[14] VPWR VGND sg13cmos5l_buf_1
X_2824_ _2824_/Q Tile_X0Y4_FrameData[24] Tile_X0Y5_FrameStrobe[1] VPWR VGND sg13cmos5l_dlhq_1
XFILLER_219_21 VPWR VGND sg13cmos5l_fill_2
XFILLER_219_43 VPWR VGND sg13cmos5l_fill_1
XFILLER_76_0 VPWR VGND sg13cmos5l_decap_4
XANTENNA__2161__D Tile_X0Y1_FrameData[31] VPWR VGND sg13cmos5l_antennanp
XANTENNA__3257__D Tile_X0Y5_FrameData[23] VPWR VGND sg13cmos5l_antennanp
XANTENNA__3394__X Tile_X0Y2_EE4BEG[12] VPWR VGND sg13cmos5l_antennanp
XFILLER_144_120 VPWR VGND sg13cmos5l_decap_8
XFILLER_219_65 VPWR VGND sg13cmos5l_fill_2
X_2755_ _2755_/Q Tile_X0Y3_FrameData[13] Tile_X0Y5_FrameStrobe[7] VPWR VGND sg13cmos5l_dlhq_1
X_2686_ _2686_/Q Tile_X0Y3_FrameData[18] Tile_X0Y5_FrameStrobe[5] VPWR VGND sg13cmos5l_dlhq_1
X_1706_ _1706_/Q Tile_X0Y0_FrameData[22] Tile_X0Y5_FrameStrobe[0] VPWR VGND sg13cmos5l_dlhq_1
X_1637_ AXI_M_SOC_ARADDR7 Tile_X0Y4_WW4END[7] Tile_X0Y4_WW4END[15] Tile_X0Y4_W6END[7]
+ _1125_/X _2874_/Q _2873_/Q VPWR VGND sg13cmos5l_mux4_1
XANTENNA__3310__GATE Tile_X0Y5_FrameStrobe[7] VPWR VGND sg13cmos5l_antennanp
X_3307_ _3307_/Q Tile_X0Y5_FrameData[5] Tile_X0Y5_FrameStrobe[7] VPWR VGND sg13cmos5l_dlhq_1
X_1568_ _1568_/Y _2721_/Q _1342_/X _1567_/Y VPWR VGND sg13cmos5l_a21oi_1
XFILLER_58_104 VPWR VGND sg13cmos5l_decap_8
XANTENNA__1642__X AXI_M_SOC_ARADDR3 VPWR VGND sg13cmos5l_antennanp
XANTENNA__3570__A Tile_X0Y0_FrameData[1] VPWR VGND sg13cmos5l_antennanp
XFILLER_100_223 VPWR VGND sg13cmos5l_decap_8
X_1499_ _3653_/A Tile_X0Y3_W2MID[7] AXI_M_SOC_RDATA6 _1267_/X _1351_/X _2704_/Q _2703_/Q
+ VPWR VGND sg13cmos5l_mux4_1
X_3238_ _3238_/Q Tile_X0Y5_FrameData[10] Tile_X0Y5_FrameStrobe[5] VPWR VGND sg13cmos5l_dlhq_1
XANTENNA__1647__A2 Tile_X0Y4_W6END[3] VPWR VGND sg13cmos5l_antennanp
XANTENNA__3325__GATE Tile_X0Y5_FrameStrobe[8] VPWR VGND sg13cmos5l_antennanp
XFILLER_100_278 VPWR VGND sg13cmos5l_fill_1
X_3169_ _3169_/Q Tile_X0Y5_FrameData[15] Tile_X0Y5_FrameStrobe[3] VPWR VGND sg13cmos5l_dlhq_1
XANTENNA__0855__A0 Tile_X0Y5_W2MID[2] VPWR VGND sg13cmos5l_antennanp
XFILLER_214_113 VPWR VGND sg13cmos5l_decap_4
XFILLER_254_282 VPWR VGND sg13cmos5l_fill_2
XANTENNA__2336__D Tile_X0Y2_FrameData[0] VPWR VGND sg13cmos5l_antennanp
XANTENNA__2581__GATE Tile_X0Y5_FrameStrobe[2] VPWR VGND sg13cmos5l_antennanp
XANTENNA__3569__X Tile_X0Y0_FrameData_O[0] VPWR VGND sg13cmos5l_antennanp
XANTENNA__0607__A0 Tile_X0Y5_N2MID[4] VPWR VGND sg13cmos5l_antennanp
XFILLER_120_67 VPWR VGND sg13cmos5l_decap_8
XFILLER_167_212 VPWR VGND sg13cmos5l_fill_1
XANTENNA__1280__A0 Tile_X0Y1_W2END[2] VPWR VGND sg13cmos5l_antennanp
XFILLER_80_49 VPWR VGND sg13cmos5l_decap_8
XANTENNA__2596__GATE Tile_X0Y5_FrameStrobe[2] VPWR VGND sg13cmos5l_antennanp
XFILLER_127_109 VPWR VGND sg13cmos5l_fill_2
XFILLER_13_43 VPWR VGND sg13cmos5l_fill_2
XANTENNA__2071__D Tile_X0Y1_FrameData[25] VPWR VGND sg13cmos5l_antennanp
XANTENNA__3167__D Tile_X0Y5_FrameData[17] VPWR VGND sg13cmos5l_antennanp
XFILLER_89_36 VPWR VGND sg13cmos5l_decap_8
XFILLER_150_112 VPWR VGND sg13cmos5l_decap_8
XANTENNA__1335__A1 AXI_M_SOC_RDATA28 VPWR VGND sg13cmos5l_antennanp
XFILLER_150_178 VPWR VGND sg13cmos5l_fill_1
XFILLER_296_149 VPWR VGND sg13cmos5l_decap_8
XANTENNA__1552__X AXI_M_SOC_ARADDR30 VPWR VGND sg13cmos5l_antennanp
XFILLER_49_148 VPWR VGND sg13cmos5l_decap_8
XANTENNA__2534__GATE Tile_X0Y5_FrameStrobe[0] VPWR VGND sg13cmos5l_antennanp
XANTENNA__1099__A0 Tile_X0Y0_W2MID[5] VPWR VGND sg13cmos5l_antennanp
XANTENNA__1638__A2 Tile_X0Y4_WW4END[12] VPWR VGND sg13cmos5l_antennanp
XFILLER_278_0 VPWR VGND sg13cmos5l_fill_2
XANTENNA__0846__A0 Tile_X0Y5_W1END[3] VPWR VGND sg13cmos5l_antennanp
XANTENNA__1790__GATE Tile_X0Y5_FrameStrobe[2] VPWR VGND sg13cmos5l_antennanp
XFILLER_205_113 VPWR VGND sg13cmos5l_decap_8
XFILLER_57_192 VPWR VGND sg13cmos5l_decap_8
XANTENNA__2246__D Tile_X0Y2_FrameData[26] VPWR VGND sg13cmos5l_antennanp
XANTENNA__2549__GATE Tile_X0Y5_FrameStrobe[1] VPWR VGND sg13cmos5l_antennanp
XANTENNA__3479__X Tile_X0Y1_EE4BEG[15] VPWR VGND sg13cmos5l_antennanp
XFILLER_54_83 VPWR VGND sg13cmos5l_fill_1
XFILLER_158_212 VPWR VGND sg13cmos5l_fill_1
XFILLER_13_273 VPWR VGND sg13cmos5l_fill_2
XFILLER_9_222 VPWR VGND sg13cmos5l_fill_2
XANTENNA__1019__B_N Tile_X0Y5_N1END[1] VPWR VGND sg13cmos5l_antennanp
XFILLER_158_267 VPWR VGND sg13cmos5l_decap_8
X_0870_ _0870_/Y Tile_X0Y5_W2END[5] _3118_/Q _3117_/Q VPWR VGND sg13cmos5l_a21oi_1
XFILLER_70_60 VPWR VGND sg13cmos5l_fill_1
XANTENNA__1023__A0 Tile_X0Y5_W1END[1] VPWR VGND sg13cmos5l_antennanp
XANTENNA__3077__D Tile_X0Y5_FrameData[11] VPWR VGND sg13cmos5l_antennanp
X_2540_ _2540_/Q Tile_X0Y3_FrameData[4] Tile_X0Y5_FrameStrobe[0] VPWR VGND sg13cmos5l_dlhq_1
XFILLER_141_112 VPWR VGND sg13cmos5l_fill_1
X_2471_ _2471_/Q Tile_X0Y2_FrameData[25] Tile_X0Y5_FrameStrobe[7] VPWR VGND sg13cmos5l_dlhq_1
XFILLER_272_18 VPWR VGND sg13cmos5l_fill_1
X_1422_ AXI_M_SOC_WDATA15 Tile_X0Y2_WW4END[7] Tile_X0Y2_WW4END[15] Tile_X0Y2_W6END[7]
+ _1314_/X _2330_/Q _2329_/Q VPWR VGND sg13cmos5l_mux4_1
XANTENNA__1743__GATE Tile_X0Y5_FrameStrobe[1] VPWR VGND sg13cmos5l_antennanp
XFILLER_141_178 VPWR VGND sg13cmos5l_decap_8
XFILLER_79_91 VPWR VGND sg13cmos5l_decap_8
X_1353_ _1353_/X Tile_X0Y1_W1END[1] _0927_/X Tile_X0Y1_WW4END[1] _0950_/X _2211_/Q
+ _2213_/Q VPWR VGND sg13cmos5l_mux4_1
XFILLER_95_210 VPWR VGND sg13cmos5l_decap_8
X_1284_ _3478_/A Tile_X0Y1_WW4END[1] AXI_M_SOC_RDATA23 _1218_/X _1105_/X _2100_/Q
+ _2099_/Q VPWR VGND sg13cmos5l_mux4_1
XANTENNA__1758__GATE Tile_X0Y5_FrameStrobe[1] VPWR VGND sg13cmos5l_antennanp
X_3023_ _3023_/Q Tile_X0Y4_FrameData[17] Tile_X0Y5_FrameStrobe[7] VPWR VGND sg13cmos5l_dlhq_1
XANTENNA__0837__A0 Tile_X0Y5_WW4END[2] VPWR VGND sg13cmos5l_antennanp
XANTENNA__2156__D Tile_X0Y1_FrameData[4] VPWR VGND sg13cmos5l_antennanp
XANTENNA__3389__X Tile_X0Y2_EE4BEG[7] VPWR VGND sg13cmos5l_antennanp
XFILLER_221_55 VPWR VGND sg13cmos5l_decap_8
XFILLER_236_293 VPWR VGND sg13cmos5l_fill_2
XFILLER_211_105 VPWR VGND sg13cmos5l_decap_8
XFILLER_63_195 VPWR VGND sg13cmos5l_decap_4
XANTENNA__1995__D Tile_X0Y1_FrameData[5] VPWR VGND sg13cmos5l_antennanp
XFILLER_149_201 VPWR VGND sg13cmos5l_fill_1
X_3925_ Tile_X0Y5_S4BEG[14] _3925_/A VPWR VGND sg13cmos5l_buf_1
XANTENNA__1262__A0 Tile_X0Y0_W2END[4] VPWR VGND sg13cmos5l_antennanp
XFILLER_109_109 VPWR VGND sg13cmos5l_decap_8
XFILLER_149_256 VPWR VGND sg13cmos5l_decap_8
XFILLER_164_215 VPWR VGND sg13cmos5l_decap_8
X_3856_ Tile_X0Y5_EE4BEG[13] _3856_/A VPWR VGND sg13cmos5l_buf_1
XANTENNA__1014__A0 Tile_X0Y2_W2MID[5] VPWR VGND sg13cmos5l_antennanp
XANTENNA__1637__X AXI_M_SOC_ARADDR7 VPWR VGND sg13cmos5l_antennanp
XANTENNA__3565__A Tile_X0Y5_FrameStrobe[16] VPWR VGND sg13cmos5l_antennanp
XFILLER_164_248 VPWR VGND sg13cmos5l_fill_2
X_2807_ _2807_/Q Tile_X0Y4_FrameData[9] Tile_X0Y5_FrameStrobe[0] VPWR VGND sg13cmos5l_dlhq_1
X_3787_ Tile_X0Y4_FrameData_O[9] Tile_X0Y4_FrameData[9] VPWR VGND sg13cmos5l_buf_1
X_0999_ _0999_/Y _3026_/Q _1013_/X VPWR VGND sg13cmos5l_nor2b_1
XFILLER_246_30 VPWR VGND sg13cmos5l_fill_1
X_2738_ _2738_/Q Tile_X0Y3_FrameData[30] Tile_X0Y5_FrameStrobe[7] VPWR VGND sg13cmos5l_dlhq_1
XANTENNA__1565__A1 Tile_X0Y3_WW4END[13] VPWR VGND sg13cmos5l_antennanp
XFILLER_172_270 VPWR VGND sg13cmos5l_fill_1
XFILLER_172_281 VPWR VGND sg13cmos5l_fill_2
XFILLER_246_52 VPWR VGND sg13cmos5l_fill_2
XFILLER_321_201 VPWR VGND sg13cmos5l_fill_2
XANTENNA__3852__X Tile_X0Y5_EE4BEG[9] VPWR VGND sg13cmos5l_antennanp
XFILLER_117_197 VPWR VGND sg13cmos5l_decap_8
XFILLER_132_123 VPWR VGND sg13cmos5l_decap_4
XFILLER_182_18 VPWR VGND sg13cmos5l_decap_8
X_2669_ _2669_/Q Tile_X0Y3_FrameData[3] Tile_X0Y5_FrameStrobe[4] VPWR VGND sg13cmos5l_dlhq_1
XFILLER_59_28 VPWR VGND sg13cmos5l_decap_8
XANTENNA__1317__A1 Tile_X0Y5_W2END[2] VPWR VGND sg13cmos5l_antennanp
XFILLER_262_40 VPWR VGND sg13cmos5l_fill_2
XFILLER_75_27 VPWR VGND sg13cmos5l_fill_2
XANTENNA__3264__GATE Tile_X0Y5_FrameStrobe[6] VPWR VGND sg13cmos5l_antennanp
XFILLER_75_49 VPWR VGND sg13cmos5l_fill_1
XFILLER_46_129 VPWR VGND sg13cmos5l_decap_8
XANTENNA__2066__D Tile_X0Y1_FrameData[30] VPWR VGND sg13cmos5l_antennanp
XFILLER_131_66 VPWR VGND sg13cmos5l_decap_8
XFILLER_227_293 VPWR VGND sg13cmos5l_fill_2
XANTENNA__3279__GATE Tile_X0Y5_FrameStrobe[6] VPWR VGND sg13cmos5l_antennanp
XFILLER_131_77 VPWR VGND sg13cmos5l_fill_1
XFILLER_54_195 VPWR VGND sg13cmos5l_decap_8
XANTENNA__1253__A0 Tile_X0Y0_W2END[7] VPWR VGND sg13cmos5l_antennanp
XANTENNA__3202__GATE Tile_X0Y5_FrameStrobe[4] VPWR VGND sg13cmos5l_antennanp
XFILLER_155_215 VPWR VGND sg13cmos5l_decap_4
XFILLER_155_248 VPWR VGND sg13cmos5l_decap_8
XANTENNA__1556__A1 Tile_X0Y3_W2END[3] VPWR VGND sg13cmos5l_antennanp
XFILLER_156_63 VPWR VGND sg13cmos5l_decap_4
XANTENNA__3217__GATE Tile_X0Y5_FrameStrobe[5] VPWR VGND sg13cmos5l_antennanp
XANTENNA__3762__X Tile_X0Y4_EE4BEG[0] VPWR VGND sg13cmos5l_antennanp
XFILLER_123_123 VPWR VGND sg13cmos5l_decap_4
XANTENNA__1308__A1 Tile_X0Y1_W2END[2] VPWR VGND sg13cmos5l_antennanp
XFILLER_306_44 VPWR VGND sg13cmos5l_decap_8
XFILLER_306_55 VPWR VGND sg13cmos5l_fill_1
XANTENNA__2473__GATE Tile_X0Y5_FrameStrobe[7] VPWR VGND sg13cmos5l_antennanp
XFILLER_284_108 VPWR VGND sg13cmos5l_decap_4
XFILLER_306_99 VPWR VGND sg13cmos5l_decap_4
XFILLER_49_61 VPWR VGND sg13cmos5l_decap_8
XFILLER_37_118 VPWR VGND sg13cmos5l_decap_8
XANTENNA__0819__A0 Tile_X0Y5_WW4END[4] VPWR VGND sg13cmos5l_antennanp
XANTENNA__2488__GATE Tile_X0Y5_FrameStrobe[7] VPWR VGND sg13cmos5l_antennanp
XFILLER_292_196 VPWR VGND sg13cmos5l_decap_8
XFILLER_218_293 VPWR VGND sg13cmos5l_fill_2
XFILLER_45_140 VPWR VGND sg13cmos5l_fill_2
XFILLER_322_87 VPWR VGND sg13cmos5l_decap_8
XANTENNA__2411__GATE Tile_X0Y5_FrameStrobe[5] VPWR VGND sg13cmos5l_antennanp
XFILLER_233_285 VPWR VGND sg13cmos5l_fill_2
XANTENNA__1244__A0 AXI_M_SOC_BRESP0 VPWR VGND sg13cmos5l_antennanp
XANTENNA__2704__D Tile_X0Y3_FrameData[0] VPWR VGND sg13cmos5l_antennanp
X_3710_ Tile_X0Y3_FrameData_O[13] Tile_X0Y3_FrameData[13] VPWR VGND sg13cmos5l_buf_1
X_1971_ _1971_/Q Tile_X0Y1_FrameData[29] Tile_X0Y5_FrameStrobe[0] VPWR VGND sg13cmos5l_dlhq_1
XFILLER_267_29 VPWR VGND sg13cmos5l_fill_2
X_0922_ _0922_/X Tile_X0Y5_W6END[9] _0648_/X _3301_/Q VPWR VGND sg13cmos5l_mux2_1
X_3641_ Tile_X0Y0_E2BEG[4] _3641_/A VPWR VGND sg13cmos5l_buf_1
X_0853_ _0853_/Y Tile_X0Y5_W2END[1] _3126_/Q _3125_/Q VPWR VGND sg13cmos5l_a21oi_1
XANTENNA__2426__GATE Tile_X0Y5_FrameStrobe[5] VPWR VGND sg13cmos5l_antennanp
X_3572_ Tile_X0Y0_FrameData_O[3] Tile_X0Y0_FrameData[3] VPWR VGND sg13cmos5l_buf_1
X_2523_ _2523_/Q Tile_X0Y3_FrameData[21] Tile_X0Y5_FrameStrobe[0] VPWR VGND sg13cmos5l_dlhq_1
X_0784_ _0784_/X Tile_X0Y3_W2MID[6] Tile_X0Y3_W2END[6] Tile_X0Y3_W6END[9] _1219_/X
+ _2738_/Q _2737_/Q VPWR VGND sg13cmos5l_mux4_1
XANTENNA__3672__X Tile_X0Y3_E6BEG[3] VPWR VGND sg13cmos5l_antennanp
X_2454_ _2454_/Q Tile_X0Y2_FrameData[10] Tile_X0Y5_FrameStrobe[6] VPWR VGND sg13cmos5l_dlhq_1
XANTENNA__0770__A2 Tile_X0Y1_W6END[0] VPWR VGND sg13cmos5l_antennanp
XANTENNA__1192__X AXI_M_SOC_AWADDR19 VPWR VGND sg13cmos5l_antennanp
XFILLER_114_189 VPWR VGND sg13cmos5l_decap_8
X_2385_ _2385_/Q Tile_X0Y2_FrameData[15] Tile_X0Y5_FrameStrobe[4] VPWR VGND sg13cmos5l_dlhq_1
X_1405_ _3380_/A AXI_M_SOC_RDATA20 _1315_/X _1388_/X _1175_/X _2347_/Q _2348_/Q VPWR
+ VGND sg13cmos5l_mux4_1
XFILLER_39_0 VPWR VGND sg13cmos5l_fill_2
X_1336_ _3494_/A Tile_X0Y1_W2END[5] AXI_M_SOC_RDATA27 _1100_/X _1086_/X _2140_/Q _2139_/Q
+ VPWR VGND sg13cmos5l_mux4_1
XFILLER_232_21 VPWR VGND sg13cmos5l_fill_1
XANTENNA__3270__D Tile_X0Y5_FrameData[10] VPWR VGND sg13cmos5l_antennanp
X_1267_ _1267_/X _1156_/X _1072_/X _1071_/X _1155_/X _2536_/Q _2535_/Q VPWR VGND sg13cmos5l_mux4_1
XFILLER_83_246 VPWR VGND sg13cmos5l_decap_4
XANTENNA__1078__A3 Tile_X0Y0_S2END[4] VPWR VGND sg13cmos5l_antennanp
XFILLER_209_293 VPWR VGND sg13cmos5l_fill_2
X_3006_ _3006_/Q Tile_X0Y4_FrameData[2] Tile_X0Y5_FrameStrobe[6] VPWR VGND sg13cmos5l_dlhq_1
X_1198_ AXI_M_SOC_AWADDR10 Tile_X0Y0_WW4END[2] Tile_X0Y0_WW4END[10] Tile_X0Y0_W6END[2]
+ _1007_/X _1796_/Q _1795_/Q VPWR VGND sg13cmos5l_mux4_1
XANTENNA__1235__A0 Tile_X0Y0_WW4END[7] VPWR VGND sg13cmos5l_antennanp
XANTENNA__2614__D Tile_X0Y3_FrameData[26] VPWR VGND sg13cmos5l_antennanp
XANTENNA__3847__X Tile_X0Y5_EE4BEG[4] VPWR VGND sg13cmos5l_antennanp
XFILLER_196_148 VPWR VGND sg13cmos5l_decap_8
XFILLER_61_29 VPWR VGND sg13cmos5l_decap_8
XFILLER_51_198 VPWR VGND sg13cmos5l_fill_1
X_3908_ Tile_X0Y5_S2BEGb[5] _3908_/A VPWR VGND sg13cmos5l_buf_1
X_3839_ Tile_X0Y5_E6BEG[8] _3839_/A VPWR VGND sg13cmos5l_buf_1
XFILLER_3_217 VPWR VGND sg13cmos5l_fill_2
XANTENNA__3582__X Tile_X0Y0_FrameData_O[13] VPWR VGND sg13cmos5l_antennanp
XFILLER_105_134 VPWR VGND sg13cmos5l_fill_1
XFILLER_105_156 VPWR VGND sg13cmos5l_decap_8
XANTENNA__0761__A2 Tile_X0Y5_WW4END[10] VPWR VGND sg13cmos5l_antennanp
XFILLER_273_61 VPWR VGND sg13cmos5l_decap_8
XFILLER_19_31 VPWR VGND sg13cmos5l_fill_1
XFILLER_259_160 VPWR VGND sg13cmos5l_fill_2
XFILLER_74_213 VPWR VGND sg13cmos5l_decap_4
XANTENNA__3180__D Tile_X0Y5_FrameData[4] VPWR VGND sg13cmos5l_antennanp
XFILLER_207_219 VPWR VGND sg13cmos5l_decap_8
XANTENNA__1069__A3 Tile_X0Y0_S4END[0] VPWR VGND sg13cmos5l_antennanp
XFILLER_27_162 VPWR VGND sg13cmos5l_decap_8
XFILLER_74_268 VPWR VGND sg13cmos5l_decap_8
XANTENNA__1474__A0 Tile_X0Y2_WW4END[4] VPWR VGND sg13cmos5l_antennanp
XFILLER_42_110 VPWR VGND sg13cmos5l_decap_8
XFILLER_230_211 VPWR VGND sg13cmos5l_fill_1
XANTENNA__1226__A0 Tile_X0Y0_WW4END[11] VPWR VGND sg13cmos5l_antennanp
XANTENNA__2524__D Tile_X0Y3_FrameData[20] VPWR VGND sg13cmos5l_antennanp
XANTENNA__3141__GATE Tile_X0Y5_FrameStrobe[2] VPWR VGND sg13cmos5l_antennanp
XANTENNA__3757__X Tile_X0Y4_E6BEG[7] VPWR VGND sg13cmos5l_antennanp
XFILLER_143_0 VPWR VGND sg13cmos5l_decap_8
XFILLER_230_277 VPWR VGND sg13cmos5l_fill_1
XFILLER_310_0 VPWR VGND sg13cmos5l_fill_2
XFILLER_51_95 VPWR VGND sg13cmos5l_decap_8
XANTENNA__1529__A1 AXI_M_SOC_RDATA11 VPWR VGND sg13cmos5l_antennanp
XANTENNA__3156__GATE Tile_X0Y5_FrameStrobe[3] VPWR VGND sg13cmos5l_antennanp
XFILLER_167_84 VPWR VGND sg13cmos5l_decap_8
XANTENNA__3492__X Tile_X0Y1_E2BEGb[0] VPWR VGND sg13cmos5l_antennanp
XFILLER_183_61 VPWR VGND sg13cmos5l_decap_8
XFILLER_297_277 VPWR VGND sg13cmos5l_fill_1
X_2170_ _2170_/Q Tile_X0Y1_FrameData[22] Tile_X0Y5_FrameStrobe[6] VPWR VGND sg13cmos5l_dlhq_1
XFILLER_333_64 VPWR VGND sg13cmos5l_fill_1
XANTENNA__3090__D Tile_X0Y5_FrameData[30] VPWR VGND sg13cmos5l_antennanp
X_1121_ _1121_/X _1120_/X _0718_/X Tile_X0Y5_N4END[15] Tile_X0Y0_S4END[11] _2265_/Q
+ _2266_/Q VPWR VGND sg13cmos5l_mux4_1
X_1052_ _1052_/Y _3064_/Q Tile_X0Y5_N1END[0] VPWR VGND sg13cmos5l_nor2b_1
XANTENNA__1465__A0 Tile_X0Y2_W2END[5] VPWR VGND sg13cmos5l_antennanp
XFILLER_202_57 VPWR VGND sg13cmos5l_fill_1
XFILLER_202_68 VPWR VGND sg13cmos5l_decap_4
XANTENNA__2350__GATE Tile_X0Y5_FrameStrobe[3] VPWR VGND sg13cmos5l_antennanp
XANTENNA__2980__GATE Tile_X0Y5_FrameStrobe[6] VPWR VGND sg13cmos5l_antennanp
XFILLER_178_115 VPWR VGND sg13cmos5l_decap_8
XANTENNA__2434__D Tile_X0Y2_FrameData[30] VPWR VGND sg13cmos5l_antennanp
XANTENNA__3109__GATE Tile_X0Y5_FrameStrobe[1] VPWR VGND sg13cmos5l_antennanp
XANTENNA__3667__X Tile_X0Y3_E2BEGb[6] VPWR VGND sg13cmos5l_antennanp
XFILLER_221_233 VPWR VGND sg13cmos5l_decap_4
XFILLER_92_91 VPWR VGND sg13cmos5l_decap_8
XFILLER_33_165 VPWR VGND sg13cmos5l_decap_8
XFILLER_221_277 VPWR VGND sg13cmos5l_fill_1
X_1954_ _1954_/Q Tile_X0Y0_FrameData[30] Tile_X0Y5_FrameStrobe[8] VPWR VGND sg13cmos5l_dlhq_1
XANTENNA__2365__GATE Tile_X0Y5_FrameStrobe[3] VPWR VGND sg13cmos5l_antennanp
X_0905_ _0905_/X _1123_/X _0712_/X _0904_/Y Tile_X0Y0_S4END[7] _2017_/Q _2018_/Q VPWR
+ VGND sg13cmos5l_mux4_1
XANTENNA__2995__GATE Tile_X0Y5_FrameStrobe[6] VPWR VGND sg13cmos5l_antennanp
XFILLER_186_192 VPWR VGND sg13cmos5l_decap_8
X_3624_ Tile_X0Y0_E6BEG[7] _3624_/A VPWR VGND sg13cmos5l_buf_1
X_1885_ _1885_/Q Tile_X0Y0_FrameData[3] Tile_X0Y5_FrameStrobe[5] VPWR VGND sg13cmos5l_dlhq_1
XFILLER_335_123 VPWR VGND sg13cmos5l_decap_4
XFILLER_294_49 VPWR VGND sg13cmos5l_fill_2
X_0836_ AXI_M_SOC_RREADY Tile_X0Y5_WW4END[1] Tile_X0Y5_W6END[9] Tile_X0Y5_WW4END[9]
+ _0647_/X _3141_/Q _3142_/Q VPWR VGND sg13cmos5l_mux4_1
XANTENNA__3265__D Tile_X0Y5_FrameData[15] VPWR VGND sg13cmos5l_antennanp
X_3555_ Tile_X0Y0_FrameStrobe_O[6] Tile_X0Y5_FrameStrobe[6] VPWR VGND sg13cmos5l_buf_1
X_0767_ _0767_/X Tile_X0Y5_WW4END[1] Tile_X0Y5_W6END[1] Tile_X0Y5_WW4END[9] _0648_/X
+ _3157_/Q _3158_/Q VPWR VGND sg13cmos5l_mux4_1
XFILLER_227_76 VPWR VGND sg13cmos5l_decap_8
X_2506_ _2506_/Q Tile_X0Y2_FrameData[22] Tile_X0Y5_FrameStrobe[8] VPWR VGND sg13cmos5l_dlhq_1
X_3486_ Tile_X0Y1_E6BEG[6] _3486_/A VPWR VGND sg13cmos5l_buf_1
XFILLER_288_266 VPWR VGND sg13cmos5l_decap_4
X_2437_ _2437_/Q Tile_X0Y2_FrameData[27] Tile_X0Y5_FrameStrobe[6] VPWR VGND sg13cmos5l_dlhq_1
X_0698_ _0698_/Y _0698_/A VPWR VGND sg13cmos5l_inv_1
XFILLER_102_159 VPWR VGND sg13cmos5l_fill_1
XANTENNA__2303__GATE Tile_X0Y5_FrameStrobe[1] VPWR VGND sg13cmos5l_antennanp
XFILLER_256_141 VPWR VGND sg13cmos5l_fill_1
X_2368_ _2368_/Q Tile_X0Y2_FrameData[0] Tile_X0Y5_FrameStrobe[3] VPWR VGND sg13cmos5l_dlhq_1
XANTENNA__1650__X AXI_M_SOC_ARADDR16 VPWR VGND sg13cmos5l_antennanp
XANTENNA__2609__D Tile_X0Y3_FrameData[31] VPWR VGND sg13cmos5l_antennanp
XANTENNA__2933__GATE Tile_X0Y5_FrameStrobe[4] VPWR VGND sg13cmos5l_antennanp
X_2299_ _2299_/Q Tile_X0Y2_FrameData[5] Tile_X0Y5_FrameStrobe[1] VPWR VGND sg13cmos5l_dlhq_1
X_1319_ _1319_/X _1269_/X _0606_/X Tile_X0Y5_N2MID[4] _1270_/X _2799_/Q _2800_/Q VPWR
+ VGND sg13cmos5l_mux4_1
XFILLER_112_24 VPWR VGND sg13cmos5l_decap_8
XFILLER_271_111 VPWR VGND sg13cmos5l_decap_4
XANTENNA__1456__A0 Tile_X0Y2_W2MID[4] VPWR VGND sg13cmos5l_antennanp
XANTENNA__2318__GATE Tile_X0Y5_FrameStrobe[2] VPWR VGND sg13cmos5l_antennanp
XFILLER_271_155 VPWR VGND sg13cmos5l_fill_2
XANTENNA__2948__GATE Tile_X0Y5_FrameStrobe[5] VPWR VGND sg13cmos5l_antennanp
XFILLER_169_104 VPWR VGND sg13cmos5l_decap_8
XFILLER_24_121 VPWR VGND sg13cmos5l_fill_2
XFILLER_72_28 VPWR VGND sg13cmos5l_fill_2
XANTENNA__1208__A0 Tile_X0Y0_W1END[2] VPWR VGND sg13cmos5l_antennanp
XANTENNA__3577__X Tile_X0Y0_FrameData_O[8] VPWR VGND sg13cmos5l_antennanp
XFILLER_339_8 VPWR VGND sg13cmos5l_fill_1
XANTENNA__2344__D Tile_X0Y2_FrameData[24] VPWR VGND sg13cmos5l_antennanp
XFILLER_212_277 VPWR VGND sg13cmos5l_decap_8
XFILLER_177_192 VPWR VGND sg13cmos5l_decap_8
XFILLER_326_145 VPWR VGND sg13cmos5l_decap_4
XANTENNA__3175__D Tile_X0Y5_FrameData[9] VPWR VGND sg13cmos5l_antennanp
XFILLER_21_87 VPWR VGND sg13cmos5l_decap_8
XFILLER_137_76 VPWR VGND sg13cmos5l_fill_1
XFILLER_284_93 VPWR VGND sg13cmos5l_fill_2
XFILLER_239_108 VPWR VGND sg13cmos5l_decap_4
XFILLER_279_277 VPWR VGND sg13cmos5l_fill_1
XFILLER_294_214 VPWR VGND sg13cmos5l_decap_8
XANTENNA__1560__X AXI_M_SOC_WDATA0 VPWR VGND sg13cmos5l_antennanp
XANTENNA__1695__A0 Tile_X0Y5_W2MID[6] VPWR VGND sg13cmos5l_antennanp
XANTENNA__2519__D Tile_X0Y3_FrameData[25] VPWR VGND sg13cmos5l_antennanp
XFILLER_101_181 VPWR VGND sg13cmos5l_decap_8
XFILLER_247_196 VPWR VGND sg13cmos5l_decap_8
XANTENNA__1447__A0 Tile_X0Y2_WW4END[10] VPWR VGND sg13cmos5l_antennanp
XFILLER_260_0 VPWR VGND sg13cmos5l_fill_2
XFILLER_62_227 VPWR VGND sg13cmos5l_decap_8
XFILLER_46_95 VPWR VGND sg13cmos5l_fill_2
XANTENNA__3080__GATE Tile_X0Y5_FrameStrobe[0] VPWR VGND sg13cmos5l_antennanp
XANTENNA__3487__X Tile_X0Y1_E6BEG[7] VPWR VGND sg13cmos5l_antennanp
XANTENNA__2254__D Tile_X0Y2_FrameData[18] VPWR VGND sg13cmos5l_antennanp
XFILLER_70_293 VPWR VGND sg13cmos5l_fill_2
XFILLER_70_282 VPWR VGND sg13cmos5l_fill_2
XFILLER_30_179 VPWR VGND sg13cmos5l_decap_8
XFILLER_7_12 VPWR VGND sg13cmos5l_decap_4
XANTENNA__3095__GATE Tile_X0Y5_FrameStrobe[1] VPWR VGND sg13cmos5l_antennanp
X_1670_ _3735_/A Tile_X0Y4_W2MID[6] AXI_M_SOC_RRESP1 _1049_/X _1360_/X _2974_/Q _2973_/Q
+ VPWR VGND sg13cmos5l_mux4_1
XFILLER_7_78 VPWR VGND sg13cmos5l_fill_1
XANTENNA__0973__A2 Tile_X0Y5_W6END[11] VPWR VGND sg13cmos5l_antennanp
XANTENNA__3085__D Tile_X0Y5_FrameData[3] VPWR VGND sg13cmos5l_antennanp
X_0621_ _0621_/Y _1973_/Q _0621_/B _0621_/C VPWR VGND sg13cmos5l_nor3_1
X_3340_ _3340_/Q Tile_X0Y5_FrameData[6] Tile_X0Y5_FrameStrobe[8] VPWR VGND sg13cmos5l_dlhq_1
X_0552_ _0552_/Y _1121_/X VPWR VGND sg13cmos5l_inv_1
X_3271_ _3271_/Q Tile_X0Y5_FrameData[9] Tile_X0Y5_FrameStrobe[6] VPWR VGND sg13cmos5l_dlhq_1
X_2222_ _2222_/Q Tile_X0Y1_FrameData[2] Tile_X0Y5_FrameStrobe[7] VPWR VGND sg13cmos5l_dlhq_1
XFILLER_38_202 VPWR VGND sg13cmos5l_fill_2
XANTENNA__2429__D Tile_X0Y2_FrameData[3] VPWR VGND sg13cmos5l_antennanp
XANTENNA__3033__GATE Tile_X0Y5_FrameStrobe[7] VPWR VGND sg13cmos5l_antennanp
X_2153_ _2153_/Q Tile_X0Y1_FrameData[7] Tile_X0Y5_FrameStrobe[5] VPWR VGND sg13cmos5l_dlhq_1
XANTENNA__1150__A2 Tile_X0Y4_W6END[5] VPWR VGND sg13cmos5l_antennanp
X_1104_ _1104_/X Tile_X0Y0_W2MID[6] Tile_X0Y0_W2END[6] Tile_X0Y0_W6END[9] _1140_/X
+ _1922_/Q _1921_/Q VPWR VGND sg13cmos5l_mux4_1
XANTENNA__1438__A0 Tile_X0Y2_W1END[1] VPWR VGND sg13cmos5l_antennanp
X_2084_ _2084_/Q Tile_X0Y1_FrameData[12] Tile_X0Y5_FrameStrobe[3] VPWR VGND sg13cmos5l_dlhq_1
XFILLER_53_227 VPWR VGND sg13cmos5l_decap_4
XANTENNA__3048__GATE Tile_X0Y5_FrameStrobe[8] VPWR VGND sg13cmos5l_antennanp
X_1035_ _1035_/Y _3028_/Q _1033_/Y _1034_/Y VPWR VGND sg13cmos5l_a21oi_1
XANTENNA__2164__D Tile_X0Y1_FrameData[28] VPWR VGND sg13cmos5l_antennanp
XANTENNA__3397__X Tile_X0Y2_EE4BEG[15] VPWR VGND sg13cmos5l_antennanp
XFILLER_21_124 VPWR VGND sg13cmos5l_fill_2
XFILLER_61_293 VPWR VGND sg13cmos5l_fill_2
XFILLER_166_129 VPWR VGND sg13cmos5l_decap_4
X_2986_ _2986_/Q Tile_X0Y4_FrameData[22] Tile_X0Y5_FrameStrobe[6] VPWR VGND sg13cmos5l_dlhq_1
XANTENNA__1610__A0 Tile_X0Y4_WW4END[7] VPWR VGND sg13cmos5l_antennanp
X_1937_ _1937_/Q Tile_X0Y0_FrameData[15] Tile_X0Y5_FrameStrobe[7] VPWR VGND sg13cmos5l_dlhq_1
XFILLER_238_64 VPWR VGND sg13cmos5l_fill_2
XFILLER_308_167 VPWR VGND sg13cmos5l_decap_8
X_1868_ _1868_/Q Tile_X0Y0_FrameData[20] Tile_X0Y5_FrameStrobe[5] VPWR VGND sg13cmos5l_dlhq_1
XFILLER_174_19 VPWR VGND sg13cmos5l_decap_8
X_3607_ Tile_X0Y0_EE4BEG[6] _3607_/A VPWR VGND sg13cmos5l_buf_1
X_0819_ _3854_/A Tile_X0Y5_WW4END[4] _0778_/X _0597_/X _0607_/X _3194_/Q _3193_/Q
+ VPWR VGND sg13cmos5l_mux4_1
XANTENNA__1645__X AXI_M_SOC_ARADDR23 VPWR VGND sg13cmos5l_antennanp
XANTENNA__3573__A Tile_X0Y0_FrameData[4] VPWR VGND sg13cmos5l_antennanp
X_3538_ Tile_X0Y0_N2BEG[1] _3538_/A VPWR VGND sg13cmos5l_buf_1
X_1799_ _1799_/Q Tile_X0Y0_FrameData[25] Tile_X0Y5_FrameStrobe[3] VPWR VGND sg13cmos5l_dlhq_1
XANTENNA__2242__GATE Tile_X0Y5_FrameStrobe[0] VPWR VGND sg13cmos5l_antennanp
XANTENNA__3860__X Tile_X0Y5_FrameData_O[1] VPWR VGND sg13cmos5l_antennanp
XFILLER_130_221 VPWR VGND sg13cmos5l_decap_8
XFILLER_130_232 VPWR VGND sg13cmos5l_decap_4
XFILLER_276_214 VPWR VGND sg13cmos5l_decap_8
XFILLER_276_225 VPWR VGND sg13cmos5l_fill_2
X_3469_ Tile_X0Y1_EE4BEG[5] _3469_/A VPWR VGND sg13cmos5l_buf_1
XFILLER_88_146 VPWR VGND sg13cmos5l_decap_8
XANTENNA__2872__GATE Tile_X0Y5_FrameStrobe[2] VPWR VGND sg13cmos5l_antennanp
XFILLER_191_8 VPWR VGND sg13cmos5l_decap_8
XANTENNA__1677__A0 Tile_X0Y4_W2END[5] VPWR VGND sg13cmos5l_antennanp
XANTENNA__2339__D Tile_X0Y2_FrameData[29] VPWR VGND sg13cmos5l_antennanp
XFILLER_123_34 VPWR VGND sg13cmos5l_fill_1
XFILLER_96_190 VPWR VGND sg13cmos5l_fill_1
XANTENNA__1141__A2 Tile_X0Y1_W6END[9] VPWR VGND sg13cmos5l_antennanp
XANTENNA__2257__GATE Tile_X0Y5_FrameStrobe[0] VPWR VGND sg13cmos5l_antennanp
XFILLER_270_62 VPWR VGND sg13cmos5l_decap_4
XANTENNA__1429__A0 Tile_X0Y2_W2MID[5] VPWR VGND sg13cmos5l_antennanp
XANTENNA__2887__GATE Tile_X0Y5_FrameStrobe[3] VPWR VGND sg13cmos5l_antennanp
XFILLER_83_49 VPWR VGND sg13cmos5l_decap_8
XFILLER_44_227 VPWR VGND sg13cmos5l_fill_1
XANTENNA__0652__A1 Tile_X0Y5_WW4END[13] VPWR VGND sg13cmos5l_antennanp
XANTENNA__2074__D Tile_X0Y1_FrameData[22] VPWR VGND sg13cmos5l_antennanp
XANTENNA__2810__GATE Tile_X0Y5_FrameStrobe[0] VPWR VGND sg13cmos5l_antennanp
XFILLER_12_135 VPWR VGND sg13cmos5l_decap_8
XFILLER_197_254 VPWR VGND sg13cmos5l_fill_2
XFILLER_279_93 VPWR VGND sg13cmos5l_fill_2
XFILLER_52_293 VPWR VGND sg13cmos5l_fill_2
XANTENNA__2802__D Tile_X0Y4_FrameData[14] VPWR VGND sg13cmos5l_antennanp
XFILLER_8_139 VPWR VGND sg13cmos5l_decap_8
XFILLER_32_64 VPWR VGND sg13cmos5l_decap_8
XANTENNA__1052__B_N Tile_X0Y5_N1END[0] VPWR VGND sg13cmos5l_antennanp
XFILLER_32_75 VPWR VGND sg13cmos5l_fill_2
XANTENNA__2825__GATE Tile_X0Y5_FrameStrobe[1] VPWR VGND sg13cmos5l_antennanp
XANTENNA__1555__X AXI_M_SOC_WDATA4 VPWR VGND sg13cmos5l_antennanp
XFILLER_106_0 VPWR VGND sg13cmos5l_fill_2
XFILLER_180_154 VPWR VGND sg13cmos5l_fill_1
XFILLER_164_30 VPWR VGND sg13cmos5l_fill_2
XFILLER_180_176 VPWR VGND sg13cmos5l_decap_8
XFILLER_79_102 VPWR VGND sg13cmos5l_fill_1
XANTENNA__3770__X Tile_X0Y4_EE4BEG[8] VPWR VGND sg13cmos5l_antennanp
XANTENNA__1380__A2 Tile_X0Y5_N4END[14] VPWR VGND sg13cmos5l_antennanp
XANTENNA__2249__D Tile_X0Y2_FrameData[23] VPWR VGND sg13cmos5l_antennanp
XFILLER_94_138 VPWR VGND sg13cmos5l_decap_8
XFILLER_180_73 VPWR VGND sg13cmos5l_decap_8
XFILLER_250_114 VPWR VGND sg13cmos5l_decap_4
XFILLER_188_210 VPWR VGND sg13cmos5l_decap_8
XFILLER_250_136 VPWR VGND sg13cmos5l_decap_8
XANTENNA__1435__A3 Tile_X0Y0_S4END[15] VPWR VGND sg13cmos5l_antennanp
X_2840_ _2840_/Q Tile_X0Y4_FrameData[8] Tile_X0Y5_FrameStrobe[1] VPWR VGND sg13cmos5l_dlhq_1
XFILLER_188_276 VPWR VGND sg13cmos5l_fill_2
XFILLER_337_218 VPWR VGND sg13cmos5l_fill_2
XANTENNA__1199__A2 Tile_X0Y0_W6END[10] VPWR VGND sg13cmos5l_antennanp
X_2771_ _2771_/Q Tile_X0Y3_FrameData[29] Tile_X0Y5_FrameStrobe[8] VPWR VGND sg13cmos5l_dlhq_1
XANTENNA__2712__D Tile_X0Y3_FrameData[24] VPWR VGND sg13cmos5l_antennanp
XFILLER_156_151 VPWR VGND sg13cmos5l_decap_8
X_1722_ _1722_/Q Tile_X0Y0_FrameData[6] Tile_X0Y5_FrameStrobe[0] VPWR VGND sg13cmos5l_dlhq_1
X_1653_ AXI_M_SOC_ARADDR13 Tile_X0Y4_W1END[1] Tile_X0Y4_WW4END[5] Tile_X0Y4_WW4END[13]
+ _1046_/X _2862_/Q _2861_/Q VPWR VGND sg13cmos5l_mux4_1
XFILLER_171_154 VPWR VGND sg13cmos5l_decap_8
X_0604_ _0604_/Y _0531_/Y _0603_/X _3266_/Q VPWR VGND sg13cmos5l_a21oi_1
X_1584_ _1584_/Y _2751_/Q _0971_/X _2750_/Q VPWR VGND sg13cmos5l_a21oi_1
XANTENNA__3680__X Tile_X0Y3_E6BEG[11] VPWR VGND sg13cmos5l_antennanp
XFILLER_112_243 VPWR VGND sg13cmos5l_decap_8
X_3323_ _3323_/Q Tile_X0Y5_FrameData[21] Tile_X0Y5_FrameStrobe[8] VPWR VGND sg13cmos5l_dlhq_1
X_0535_ _0535_/Y _3259_/Q VPWR VGND sg13cmos5l_inv_1
XANTENNA__1371__A2 Tile_X0Y5_N4END[15] VPWR VGND sg13cmos5l_antennanp
XFILLER_21_0 VPWR VGND sg13cmos5l_fill_2
X_3254_ _3254_/Q Tile_X0Y5_FrameData[26] Tile_X0Y5_FrameStrobe[6] VPWR VGND sg13cmos5l_dlhq_1
XFILLER_85_116 VPWR VGND sg13cmos5l_decap_8
XANTENNA__1659__A0 Tile_X0Y4_W2END[7] VPWR VGND sg13cmos5l_antennanp
XANTENNA__2159__D Tile_X0Y1_FrameData[1] VPWR VGND sg13cmos5l_antennanp
X_2205_ _2205_/Q Tile_X0Y1_FrameData[19] Tile_X0Y5_FrameStrobe[7] VPWR VGND sg13cmos5l_dlhq_1
X_3185_ _3185_/Q Tile_X0Y5_FrameData[31] Tile_X0Y5_FrameStrobe[4] VPWR VGND sg13cmos5l_dlhq_1
XANTENNA__1998__D Tile_X0Y1_FrameData[2] VPWR VGND sg13cmos5l_antennanp
X_2136_ _2136_/Q Tile_X0Y1_FrameData[24] Tile_X0Y5_FrameStrobe[5] VPWR VGND sg13cmos5l_dlhq_1
XFILLER_226_188 VPWR VGND sg13cmos5l_decap_8
X_2067_ _2067_/Q Tile_X0Y1_FrameData[29] Tile_X0Y5_FrameStrobe[3] VPWR VGND sg13cmos5l_dlhq_1
XFILLER_179_221 VPWR VGND sg13cmos5l_decap_8
X_1018_ _1018_/X Tile_X0Y3_W1END[1] Tile_X0Y3_W6END[5] _0885_/X _0634_/X _2782_/Q
+ _2781_/Q VPWR VGND sg13cmos5l_mux4_1
XANTENNA__3568__A Tile_X0Y5_FrameStrobe[19] VPWR VGND sg13cmos5l_antennanp
XFILLER_194_213 VPWR VGND sg13cmos5l_decap_8
XANTENNA__3855__X Tile_X0Y5_EE4BEG[12] VPWR VGND sg13cmos5l_antennanp
X_2969_ _2969_/Q Tile_X0Y4_FrameData[7] Tile_X0Y5_FrameStrobe[5] VPWR VGND sg13cmos5l_dlhq_1
XANTENNA__2622__D Tile_X0Y3_FrameData[18] VPWR VGND sg13cmos5l_antennanp
XFILLER_336_273 VPWR VGND sg13cmos5l_fill_2
XFILLER_162_143 VPWR VGND sg13cmos5l_decap_8
XANTENNA__0720__A Tile_X0Y2_W6END[3] VPWR VGND sg13cmos5l_antennanp
XANTENNA__2181__GATE Tile_X0Y5_FrameStrobe[6] VPWR VGND sg13cmos5l_antennanp
XFILLER_162_187 VPWR VGND sg13cmos5l_fill_2
XANTENNA__3590__X Tile_X0Y0_FrameData_O[21] VPWR VGND sg13cmos5l_antennanp
XFILLER_311_129 VPWR VGND sg13cmos5l_decap_8
XANTENNA__1362__A2 Tile_X0Y2_WW4END[12] VPWR VGND sg13cmos5l_antennanp
XANTENNA__2069__D Tile_X0Y1_FrameData[27] VPWR VGND sg13cmos5l_antennanp
XFILLER_94_15 VPWR VGND sg13cmos5l_fill_2
XFILLER_76_149 VPWR VGND sg13cmos5l_fill_1
XANTENNA__1114__A2 Tile_X0Y0_W2END[0] VPWR VGND sg13cmos5l_antennanp
XANTENNA__2196__GATE Tile_X0Y5_FrameStrobe[7] VPWR VGND sg13cmos5l_antennanp
XFILLER_91_119 VPWR VGND sg13cmos5l_decap_8
XANTENNA__1701__D Tile_X0Y0_FrameData[27] VPWR VGND sg13cmos5l_antennanp
XFILLER_17_249 VPWR VGND sg13cmos5l_fill_1
XFILLER_272_272 VPWR VGND sg13cmos5l_fill_1
XFILLER_32_208 VPWR VGND sg13cmos5l_fill_1
XFILLER_25_293 VPWR VGND sg13cmos5l_fill_2
XFILLER_159_30 VPWR VGND sg13cmos5l_decap_8
XFILLER_40_252 VPWR VGND sg13cmos5l_fill_2
XANTENNA__0614__B Tile_X0Y0_S1END[1] VPWR VGND sg13cmos5l_antennanp
XANTENNA__2134__GATE Tile_X0Y5_FrameStrobe[5] VPWR VGND sg13cmos5l_antennanp
XFILLER_185_246 VPWR VGND sg13cmos5l_decap_8
XFILLER_319_229 VPWR VGND sg13cmos5l_fill_1
XANTENNA__2532__D Tile_X0Y3_FrameData[12] VPWR VGND sg13cmos5l_antennanp
XANTENNA__2764__GATE Tile_X0Y5_FrameStrobe[7] VPWR VGND sg13cmos5l_antennanp
XANTENNA__3765__X Tile_X0Y4_EE4BEG[3] VPWR VGND sg13cmos5l_antennanp
XANTENNA__0928__A2 Tile_X0Y1_W6END[5] VPWR VGND sg13cmos5l_antennanp
XANTENNA__1050__A1 Tile_X0Y4_W6END[4] VPWR VGND sg13cmos5l_antennanp
XFILLER_4_142 VPWR VGND sg13cmos5l_fill_2
XANTENNA__2149__GATE Tile_X0Y5_FrameStrobe[5] VPWR VGND sg13cmos5l_antennanp
XFILLER_175_95 VPWR VGND sg13cmos5l_decap_8
XANTENNA__2779__GATE Tile_X0Y5_FrameStrobe[8] VPWR VGND sg13cmos5l_antennanp
XFILLER_325_54 VPWR VGND sg13cmos5l_fill_2
XANTENNA__0561__A0 Tile_X0Y4_W1END[3] VPWR VGND sg13cmos5l_antennanp
XANTENNA__1353__A2 Tile_X0Y1_WW4END[1] VPWR VGND sg13cmos5l_antennanp
XFILLER_67_105 VPWR VGND sg13cmos5l_fill_1
XFILLER_4_79 VPWR VGND sg13cmos5l_fill_1
XFILLER_325_65 VPWR VGND sg13cmos5l_fill_1
XFILLER_68_82 VPWR VGND sg13cmos5l_decap_8
XANTENNA__2702__GATE Tile_X0Y5_FrameStrobe[5] VPWR VGND sg13cmos5l_antennanp
XFILLER_255_228 VPWR VGND sg13cmos5l_fill_1
XFILLER_310_195 VPWR VGND sg13cmos5l_fill_2
XFILLER_75_171 VPWR VGND sg13cmos5l_decap_8
XANTENNA__2707__D Tile_X0Y3_FrameData[29] VPWR VGND sg13cmos5l_antennanp
XANTENNA__2717__GATE Tile_X0Y5_FrameStrobe[6] VPWR VGND sg13cmos5l_antennanp
XFILLER_16_293 VPWR VGND sg13cmos5l_fill_2
XANTENNA__1973__GATE Tile_X0Y5_FrameStrobe[0] VPWR VGND sg13cmos5l_antennanp
XFILLER_231_180 VPWR VGND sg13cmos5l_fill_1
X_3872_ Tile_X0Y5_FrameData_O[13] Tile_X0Y5_FrameData[13] VPWR VGND sg13cmos5l_buf_1
X_2823_ _2823_/Q Tile_X0Y4_FrameData[25] Tile_X0Y5_FrameStrobe[1] VPWR VGND sg13cmos5l_dlhq_1
XANTENNA__2442__D Tile_X0Y2_FrameData[22] VPWR VGND sg13cmos5l_antennanp
XANTENNA__3675__X Tile_X0Y3_E6BEG[6] VPWR VGND sg13cmos5l_antennanp
XFILLER_176_268 VPWR VGND sg13cmos5l_decap_8
XFILLER_219_33 VPWR VGND sg13cmos5l_fill_2
X_2754_ _2754_/Q Tile_X0Y3_FrameData[14] Tile_X0Y5_FrameStrobe[7] VPWR VGND sg13cmos5l_dlhq_1
XFILLER_318_251 VPWR VGND sg13cmos5l_decap_8
X_1705_ _1705_/Q Tile_X0Y0_FrameData[23] Tile_X0Y5_FrameStrobe[0] VPWR VGND sg13cmos5l_dlhq_1
XFILLER_69_0 VPWR VGND sg13cmos5l_decap_8
XANTENNA__1195__X AXI_M_SOC_AWADDR13 VPWR VGND sg13cmos5l_antennanp
XANTENNA__1988__GATE Tile_X0Y5_FrameStrobe[0] VPWR VGND sg13cmos5l_antennanp
X_2685_ _2685_/Q Tile_X0Y3_FrameData[19] Tile_X0Y5_FrameStrobe[5] VPWR VGND sg13cmos5l_dlhq_1
XANTENNA__0540__A Tile_X0Y0_S1END[3] VPWR VGND sg13cmos5l_antennanp
X_1636_ AXI_M_SOC_ARADDR8 Tile_X0Y4_WW4END[0] Tile_X0Y4_W6END[8] Tile_X0Y4_WW4END[8]
+ _1063_/X _2871_/Q _2872_/Q VPWR VGND sg13cmos5l_mux4_1
XANTENNA__3273__D Tile_X0Y5_FrameData[7] VPWR VGND sg13cmos5l_antennanp
X_1567_ _1567_/Y _2721_/Q _0554_/Y _2720_/Q VPWR VGND sg13cmos5l_o21ai_1
XANTENNA__1344__A2 Tile_X0Y1_WW4END[0] VPWR VGND sg13cmos5l_antennanp
XANTENNA__1911__GATE Tile_X0Y5_FrameStrobe[6] VPWR VGND sg13cmos5l_antennanp
XFILLER_301_151 VPWR VGND sg13cmos5l_decap_8
X_3306_ _3306_/Q Tile_X0Y5_FrameData[6] Tile_X0Y5_FrameStrobe[7] VPWR VGND sg13cmos5l_dlhq_1
X_1498_ _3654_/A Tile_X0Y3_W2MID[6] AXI_M_SOC_RDATA7 _1219_/X _1348_/X _2702_/Q _2701_/Q
+ VPWR VGND sg13cmos5l_mux4_1
XFILLER_100_246 VPWR VGND sg13cmos5l_fill_2
XFILLER_104_25 VPWR VGND sg13cmos5l_decap_4
X_3237_ _3237_/Q Tile_X0Y5_FrameData[11] Tile_X0Y5_FrameStrobe[5] VPWR VGND sg13cmos5l_dlhq_1
XFILLER_73_108 VPWR VGND sg13cmos5l_fill_1
XANTENNA__1926__GATE Tile_X0Y5_FrameStrobe[7] VPWR VGND sg13cmos5l_antennanp
X_3168_ _3168_/Q Tile_X0Y5_FrameData[16] Tile_X0Y5_FrameStrobe[3] VPWR VGND sg13cmos5l_dlhq_1
XANTENNA__0855__A1 Tile_X0Y5_W2END[2] VPWR VGND sg13cmos5l_antennanp
XANTENNA__2617__D Tile_X0Y3_FrameData[23] VPWR VGND sg13cmos5l_antennanp
X_2119_ _2119_/Q Tile_X0Y1_FrameData[9] Tile_X0Y5_FrameStrobe[4] VPWR VGND sg13cmos5l_dlhq_1
XFILLER_64_29 VPWR VGND sg13cmos5l_decap_8
XFILLER_214_136 VPWR VGND sg13cmos5l_decap_8
XFILLER_254_294 VPWR VGND sg13cmos5l_fill_1
X_3099_ _3099_/Q Tile_X0Y5_FrameData[21] Tile_X0Y5_FrameStrobe[1] VPWR VGND sg13cmos5l_dlhq_1
XFILLER_120_57 VPWR VGND sg13cmos5l_fill_2
XANTENNA__0607__A1 Tile_X0Y5_N2END[4] VPWR VGND sg13cmos5l_antennanp
XFILLER_22_241 VPWR VGND sg13cmos5l_decap_8
XFILLER_80_28 VPWR VGND sg13cmos5l_decap_8
XANTENNA__1280__A1 AXI_M_SOC_RDATA24 VPWR VGND sg13cmos5l_antennanp
XANTENNA__2352__D Tile_X0Y2_FrameData[16] VPWR VGND sg13cmos5l_antennanp
XANTENNA__3585__X Tile_X0Y0_FrameData_O[16] VPWR VGND sg13cmos5l_antennanp
XFILLER_13_55 VPWR VGND sg13cmos5l_fill_1
XFILLER_13_66 VPWR VGND sg13cmos5l_fill_2
XFILLER_167_279 VPWR VGND sg13cmos5l_fill_2
XFILLER_276_61 VPWR VGND sg13cmos5l_fill_2
XFILLER_89_15 VPWR VGND sg13cmos5l_decap_8
XFILLER_324_210 VPWR VGND sg13cmos5l_fill_2
XFILLER_276_83 VPWR VGND sg13cmos5l_fill_2
XANTENNA__0791__A0 Tile_X0Y5_W2MID[5] VPWR VGND sg13cmos5l_antennanp
XFILLER_135_165 VPWR VGND sg13cmos5l_decap_8
XFILLER_324_276 VPWR VGND sg13cmos5l_fill_2
XANTENNA__3183__D Tile_X0Y5_FrameData[1] VPWR VGND sg13cmos5l_antennanp
XFILLER_150_146 VPWR VGND sg13cmos5l_fill_2
XFILLER_190_293 VPWR VGND sg13cmos5l_fill_2
XFILLER_237_228 VPWR VGND sg13cmos5l_decap_4
XANTENNA__1099__A1 Tile_X0Y0_W2END[5] VPWR VGND sg13cmos5l_antennanp
XFILLER_38_74 VPWR VGND sg13cmos5l_fill_1
XANTENNA__0846__A1 Tile_X0Y5_WW4END[15] VPWR VGND sg13cmos5l_antennanp
XANTENNA__2527__D Tile_X0Y3_FrameData[17] VPWR VGND sg13cmos5l_antennanp
XFILLER_173_0 VPWR VGND sg13cmos5l_fill_1
XFILLER_245_250 VPWR VGND sg13cmos5l_fill_2
XFILLER_245_272 VPWR VGND sg13cmos5l_decap_4
XFILLER_245_294 VPWR VGND sg13cmos5l_fill_1
XFILLER_205_169 VPWR VGND sg13cmos5l_fill_1
XFILLER_260_253 VPWR VGND sg13cmos5l_decap_4
XANTENNA__0625__A Tile_X0Y2_W6END[1] VPWR VGND sg13cmos5l_antennanp
XANTENNA__2073__GATE Tile_X0Y5_FrameStrobe[3] VPWR VGND sg13cmos5l_antennanp
XFILLER_9_201 VPWR VGND sg13cmos5l_decap_8
XANTENNA__2262__D Tile_X0Y2_FrameData[10] VPWR VGND sg13cmos5l_antennanp
XANTENNA__3495__X Tile_X0Y1_E2BEGb[3] VPWR VGND sg13cmos5l_antennanp
XFILLER_70_94 VPWR VGND sg13cmos5l_decap_4
XANTENNA__2088__GATE Tile_X0Y5_FrameStrobe[3] VPWR VGND sg13cmos5l_antennanp
XFILLER_126_132 VPWR VGND sg13cmos5l_fill_2
XFILLER_62_7 VPWR VGND sg13cmos5l_decap_8
XFILLER_315_243 VPWR VGND sg13cmos5l_decap_4
XFILLER_315_221 VPWR VGND sg13cmos5l_fill_1
XANTENNA__0782__A0 Tile_X0Y5_N2MID[0] VPWR VGND sg13cmos5l_antennanp
X_2470_ _2470_/Q Tile_X0Y2_FrameData[26] Tile_X0Y5_FrameStrobe[7] VPWR VGND sg13cmos5l_dlhq_1
XANTENNA__3093__D Tile_X0Y5_FrameData[27] VPWR VGND sg13cmos5l_antennanp
XFILLER_126_198 VPWR VGND sg13cmos5l_decap_8
XFILLER_181_293 VPWR VGND sg13cmos5l_fill_2
X_1421_ AXI_M_SOC_WDATA16 Tile_X0Y2_WW4END[0] Tile_X0Y2_WW4END[8] Tile_X0Y2_W6END[8]
+ _1355_/X _2328_/Q _2327_/Q VPWR VGND sg13cmos5l_mux4_1
XFILLER_79_70 VPWR VGND sg13cmos5l_decap_8
XANTENNA__1326__A2 Tile_X0Y1_WW4END[2] VPWR VGND sg13cmos5l_antennanp
XANTENNA__2011__GATE Tile_X0Y5_FrameStrobe[1] VPWR VGND sg13cmos5l_antennanp
XANTENNA__2641__GATE Tile_X0Y5_FrameStrobe[4] VPWR VGND sg13cmos5l_antennanp
X_1352_ _1352_/X Tile_X0Y1_W6END[9] _0962_/X _1218_/X _1105_/X _2211_/Q _2213_/Q VPWR
+ VGND sg13cmos5l_mux4_1
XFILLER_228_239 VPWR VGND sg13cmos5l_decap_8
X_1283_ _3480_/A _0918_/Y _0956_/X Tile_X0Y0_S4END[4] _0968_/X _2095_/Q _2096_/Q VPWR
+ VGND sg13cmos5l_mux4_1
XANTENNA__2026__GATE Tile_X0Y5_FrameStrobe[1] VPWR VGND sg13cmos5l_antennanp
X_3022_ _3022_/Q Tile_X0Y4_FrameData[18] Tile_X0Y5_FrameStrobe[7] VPWR VGND sg13cmos5l_dlhq_1
XFILLER_95_91 VPWR VGND sg13cmos5l_decap_8
XFILLER_55_119 VPWR VGND sg13cmos5l_decap_4
XANTENNA__0837__A1 Tile_X0Y5_W6END[10] VPWR VGND sg13cmos5l_antennanp
XANTENNA__2437__D Tile_X0Y2_FrameData[27] VPWR VGND sg13cmos5l_antennanp
XANTENNA__2656__GATE Tile_X0Y5_FrameStrobe[4] VPWR VGND sg13cmos5l_antennanp
XFILLER_48_182 VPWR VGND sg13cmos5l_decap_8
XFILLER_63_174 VPWR VGND sg13cmos5l_decap_4
X_3924_ Tile_X0Y5_S4BEG[13] _3924_/A VPWR VGND sg13cmos5l_buf_1
XANTENNA__1262__A1 AXI_M_SOC_BRESP0 VPWR VGND sg13cmos5l_antennanp
XANTENNA__2172__D Tile_X0Y1_FrameData[20] VPWR VGND sg13cmos5l_antennanp
XANTENNA__3268__D Tile_X0Y5_FrameData[12] VPWR VGND sg13cmos5l_antennanp
X_3855_ Tile_X0Y5_EE4BEG[12] _3855_/A VPWR VGND sg13cmos5l_buf_1
X_2806_ _2806_/Q Tile_X0Y4_FrameData[10] Tile_X0Y5_FrameStrobe[0] VPWR VGND sg13cmos5l_dlhq_1
X_3786_ Tile_X0Y4_FrameData_O[8] Tile_X0Y4_FrameData[8] VPWR VGND sg13cmos5l_buf_1
X_0998_ _0998_/X _1011_/X _1012_/X _3026_/Q VPWR VGND sg13cmos5l_mux2_1
XANTENNA__1014__A1 Tile_X0Y2_W2END[5] VPWR VGND sg13cmos5l_antennanp
X_2737_ _2737_/Q Tile_X0Y3_FrameData[31] Tile_X0Y5_FrameStrobe[7] VPWR VGND sg13cmos5l_dlhq_1
XANTENNA__1565__A2 Tile_X0Y3_W6END[5] VPWR VGND sg13cmos5l_antennanp
XANTENNA__2900__D Tile_X0Y4_FrameData[12] VPWR VGND sg13cmos5l_antennanp
X_2668_ _2668_/Q Tile_X0Y3_FrameData[4] Tile_X0Y5_FrameStrobe[4] VPWR VGND sg13cmos5l_dlhq_1
XANTENNA__1850__GATE Tile_X0Y5_FrameStrobe[4] VPWR VGND sg13cmos5l_antennanp
XFILLER_172_293 VPWR VGND sg13cmos5l_fill_2
XFILLER_278_106 VPWR VGND sg13cmos5l_fill_2
X_1619_ _3777_/A Tile_X0Y4_WW4END[0] AXI_M_SOC_RRESP0 _1065_/X _1073_/X _2914_/Q _2913_/Q
+ VPWR VGND sg13cmos5l_mux4_1
XANTENNA__1317__A2 Tile_X0Y5_W6END[2] VPWR VGND sg13cmos5l_antennanp
XANTENNA__1653__X AXI_M_SOC_ARADDR13 VPWR VGND sg13cmos5l_antennanp
XANTENNA__2609__GATE Tile_X0Y5_FrameStrobe[3] VPWR VGND sg13cmos5l_antennanp
XANTENNA__3581__A Tile_X0Y0_FrameData[12] VPWR VGND sg13cmos5l_antennanp
XFILLER_132_168 VPWR VGND sg13cmos5l_fill_1
XFILLER_132_179 VPWR VGND sg13cmos5l_decap_8
X_2599_ _2599_/Q Tile_X0Y3_FrameData[9] Tile_X0Y5_FrameStrobe[2] VPWR VGND sg13cmos5l_dlhq_1
XFILLER_219_206 VPWR VGND sg13cmos5l_fill_1
XFILLER_115_79 VPWR VGND sg13cmos5l_decap_4
XFILLER_86_255 VPWR VGND sg13cmos5l_fill_1
XANTENNA__1865__GATE Tile_X0Y5_FrameStrobe[5] VPWR VGND sg13cmos5l_antennanp
XFILLER_86_277 VPWR VGND sg13cmos5l_decap_4
XFILLER_46_119 VPWR VGND sg13cmos5l_decap_4
XFILLER_39_160 VPWR VGND sg13cmos5l_decap_8
XANTENNA__2347__D Tile_X0Y2_FrameData[21] VPWR VGND sg13cmos5l_antennanp
XFILLER_227_261 VPWR VGND sg13cmos5l_fill_1
XFILLER_91_38 VPWR VGND sg13cmos5l_decap_8
XFILLER_24_32 VPWR VGND sg13cmos5l_decap_8
XANTENNA__1253__A1 AXI_M_SOC_AWREADY VPWR VGND sg13cmos5l_antennanp
XFILLER_10_200 VPWR VGND sg13cmos5l_fill_1
XANTENNA__1803__GATE Tile_X0Y5_FrameStrobe[3] VPWR VGND sg13cmos5l_antennanp
XANTENNA__2082__D Tile_X0Y1_FrameData[14] VPWR VGND sg13cmos5l_antennanp
XANTENNA__3178__D Tile_X0Y5_FrameData[6] VPWR VGND sg13cmos5l_antennanp
XFILLER_24_98 VPWR VGND sg13cmos5l_decap_4
XFILLER_10_277 VPWR VGND sg13cmos5l_decap_4
XFILLER_6_237 VPWR VGND sg13cmos5l_fill_2
XANTENNA__0764__A0 Tile_X0Y1_WW4END[1] VPWR VGND sg13cmos5l_antennanp
XANTENNA__1556__A2 Tile_X0Y3_W6END[3] VPWR VGND sg13cmos5l_antennanp
XANTENNA__2810__D Tile_X0Y4_FrameData[6] VPWR VGND sg13cmos5l_antennanp
XFILLER_108_154 VPWR VGND sg13cmos5l_fill_1
XFILLER_108_176 VPWR VGND sg13cmos5l_fill_1
XFILLER_156_42 VPWR VGND sg13cmos5l_decap_8
XFILLER_40_75 VPWR VGND sg13cmos5l_decap_8
XANTENNA__1818__GATE Tile_X0Y5_FrameStrobe[3] VPWR VGND sg13cmos5l_antennanp
XFILLER_108_198 VPWR VGND sg13cmos5l_decap_8
XANTENNA__1308__A2 Tile_X0Y1_W6END[2] VPWR VGND sg13cmos5l_antennanp
XANTENNA__1563__X AXI_M_SOC_WDATA6 VPWR VGND sg13cmos5l_antennanp
XFILLER_172_30 VPWR VGND sg13cmos5l_fill_2
XFILLER_277_150 VPWR VGND sg13cmos5l_decap_8
XFILLER_290_0 VPWR VGND sg13cmos5l_fill_2
XFILLER_312_279 VPWR VGND sg13cmos5l_fill_1
XFILLER_77_211 VPWR VGND sg13cmos5l_decap_8
XFILLER_49_40 VPWR VGND sg13cmos5l_decap_8
XFILLER_1_36 VPWR VGND sg13cmos5l_fill_2
XFILLER_292_131 VPWR VGND sg13cmos5l_decap_4
XFILLER_292_153 VPWR VGND sg13cmos5l_fill_1
XANTENNA__2257__D Tile_X0Y2_FrameData[15] VPWR VGND sg13cmos5l_antennanp
XFILLER_92_258 VPWR VGND sg13cmos5l_decap_8
XFILLER_65_50 VPWR VGND sg13cmos5l_decap_8
XFILLER_322_44 VPWR VGND sg13cmos5l_decap_4
XANTENNA__0907__X AXI_M_SOC_AWBURST0 VPWR VGND sg13cmos5l_antennanp
XFILLER_65_94 VPWR VGND sg13cmos5l_fill_2
XFILLER_65_61 VPWR VGND sg13cmos5l_fill_2
XFILLER_45_174 VPWR VGND sg13cmos5l_decap_8
X_1970_ _1970_/Q Tile_X0Y1_FrameData[30] Tile_X0Y5_FrameStrobe[0] VPWR VGND sg13cmos5l_dlhq_1
XFILLER_60_144 VPWR VGND sg13cmos5l_decap_4
X_0921_ AXI_M_SOC_AWBURST1 _3335_/Q _0920_/X VPWR VGND sg13cmos5l_nor2b_1
XANTENNA__3088__D Tile_X0Y5_FrameData[0] VPWR VGND sg13cmos5l_antennanp
XFILLER_267_19 VPWR VGND sg13cmos5l_fill_1
XFILLER_146_205 VPWR VGND sg13cmos5l_decap_8
XFILLER_197_82 VPWR VGND sg13cmos5l_fill_2
X_3640_ Tile_X0Y0_E2BEG[3] _3640_/A VPWR VGND sg13cmos5l_buf_1
X_0852_ _0852_/Y _3126_/Q Tile_X0Y5_W2MID[1] VPWR VGND sg13cmos5l_nand2b_1
X_3571_ Tile_X0Y0_FrameData_O[2] Tile_X0Y0_FrameData[2] VPWR VGND sg13cmos5l_buf_1
X_0783_ _3815_/A Tile_X0Y5_W2MID[7] _0775_/X _0782_/X _0563_/X _3248_/Q _3247_/Q VPWR
+ VGND sg13cmos5l_mux4_1
XFILLER_60_4 VPWR VGND sg13cmos5l_fill_1
XANTENNA__2720__D Tile_X0Y3_FrameData[16] VPWR VGND sg13cmos5l_antennanp
XANTENNA__3324__GATE Tile_X0Y5_FrameStrobe[8] VPWR VGND sg13cmos5l_antennanp
XFILLER_114_102 VPWR VGND sg13cmos5l_decap_8
X_2522_ _2522_/Q Tile_X0Y3_FrameData[22] Tile_X0Y5_FrameStrobe[0] VPWR VGND sg13cmos5l_dlhq_1
XANTENNA__0755__A0 Tile_X0Y5_WW4END[3] VPWR VGND sg13cmos5l_antennanp
XFILLER_154_293 VPWR VGND sg13cmos5l_fill_2
XANTENNA__2580__GATE Tile_X0Y5_FrameStrobe[2] VPWR VGND sg13cmos5l_antennanp
XFILLER_114_168 VPWR VGND sg13cmos5l_decap_8
XFILLER_216_23 VPWR VGND sg13cmos5l_decap_8
XFILLER_216_45 VPWR VGND sg13cmos5l_fill_1
X_2453_ _2453_/Q Tile_X0Y2_FrameData[11] Tile_X0Y5_FrameStrobe[6] VPWR VGND sg13cmos5l_dlhq_1
XANTENNA__3339__GATE Tile_X0Y5_FrameStrobe[8] VPWR VGND sg13cmos5l_antennanp
XFILLER_216_89 VPWR VGND sg13cmos5l_decap_8
X_2384_ _2384_/Q Tile_X0Y2_FrameData[16] Tile_X0Y5_FrameStrobe[4] VPWR VGND sg13cmos5l_dlhq_1
X_1404_ _3374_/A AXI_M_SOC_RDATA14 _1370_/X _1314_/X _1157_/X _2359_/Q _2360_/Q VPWR
+ VGND sg13cmos5l_mux4_1
XANTENNA__1180__A0 Tile_X0Y0_W2MID[0] VPWR VGND sg13cmos5l_antennanp
XFILLER_122_190 VPWR VGND sg13cmos5l_decap_8
X_1335_ _3493_/A Tile_X0Y1_W2END[6] AXI_M_SOC_RDATA28 _1105_/X _1083_/X _2142_/Q _2141_/Q
+ VPWR VGND sg13cmos5l_mux4_1
XFILLER_83_203 VPWR VGND sg13cmos5l_fill_2
XANTENNA__2167__D Tile_X0Y1_FrameData[25] VPWR VGND sg13cmos5l_antennanp
XANTENNA__2595__GATE Tile_X0Y5_FrameStrobe[2] VPWR VGND sg13cmos5l_antennanp
XFILLER_232_44 VPWR VGND sg13cmos5l_decap_8
X_3005_ _3005_/Q Tile_X0Y4_FrameData[3] Tile_X0Y5_FrameStrobe[6] VPWR VGND sg13cmos5l_dlhq_1
X_1266_ _3636_/A Tile_X0Y0_W2END[0] AXI_M_SOC_RDATA30 _1145_/X _1136_/X _1858_/Q _1857_/Q
+ VPWR VGND sg13cmos5l_mux4_1
XFILLER_283_197 VPWR VGND sg13cmos5l_fill_1
X_1197_ AXI_M_SOC_AWADDR11 Tile_X0Y0_WW4END[3] Tile_X0Y0_WW4END[11] Tile_X0Y0_W6END[3]
+ _1080_/X _1794_/Q _1793_/Q VPWR VGND sg13cmos5l_mux4_1
XFILLER_224_253 VPWR VGND sg13cmos5l_fill_2
XFILLER_36_163 VPWR VGND sg13cmos5l_decap_8
XFILLER_224_275 VPWR VGND sg13cmos5l_decap_4
XFILLER_101_59 VPWR VGND sg13cmos5l_fill_2
XFILLER_189_190 VPWR VGND sg13cmos5l_fill_1
XFILLER_51_166 VPWR VGND sg13cmos5l_fill_1
XANTENNA__1648__X AXI_M_SOC_ARADDR18 VPWR VGND sg13cmos5l_antennanp
XANTENNA__3576__A Tile_X0Y0_FrameData[7] VPWR VGND sg13cmos5l_antennanp
X_3907_ Tile_X0Y5_S2BEGb[4] _3907_/A VPWR VGND sg13cmos5l_buf_1
XFILLER_338_154 VPWR VGND sg13cmos5l_decap_8
XFILLER_338_121 VPWR VGND sg13cmos5l_decap_4
XANTENNA__0994__A0 Tile_X0Y0_W1END[2] VPWR VGND sg13cmos5l_antennanp
XANTENNA__2533__GATE Tile_X0Y5_FrameStrobe[0] VPWR VGND sg13cmos5l_antennanp
XFILLER_137_227 VPWR VGND sg13cmos5l_decap_4
X_3838_ Tile_X0Y5_E6BEG[7] _3838_/A VPWR VGND sg13cmos5l_buf_1
XFILLER_338_176 VPWR VGND sg13cmos5l_fill_2
XFILLER_137_249 VPWR VGND sg13cmos5l_decap_8
XANTENNA__1538__A2 Tile_X0Y0_S4END[12] VPWR VGND sg13cmos5l_antennanp
XANTENNA__2630__D Tile_X0Y3_FrameData[10] VPWR VGND sg13cmos5l_antennanp
XANTENNA__3863__X Tile_X0Y5_FrameData_O[4] VPWR VGND sg13cmos5l_antennanp
XFILLER_193_18 VPWR VGND sg13cmos5l_decap_8
X_3769_ Tile_X0Y4_EE4BEG[7] _3769_/A VPWR VGND sg13cmos5l_buf_1
XFILLER_145_293 VPWR VGND sg13cmos5l_fill_2
XANTENNA__2548__GATE Tile_X0Y5_FrameStrobe[1] VPWR VGND sg13cmos5l_antennanp
XFILLER_160_252 VPWR VGND sg13cmos5l_fill_1
XFILLER_160_285 VPWR VGND sg13cmos5l_fill_2
XFILLER_59_244 VPWR VGND sg13cmos5l_decap_8
XANTENNA__1171__A0 Tile_X0Y0_W1END[1] VPWR VGND sg13cmos5l_antennanp
XFILLER_142_22 VPWR VGND sg13cmos5l_decap_8
XANTENNA__2077__D Tile_X0Y1_FrameData[19] VPWR VGND sg13cmos5l_antennanp
XFILLER_274_153 VPWR VGND sg13cmos5l_decap_8
XFILLER_215_220 VPWR VGND sg13cmos5l_fill_2
XFILLER_27_141 VPWR VGND sg13cmos5l_decap_8
XFILLER_35_20 VPWR VGND sg13cmos5l_fill_2
XANTENNA__2805__D Tile_X0Y4_FrameData[11] VPWR VGND sg13cmos5l_antennanp
XFILLER_35_64 VPWR VGND sg13cmos5l_decap_8
XANTENNA__1226__A1 AXI_M_SOC_BRESP0 VPWR VGND sg13cmos5l_antennanp
XANTENNA__1742__GATE Tile_X0Y5_FrameStrobe[1] VPWR VGND sg13cmos5l_antennanp
XANTENNA__1558__X AXI_M_SOC_WDATA7 VPWR VGND sg13cmos5l_antennanp
XFILLER_136_0 VPWR VGND sg13cmos5l_decap_8
XFILLER_195_171 VPWR VGND sg13cmos5l_fill_1
XFILLER_51_63 VPWR VGND sg13cmos5l_decap_8
XFILLER_128_238 VPWR VGND sg13cmos5l_fill_2
XFILLER_167_63 VPWR VGND sg13cmos5l_decap_8
XANTENNA__1757__GATE Tile_X0Y5_FrameStrobe[1] VPWR VGND sg13cmos5l_antennanp
XANTENNA__2540__D Tile_X0Y3_FrameData[4] VPWR VGND sg13cmos5l_antennanp
XANTENNA__3773__X Tile_X0Y4_EE4BEG[11] VPWR VGND sg13cmos5l_antennanp
XFILLER_303_0 VPWR VGND sg13cmos5l_fill_2
XANTENNA__0737__A0 Tile_X0Y1_W6END[7] VPWR VGND sg13cmos5l_antennanp
XFILLER_136_293 VPWR VGND sg13cmos5l_fill_2
XFILLER_151_241 VPWR VGND sg13cmos5l_decap_4
XFILLER_297_234 VPWR VGND sg13cmos5l_decap_4
XFILLER_300_227 VPWR VGND sg13cmos5l_fill_1
X_1120_ _1120_/X Tile_X0Y3_W1END[3] Tile_X0Y3_W6END[7] _1586_/B _0729_/X _2778_/Q
+ _2777_/Q VPWR VGND sg13cmos5l_mux4_1
XFILLER_65_247 VPWR VGND sg13cmos5l_decap_4
XFILLER_333_98 VPWR VGND sg13cmos5l_fill_2
XFILLER_333_87 VPWR VGND sg13cmos5l_fill_2
XFILLER_18_141 VPWR VGND sg13cmos5l_fill_2
X_1051_ _1051_/X Tile_X0Y3_W1END[0] Tile_X0Y3_W6END[4] _0882_/X _0585_/X _2784_/Q
+ _2783_/Q VPWR VGND sg13cmos5l_mux4_1
XANTENNA__1465__A1 AXI_M_SOC_RDATA19 VPWR VGND sg13cmos5l_antennanp
XFILLER_18_185 VPWR VGND sg13cmos5l_decap_8
XFILLER_206_231 VPWR VGND sg13cmos5l_fill_1
XFILLER_280_145 VPWR VGND sg13cmos5l_fill_2
XFILLER_280_167 VPWR VGND sg13cmos5l_fill_2
XANTENNA__2715__D Tile_X0Y3_FrameData[21] VPWR VGND sg13cmos5l_antennanp
XFILLER_92_70 VPWR VGND sg13cmos5l_decap_8
XFILLER_33_144 VPWR VGND sg13cmos5l_decap_8
XFILLER_33_133 VPWR VGND sg13cmos5l_fill_1
XFILLER_221_256 VPWR VGND sg13cmos5l_fill_1
XFILLER_278_29 VPWR VGND sg13cmos5l_fill_1
X_1953_ _1953_/Q Tile_X0Y0_FrameData[31] Tile_X0Y5_FrameStrobe[8] VPWR VGND sg13cmos5l_dlhq_1
X_1884_ _1884_/Q Tile_X0Y0_FrameData[4] Tile_X0Y5_FrameStrobe[5] VPWR VGND sg13cmos5l_dlhq_1
X_0904_ _0904_/Y _0896_/Y _0898_/Y _0903_/Y VPWR VGND sg13cmos5l_a21oi_1
XANTENNA__3263__GATE Tile_X0Y5_FrameStrobe[6] VPWR VGND sg13cmos5l_antennanp
XFILLER_119_249 VPWR VGND sg13cmos5l_decap_4
X_3623_ Tile_X0Y0_E6BEG[6] _3623_/A VPWR VGND sg13cmos5l_buf_1
X_0835_ _3842_/A AXI_M_SOC_RLAST _0597_/X _0599_/X _0563_/X _3161_/Q _3162_/Q VPWR
+ VGND sg13cmos5l_mux4_1
XANTENNA__2450__D Tile_X0Y2_FrameData[14] VPWR VGND sg13cmos5l_antennanp
XANTENNA__3683__X Tile_X0Y3_EE4BEG[2] VPWR VGND sg13cmos5l_antennanp
XFILLER_127_293 VPWR VGND sg13cmos5l_fill_2
XFILLER_227_55 VPWR VGND sg13cmos5l_decap_8
X_3554_ Tile_X0Y0_FrameStrobe_O[5] Tile_X0Y5_FrameStrobe[5] VPWR VGND sg13cmos5l_buf_1
X_0766_ _3812_/A Tile_X0Y5_N1END[1] _0765_/X _1021_/B AXI_M_SOC_RVALID _3253_/Q _3254_/Q
+ VPWR VGND sg13cmos5l_mux4_1
XFILLER_51_0 VPWR VGND sg13cmos5l_decap_8
XFILLER_288_223 VPWR VGND sg13cmos5l_decap_8
X_2505_ _2505_/Q Tile_X0Y2_FrameData[23] Tile_X0Y5_FrameStrobe[8] VPWR VGND sg13cmos5l_dlhq_1
X_3485_ Tile_X0Y1_E6BEG[5] _3485_/A VPWR VGND sg13cmos5l_buf_1
X_0697_ _0698_/A Tile_X0Y5_N1END[2] Tile_X0Y5_N4END[2] _0990_/B _0693_/X _3108_/Q
+ _3107_/Q VPWR VGND sg13cmos5l_mux4_1
XANTENNA__3278__GATE Tile_X0Y5_FrameStrobe[6] VPWR VGND sg13cmos5l_antennanp
X_2436_ _2436_/Q Tile_X0Y2_FrameData[28] Tile_X0Y5_FrameStrobe[6] VPWR VGND sg13cmos5l_dlhq_1
XANTENNA__1153__A0 Tile_X0Y0_W1END[3] VPWR VGND sg13cmos5l_antennanp
XANTENNA__3281__D Tile_X0Y5_FrameData[31] VPWR VGND sg13cmos5l_antennanp
X_2367_ _2367_/Q Tile_X0Y2_FrameData[1] Tile_X0Y5_FrameStrobe[3] VPWR VGND sg13cmos5l_dlhq_1
XFILLER_56_203 VPWR VGND sg13cmos5l_decap_8
XANTENNA__3201__GATE Tile_X0Y5_FrameStrobe[4] VPWR VGND sg13cmos5l_antennanp
X_2298_ _2298_/Q Tile_X0Y2_FrameData[6] Tile_X0Y5_FrameStrobe[1] VPWR VGND sg13cmos5l_dlhq_1
X_1318_ _1318_/X _1317_/X _0655_/X Tile_X0Y5_N2MID[5] _1316_/X _2797_/Q _2798_/Q VPWR
+ VGND sg13cmos5l_mux4_1
XFILLER_56_214 VPWR VGND sg13cmos5l_fill_1
X_1249_ _3648_/A _0986_/X AXI_M_SOC_RDATA30 Tile_X0Y0_S1END[3] AXI_M_SOC_BRESP0 _1889_/Q
+ _1890_/Q VPWR VGND sg13cmos5l_mux4_1
XANTENNA__1456__A1 AXI_M_SOC_RDATA17 VPWR VGND sg13cmos5l_antennanp
XFILLER_71_239 VPWR VGND sg13cmos5l_decap_8
XANTENNA__2625__D Tile_X0Y3_FrameData[15] VPWR VGND sg13cmos5l_antennanp
XANTENNA__3216__GATE Tile_X0Y5_FrameStrobe[4] VPWR VGND sg13cmos5l_antennanp
XANTENNA__3858__X Tile_X0Y5_EE4BEG[15] VPWR VGND sg13cmos5l_antennanp
XFILLER_112_69 VPWR VGND sg13cmos5l_decap_8
XANTENNA__1208__A1 Tile_X0Y0_WW4END[14] VPWR VGND sg13cmos5l_antennanp
XANTENNA__2472__GATE Tile_X0Y5_FrameStrobe[7] VPWR VGND sg13cmos5l_antennanp
XFILLER_177_171 VPWR VGND sg13cmos5l_decap_8
XANTENNA__2360__D Tile_X0Y2_FrameData[8] VPWR VGND sg13cmos5l_antennanp
XANTENNA__3593__X Tile_X0Y0_FrameData_O[24] VPWR VGND sg13cmos5l_antennanp
XFILLER_137_11 VPWR VGND sg13cmos5l_fill_1
XANTENNA__2487__GATE Tile_X0Y5_FrameStrobe[7] VPWR VGND sg13cmos5l_antennanp
XFILLER_118_293 VPWR VGND sg13cmos5l_fill_2
XFILLER_21_66 VPWR VGND sg13cmos5l_decap_8
XFILLER_284_83 VPWR VGND sg13cmos5l_fill_1
XFILLER_334_190 VPWR VGND sg13cmos5l_fill_1
XFILLER_133_274 VPWR VGND sg13cmos5l_decap_4
XFILLER_133_285 VPWR VGND sg13cmos5l_fill_2
XFILLER_97_48 VPWR VGND sg13cmos5l_decap_8
XANTENNA__2410__GATE Tile_X0Y5_FrameStrobe[5] VPWR VGND sg13cmos5l_antennanp
XANTENNA__1144__A0 Tile_X0Y0_W2MID[6] VPWR VGND sg13cmos5l_antennanp
XANTENNA__1704__D Tile_X0Y0_FrameData[24] VPWR VGND sg13cmos5l_antennanp
XANTENNA__3191__D Tile_X0Y5_FrameData[25] VPWR VGND sg13cmos5l_antennanp
XFILLER_153_76 VPWR VGND sg13cmos5l_decap_8
XANTENNA__1695__A1 Tile_X0Y5_W2END[6] VPWR VGND sg13cmos5l_antennanp
XFILLER_101_160 VPWR VGND sg13cmos5l_decap_8
XFILLER_153_87 VPWR VGND sg13cmos5l_fill_1
XANTENNA__2425__GATE Tile_X0Y5_FrameStrobe[5] VPWR VGND sg13cmos5l_antennanp
XFILLER_46_74 VPWR VGND sg13cmos5l_decap_4
XANTENNA__2535__D Tile_X0Y3_FrameData[9] VPWR VGND sg13cmos5l_antennanp
XANTENNA__3768__X Tile_X0Y4_EE4BEG[6] VPWR VGND sg13cmos5l_antennanp
XFILLER_203_201 VPWR VGND sg13cmos5l_decap_8
XFILLER_253_0 VPWR VGND sg13cmos5l_fill_2
XFILLER_262_189 VPWR VGND sg13cmos5l_fill_1
XFILLER_15_199 VPWR VGND sg13cmos5l_decap_8
XFILLER_30_158 VPWR VGND sg13cmos5l_decap_8
XFILLER_62_95 VPWR VGND sg13cmos5l_fill_1
XFILLER_62_84 VPWR VGND sg13cmos5l_decap_8
XFILLER_168_193 VPWR VGND sg13cmos5l_fill_2
XANTENNA__2270__D Tile_X0Y2_FrameData[2] VPWR VGND sg13cmos5l_antennanp
XFILLER_109_293 VPWR VGND sg13cmos5l_fill_2
XFILLER_183_174 VPWR VGND sg13cmos5l_fill_1
X_0620_ _0621_/C _1974_/Q _1139_/X VPWR VGND sg13cmos5l_nor2_1
XFILLER_194_94 VPWR VGND sg13cmos5l_decap_8
X_0551_ _0551_/Y _0976_/X VPWR VGND sg13cmos5l_inv_1
XFILLER_124_263 VPWR VGND sg13cmos5l_fill_1
X_3270_ _3270_/Q Tile_X0Y5_FrameData[10] Tile_X0Y5_FrameStrobe[6] VPWR VGND sg13cmos5l_dlhq_1
X_2221_ _2221_/Q Tile_X0Y1_FrameData[3] Tile_X0Y5_FrameStrobe[7] VPWR VGND sg13cmos5l_dlhq_1
XFILLER_87_70 VPWR VGND sg13cmos5l_fill_2
XANTENNA__1135__A0 Tile_X0Y5_W1END[3] VPWR VGND sg13cmos5l_antennanp
X_2152_ _2152_/Q Tile_X0Y1_FrameData[8] Tile_X0Y5_FrameStrobe[5] VPWR VGND sg13cmos5l_dlhq_1
XFILLER_253_112 VPWR VGND sg13cmos5l_decap_4
X_2083_ _2083_/Q Tile_X0Y1_FrameData[13] Tile_X0Y5_FrameStrobe[3] VPWR VGND sg13cmos5l_dlhq_1
X_1103_ _1103_/X Tile_X0Y2_W2MID[6] Tile_X0Y2_W2END[6] Tile_X0Y2_W6END[6] _1143_/X
+ _2502_/Q _2501_/Q VPWR VGND sg13cmos5l_mux4_1
XANTENNA__1438__A1 Tile_X0Y2_W6END[5] VPWR VGND sg13cmos5l_antennanp
X_1034_ _1034_/Y _3028_/Q _1031_/X _3027_/Q VPWR VGND sg13cmos5l_o21ai_1
XANTENNA__2445__D Tile_X0Y2_FrameData[19] VPWR VGND sg13cmos5l_antennanp
XANTENNA__3678__X Tile_X0Y3_E6BEG[9] VPWR VGND sg13cmos5l_antennanp
XFILLER_99_0 VPWR VGND sg13cmos5l_fill_2
XANTENNA__1198__X AXI_M_SOC_AWADDR10 VPWR VGND sg13cmos5l_antennanp
X_2985_ _2985_/Q Tile_X0Y4_FrameData[23] Tile_X0Y5_FrameStrobe[6] VPWR VGND sg13cmos5l_dlhq_1
XFILLER_159_193 VPWR VGND sg13cmos5l_decap_8
X_1936_ _1936_/Q Tile_X0Y0_FrameData[16] Tile_X0Y5_FrameStrobe[7] VPWR VGND sg13cmos5l_dlhq_1
XANTENNA__1610__A1 AXI_M_SOC_RDATA5 VPWR VGND sg13cmos5l_antennanp
XANTENNA__2180__D Tile_X0Y1_FrameData[12] VPWR VGND sg13cmos5l_antennanp
XANTENNA__3276__D Tile_X0Y5_FrameData[4] VPWR VGND sg13cmos5l_antennanp
X_1867_ _1867_/Q Tile_X0Y0_FrameData[21] Tile_X0Y5_FrameStrobe[5] VPWR VGND sg13cmos5l_dlhq_1
X_3606_ Tile_X0Y0_EE4BEG[5] _3606_/A VPWR VGND sg13cmos5l_buf_1
X_1798_ _1798_/Q Tile_X0Y0_FrameData[26] Tile_X0Y5_FrameStrobe[3] VPWR VGND sg13cmos5l_dlhq_1
X_0818_ _3853_/A Tile_X0Y5_WW4END[5] _0773_/X _0646_/X _0656_/X _3196_/Q _3195_/Q
+ VPWR VGND sg13cmos5l_mux4_1
X_3537_ Tile_X0Y0_N2BEG[0] _3537_/A VPWR VGND sg13cmos5l_buf_1
XFILLER_107_25 VPWR VGND sg13cmos5l_decap_8
XFILLER_115_263 VPWR VGND sg13cmos5l_fill_1
XFILLER_115_274 VPWR VGND sg13cmos5l_fill_2
XFILLER_130_200 VPWR VGND sg13cmos5l_decap_4
XFILLER_254_31 VPWR VGND sg13cmos5l_fill_2
X_0749_ _0749_/X _0740_/X _0563_/X _3259_/Q VPWR VGND sg13cmos5l_mux2_1
XFILLER_254_75 VPWR VGND sg13cmos5l_fill_2
X_3468_ Tile_X0Y1_EE4BEG[4] _3468_/A VPWR VGND sg13cmos5l_buf_1
XANTENNA__3140__GATE Tile_X0Y5_FrameStrobe[2] VPWR VGND sg13cmos5l_antennanp
XFILLER_276_248 VPWR VGND sg13cmos5l_decap_4
X_2419_ _2419_/Q Tile_X0Y2_FrameData[13] Tile_X0Y5_FrameStrobe[5] VPWR VGND sg13cmos5l_dlhq_1
X_3399_ Tile_X0Y2_FrameData_O[1] Tile_X0Y2_FrameData[1] VPWR VGND sg13cmos5l_buf_1
XANTENNA__1677__A1 AXI_M_SOC_RDATA3 VPWR VGND sg13cmos5l_antennanp
XANTENNA__1429__A1 Tile_X0Y2_W2END[5] VPWR VGND sg13cmos5l_antennanp
XANTENNA__3155__GATE Tile_X0Y5_FrameStrobe[3] VPWR VGND sg13cmos5l_antennanp
XFILLER_244_134 VPWR VGND sg13cmos5l_fill_1
XFILLER_83_28 VPWR VGND sg13cmos5l_decap_8
XANTENNA__2355__D Tile_X0Y2_FrameData[13] VPWR VGND sg13cmos5l_antennanp
XANTENNA__3588__X Tile_X0Y0_FrameData_O[19] VPWR VGND sg13cmos5l_antennanp
XFILLER_199_39 VPWR VGND sg13cmos5l_fill_1
XFILLER_339_293 VPWR VGND sg13cmos5l_fill_2
XANTENNA__2090__D Tile_X0Y1_FrameData[6] VPWR VGND sg13cmos5l_antennanp
XANTENNA__3186__D Tile_X0Y5_FrameData[30] VPWR VGND sg13cmos5l_antennanp
XFILLER_148_54 VPWR VGND sg13cmos5l_decap_8
XFILLER_32_98 VPWR VGND sg13cmos5l_decap_8
XFILLER_165_174 VPWR VGND sg13cmos5l_fill_1
XFILLER_106_274 VPWR VGND sg13cmos5l_fill_2
XFILLER_164_75 VPWR VGND sg13cmos5l_decap_4
XANTENNA__1117__A0 Tile_X0Y3_WW4END[3] VPWR VGND sg13cmos5l_antennanp
XANTENNA__1380__A3 Tile_X0Y0_S4END[10] VPWR VGND sg13cmos5l_antennanp
XANTENNA__3108__GATE Tile_X0Y5_FrameStrobe[1] VPWR VGND sg13cmos5l_antennanp
XFILLER_94_117 VPWR VGND sg13cmos5l_decap_8
XFILLER_79_169 VPWR VGND sg13cmos5l_fill_1
XFILLER_282_218 VPWR VGND sg13cmos5l_fill_2
XANTENNA__2364__GATE Tile_X0Y5_FrameStrobe[3] VPWR VGND sg13cmos5l_antennanp
XFILLER_235_112 VPWR VGND sg13cmos5l_fill_1
XANTENNA__2994__GATE Tile_X0Y5_FrameStrobe[6] VPWR VGND sg13cmos5l_antennanp
XANTENNA__0891__A2 Tile_X0Y5_N4END[11] VPWR VGND sg13cmos5l_antennanp
XANTENNA__3498__X Tile_X0Y1_E2BEGb[6] VPWR VGND sg13cmos5l_antennanp
XFILLER_235_189 VPWR VGND sg13cmos5l_decap_8
XANTENNA__2265__D Tile_X0Y2_FrameData[7] VPWR VGND sg13cmos5l_antennanp
XANTENNA__2379__GATE Tile_X0Y5_FrameStrobe[4] VPWR VGND sg13cmos5l_antennanp
XFILLER_73_83 VPWR VGND sg13cmos5l_decap_8
XFILLER_330_77 VPWR VGND sg13cmos5l_decap_4
XANTENNA__0643__A2 Tile_X0Y1_WW4END[13] VPWR VGND sg13cmos5l_antennanp
XFILLER_92_7 VPWR VGND sg13cmos5l_decap_8
XFILLER_43_294 VPWR VGND sg13cmos5l_fill_1
XFILLER_337_208 VPWR VGND sg13cmos5l_fill_1
XANTENNA__2302__GATE Tile_X0Y5_FrameStrobe[1] VPWR VGND sg13cmos5l_antennanp
X_2770_ _2770_/Q Tile_X0Y3_FrameData[30] Tile_X0Y5_FrameStrobe[8] VPWR VGND sg13cmos5l_dlhq_1
XANTENNA__2932__GATE Tile_X0Y5_FrameStrobe[4] VPWR VGND sg13cmos5l_antennanp
XANTENNA__3096__D Tile_X0Y5_FrameData[24] VPWR VGND sg13cmos5l_antennanp
XFILLER_11_191 VPWR VGND sg13cmos5l_fill_2
X_1721_ _1721_/Q Tile_X0Y0_FrameData[7] Tile_X0Y5_FrameStrobe[0] VPWR VGND sg13cmos5l_dlhq_1
X_1652_ AXI_M_SOC_ARADDR14 Tile_X0Y4_W1END[2] Tile_X0Y4_WW4END[6] Tile_X0Y4_WW4END[14]
+ _1013_/X _2860_/Q _2859_/Q VPWR VGND sg13cmos5l_mux4_1
X_0603_ _0603_/X Tile_X0Y5_W1END[0] Tile_X0Y5_WW4END[12] _3268_/Q VPWR VGND sg13cmos5l_mux2_1
XANTENNA__2317__GATE Tile_X0Y5_FrameStrobe[2] VPWR VGND sg13cmos5l_antennanp
X_1583_ _1583_/Y _1583_/A VPWR VGND sg13cmos5l_inv_1
XANTENNA__2947__GATE Tile_X0Y5_FrameStrobe[5] VPWR VGND sg13cmos5l_antennanp
XFILLER_112_222 VPWR VGND sg13cmos5l_decap_8
XFILLER_313_193 VPWR VGND sg13cmos5l_decap_4
X_3322_ _3322_/Q Tile_X0Y5_FrameData[22] Tile_X0Y5_FrameStrobe[8] VPWR VGND sg13cmos5l_dlhq_1
X_0534_ _0534_/Y _3261_/Q VPWR VGND sg13cmos5l_inv_1
XANTENNA__1108__A0 Tile_X0Y0_W2MID[7] VPWR VGND sg13cmos5l_antennanp
XANTENNA__1371__A3 Tile_X0Y0_S4END[11] VPWR VGND sg13cmos5l_antennanp
XFILLER_112_277 VPWR VGND sg13cmos5l_fill_2
X_3253_ _3253_/Q Tile_X0Y5_FrameData[27] Tile_X0Y5_FrameStrobe[6] VPWR VGND sg13cmos5l_dlhq_1
XANTENNA__1659__A1 AXI_M_SOC_RDATA5 VPWR VGND sg13cmos5l_antennanp
X_3184_ _3184_/Q Tile_X0Y5_FrameData[0] Tile_X0Y5_FrameStrobe[3] VPWR VGND sg13cmos5l_dlhq_1
X_2204_ _2204_/Q Tile_X0Y1_FrameData[20] Tile_X0Y5_FrameStrobe[7] VPWR VGND sg13cmos5l_dlhq_1
XFILLER_14_0 VPWR VGND sg13cmos5l_fill_2
X_2135_ _2135_/Q Tile_X0Y1_FrameData[25] Tile_X0Y5_FrameStrobe[5] VPWR VGND sg13cmos5l_dlhq_1
XFILLER_226_134 VPWR VGND sg13cmos5l_decap_8
XFILLER_226_145 VPWR VGND sg13cmos5l_fill_1
XANTENNA__0882__A2 Tile_X0Y5_N4END[8] VPWR VGND sg13cmos5l_antennanp
X_2066_ _2066_/Q Tile_X0Y1_FrameData[30] Tile_X0Y5_FrameStrobe[3] VPWR VGND sg13cmos5l_dlhq_1
XANTENNA__2175__D Tile_X0Y1_FrameData[17] VPWR VGND sg13cmos5l_antennanp
X_1017_ _1017_/X Tile_X0Y4_W1END[1] Tile_X0Y4_W6END[5] _1046_/X _0640_/X _3054_/Q
+ _3053_/Q VPWR VGND sg13cmos5l_mux4_1
XANTENNA__2903__D Tile_X0Y4_FrameData[9] VPWR VGND sg13cmos5l_antennanp
XFILLER_179_277 VPWR VGND sg13cmos5l_decap_4
XFILLER_249_75 VPWR VGND sg13cmos5l_decap_8
X_2968_ _2968_/Q Tile_X0Y4_FrameData[8] Tile_X0Y5_FrameStrobe[5] VPWR VGND sg13cmos5l_dlhq_1
XANTENNA__1595__A0 Tile_X0Y3_W1END[2] VPWR VGND sg13cmos5l_antennanp
X_1919_ _1919_/Q Tile_X0Y0_FrameData[1] Tile_X0Y5_FrameStrobe[6] VPWR VGND sg13cmos5l_dlhq_1
XANTENNA__3584__A Tile_X0Y0_FrameData[15] VPWR VGND sg13cmos5l_antennanp
X_2899_ _2899_/Q Tile_X0Y4_FrameData[13] Tile_X0Y5_FrameStrobe[3] VPWR VGND sg13cmos5l_dlhq_1
XANTENNA__1347__A0 Tile_X0Y2_W1END[2] VPWR VGND sg13cmos5l_antennanp
XANTENNA__3871__X Tile_X0Y5_FrameData_O[12] VPWR VGND sg13cmos5l_antennanp
XFILLER_78_28 VPWR VGND sg13cmos5l_fill_1
XFILLER_103_211 VPWR VGND sg13cmos5l_decap_8
XFILLER_257_270 VPWR VGND sg13cmos5l_decap_8
XFILLER_94_38 VPWR VGND sg13cmos5l_fill_1
XANTENNA__3094__GATE Tile_X0Y5_FrameStrobe[1] VPWR VGND sg13cmos5l_antennanp
XFILLER_17_217 VPWR VGND sg13cmos5l_decap_8
XANTENNA__2085__D Tile_X0Y1_FrameData[11] VPWR VGND sg13cmos5l_antennanp
XFILLER_43_31 VPWR VGND sg13cmos5l_decap_8
XFILLER_43_20 VPWR VGND sg13cmos5l_fill_1
XANTENNA__2813__D Tile_X0Y4_FrameData[3] VPWR VGND sg13cmos5l_antennanp
XFILLER_43_64 VPWR VGND sg13cmos5l_decap_8
XFILLER_43_86 VPWR VGND sg13cmos5l_decap_8
XFILLER_40_275 VPWR VGND sg13cmos5l_fill_2
XANTENNA__3032__GATE Tile_X0Y5_FrameStrobe[7] VPWR VGND sg13cmos5l_antennanp
XFILLER_309_12 VPWR VGND sg13cmos5l_fill_1
XFILLER_193_280 VPWR VGND sg13cmos5l_fill_1
XFILLER_216_0 VPWR VGND sg13cmos5l_fill_2
XFILLER_327_285 VPWR VGND sg13cmos5l_fill_2
XFILLER_309_78 VPWR VGND sg13cmos5l_decap_4
XANTENNA__1338__A0 Tile_X0Y1_W2MID[1] VPWR VGND sg13cmos5l_antennanp
XANTENNA__3781__X Tile_X0Y4_FrameData_O[3] VPWR VGND sg13cmos5l_antennanp
XFILLER_175_74 VPWR VGND sg13cmos5l_decap_8
XANTENNA__3047__GATE Tile_X0Y5_FrameStrobe[8] VPWR VGND sg13cmos5l_antennanp
XFILLER_4_58 VPWR VGND sg13cmos5l_decap_4
XFILLER_68_61 VPWR VGND sg13cmos5l_decap_8
XANTENNA__0561__A1 Tile_X0Y4_W2MID[0] VPWR VGND sg13cmos5l_antennanp
XFILLER_191_73 VPWR VGND sg13cmos5l_decap_8
XANTENNA__1105__A3 Tile_X0Y0_S2MID[1] VPWR VGND sg13cmos5l_antennanp
XANTENNA__1510__A0 Tile_X0Y3_WW4END[7] VPWR VGND sg13cmos5l_antennanp
XFILLER_263_251 VPWR VGND sg13cmos5l_decap_4
XFILLER_263_273 VPWR VGND sg13cmos5l_fill_2
XFILLER_90_164 VPWR VGND sg13cmos5l_decap_8
XANTENNA__2241__GATE Tile_X0Y5_FrameStrobe[0] VPWR VGND sg13cmos5l_antennanp
XANTENNA__2723__D Tile_X0Y3_FrameData[13] VPWR VGND sg13cmos5l_antennanp
XFILLER_176_214 VPWR VGND sg13cmos5l_fill_2
XFILLER_210_69 VPWR VGND sg13cmos5l_decap_8
X_3871_ Tile_X0Y5_FrameData_O[12] Tile_X0Y5_FrameData[12] VPWR VGND sg13cmos5l_buf_1
XANTENNA__2871__GATE Tile_X0Y5_FrameStrobe[2] VPWR VGND sg13cmos5l_antennanp
XFILLER_176_247 VPWR VGND sg13cmos5l_decap_8
X_2822_ _2822_/Q Tile_X0Y4_FrameData[26] Tile_X0Y5_FrameStrobe[1] VPWR VGND sg13cmos5l_dlhq_1
XFILLER_31_286 VPWR VGND sg13cmos5l_fill_1
X_2753_ _2753_/Q Tile_X0Y3_FrameData[15] Tile_X0Y5_FrameStrobe[7] VPWR VGND sg13cmos5l_dlhq_1
XANTENNA__0919__A3 Tile_X0Y0_S4END[4] VPWR VGND sg13cmos5l_antennanp
XANTENNA__1041__A2 Tile_X0Y0_S1END[1] VPWR VGND sg13cmos5l_antennanp
XFILLER_219_67 VPWR VGND sg13cmos5l_fill_1
X_1704_ _1704_/Q Tile_X0Y0_FrameData[24] Tile_X0Y5_FrameStrobe[0] VPWR VGND sg13cmos5l_dlhq_1
XANTENNA__2256__GATE Tile_X0Y5_FrameStrobe[0] VPWR VGND sg13cmos5l_antennanp
X_2684_ _2684_/Q Tile_X0Y3_FrameData[20] Tile_X0Y5_FrameStrobe[5] VPWR VGND sg13cmos5l_dlhq_1
XANTENNA__1329__A0 Tile_X0Y1_W1END[3] VPWR VGND sg13cmos5l_antennanp
XANTENNA__2886__GATE Tile_X0Y5_FrameStrobe[3] VPWR VGND sg13cmos5l_antennanp
XANTENNA__3691__X Tile_X0Y3_EE4BEG[10] VPWR VGND sg13cmos5l_antennanp
X_1635_ AXI_M_SOC_ARADDR9 Tile_X0Y4_WW4END[1] Tile_X0Y4_WW4END[9] Tile_X0Y4_W6END[9]
+ _1040_/X _2870_/Q _2869_/Q VPWR VGND sg13cmos5l_mux4_1
X_1566_ _1566_/Y _2719_/Q _1566_/B VPWR VGND sg13cmos5l_nand2b_1
X_3305_ _3305_/Q Tile_X0Y5_FrameData[7] Tile_X0Y5_FrameStrobe[7] VPWR VGND sg13cmos5l_dlhq_1
X_1497_ _3655_/A Tile_X0Y3_W2MID[5] AXI_M_SOC_RDATA8 _1216_/X _1342_/X _2700_/Q _2699_/Q
+ VPWR VGND sg13cmos5l_mux4_1
XFILLER_239_270 VPWR VGND sg13cmos5l_decap_8
X_3236_ _3236_/Q Tile_X0Y5_FrameData[12] Tile_X0Y5_FrameStrobe[5] VPWR VGND sg13cmos5l_dlhq_1
XANTENNA__1501__A0 Tile_X0Y3_W2END[6] VPWR VGND sg13cmos5l_antennanp
XANTENNA__1802__D Tile_X0Y0_FrameData[22] VPWR VGND sg13cmos5l_antennanp
X_3167_ _3167_/Q Tile_X0Y5_FrameData[17] Tile_X0Y5_FrameStrobe[3] VPWR VGND sg13cmos5l_dlhq_1
XANTENNA__0855__A2 Tile_X0Y5_W6END[2] VPWR VGND sg13cmos5l_antennanp
XANTENNA__2824__GATE Tile_X0Y5_FrameStrobe[1] VPWR VGND sg13cmos5l_antennanp
X_3098_ _3098_/Q Tile_X0Y5_FrameData[22] Tile_X0Y5_FrameStrobe[1] VPWR VGND sg13cmos5l_dlhq_1
X_2118_ _2118_/Q Tile_X0Y1_FrameData[10] Tile_X0Y5_FrameStrobe[4] VPWR VGND sg13cmos5l_dlhq_1
XANTENNA__3579__A Tile_X0Y0_FrameData[10] VPWR VGND sg13cmos5l_antennanp
X_2049_ _2049_/Q Tile_X0Y1_FrameData[15] Tile_X0Y5_FrameStrobe[2] VPWR VGND sg13cmos5l_dlhq_1
XFILLER_120_36 VPWR VGND sg13cmos5l_decap_4
XANTENNA__2209__GATE Tile_X0Y5_FrameStrobe[7] VPWR VGND sg13cmos5l_antennanp
XANTENNA__3866__X Tile_X0Y5_FrameData_O[7] VPWR VGND sg13cmos5l_antennanp
XFILLER_147_8 VPWR VGND sg13cmos5l_decap_8
XANTENNA__2633__D Tile_X0Y3_FrameData[7] VPWR VGND sg13cmos5l_antennanp
XANTENNA__2839__GATE Tile_X0Y5_FrameStrobe[1] VPWR VGND sg13cmos5l_antennanp
XFILLER_13_45 VPWR VGND sg13cmos5l_fill_1
XFILLER_129_56 VPWR VGND sg13cmos5l_decap_8
XFILLER_309_263 VPWR VGND sg13cmos5l_decap_8
XFILLER_324_244 VPWR VGND sg13cmos5l_fill_2
XFILLER_145_11 VPWR VGND sg13cmos5l_fill_2
XFILLER_150_169 VPWR VGND sg13cmos5l_decap_8
XFILLER_289_181 VPWR VGND sg13cmos5l_fill_2
XFILLER_49_139 VPWR VGND sg13cmos5l_fill_1
XFILLER_49_128 VPWR VGND sg13cmos5l_decap_8
XFILLER_161_32 VPWR VGND sg13cmos5l_decap_8
XFILLER_38_53 VPWR VGND sg13cmos5l_decap_8
XANTENNA__1099__A2 Tile_X0Y0_W6END[10] VPWR VGND sg13cmos5l_antennanp
XANTENNA__1712__D Tile_X0Y0_FrameData[16] VPWR VGND sg13cmos5l_antennanp
XANTENNA__2808__D Tile_X0Y4_FrameData[8] VPWR VGND sg13cmos5l_antennanp
XFILLER_161_65 VPWR VGND sg13cmos5l_decap_8
XANTENNA__0846__A2 Tile_X0Y5_WW4END[7] VPWR VGND sg13cmos5l_antennanp
XFILLER_311_24 VPWR VGND sg13cmos5l_fill_1
XFILLER_166_0 VPWR VGND sg13cmos5l_fill_2
XFILLER_260_232 VPWR VGND sg13cmos5l_decap_4
XFILLER_311_68 VPWR VGND sg13cmos5l_decap_8
XFILLER_54_74 VPWR VGND sg13cmos5l_fill_2
XANTENNA__3776__X Tile_X0Y4_EE4BEG[14] VPWR VGND sg13cmos5l_antennanp
XFILLER_333_0 VPWR VGND sg13cmos5l_fill_2
XANTENNA__2543__D Tile_X0Y3_FrameData[1] VPWR VGND sg13cmos5l_antennanp
XFILLER_13_275 VPWR VGND sg13cmos5l_fill_1
XFILLER_213_181 VPWR VGND sg13cmos5l_decap_8
XANTENNA__1559__A0 Tile_X0Y3_W2MID[1] VPWR VGND sg13cmos5l_antennanp
XFILLER_126_111 VPWR VGND sg13cmos5l_decap_4
XFILLER_173_239 VPWR VGND sg13cmos5l_decap_8
XANTENNA__1023__A2 Tile_X0Y5_W6END[5] VPWR VGND sg13cmos5l_antennanp
XANTENNA__0782__A1 Tile_X0Y5_N2END[0] VPWR VGND sg13cmos5l_antennanp
XFILLER_126_166 VPWR VGND sg13cmos5l_fill_1
XFILLER_181_250 VPWR VGND sg13cmos5l_fill_1
XFILLER_55_7 VPWR VGND sg13cmos5l_decap_8
X_1420_ AXI_M_SOC_WDATA17 Tile_X0Y2_WW4END[1] Tile_X0Y2_WW4END[9] Tile_X0Y2_W6END[9]
+ _1369_/X _2326_/Q _2325_/Q VPWR VGND sg13cmos5l_mux4_1
X_1351_ _1351_/X _1178_/X _1349_/X _1350_/X _1177_/X _2522_/Q _2521_/Q VPWR VGND sg13cmos5l_mux4_1
XFILLER_205_25 VPWR VGND sg13cmos5l_fill_2
XFILLER_205_58 VPWR VGND sg13cmos5l_decap_4
X_1282_ _3468_/A Tile_X0Y1_WW4END[11] AXI_M_SOC_RDATA26 _0956_/X _1094_/X _2120_/Q
+ _2119_/Q VPWR VGND sg13cmos5l_mux4_1
XANTENNA__2718__D Tile_X0Y3_FrameData[18] VPWR VGND sg13cmos5l_antennanp
X_3021_ _3021_/Q Tile_X0Y4_FrameData[19] Tile_X0Y5_FrameStrobe[7] VPWR VGND sg13cmos5l_dlhq_1
XFILLER_95_70 VPWR VGND sg13cmos5l_decap_8
XFILLER_48_161 VPWR VGND sg13cmos5l_decap_8
XANTENNA__0837__A2 Tile_X0Y5_WW4END[10] VPWR VGND sg13cmos5l_antennanp
XFILLER_236_251 VPWR VGND sg13cmos5l_fill_1
XANTENNA__3399__A Tile_X0Y2_FrameData[1] VPWR VGND sg13cmos5l_antennanp
XANTENNA__2180__GATE Tile_X0Y5_FrameStrobe[6] VPWR VGND sg13cmos5l_antennanp
X_3923_ Tile_X0Y5_S4BEG[12] _3923_/A VPWR VGND sg13cmos5l_buf_1
XANTENNA__2453__D Tile_X0Y2_FrameData[11] VPWR VGND sg13cmos5l_antennanp
XANTENNA__3686__X Tile_X0Y3_EE4BEG[5] VPWR VGND sg13cmos5l_antennanp
X_3854_ Tile_X0Y5_EE4BEG[11] _3854_/A VPWR VGND sg13cmos5l_buf_1
X_2805_ _2805_/Q Tile_X0Y4_FrameData[11] Tile_X0Y5_FrameStrobe[0] VPWR VGND sg13cmos5l_dlhq_1
XFILLER_81_0 VPWR VGND sg13cmos5l_fill_2
XANTENNA__2195__GATE Tile_X0Y5_FrameStrobe[7] VPWR VGND sg13cmos5l_antennanp
X_3785_ Tile_X0Y4_FrameData_O[7] Tile_X0Y4_FrameData[7] VPWR VGND sg13cmos5l_buf_1
X_0997_ _0997_/X Tile_X0Y4_W1END[2] Tile_X0Y4_WW4END[2] Tile_X0Y4_W6END[10] _0996_/X
+ _3026_/Q _3025_/Q VPWR VGND sg13cmos5l_mux4_1
XANTENNA__1014__A2 Tile_X0Y2_W6END[10] VPWR VGND sg13cmos5l_antennanp
X_2736_ _2736_/Q Tile_X0Y3_FrameData[0] Tile_X0Y5_FrameStrobe[6] VPWR VGND sg13cmos5l_dlhq_1
XANTENNA__3284__D Tile_X0Y5_FrameData[28] VPWR VGND sg13cmos5l_antennanp
XFILLER_117_166 VPWR VGND sg13cmos5l_decap_8
XFILLER_172_261 VPWR VGND sg13cmos5l_decap_8
XFILLER_246_54 VPWR VGND sg13cmos5l_fill_1
X_2667_ _2667_/Q Tile_X0Y3_FrameData[5] Tile_X0Y5_FrameStrobe[4] VPWR VGND sg13cmos5l_dlhq_1
XANTENNA__3862__A Tile_X0Y5_FrameData[3] VPWR VGND sg13cmos5l_antennanp
XFILLER_172_283 VPWR VGND sg13cmos5l_fill_1
X_1618_ _3750_/A Tile_X0Y5_N4END[4] _1126_/X _1061_/X _1127_/X _2911_/Q _2912_/Q VPWR
+ VGND sg13cmos5l_mux4_1
XFILLER_321_225 VPWR VGND sg13cmos5l_decap_4
XFILLER_321_203 VPWR VGND sg13cmos5l_fill_1
X_2598_ _2598_/Q Tile_X0Y3_FrameData[10] Tile_X0Y5_FrameStrobe[2] VPWR VGND sg13cmos5l_dlhq_1
XFILLER_115_36 VPWR VGND sg13cmos5l_fill_2
X_1549_ AXI_M_SOC_ARADDR27 Tile_X0Y3_WW4END[3] Tile_X0Y3_WW4END[11] Tile_X0Y3_W6END[3]
+ _1526_/X _2610_/Q _2609_/Q VPWR VGND sg13cmos5l_mux4_1
XFILLER_86_223 VPWR VGND sg13cmos5l_decap_4
XFILLER_140_180 VPWR VGND sg13cmos5l_fill_2
XFILLER_75_18 VPWR VGND sg13cmos5l_fill_2
XANTENNA__2133__GATE Tile_X0Y5_FrameStrobe[5] VPWR VGND sg13cmos5l_antennanp
XANTENNA__2628__D Tile_X0Y3_FrameData[12] VPWR VGND sg13cmos5l_antennanp
X_3219_ _3219_/Q Tile_X0Y5_FrameData[29] Tile_X0Y5_FrameStrobe[5] VPWR VGND sg13cmos5l_dlhq_1
XANTENNA__2763__GATE Tile_X0Y5_FrameStrobe[7] VPWR VGND sg13cmos5l_antennanp
XFILLER_264_8 VPWR VGND sg13cmos5l_fill_1
XANTENNA__0726__A Tile_X0Y3_W6END[3] VPWR VGND sg13cmos5l_antennanp
XANTENNA__2148__GATE Tile_X0Y5_FrameStrobe[5] VPWR VGND sg13cmos5l_antennanp
XANTENNA__2778__GATE Tile_X0Y5_FrameStrobe[8] VPWR VGND sg13cmos5l_antennanp
XANTENNA__2363__D Tile_X0Y2_FrameData[5] VPWR VGND sg13cmos5l_antennanp
XANTENNA__3596__X Tile_X0Y0_FrameData_O[27] VPWR VGND sg13cmos5l_antennanp
XANTENNA__2701__GATE Tile_X0Y5_FrameStrobe[5] VPWR VGND sg13cmos5l_antennanp
XANTENNA__1005__A2 Tile_X0Y0_S1END[2] VPWR VGND sg13cmos5l_antennanp
XFILLER_156_21 VPWR VGND sg13cmos5l_decap_8
XFILLER_40_54 VPWR VGND sg13cmos5l_decap_8
XFILLER_40_43 VPWR VGND sg13cmos5l_fill_1
XFILLER_40_32 VPWR VGND sg13cmos5l_decap_8
XANTENNA__1707__D Tile_X0Y0_FrameData[21] VPWR VGND sg13cmos5l_antennanp
XANTENNA__3194__D Tile_X0Y5_FrameData[22] VPWR VGND sg13cmos5l_antennanp
XANTENNA__0764__A1 Tile_X0Y1_WW4END[9] VPWR VGND sg13cmos5l_antennanp
XFILLER_40_98 VPWR VGND sg13cmos5l_decap_8
XANTENNA__2716__GATE Tile_X0Y5_FrameStrobe[6] VPWR VGND sg13cmos5l_antennanp
XFILLER_312_258 VPWR VGND sg13cmos5l_decap_4
XFILLER_277_140 VPWR VGND sg13cmos5l_fill_1
XANTENNA__1972__GATE Tile_X0Y5_FrameStrobe[0] VPWR VGND sg13cmos5l_antennanp
XFILLER_172_64 VPWR VGND sg13cmos5l_decap_4
XANTENNA__2538__D Tile_X0Y3_FrameData[6] VPWR VGND sg13cmos5l_antennanp
XFILLER_283_0 VPWR VGND sg13cmos5l_fill_2
XFILLER_92_215 VPWR VGND sg13cmos5l_fill_2
XFILLER_92_204 VPWR VGND sg13cmos5l_decap_8
XFILLER_218_262 VPWR VGND sg13cmos5l_fill_2
XFILLER_45_153 VPWR VGND sg13cmos5l_decap_8
XFILLER_45_142 VPWR VGND sg13cmos5l_fill_1
XANTENNA__1492__A2 AXI_M_SOC_RDATA14 VPWR VGND sg13cmos5l_antennanp
XANTENNA__1987__GATE Tile_X0Y5_FrameStrobe[0] VPWR VGND sg13cmos5l_antennanp
XFILLER_60_101 VPWR VGND sg13cmos5l_fill_2
XFILLER_233_276 VPWR VGND sg13cmos5l_fill_1
XANTENNA__1910__GATE Tile_X0Y5_FrameStrobe[6] VPWR VGND sg13cmos5l_antennanp
XANTENNA__2273__D Tile_X0Y2_FrameData[31] VPWR VGND sg13cmos5l_antennanp
XFILLER_198_180 VPWR VGND sg13cmos5l_fill_1
X_0920_ _0920_/X Tile_X0Y1_WW4END[4] Tile_X0Y1_WW4END[12] Tile_X0Y1_W6END[4] _0919_/X
+ _2064_/Q _2063_/Q VPWR VGND sg13cmos5l_mux4_1
XFILLER_81_61 VPWR VGND sg13cmos5l_fill_2
XFILLER_201_140 VPWR VGND sg13cmos5l_fill_1
X_0851_ _0851_/Y _3126_/Q _0786_/X _0850_/Y VPWR VGND sg13cmos5l_a21oi_1
X_3570_ Tile_X0Y0_FrameData_O[1] Tile_X0Y0_FrameData[1] VPWR VGND sg13cmos5l_buf_1
X_0782_ _0782_/X Tile_X0Y5_N2MID[0] Tile_X0Y5_N2END[0] _3903_/A _0780_/X _3080_/Q
+ _3079_/Q VPWR VGND sg13cmos5l_mux4_1
XANTENNA__1925__GATE Tile_X0Y5_FrameStrobe[7] VPWR VGND sg13cmos5l_antennanp
X_2521_ _2521_/Q Tile_X0Y3_FrameData[23] Tile_X0Y5_FrameStrobe[0] VPWR VGND sg13cmos5l_dlhq_1
XANTENNA__0755__A1 Tile_X0Y5_W6END[3] VPWR VGND sg13cmos5l_antennanp
XFILLER_114_147 VPWR VGND sg13cmos5l_decap_8
X_2452_ _2452_/Q Tile_X0Y2_FrameData[12] Tile_X0Y5_FrameStrobe[6] VPWR VGND sg13cmos5l_dlhq_1
XFILLER_268_140 VPWR VGND sg13cmos5l_decap_4
X_2383_ _2383_/Q Tile_X0Y2_FrameData[17] Tile_X0Y5_FrameStrobe[4] VPWR VGND sg13cmos5l_dlhq_1
X_1403_ _3375_/A AXI_M_SOC_RDATA15 _1379_/X _1313_/X _1143_/X _2357_/Q _2358_/Q VPWR
+ VGND sg13cmos5l_mux4_1
XFILLER_68_212 VPWR VGND sg13cmos5l_fill_1
XFILLER_68_201 VPWR VGND sg13cmos5l_decap_8
X_1334_ _3492_/A Tile_X0Y1_W2END[7] AXI_M_SOC_RDATA29 _1110_/X _1115_/X _2144_/Q _2143_/Q
+ VPWR VGND sg13cmos5l_mux4_1
XANTENNA__1180__A1 Tile_X0Y0_W2END[0] VPWR VGND sg13cmos5l_antennanp
XANTENNA__2448__D Tile_X0Y2_FrameData[16] VPWR VGND sg13cmos5l_antennanp
X_1265_ _3601_/A Tile_X0Y0_WW4END[15] AXI_M_SOC_RDATA30 _1124_/X _1136_/X _1856_/Q
+ _1855_/Q VPWR VGND sg13cmos5l_mux4_1
XFILLER_283_154 VPWR VGND sg13cmos5l_fill_2
X_3004_ _3004_/Q Tile_X0Y4_FrameData[4] Tile_X0Y5_FrameStrobe[6] VPWR VGND sg13cmos5l_dlhq_1
XFILLER_36_120 VPWR VGND sg13cmos5l_fill_1
XFILLER_209_273 VPWR VGND sg13cmos5l_fill_1
X_1196_ AXI_M_SOC_AWADDR12 Tile_X0Y0_WW4END[4] Tile_X0Y0_W6END[4] Tile_X0Y0_WW4END[12]
+ _1068_/X _1791_/Q _1792_/Q VPWR VGND sg13cmos5l_mux4_1
XFILLER_36_142 VPWR VGND sg13cmos5l_fill_2
XFILLER_36_131 VPWR VGND sg13cmos5l_decap_8
XANTENNA__0691__A0 Tile_X0Y1_W6END[6] VPWR VGND sg13cmos5l_antennanp
XANTENNA__3279__D Tile_X0Y5_FrameData[1] VPWR VGND sg13cmos5l_antennanp
XFILLER_101_38 VPWR VGND sg13cmos5l_decap_8
XANTENNA__2183__D Tile_X0Y1_FrameData[9] VPWR VGND sg13cmos5l_antennanp
X_3906_ Tile_X0Y5_S2BEGb[3] _3906_/A VPWR VGND sg13cmos5l_buf_1
XFILLER_51_189 VPWR VGND sg13cmos5l_decap_4
XANTENNA__1235__A2 AXI_M_SOC_AWREADY VPWR VGND sg13cmos5l_antennanp
XFILLER_338_144 VPWR VGND sg13cmos5l_fill_2
XANTENNA__0994__A1 Tile_X0Y0_WW4END[14] VPWR VGND sg13cmos5l_antennanp
X_3837_ Tile_X0Y5_E6BEG[6] _3837_/A VPWR VGND sg13cmos5l_buf_1
XANTENNA__2911__D Tile_X0Y4_FrameData[1] VPWR VGND sg13cmos5l_antennanp
X_3768_ Tile_X0Y4_EE4BEG[6] _3768_/A VPWR VGND sg13cmos5l_buf_1
XFILLER_338_188 VPWR VGND sg13cmos5l_fill_1
XFILLER_257_86 VPWR VGND sg13cmos5l_decap_8
XFILLER_257_97 VPWR VGND sg13cmos5l_fill_2
X_2719_ _2719_/Q Tile_X0Y3_FrameData[17] Tile_X0Y5_FrameStrobe[6] VPWR VGND sg13cmos5l_dlhq_1
XANTENNA__3592__A Tile_X0Y0_FrameData[23] VPWR VGND sg13cmos5l_antennanp
XFILLER_105_103 VPWR VGND sg13cmos5l_decap_8
X_3699_ Tile_X0Y3_FrameData_O[2] Tile_X0Y3_FrameData[2] VPWR VGND sg13cmos5l_buf_1
XANTENNA__2072__GATE Tile_X0Y5_FrameStrobe[3] VPWR VGND sg13cmos5l_antennanp
XANTENNA__1171__A1 Tile_X0Y0_WW4END[1] VPWR VGND sg13cmos5l_antennanp
XANTENNA__2358__D Tile_X0Y2_FrameData[10] VPWR VGND sg13cmos5l_antennanp
XFILLER_274_187 VPWR VGND sg13cmos5l_decap_4
XANTENNA__1474__A2 AXI_M_SOC_RDATA18 VPWR VGND sg13cmos5l_antennanp
XANTENNA__2087__GATE Tile_X0Y5_FrameStrobe[3] VPWR VGND sg13cmos5l_antennanp
XFILLER_215_243 VPWR VGND sg13cmos5l_decap_8
XFILLER_215_254 VPWR VGND sg13cmos5l_fill_1
XFILLER_35_43 VPWR VGND sg13cmos5l_decap_8
XFILLER_215_276 VPWR VGND sg13cmos5l_decap_4
XFILLER_230_202 VPWR VGND sg13cmos5l_decap_8
XFILLER_27_197 VPWR VGND sg13cmos5l_decap_8
XANTENNA__2010__GATE Tile_X0Y5_FrameStrobe[1] VPWR VGND sg13cmos5l_antennanp
XANTENNA__2093__D Tile_X0Y1_FrameData[3] VPWR VGND sg13cmos5l_antennanp
XANTENNA__3189__D Tile_X0Y5_FrameData[27] VPWR VGND sg13cmos5l_antennanp
XANTENNA__2640__GATE Tile_X0Y5_FrameStrobe[3] VPWR VGND sg13cmos5l_antennanp
XFILLER_51_42 VPWR VGND sg13cmos5l_decap_8
XANTENNA__2821__D Tile_X0Y4_FrameData[27] VPWR VGND sg13cmos5l_antennanp
XFILLER_129_0 VPWR VGND sg13cmos5l_fill_2
XFILLER_167_42 VPWR VGND sg13cmos5l_decap_8
XANTENNA__2025__GATE Tile_X0Y5_FrameStrobe[1] VPWR VGND sg13cmos5l_antennanp
XANTENNA__2655__GATE Tile_X0Y5_FrameStrobe[4] VPWR VGND sg13cmos5l_antennanp
XFILLER_104_191 VPWR VGND sg13cmos5l_decap_8
XFILLER_333_44 VPWR VGND sg13cmos5l_decap_8
XANTENNA__2268__D Tile_X0Y2_FrameData[4] VPWR VGND sg13cmos5l_antennanp
XFILLER_333_55 VPWR VGND sg13cmos5l_fill_1
XFILLER_65_215 VPWR VGND sg13cmos5l_fill_2
XFILLER_206_210 VPWR VGND sg13cmos5l_fill_2
X_1050_ _1050_/X Tile_X0Y4_W1END[0] Tile_X0Y4_W6END[4] _1070_/X _0591_/X _3056_/Q
+ _3055_/Q VPWR VGND sg13cmos5l_mux4_1
XANTENNA__1900__D Tile_X0Y0_FrameData[20] VPWR VGND sg13cmos5l_antennanp
XFILLER_80_229 VPWR VGND sg13cmos5l_decap_8
XFILLER_206_265 VPWR VGND sg13cmos5l_fill_2
XFILLER_280_179 VPWR VGND sg13cmos5l_fill_1
XANTENNA__3099__D Tile_X0Y5_FrameData[21] VPWR VGND sg13cmos5l_antennanp
XANTENNA__2608__GATE Tile_X0Y5_FrameStrobe[2] VPWR VGND sg13cmos5l_antennanp
X_1952_ _1952_/Q Tile_X0Y0_FrameData[0] Tile_X0Y5_FrameStrobe[7] VPWR VGND sg13cmos5l_dlhq_1
XFILLER_119_228 VPWR VGND sg13cmos5l_decap_8
X_1883_ _1883_/Q Tile_X0Y0_FrameData[5] Tile_X0Y5_FrameStrobe[5] VPWR VGND sg13cmos5l_dlhq_1
X_0903_ _0903_/Y _3294_/Q _0899_/X _0902_/Y VPWR VGND sg13cmos5l_a21oi_1
XANTENNA__1864__GATE Tile_X0Y5_FrameStrobe[5] VPWR VGND sg13cmos5l_antennanp
XANTENNA__2731__D Tile_X0Y3_FrameData[5] VPWR VGND sg13cmos5l_antennanp
X_3622_ Tile_X0Y0_E6BEG[5] _3622_/A VPWR VGND sg13cmos5l_buf_1
X_0834_ _3841_/A AXI_M_SOC_RVALID _0646_/X _0648_/X _0559_/X _3163_/Q _3164_/Q VPWR
+ VGND sg13cmos5l_mux4_1
X_3553_ Tile_X0Y0_FrameStrobe_O[4] Tile_X0Y5_FrameStrobe[4] VPWR VGND sg13cmos5l_buf_1
X_0765_ _0765_/X _0763_/X _0764_/X _0762_/X _0761_/X _3343_/Q _3342_/Q VPWR VGND sg13cmos5l_mux4_1
XFILLER_227_67 VPWR VGND sg13cmos5l_fill_2
X_2504_ _2504_/Q Tile_X0Y2_FrameData[24] Tile_X0Y5_FrameStrobe[8] VPWR VGND sg13cmos5l_dlhq_1
X_3484_ Tile_X0Y1_E6BEG[4] _3484_/A VPWR VGND sg13cmos5l_buf_1
X_0696_ _0696_/X Tile_X0Y5_N1END[2] Tile_X0Y5_N4END[2] _0990_/B _0693_/X _3092_/Q
+ _3091_/Q VPWR VGND sg13cmos5l_mux4_1
XFILLER_44_0 VPWR VGND sg13cmos5l_fill_2
XANTENNA__1879__GATE Tile_X0Y5_FrameStrobe[5] VPWR VGND sg13cmos5l_antennanp
X_2435_ _2435_/Q Tile_X0Y2_FrameData[29] Tile_X0Y5_FrameStrobe[6] VPWR VGND sg13cmos5l_dlhq_1
XANTENNA__1153__A1 Tile_X0Y0_W6END[7] VPWR VGND sg13cmos5l_antennanp
XANTENNA__2178__D Tile_X0Y1_FrameData[14] VPWR VGND sg13cmos5l_antennanp
X_2366_ _2366_/Q Tile_X0Y2_FrameData[2] Tile_X0Y5_FrameStrobe[3] VPWR VGND sg13cmos5l_dlhq_1
XANTENNA__1802__GATE Tile_X0Y5_FrameStrobe[3] VPWR VGND sg13cmos5l_antennanp
XFILLER_256_176 VPWR VGND sg13cmos5l_fill_1
X_2297_ _2297_/Q Tile_X0Y2_FrameData[7] Tile_X0Y5_FrameStrobe[1] VPWR VGND sg13cmos5l_dlhq_1
X_1317_ _1317_/X Tile_X0Y5_W2MID[2] Tile_X0Y5_W2END[2] Tile_X0Y5_W6END[2] _0656_/X
+ _3310_/Q _3309_/Q VPWR VGND sg13cmos5l_mux4_1
XFILLER_56_237 VPWR VGND sg13cmos5l_decap_4
XFILLER_2_91 VPWR VGND sg13cmos5l_fill_1
X_1248_ _3647_/A _1024_/X AXI_M_SOC_RDATA31 Tile_X0Y0_S1END[2] AXI_M_SOC_BRESP1 _1891_/Q
+ _1892_/Q VPWR VGND sg13cmos5l_mux4_1
XANTENNA__1810__D Tile_X0Y0_FrameData[14] VPWR VGND sg13cmos5l_antennanp
XANTENNA__2906__D Tile_X0Y4_FrameData[6] VPWR VGND sg13cmos5l_antennanp
XFILLER_112_48 VPWR VGND sg13cmos5l_decap_8
XANTENNA__1817__GATE Tile_X0Y5_FrameStrobe[3] VPWR VGND sg13cmos5l_antennanp
XFILLER_24_123 VPWR VGND sg13cmos5l_fill_1
X_1179_ _1179_/X _1112_/X _1177_/X _1178_/X _1114_/X _2249_/Q _2250_/Q VPWR VGND sg13cmos5l_mux4_1
XANTENNA__3587__A Tile_X0Y0_FrameData[18] VPWR VGND sg13cmos5l_antennanp
XFILLER_169_128 VPWR VGND sg13cmos5l_fill_2
XFILLER_212_246 VPWR VGND sg13cmos5l_decap_4
XANTENNA__1208__A2 Tile_X0Y0_WW4END[6] VPWR VGND sg13cmos5l_antennanp
XFILLER_268_52 VPWR VGND sg13cmos5l_decap_4
XFILLER_268_63 VPWR VGND sg13cmos5l_fill_2
XANTENNA__2641__D Tile_X0Y3_FrameData[31] VPWR VGND sg13cmos5l_antennanp
XANTENNA__3874__X Tile_X0Y5_FrameData_O[15] VPWR VGND sg13cmos5l_antennanp
XFILLER_125_209 VPWR VGND sg13cmos5l_decap_8
XFILLER_284_95 VPWR VGND sg13cmos5l_fill_1
XFILLER_97_27 VPWR VGND sg13cmos5l_decap_4
XFILLER_279_268 VPWR VGND sg13cmos5l_fill_1
XANTENNA__1144__A1 Tile_X0Y0_W2END[6] VPWR VGND sg13cmos5l_antennanp
XANTENNA__2088__D Tile_X0Y1_FrameData[8] VPWR VGND sg13cmos5l_antennanp
XFILLER_153_55 VPWR VGND sg13cmos5l_decap_8
XFILLER_247_121 VPWR VGND sg13cmos5l_fill_1
XANTENNA__1695__A2 Tile_X0Y5_W6END[9] VPWR VGND sg13cmos5l_antennanp
XANTENNA__1447__A2 AXI_M_SOC_RDATA19 VPWR VGND sg13cmos5l_antennanp
XANTENNA__1720__D Tile_X0Y0_FrameData[8] VPWR VGND sg13cmos5l_antennanp
XANTENNA__2816__D Tile_X0Y4_FrameData[0] VPWR VGND sg13cmos5l_antennanp
XANTENNA__3323__GATE Tile_X0Y5_FrameStrobe[8] VPWR VGND sg13cmos5l_antennanp
XFILLER_262_146 VPWR VGND sg13cmos5l_decap_8
XFILLER_46_53 VPWR VGND sg13cmos5l_decap_8
XANTENNA__0655__A0 Tile_X0Y3_W1END[1] VPWR VGND sg13cmos5l_antennanp
XFILLER_46_97 VPWR VGND sg13cmos5l_fill_1
XFILLER_15_145 VPWR VGND sg13cmos5l_decap_8
XFILLER_15_178 VPWR VGND sg13cmos5l_decap_8
XFILLER_246_0 VPWR VGND sg13cmos5l_fill_2
XFILLER_203_279 VPWR VGND sg13cmos5l_fill_2
XFILLER_62_63 VPWR VGND sg13cmos5l_decap_8
XANTENNA__3338__GATE Tile_X0Y5_FrameStrobe[8] VPWR VGND sg13cmos5l_antennanp
XANTENNA__2551__D Tile_X0Y3_FrameData[25] VPWR VGND sg13cmos5l_antennanp
XANTENNA__3784__X Tile_X0Y4_FrameData_O[6] VPWR VGND sg13cmos5l_antennanp
XFILLER_178_74 VPWR VGND sg13cmos5l_decap_8
XFILLER_328_22 VPWR VGND sg13cmos5l_fill_2
XFILLER_317_125 VPWR VGND sg13cmos5l_fill_2
XANTENNA__2594__GATE Tile_X0Y5_FrameStrobe[2] VPWR VGND sg13cmos5l_antennanp
XFILLER_7_69 VPWR VGND sg13cmos5l_decap_8
XFILLER_194_51 VPWR VGND sg13cmos5l_decap_8
XFILLER_328_77 VPWR VGND sg13cmos5l_fill_2
X_0550_ _0550_/Y _1025_/X VPWR VGND sg13cmos5l_inv_1
XFILLER_285_205 VPWR VGND sg13cmos5l_fill_2
XFILLER_285_216 VPWR VGND sg13cmos5l_fill_2
X_2220_ _2220_/Q Tile_X0Y1_FrameData[4] Tile_X0Y5_FrameStrobe[7] VPWR VGND sg13cmos5l_dlhq_1
XFILLER_97_137 VPWR VGND sg13cmos5l_fill_2
XANTENNA__1135__A1 Tile_X0Y5_W6END[7] VPWR VGND sg13cmos5l_antennanp
XFILLER_285_238 VPWR VGND sg13cmos5l_fill_1
XFILLER_293_260 VPWR VGND sg13cmos5l_decap_8
X_2151_ _2151_/Q Tile_X0Y1_FrameData[9] Tile_X0Y5_FrameStrobe[5] VPWR VGND sg13cmos5l_dlhq_1
XANTENNA__2532__GATE Tile_X0Y5_FrameStrobe[0] VPWR VGND sg13cmos5l_antennanp
XFILLER_213_36 VPWR VGND sg13cmos5l_decap_4
XFILLER_213_58 VPWR VGND sg13cmos5l_decap_8
XFILLER_293_293 VPWR VGND sg13cmos5l_fill_2
X_2082_ _2082_/Q Tile_X0Y1_FrameData[14] Tile_X0Y5_FrameStrobe[3] VPWR VGND sg13cmos5l_dlhq_1
X_1102_ _1102_/X Tile_X0Y3_W2MID[6] Tile_X0Y3_W2END[6] Tile_X0Y3_W6END[6] _1219_/X
+ _2774_/Q _2773_/Q VPWR VGND sg13cmos5l_mux4_1
XFILLER_38_248 VPWR VGND sg13cmos5l_decap_8
XANTENNA__2726__D Tile_X0Y3_FrameData[10] VPWR VGND sg13cmos5l_antennanp
X_1033_ _1033_/Y _3029_/Q _1049_/X _1032_/Y VPWR VGND sg13cmos5l_a21oi_1
XFILLER_53_207 VPWR VGND sg13cmos5l_decap_8
XANTENNA__0646__A0 Tile_X0Y5_N1END[1] VPWR VGND sg13cmos5l_antennanp
XANTENNA__1438__A2 Tile_X0Y2_WW4END[13] VPWR VGND sg13cmos5l_antennanp
XANTENNA__2547__GATE Tile_X0Y5_FrameStrobe[1] VPWR VGND sg13cmos5l_antennanp
XFILLER_21_126 VPWR VGND sg13cmos5l_fill_1
X_2984_ _2984_/Q Tile_X0Y4_FrameData[24] Tile_X0Y5_FrameStrobe[6] VPWR VGND sg13cmos5l_dlhq_1
XFILLER_61_284 VPWR VGND sg13cmos5l_fill_2
XFILLER_21_148 VPWR VGND sg13cmos5l_fill_2
X_1935_ _1935_/Q Tile_X0Y0_FrameData[17] Tile_X0Y5_FrameStrobe[7] VPWR VGND sg13cmos5l_dlhq_1
XANTENNA__1071__A0 Tile_X0Y2_W2MID[7] VPWR VGND sg13cmos5l_antennanp
XANTENNA__2461__D Tile_X0Y2_FrameData[3] VPWR VGND sg13cmos5l_antennanp
XANTENNA__3694__X Tile_X0Y3_EE4BEG[13] VPWR VGND sg13cmos5l_antennanp
XFILLER_159_172 VPWR VGND sg13cmos5l_decap_8
XFILLER_174_164 VPWR VGND sg13cmos5l_decap_8
XFILLER_238_44 VPWR VGND sg13cmos5l_fill_2
XFILLER_238_66 VPWR VGND sg13cmos5l_fill_1
X_1866_ _1866_/Q Tile_X0Y0_FrameData[22] Tile_X0Y5_FrameStrobe[5] VPWR VGND sg13cmos5l_dlhq_1
XFILLER_174_197 VPWR VGND sg13cmos5l_decap_4
X_3605_ Tile_X0Y0_EE4BEG[4] _3605_/A VPWR VGND sg13cmos5l_buf_1
X_1797_ _1797_/Q Tile_X0Y0_FrameData[27] Tile_X0Y5_FrameStrobe[3] VPWR VGND sg13cmos5l_dlhq_1
X_0817_ _3852_/A Tile_X0Y5_WW4END[6] _0695_/X AXI_M_SOC_RVALID _0559_/X _3197_/Q _3198_/Q
+ VPWR VGND sg13cmos5l_mux4_1
X_3536_ Tile_X0Y0_N2BEGb[7] _3536_/A VPWR VGND sg13cmos5l_buf_1
X_0748_ _0748_/Y _0536_/Y _0747_/X _3257_/Q VPWR VGND sg13cmos5l_a21oi_1
XANTENNA__3292__D Tile_X0Y5_FrameData[20] VPWR VGND sg13cmos5l_antennanp
XFILLER_115_253 VPWR VGND sg13cmos5l_fill_2
XANTENNA__1805__D Tile_X0Y0_FrameData[19] VPWR VGND sg13cmos5l_antennanp
XANTENNA__3870__A Tile_X0Y5_FrameData[11] VPWR VGND sg13cmos5l_antennanp
X_3467_ Tile_X0Y1_EE4BEG[3] _3467_/A VPWR VGND sg13cmos5l_buf_1
X_0679_ _0679_/Y _2516_/Q _2515_/Q VPWR VGND sg13cmos5l_nor2b_1
XFILLER_331_183 VPWR VGND sg13cmos5l_fill_2
XANTENNA__1741__GATE Tile_X0Y5_FrameStrobe[1] VPWR VGND sg13cmos5l_antennanp
X_2418_ _2418_/Q Tile_X0Y2_FrameData[14] Tile_X0Y5_FrameStrobe[5] VPWR VGND sg13cmos5l_dlhq_1
X_3398_ Tile_X0Y2_FrameData_O[0] Tile_X0Y2_FrameData[0] VPWR VGND sg13cmos5l_buf_1
XFILLER_229_143 VPWR VGND sg13cmos5l_decap_8
XFILLER_229_154 VPWR VGND sg13cmos5l_fill_1
XFILLER_270_20 VPWR VGND sg13cmos5l_decap_4
X_2349_ _2349_/Q Tile_X0Y2_FrameData[19] Tile_X0Y5_FrameStrobe[3] VPWR VGND sg13cmos5l_dlhq_1
XFILLER_284_293 VPWR VGND sg13cmos5l_fill_2
XANTENNA__2636__D Tile_X0Y3_FrameData[4] VPWR VGND sg13cmos5l_antennanp
XANTENNA__3869__X Tile_X0Y5_FrameData_O[10] VPWR VGND sg13cmos5l_antennanp
XFILLER_44_218 VPWR VGND sg13cmos5l_decap_8
XANTENNA__1429__A2 Tile_X0Y2_W6END[5] VPWR VGND sg13cmos5l_antennanp
XANTENNA__1756__GATE Tile_X0Y5_FrameStrobe[1] VPWR VGND sg13cmos5l_antennanp
XFILLER_203_80 VPWR VGND sg13cmos5l_decap_8
XFILLER_32_22 VPWR VGND sg13cmos5l_fill_1
XANTENNA__2371__D Tile_X0Y2_FrameData[29] VPWR VGND sg13cmos5l_antennanp
XFILLER_148_33 VPWR VGND sg13cmos5l_decap_8
XFILLER_295_50 VPWR VGND sg13cmos5l_decap_4
XFILLER_148_99 VPWR VGND sg13cmos5l_fill_1
XFILLER_180_101 VPWR VGND sg13cmos5l_decap_4
XFILLER_295_94 VPWR VGND sg13cmos5l_decap_8
XFILLER_307_191 VPWR VGND sg13cmos5l_decap_4
XFILLER_164_32 VPWR VGND sg13cmos5l_fill_1
XFILLER_164_43 VPWR VGND sg13cmos5l_decap_4
XANTENNA__1715__D Tile_X0Y0_FrameData[13] VPWR VGND sg13cmos5l_antennanp
XANTENNA__3780__A Tile_X0Y4_FrameData[2] VPWR VGND sg13cmos5l_antennanp
XFILLER_79_148 VPWR VGND sg13cmos5l_decap_8
XANTENNA__1117__A1 Tile_X0Y3_WW4END[11] VPWR VGND sg13cmos5l_antennanp
XANTENNA__1709__GATE Tile_X0Y5_FrameStrobe[0] VPWR VGND sg13cmos5l_antennanp
XFILLER_121_267 VPWR VGND sg13cmos5l_fill_1
XANTENNA__1668__A2 AXI_M_SOC_RRESP0 VPWR VGND sg13cmos5l_antennanp
XFILLER_196_0 VPWR VGND sg13cmos5l_fill_2
XFILLER_275_293 VPWR VGND sg13cmos5l_fill_2
XFILLER_57_63 VPWR VGND sg13cmos5l_decap_8
XANTENNA__2546__D Tile_X0Y3_FrameData[30] VPWR VGND sg13cmos5l_antennanp
XANTENNA__3262__GATE Tile_X0Y5_FrameStrobe[6] VPWR VGND sg13cmos5l_antennanp
XANTENNA__3779__X Tile_X0Y4_FrameData_O[1] VPWR VGND sg13cmos5l_antennanp
XFILLER_290_241 VPWR VGND sg13cmos5l_decap_8
XANTENNA__0891__A3 Tile_X0Y0_S4END[15] VPWR VGND sg13cmos5l_antennanp
XFILLER_113_80 VPWR VGND sg13cmos5l_decap_8
XANTENNA__1299__X AXI_M_SOC_AWADDR4 VPWR VGND sg13cmos5l_antennanp
XFILLER_43_251 VPWR VGND sg13cmos5l_fill_1
XFILLER_330_67 VPWR VGND sg13cmos5l_fill_1
XANTENNA__3277__GATE Tile_X0Y5_FrameStrobe[6] VPWR VGND sg13cmos5l_antennanp
XANTENNA__2281__D Tile_X0Y2_FrameData[23] VPWR VGND sg13cmos5l_antennanp
XANTENNA__3200__GATE Tile_X0Y5_FrameStrobe[4] VPWR VGND sg13cmos5l_antennanp
X_1720_ _1720_/Q Tile_X0Y0_FrameData[8] Tile_X0Y5_FrameStrobe[0] VPWR VGND sg13cmos5l_dlhq_1
XFILLER_7_130 VPWR VGND sg13cmos5l_fill_1
XANTENNA__0800__A0 Tile_X0Y5_W2END[7] VPWR VGND sg13cmos5l_antennanp
XFILLER_156_186 VPWR VGND sg13cmos5l_decap_8
XFILLER_171_112 VPWR VGND sg13cmos5l_decap_4
XFILLER_208_14 VPWR VGND sg13cmos5l_decap_8
X_1651_ AXI_M_SOC_ARADDR15 Tile_X0Y4_W1END[3] Tile_X0Y4_WW4END[7] Tile_X0Y4_WW4END[15]
+ _1127_/X _2858_/Q _2857_/Q VPWR VGND sg13cmos5l_mux4_1
XFILLER_7_152 VPWR VGND sg13cmos5l_decap_4
XFILLER_208_25 VPWR VGND sg13cmos5l_fill_1
X_0602_ _0602_/Y _0530_/Y _0599_/X _0601_/Y VPWR VGND sg13cmos5l_o21ai_1
XFILLER_112_201 VPWR VGND sg13cmos5l_decap_8
X_3321_ _3321_/Q Tile_X0Y5_FrameData[23] Tile_X0Y5_FrameStrobe[8] VPWR VGND sg13cmos5l_dlhq_1
X_1582_ _1583_/A Tile_X0Y3_W1END[3] Tile_X0Y3_W6END[11] Tile_X0Y3_WW4END[3] _1526_/X
+ _2750_/Q _2751_/Q VPWR VGND sg13cmos5l_mux4_1
XANTENNA__3215__GATE Tile_X0Y5_FrameStrobe[4] VPWR VGND sg13cmos5l_antennanp
X_0533_ _0533_/Y _3264_/Q VPWR VGND sg13cmos5l_inv_1
XANTENNA__1108__A1 Tile_X0Y0_W2END[7] VPWR VGND sg13cmos5l_antennanp
X_3252_ _3252_/Q Tile_X0Y5_FrameData[28] Tile_X0Y5_FrameStrobe[6] VPWR VGND sg13cmos5l_dlhq_1
XANTENNA__2471__GATE Tile_X0Y5_FrameStrobe[7] VPWR VGND sg13cmos5l_antennanp
X_3183_ _3183_/Q Tile_X0Y5_FrameData[1] Tile_X0Y5_FrameStrobe[3] VPWR VGND sg13cmos5l_dlhq_1
X_2203_ _2203_/Q Tile_X0Y1_FrameData[21] Tile_X0Y5_FrameStrobe[7] VPWR VGND sg13cmos5l_dlhq_1
XFILLER_78_170 VPWR VGND sg13cmos5l_fill_1
XFILLER_224_79 VPWR VGND sg13cmos5l_decap_4
X_2134_ _2134_/Q Tile_X0Y1_FrameData[26] Tile_X0Y5_FrameStrobe[5] VPWR VGND sg13cmos5l_dlhq_1
XANTENNA__2456__D Tile_X0Y2_FrameData[8] VPWR VGND sg13cmos5l_antennanp
XANTENNA__3689__X Tile_X0Y3_EE4BEG[8] VPWR VGND sg13cmos5l_antennanp
XFILLER_240_23 VPWR VGND sg13cmos5l_decap_8
XFILLER_266_293 VPWR VGND sg13cmos5l_fill_2
XFILLER_93_151 VPWR VGND sg13cmos5l_decap_8
XANTENNA__0882__A3 Tile_X0Y0_S4END[12] VPWR VGND sg13cmos5l_antennanp
XFILLER_241_105 VPWR VGND sg13cmos5l_fill_2
XFILLER_281_274 VPWR VGND sg13cmos5l_fill_1
X_2065_ _2065_/Q Tile_X0Y1_FrameData[31] Tile_X0Y5_FrameStrobe[3] VPWR VGND sg13cmos5l_dlhq_1
XFILLER_93_184 VPWR VGND sg13cmos5l_decap_8
XANTENNA__2486__GATE Tile_X0Y5_FrameStrobe[7] VPWR VGND sg13cmos5l_antennanp
X_1016_ _1016_/X _1015_/X _0788_/X Tile_X0Y5_N2MID[2] _1014_/X _2803_/Q _2804_/Q VPWR
+ VGND sg13cmos5l_mux4_1
XANTENNA__1292__A0 Tile_X0Y1_WW4END[0] VPWR VGND sg13cmos5l_antennanp
XFILLER_179_267 VPWR VGND sg13cmos5l_fill_1
XANTENNA__1044__A0 Tile_X0Y1_W2MID[2] VPWR VGND sg13cmos5l_antennanp
XANTENNA__2191__D Tile_X0Y1_FrameData[1] VPWR VGND sg13cmos5l_antennanp
XANTENNA__3287__D Tile_X0Y5_FrameData[25] VPWR VGND sg13cmos5l_antennanp
XANTENNA__3865__A Tile_X0Y5_FrameData[6] VPWR VGND sg13cmos5l_antennanp
XFILLER_249_54 VPWR VGND sg13cmos5l_decap_4
X_2967_ _2967_/Q Tile_X0Y4_FrameData[9] Tile_X0Y5_FrameStrobe[5] VPWR VGND sg13cmos5l_dlhq_1
XANTENNA__1595__A1 Tile_X0Y3_WW4END[14] VPWR VGND sg13cmos5l_antennanp
X_2898_ _2898_/Q Tile_X0Y4_FrameData[14] Tile_X0Y5_FrameStrobe[3] VPWR VGND sg13cmos5l_dlhq_1
X_1918_ _1918_/Q Tile_X0Y0_FrameData[2] Tile_X0Y5_FrameStrobe[6] VPWR VGND sg13cmos5l_dlhq_1
X_1849_ _1849_/Q Tile_X0Y0_FrameData[7] Tile_X0Y5_FrameStrobe[4] VPWR VGND sg13cmos5l_dlhq_1
XFILLER_336_286 VPWR VGND sg13cmos5l_fill_1
XFILLER_336_253 VPWR VGND sg13cmos5l_fill_1
XANTENNA__2424__GATE Tile_X0Y5_FrameStrobe[5] VPWR VGND sg13cmos5l_antennanp
XFILLER_118_25 VPWR VGND sg13cmos5l_fill_2
XFILLER_265_42 VPWR VGND sg13cmos5l_fill_1
XANTENNA__1347__A1 Tile_X0Y2_W2MID[1] VPWR VGND sg13cmos5l_antennanp
XFILLER_118_69 VPWR VGND sg13cmos5l_decap_8
XFILLER_265_64 VPWR VGND sg13cmos5l_fill_1
XFILLER_265_97 VPWR VGND sg13cmos5l_fill_1
X_3519_ Tile_X0Y0_N4BEG[6] _3519_/A VPWR VGND sg13cmos5l_buf_1
XFILLER_134_35 VPWR VGND sg13cmos5l_decap_4
XANTENNA__2439__GATE Tile_X0Y5_FrameStrobe[6] VPWR VGND sg13cmos5l_antennanp
XFILLER_217_113 VPWR VGND sg13cmos5l_decap_8
XFILLER_281_96 VPWR VGND sg13cmos5l_fill_2
XFILLER_287_7 VPWR VGND sg13cmos5l_decap_8
XFILLER_69_181 VPWR VGND sg13cmos5l_decap_8
XANTENNA__2366__D Tile_X0Y2_FrameData[2] VPWR VGND sg13cmos5l_antennanp
XANTENNA__3599__X Tile_X0Y0_FrameData_O[30] VPWR VGND sg13cmos5l_antennanp
XFILLER_217_146 VPWR VGND sg13cmos5l_decap_4
XFILLER_257_293 VPWR VGND sg13cmos5l_fill_2
XFILLER_84_195 VPWR VGND sg13cmos5l_decap_8
XANTENNA__3197__D Tile_X0Y5_FrameData[19] VPWR VGND sg13cmos5l_antennanp
XFILLER_309_57 VPWR VGND sg13cmos5l_decap_8
XFILLER_111_0 VPWR VGND sg13cmos5l_fill_2
XFILLER_209_0 VPWR VGND sg13cmos5l_fill_2
XFILLER_4_122 VPWR VGND sg13cmos5l_fill_2
XANTENNA__1338__A1 AXI_M_SOC_RDATA28 VPWR VGND sg13cmos5l_antennanp
XFILLER_4_144 VPWR VGND sg13cmos5l_fill_1
XFILLER_191_30 VPWR VGND sg13cmos5l_decap_4
XFILLER_68_40 VPWR VGND sg13cmos5l_decap_4
XFILLER_325_78 VPWR VGND sg13cmos5l_fill_1
XFILLER_325_56 VPWR VGND sg13cmos5l_fill_1
XANTENNA__0561__A2 Tile_X0Y4_W2END[0] VPWR VGND sg13cmos5l_antennanp
XFILLER_310_197 VPWR VGND sg13cmos5l_fill_1
XANTENNA__1510__A1 AXI_M_SOC_RDATA13 VPWR VGND sg13cmos5l_antennanp
XANTENNA__2276__D Tile_X0Y2_FrameData[28] VPWR VGND sg13cmos5l_antennanp
XFILLER_208_135 VPWR VGND sg13cmos5l_decap_8
XFILLER_208_146 VPWR VGND sg13cmos5l_fill_1
XFILLER_84_72 VPWR VGND sg13cmos5l_decap_4
XFILLER_223_116 VPWR VGND sg13cmos5l_decap_8
XFILLER_84_94 VPWR VGND sg13cmos5l_fill_2
XANTENNA__1274__A0 Tile_X0Y1_WW4END[13] VPWR VGND sg13cmos5l_antennanp
X_3870_ Tile_X0Y5_FrameData_O[11] Tile_X0Y5_FrameData[11] VPWR VGND sg13cmos5l_buf_1
XANTENNA__1026__A0 Tile_X0Y0_W6END[5] VPWR VGND sg13cmos5l_antennanp
X_2821_ _2821_/Q Tile_X0Y4_FrameData[27] Tile_X0Y5_FrameStrobe[1] VPWR VGND sg13cmos5l_dlhq_1
XFILLER_31_254 VPWR VGND sg13cmos5l_decap_8
XFILLER_129_120 VPWR VGND sg13cmos5l_decap_8
XFILLER_129_131 VPWR VGND sg13cmos5l_fill_1
X_2752_ _2752_/Q Tile_X0Y3_FrameData[16] Tile_X0Y5_FrameStrobe[7] VPWR VGND sg13cmos5l_dlhq_1
XFILLER_129_175 VPWR VGND sg13cmos5l_decap_8
X_1703_ _1703_/Q Tile_X0Y0_FrameData[25] Tile_X0Y5_FrameStrobe[0] VPWR VGND sg13cmos5l_dlhq_1
XANTENNA__1041__A3 Tile_X0Y0_S4END[1] VPWR VGND sg13cmos5l_antennanp
X_2683_ _2683_/Q Tile_X0Y3_FrameData[21] Tile_X0Y5_FrameStrobe[5] VPWR VGND sg13cmos5l_dlhq_1
XANTENNA__3154__GATE Tile_X0Y5_FrameStrobe[3] VPWR VGND sg13cmos5l_antennanp
X_1634_ AXI_M_SOC_ARADDR2 Tile_X0Y4_WW4END[2] Tile_X0Y4_W6END[2] Tile_X0Y4_WW4END[10]
+ _0996_/X _2883_/Q _2884_/Q VPWR VGND sg13cmos5l_mux4_1
X_1565_ _1566_/B Tile_X0Y3_W1END[1] Tile_X0Y3_WW4END[13] Tile_X0Y3_W6END[5] _1530_/X
+ _2721_/Q _2720_/Q VPWR VGND sg13cmos5l_mux4_1
XFILLER_301_120 VPWR VGND sg13cmos5l_fill_2
X_3304_ _3304_/Q Tile_X0Y5_FrameData[8] Tile_X0Y5_FrameStrobe[7] VPWR VGND sg13cmos5l_dlhq_1
XFILLER_98_254 VPWR VGND sg13cmos5l_fill_1
X_3235_ _3235_/Q Tile_X0Y5_FrameData[13] Tile_X0Y5_FrameStrobe[5] VPWR VGND sg13cmos5l_dlhq_1
X_1496_ _3650_/A _1017_/X _0629_/X AXI_M_SOC_RDATA8 AXI_M_SOC_RDATA12 _2710_/Q _2709_/Q
+ VPWR VGND sg13cmos5l_mux4_1
XFILLER_58_118 VPWR VGND sg13cmos5l_decap_4
XANTENNA__3169__GATE Tile_X0Y5_FrameStrobe[3] VPWR VGND sg13cmos5l_antennanp
XFILLER_100_237 VPWR VGND sg13cmos5l_fill_2
XANTENNA__1501__A1 AXI_M_SOC_RDATA12 VPWR VGND sg13cmos5l_antennanp
XFILLER_239_293 VPWR VGND sg13cmos5l_fill_2
X_3166_ _3166_/Q Tile_X0Y5_FrameData[18] Tile_X0Y5_FrameStrobe[3] VPWR VGND sg13cmos5l_dlhq_1
XANTENNA__0836__X AXI_M_SOC_RREADY VPWR VGND sg13cmos5l_antennanp
XANTENNA__2186__D Tile_X0Y1_FrameData[6] VPWR VGND sg13cmos5l_antennanp
X_3097_ _3097_/Q Tile_X0Y5_FrameData[23] Tile_X0Y5_FrameStrobe[1] VPWR VGND sg13cmos5l_dlhq_1
X_2117_ _2117_/Q Tile_X0Y1_FrameData[11] Tile_X0Y5_FrameStrobe[4] VPWR VGND sg13cmos5l_dlhq_1
XFILLER_81_121 VPWR VGND sg13cmos5l_fill_1
X_2048_ _2048_/Q Tile_X0Y1_FrameData[16] Tile_X0Y5_FrameStrobe[2] VPWR VGND sg13cmos5l_dlhq_1
XANTENNA__1265__A0 Tile_X0Y0_WW4END[15] VPWR VGND sg13cmos5l_antennanp
XANTENNA__2914__D Tile_X0Y4_FrameData[30] VPWR VGND sg13cmos5l_antennanp
XFILLER_120_59 VPWR VGND sg13cmos5l_fill_1
XANTENNA__3107__GATE Tile_X0Y5_FrameStrobe[1] VPWR VGND sg13cmos5l_antennanp
XFILLER_13_24 VPWR VGND sg13cmos5l_decap_4
XFILLER_196_19 VPWR VGND sg13cmos5l_decap_8
XFILLER_222_182 VPWR VGND sg13cmos5l_fill_2
XANTENNA__1017__A0 Tile_X0Y4_W1END[1] VPWR VGND sg13cmos5l_antennanp
XANTENNA__3595__A Tile_X0Y0_FrameData[26] VPWR VGND sg13cmos5l_antennanp
XFILLER_129_24 VPWR VGND sg13cmos5l_fill_1
XFILLER_309_242 VPWR VGND sg13cmos5l_decap_4
XANTENNA__2363__GATE Tile_X0Y5_FrameStrobe[3] VPWR VGND sg13cmos5l_antennanp
XFILLER_135_101 VPWR VGND sg13cmos5l_decap_8
XFILLER_13_68 VPWR VGND sg13cmos5l_fill_1
XANTENNA__2993__GATE Tile_X0Y5_FrameStrobe[6] VPWR VGND sg13cmos5l_antennanp
XANTENNA__3882__X Tile_X0Y5_FrameData_O[23] VPWR VGND sg13cmos5l_antennanp
XFILLER_190_251 VPWR VGND sg13cmos5l_decap_4
XFILLER_209_90 VPWR VGND sg13cmos5l_fill_2
XFILLER_292_40 VPWR VGND sg13cmos5l_fill_1
XFILLER_296_108 VPWR VGND sg13cmos5l_fill_1
XANTENNA__2378__GATE Tile_X0Y5_FrameStrobe[4] VPWR VGND sg13cmos5l_antennanp
XFILLER_292_51 VPWR VGND sg13cmos5l_decap_8
XFILLER_145_89 VPWR VGND sg13cmos5l_fill_2
XFILLER_89_276 VPWR VGND sg13cmos5l_fill_2
XFILLER_49_107 VPWR VGND sg13cmos5l_decap_8
XFILLER_285_4 VPWR VGND sg13cmos5l_fill_1
XFILLER_38_32 VPWR VGND sg13cmos5l_decap_8
XANTENNA__2301__GATE Tile_X0Y5_FrameStrobe[1] VPWR VGND sg13cmos5l_antennanp
XANTENNA__2096__D Tile_X0Y1_FrameData[0] VPWR VGND sg13cmos5l_antennanp
XANTENNA__2931__GATE Tile_X0Y5_FrameStrobe[4] VPWR VGND sg13cmos5l_antennanp
XFILLER_57_184 VPWR VGND sg13cmos5l_decap_4
XFILLER_205_127 VPWR VGND sg13cmos5l_decap_4
XANTENNA__1256__A0 Tile_X0Y0_W2MID[5] VPWR VGND sg13cmos5l_antennanp
XANTENNA__2316__GATE Tile_X0Y5_FrameStrobe[2] VPWR VGND sg13cmos5l_antennanp
XANTENNA__2824__D Tile_X0Y4_FrameData[24] VPWR VGND sg13cmos5l_antennanp
XFILLER_159_0 VPWR VGND sg13cmos5l_fill_1
XFILLER_72_198 VPWR VGND sg13cmos5l_decap_8
XFILLER_72_176 VPWR VGND sg13cmos5l_decap_4
XFILLER_54_53 VPWR VGND sg13cmos5l_decap_8
XANTENNA__2946__GATE Tile_X0Y5_FrameStrobe[5] VPWR VGND sg13cmos5l_antennanp
XFILLER_13_254 VPWR VGND sg13cmos5l_fill_2
XANTENNA__1008__A0 Tile_X0Y2_W2MID[1] VPWR VGND sg13cmos5l_antennanp
XFILLER_158_259 VPWR VGND sg13cmos5l_fill_2
XANTENNA__1559__A1 Tile_X0Y3_W2END[1] VPWR VGND sg13cmos5l_antennanp
XFILLER_186_30 VPWR VGND sg13cmos5l_fill_2
XFILLER_70_74 VPWR VGND sg13cmos5l_decap_4
XANTENNA__3792__X Tile_X0Y4_FrameData_O[14] VPWR VGND sg13cmos5l_antennanp
XFILLER_141_137 VPWR VGND sg13cmos5l_fill_2
XFILLER_48_7 VPWR VGND sg13cmos5l_decap_8
X_1350_ _1350_/X Tile_X0Y2_W1END[3] Tile_X0Y2_W2MID[0] Tile_X0Y2_W2END[0] _1179_/X
+ _2454_/Q _2453_/Q VPWR VGND sg13cmos5l_mux4_1
XFILLER_95_224 VPWR VGND sg13cmos5l_decap_4
XANTENNA__1903__D Tile_X0Y0_FrameData[17] VPWR VGND sg13cmos5l_antennanp
X_1281_ _3469_/A Tile_X0Y1_WW4END[10] AXI_M_SOC_RDATA27 _0953_/X _1100_/X _2118_/Q
+ _2117_/Q VPWR VGND sg13cmos5l_mux4_1
X_3020_ _3020_/Q Tile_X0Y4_FrameData[20] Tile_X0Y5_FrameStrobe[7] VPWR VGND sg13cmos5l_dlhq_1
XFILLER_48_140 VPWR VGND sg13cmos5l_decap_8
XFILLER_221_14 VPWR VGND sg13cmos5l_decap_8
XFILLER_236_263 VPWR VGND sg13cmos5l_fill_1
XFILLER_221_47 VPWR VGND sg13cmos5l_fill_2
XFILLER_251_222 VPWR VGND sg13cmos5l_decap_8
XANTENNA__1247__A0 AXI_M_SOC_ARREADY VPWR VGND sg13cmos5l_antennanp
XANTENNA__2734__D Tile_X0Y3_FrameData[2] VPWR VGND sg13cmos5l_antennanp
XFILLER_204_171 VPWR VGND sg13cmos5l_decap_8
X_3922_ Tile_X0Y5_S4BEG[11] _3922_/A VPWR VGND sg13cmos5l_buf_1
XFILLER_149_226 VPWR VGND sg13cmos5l_decap_4
X_3853_ Tile_X0Y5_EE4BEG[10] _3853_/A VPWR VGND sg13cmos5l_buf_1
X_2804_ _2804_/Q Tile_X0Y4_FrameData[12] Tile_X0Y5_FrameStrobe[0] VPWR VGND sg13cmos5l_dlhq_1
XFILLER_117_101 VPWR VGND sg13cmos5l_decap_8
XFILLER_164_229 VPWR VGND sg13cmos5l_fill_2
X_3784_ Tile_X0Y4_FrameData_O[6] Tile_X0Y4_FrameData[6] VPWR VGND sg13cmos5l_buf_1
X_0996_ _0996_/X _0992_/X _0684_/X Tile_X0Y5_N4END[6] _0995_/X _2835_/Q _2836_/Q VPWR
+ VGND sg13cmos5l_mux4_1
XFILLER_74_0 VPWR VGND sg13cmos5l_fill_2
XANTENNA__3093__GATE Tile_X0Y5_FrameStrobe[1] VPWR VGND sg13cmos5l_antennanp
XFILLER_306_212 VPWR VGND sg13cmos5l_decap_4
X_2735_ _2735_/Q Tile_X0Y3_FrameData[1] Tile_X0Y5_FrameStrobe[6] VPWR VGND sg13cmos5l_dlhq_1
X_2666_ _2666_/Q Tile_X0Y3_FrameData[6] Tile_X0Y5_FrameStrobe[4] VPWR VGND sg13cmos5l_dlhq_1
X_1617_ _3753_/A Tile_X0Y5_N4END[7] _1063_/X _0980_/X _1070_/X _2905_/Q _2906_/Q VPWR
+ VGND sg13cmos5l_mux4_1
X_2597_ _2597_/Q Tile_X0Y3_FrameData[11] Tile_X0Y5_FrameStrobe[2] VPWR VGND sg13cmos5l_dlhq_1
XFILLER_286_130 VPWR VGND sg13cmos5l_fill_1
X_1548_ AXI_M_SOC_ARADDR31 Tile_X0Y3_WW4END[7] Tile_X0Y3_WW4END[15] Tile_X0Y3_W6END[7]
+ _1435_/X _2602_/Q _2601_/Q VPWR VGND sg13cmos5l_mux4_1
XANTENNA__1813__D Tile_X0Y0_FrameData[11] VPWR VGND sg13cmos5l_antennanp
XANTENNA__2909__D Tile_X0Y4_FrameData[3] VPWR VGND sg13cmos5l_antennanp
X_1479_ _1479_/Y _2446_/Q _0551_/Y _2445_/Q VPWR VGND sg13cmos5l_o21ai_1
XFILLER_262_98 VPWR VGND sg13cmos5l_decap_8
X_3218_ _3218_/Q Tile_X0Y5_FrameData[30] Tile_X0Y5_FrameStrobe[5] VPWR VGND sg13cmos5l_dlhq_1
XANTENNA__3031__GATE Tile_X0Y5_FrameStrobe[7] VPWR VGND sg13cmos5l_antennanp
XFILLER_131_14 VPWR VGND sg13cmos5l_decap_8
X_3149_ _3149_/Q Tile_X0Y5_FrameData[3] Tile_X0Y5_FrameStrobe[2] VPWR VGND sg13cmos5l_dlhq_1
XFILLER_131_47 VPWR VGND sg13cmos5l_fill_2
XFILLER_227_274 VPWR VGND sg13cmos5l_fill_2
XFILLER_242_200 VPWR VGND sg13cmos5l_fill_1
XFILLER_54_143 VPWR VGND sg13cmos5l_fill_1
XANTENNA__1238__A0 AXI_M_SOC_AWREADY VPWR VGND sg13cmos5l_antennanp
XANTENNA__2644__D Tile_X0Y3_FrameData[28] VPWR VGND sg13cmos5l_antennanp
XANTENNA__3877__X Tile_X0Y5_FrameData_O[18] VPWR VGND sg13cmos5l_antennanp
XFILLER_199_126 VPWR VGND sg13cmos5l_fill_1
XFILLER_242_244 VPWR VGND sg13cmos5l_fill_1
XFILLER_242_266 VPWR VGND sg13cmos5l_fill_1
XFILLER_54_165 VPWR VGND sg13cmos5l_fill_2
XANTENNA__3046__GATE Tile_X0Y5_FrameStrobe[8] VPWR VGND sg13cmos5l_antennanp
XFILLER_242_277 VPWR VGND sg13cmos5l_fill_1
XANTENNA__0877__B_N Tile_X0Y5_W6END[7] VPWR VGND sg13cmos5l_antennanp
XFILLER_210_174 VPWR VGND sg13cmos5l_decap_8
XANTENNA__1005__A3 Tile_X0Y0_S4END[2] VPWR VGND sg13cmos5l_antennanp
XFILLER_6_228 VPWR VGND sg13cmos5l_decap_4
XANTENNA__1410__A0 Tile_X0Y2_WW4END[5] VPWR VGND sg13cmos5l_antennanp
XFILLER_108_145 VPWR VGND sg13cmos5l_decap_8
XANTENNA__0764__A2 Tile_X0Y1_W6END[1] VPWR VGND sg13cmos5l_antennanp
XFILLER_163_284 VPWR VGND sg13cmos5l_fill_2
XFILLER_269_108 VPWR VGND sg13cmos5l_decap_4
XFILLER_172_32 VPWR VGND sg13cmos5l_fill_1
XANTENNA__1723__D Tile_X0Y0_FrameData[5] VPWR VGND sg13cmos5l_antennanp
XANTENNA__2240__GATE Tile_X0Y5_FrameStrobe[8] VPWR VGND sg13cmos5l_antennanp
XANTENNA__2819__D Tile_X0Y4_FrameData[29] VPWR VGND sg13cmos5l_antennanp
XFILLER_172_43 VPWR VGND sg13cmos5l_decap_8
XFILLER_292_100 VPWR VGND sg13cmos5l_decap_8
XFILLER_49_75 VPWR VGND sg13cmos5l_decap_8
XANTENNA__2870__GATE Tile_X0Y5_FrameStrobe[2] VPWR VGND sg13cmos5l_antennanp
XFILLER_172_87 VPWR VGND sg13cmos5l_decap_8
XFILLER_277_196 VPWR VGND sg13cmos5l_fill_1
XFILLER_322_13 VPWR VGND sg13cmos5l_fill_1
XANTENNA__1477__A0 Tile_X0Y2_W1END[2] VPWR VGND sg13cmos5l_antennanp
XFILLER_218_241 VPWR VGND sg13cmos5l_decap_8
XFILLER_65_30 VPWR VGND sg13cmos5l_decap_8
XFILLER_218_285 VPWR VGND sg13cmos5l_fill_2
XANTENNA__1229__A0 Tile_X0Y0_WW4END[2] VPWR VGND sg13cmos5l_antennanp
XANTENNA__1492__A3 AXI_M_SOC_RDATA18 VPWR VGND sg13cmos5l_antennanp
XANTENNA__2255__GATE Tile_X0Y5_FrameStrobe[0] VPWR VGND sg13cmos5l_antennanp
XANTENNA__2885__GATE Tile_X0Y5_FrameStrobe[3] VPWR VGND sg13cmos5l_antennanp
XANTENNA__3787__X Tile_X0Y4_FrameData_O[9] VPWR VGND sg13cmos5l_antennanp
XANTENNA__2554__D Tile_X0Y3_FrameData[22] VPWR VGND sg13cmos5l_antennanp
XFILLER_197_51 VPWR VGND sg13cmos5l_decap_8
XFILLER_146_229 VPWR VGND sg13cmos5l_fill_1
X_0850_ _0850_/Y _3126_/Q Tile_X0Y5_W6END[1] VPWR VGND sg13cmos5l_nor2b_1
X_0781_ _3903_/A Tile_X0Y4_W2MID[7] Tile_X0Y4_W2END[7] Tile_X0Y4_W6END[8] _1073_/X
+ _3012_/Q _3011_/Q VPWR VGND sg13cmos5l_mux4_1
XANTENNA__1401__A0 Tile_X0Y2_WW4END[0] VPWR VGND sg13cmos5l_antennanp
X_2520_ _2520_/Q Tile_X0Y3_FrameData[24] Tile_X0Y5_FrameStrobe[0] VPWR VGND sg13cmos5l_dlhq_1
XANTENNA__0755__A2 Tile_X0Y5_WW4END[11] VPWR VGND sg13cmos5l_antennanp
XANTENNA__2823__GATE Tile_X0Y5_FrameStrobe[1] VPWR VGND sg13cmos5l_antennanp
XFILLER_114_126 VPWR VGND sg13cmos5l_decap_8
XFILLER_303_215 VPWR VGND sg13cmos5l_decap_4
X_2451_ _2451_/Q Tile_X0Y2_FrameData[13] Tile_X0Y5_FrameStrobe[6] VPWR VGND sg13cmos5l_dlhq_1
XFILLER_216_36 VPWR VGND sg13cmos5l_decap_8
XFILLER_303_259 VPWR VGND sg13cmos5l_decap_8
X_1402_ _3396_/A Tile_X0Y2_WW4END[1] AXI_M_SOC_RDATA15 _1388_/X _1143_/X _2372_/Q
+ _2371_/Q VPWR VGND sg13cmos5l_mux4_1
X_2382_ _2382_/Q Tile_X0Y2_FrameData[18] Tile_X0Y5_FrameStrobe[4] VPWR VGND sg13cmos5l_dlhq_1
XANTENNA__2208__GATE Tile_X0Y5_FrameStrobe[7] VPWR VGND sg13cmos5l_antennanp
XANTENNA__2729__D Tile_X0Y3_FrameData[7] VPWR VGND sg13cmos5l_antennanp
XFILLER_283_100 VPWR VGND sg13cmos5l_decap_4
X_1333_ _3495_/A Tile_X0Y1_W2END[4] AXI_M_SOC_RDATA26 _1094_/X _1089_/X _2138_/Q _2137_/Q
+ VPWR VGND sg13cmos5l_mux4_1
XANTENNA__1180__A2 Tile_X0Y0_W6END[0] VPWR VGND sg13cmos5l_antennanp
XANTENNA__2838__GATE Tile_X0Y5_FrameStrobe[1] VPWR VGND sg13cmos5l_antennanp
XFILLER_283_133 VPWR VGND sg13cmos5l_decap_8
XFILLER_283_144 VPWR VGND sg13cmos5l_fill_1
X_1264_ _3635_/A Tile_X0Y0_W2END[1] AXI_M_SOC_RDATA31 _1140_/X _1010_/X _1860_/Q _1859_/Q
+ VPWR VGND sg13cmos5l_mux4_1
XFILLER_68_279 VPWR VGND sg13cmos5l_fill_1
XANTENNA__1468__A0 Tile_X0Y2_W2END[6] VPWR VGND sg13cmos5l_antennanp
X_3003_ _3003_/Q Tile_X0Y4_FrameData[5] Tile_X0Y5_FrameStrobe[6] VPWR VGND sg13cmos5l_dlhq_1
X_1195_ AXI_M_SOC_AWADDR13 Tile_X0Y0_WW4END[5] Tile_X0Y0_W6END[5] Tile_X0Y0_WW4END[13]
+ _1037_/X _1789_/Q _1790_/Q VPWR VGND sg13cmos5l_mux4_1
XANTENNA__3697__X Tile_X0Y3_FrameData_O[0] VPWR VGND sg13cmos5l_antennanp
XFILLER_51_102 VPWR VGND sg13cmos5l_decap_8
XANTENNA__2464__D Tile_X0Y2_FrameData[0] VPWR VGND sg13cmos5l_antennanp
XFILLER_101_17 VPWR VGND sg13cmos5l_decap_8
XFILLER_91_293 VPWR VGND sg13cmos5l_fill_2
XFILLER_51_113 VPWR VGND sg13cmos5l_fill_1
X_3905_ Tile_X0Y5_S2BEGb[2] _3905_/A VPWR VGND sg13cmos5l_buf_1
XFILLER_338_101 VPWR VGND sg13cmos5l_fill_1
XANTENNA__1640__A0 Tile_X0Y4_WW4END[5] VPWR VGND sg13cmos5l_antennanp
XFILLER_338_112 VPWR VGND sg13cmos5l_fill_1
X_3836_ Tile_X0Y5_E6BEG[5] _3836_/A VPWR VGND sg13cmos5l_buf_1
XANTENNA__1808__D Tile_X0Y0_FrameData[16] VPWR VGND sg13cmos5l_antennanp
XANTENNA__3295__D Tile_X0Y5_FrameData[17] VPWR VGND sg13cmos5l_antennanp
XFILLER_257_54 VPWR VGND sg13cmos5l_fill_1
X_3767_ Tile_X0Y4_EE4BEG[5] _3767_/A VPWR VGND sg13cmos5l_buf_1
X_0979_ _0979_/X Tile_X0Y0_W1END[3] Tile_X0Y0_WW4END[15] _0985_/X _1137_/X _1899_/Q
+ _1897_/Q VPWR VGND sg13cmos5l_mux4_1
XANTENNA__3873__A Tile_X0Y5_FrameData[14] VPWR VGND sg13cmos5l_antennanp
XFILLER_257_65 VPWR VGND sg13cmos5l_decap_8
X_2718_ _2718_/Q Tile_X0Y3_FrameData[18] Tile_X0Y5_FrameStrobe[6] VPWR VGND sg13cmos5l_dlhq_1
X_3698_ Tile_X0Y3_FrameData_O[1] Tile_X0Y3_FrameData[1] VPWR VGND sg13cmos5l_buf_1
X_2649_ _2649_/Q Tile_X0Y3_FrameData[23] Tile_X0Y5_FrameStrobe[4] VPWR VGND sg13cmos5l_dlhq_1
XFILLER_126_69 VPWR VGND sg13cmos5l_decap_8
XFILLER_273_75 VPWR VGND sg13cmos5l_fill_2
XFILLER_86_29 VPWR VGND sg13cmos5l_decap_8
XANTENNA__2639__D Tile_X0Y3_FrameData[1] VPWR VGND sg13cmos5l_antennanp
XFILLER_19_45 VPWR VGND sg13cmos5l_decap_4
XFILLER_206_91 VPWR VGND sg13cmos5l_fill_2
XFILLER_259_196 VPWR VGND sg13cmos5l_fill_2
XFILLER_274_111 VPWR VGND sg13cmos5l_fill_2
XFILLER_274_133 VPWR VGND sg13cmos5l_fill_2
XFILLER_59_268 VPWR VGND sg13cmos5l_fill_2
XANTENNA__1459__A0 Tile_X0Y2_W2MID[1] VPWR VGND sg13cmos5l_antennanp
XFILLER_142_46 VPWR VGND sg13cmos5l_decap_8
XFILLER_27_110 VPWR VGND sg13cmos5l_decap_8
XFILLER_74_238 VPWR VGND sg13cmos5l_decap_8
XFILLER_27_176 VPWR VGND sg13cmos5l_decap_8
XFILLER_35_22 VPWR VGND sg13cmos5l_fill_1
XANTENNA__2374__D Tile_X0Y2_FrameData[26] VPWR VGND sg13cmos5l_antennanp
XFILLER_42_135 VPWR VGND sg13cmos5l_fill_1
XFILLER_42_124 VPWR VGND sg13cmos5l_decap_8
XANTENNA__3400__X Tile_X0Y2_FrameData_O[2] VPWR VGND sg13cmos5l_antennanp
XFILLER_150_4 VPWR VGND sg13cmos5l_fill_1
XFILLER_42_168 VPWR VGND sg13cmos5l_fill_1
XANTENNA__1631__A0 Tile_X0Y4_WW4END[1] VPWR VGND sg13cmos5l_antennanp
XFILLER_51_21 VPWR VGND sg13cmos5l_decap_8
XFILLER_128_207 VPWR VGND sg13cmos5l_decap_8
XANTENNA__0985__A2 Tile_X0Y0_S1END[3] VPWR VGND sg13cmos5l_antennanp
XANTENNA__1718__D Tile_X0Y0_FrameData[10] VPWR VGND sg13cmos5l_antennanp
XANTENNA__3783__A Tile_X0Y4_FrameData[5] VPWR VGND sg13cmos5l_antennanp
XFILLER_167_98 VPWR VGND sg13cmos5l_decap_8
XFILLER_183_75 VPWR VGND sg13cmos5l_decap_8
XFILLER_300_218 VPWR VGND sg13cmos5l_decap_4
XANTENNA__2549__D Tile_X0Y3_FrameData[27] VPWR VGND sg13cmos5l_antennanp
XFILLER_18_8 VPWR VGND sg13cmos5l_fill_1
XFILLER_265_144 VPWR VGND sg13cmos5l_fill_2
XANTENNA__2194__GATE Tile_X0Y5_FrameStrobe[7] VPWR VGND sg13cmos5l_antennanp
XFILLER_18_143 VPWR VGND sg13cmos5l_fill_1
XFILLER_280_125 VPWR VGND sg13cmos5l_fill_1
XFILLER_280_158 VPWR VGND sg13cmos5l_decap_4
XANTENNA__2284__D Tile_X0Y2_FrameData[20] VPWR VGND sg13cmos5l_antennanp
XFILLER_73_293 VPWR VGND sg13cmos5l_fill_2
XFILLER_33_124 VPWR VGND sg13cmos5l_decap_8
XFILLER_178_129 VPWR VGND sg13cmos5l_decap_4
XFILLER_33_179 VPWR VGND sg13cmos5l_decap_8
XANTENNA__1217__A3 Tile_X0Y0_S4END[6] VPWR VGND sg13cmos5l_antennanp
X_1951_ _1951_/Q Tile_X0Y0_FrameData[1] Tile_X0Y5_FrameStrobe[7] VPWR VGND sg13cmos5l_dlhq_1
XANTENNA__1622__A0 Tile_X0Y5_N4END[6] VPWR VGND sg13cmos5l_antennanp
XFILLER_119_207 VPWR VGND sg13cmos5l_decap_8
XFILLER_186_151 VPWR VGND sg13cmos5l_fill_1
XFILLER_186_173 VPWR VGND sg13cmos5l_fill_2
X_1882_ _1882_/Q Tile_X0Y0_FrameData[6] Tile_X0Y5_FrameStrobe[5] VPWR VGND sg13cmos5l_dlhq_1
X_0902_ _0902_/Y _3294_/Q _0901_/Y _3293_/Q VPWR VGND sg13cmos5l_o21ai_1
XANTENNA__0976__A2 Tile_X0Y5_N4END[14] VPWR VGND sg13cmos5l_antennanp
XANTENNA__2132__GATE Tile_X0Y5_FrameStrobe[5] VPWR VGND sg13cmos5l_antennanp
X_3621_ Tile_X0Y0_E6BEG[4] _3621_/A VPWR VGND sg13cmos5l_buf_1
X_0833_ _3840_/A _0773_/X _0695_/X _0698_/A _0656_/X _3165_/Q _3166_/Q VPWR VGND sg13cmos5l_mux4_1
XANTENNA__2762__GATE Tile_X0Y5_FrameStrobe[7] VPWR VGND sg13cmos5l_antennanp
X_3552_ Tile_X0Y0_FrameStrobe_O[3] Tile_X0Y5_FrameStrobe[3] VPWR VGND sg13cmos5l_buf_1
XFILLER_335_159 VPWR VGND sg13cmos5l_fill_2
XFILLER_227_24 VPWR VGND sg13cmos5l_decap_8
X_2503_ _2503_/Q Tile_X0Y2_FrameData[25] Tile_X0Y5_FrameStrobe[8] VPWR VGND sg13cmos5l_dlhq_1
X_0764_ _0764_/X Tile_X0Y1_WW4END[1] Tile_X0Y1_WW4END[9] Tile_X0Y1_W6END[1] _1218_/X
+ _2070_/Q _2069_/Q VPWR VGND sg13cmos5l_mux4_1
X_3483_ Tile_X0Y1_E6BEG[3] _3483_/A VPWR VGND sg13cmos5l_buf_1
X_0695_ _0695_/X Tile_X0Y5_N1END[2] Tile_X0Y5_N4END[2] _0990_/B _0693_/X _3100_/Q
+ _3099_/Q VPWR VGND sg13cmos5l_mux4_1
XANTENNA__2147__GATE Tile_X0Y5_FrameStrobe[5] VPWR VGND sg13cmos5l_antennanp
X_2434_ _2434_/Q Tile_X0Y2_FrameData[30] Tile_X0Y5_FrameStrobe[6] VPWR VGND sg13cmos5l_dlhq_1
XANTENNA__2459__D Tile_X0Y2_FrameData[5] VPWR VGND sg13cmos5l_antennanp
XANTENNA__2777__GATE Tile_X0Y5_FrameStrobe[8] VPWR VGND sg13cmos5l_antennanp
X_2365_ _2365_/Q Tile_X0Y2_FrameData[3] Tile_X0Y5_FrameStrobe[3] VPWR VGND sg13cmos5l_dlhq_1
XFILLER_37_0 VPWR VGND sg13cmos5l_fill_2
X_1316_ _1316_/X Tile_X0Y2_W1END[1] Tile_X0Y2_W2MID[2] Tile_X0Y2_W2END[2] _1183_/X
+ _2458_/Q _2457_/Q VPWR VGND sg13cmos5l_mux4_1
X_2296_ _2296_/Q Tile_X0Y2_FrameData[8] Tile_X0Y5_FrameStrobe[1] VPWR VGND sg13cmos5l_dlhq_1
XANTENNA__2700__GATE Tile_X0Y5_FrameStrobe[5] VPWR VGND sg13cmos5l_antennanp
X_1247_ _3623_/A AXI_M_SOC_ARREADY _1037_/X _1038_/X _1147_/X _1812_/Q _1811_/Q VPWR
+ VGND sg13cmos5l_mux4_1
XFILLER_24_102 VPWR VGND sg13cmos5l_fill_2
X_1178_ _1178_/X Tile_X0Y4_W2MID[0] Tile_X0Y4_W2END[0] Tile_X0Y4_W6END[0] _1361_/X
+ _3034_/Q _3033_/Q VPWR VGND sg13cmos5l_mux4_1
XANTENNA__2194__D Tile_X0Y1_FrameData[30] VPWR VGND sg13cmos5l_antennanp
XANTENNA__3868__A Tile_X0Y5_FrameData[9] VPWR VGND sg13cmos5l_antennanp
XFILLER_64_293 VPWR VGND sg13cmos5l_fill_2
XFILLER_64_271 VPWR VGND sg13cmos5l_fill_1
XANTENNA__2715__GATE Tile_X0Y5_FrameStrobe[6] VPWR VGND sg13cmos5l_antennanp
XANTENNA__2922__D Tile_X0Y4_FrameData[22] VPWR VGND sg13cmos5l_antennanp
XFILLER_212_258 VPWR VGND sg13cmos5l_fill_1
XFILLER_24_179 VPWR VGND sg13cmos5l_decap_8
XANTENNA__1613__A0 Tile_X0Y4_WW4END[9] VPWR VGND sg13cmos5l_antennanp
XANTENNA__1971__GATE Tile_X0Y5_FrameStrobe[0] VPWR VGND sg13cmos5l_antennanp
XFILLER_32_190 VPWR VGND sg13cmos5l_decap_8
X_3819_ Tile_X0Y5_E2BEG[4] _3819_/A VPWR VGND sg13cmos5l_buf_1
XFILLER_326_126 VPWR VGND sg13cmos5l_fill_2
XFILLER_326_115 VPWR VGND sg13cmos5l_fill_1
XFILLER_192_143 VPWR VGND sg13cmos5l_decap_4
XFILLER_192_165 VPWR VGND sg13cmos5l_decap_8
XFILLER_192_176 VPWR VGND sg13cmos5l_fill_1
XFILLER_192_198 VPWR VGND sg13cmos5l_decap_8
XANTENNA__1986__GATE Tile_X0Y5_FrameStrobe[0] VPWR VGND sg13cmos5l_antennanp
XANTENNA__3890__X Tile_X0Y5_FrameData_O[31] VPWR VGND sg13cmos5l_antennanp
XFILLER_133_221 VPWR VGND sg13cmos5l_decap_8
XANTENNA__2369__D Tile_X0Y2_FrameData[31] VPWR VGND sg13cmos5l_antennanp
XFILLER_153_34 VPWR VGND sg13cmos5l_decap_8
XANTENNA__1144__A2 Tile_X0Y0_W6END[6] VPWR VGND sg13cmos5l_antennanp
XFILLER_198_4 VPWR VGND sg13cmos5l_fill_1
XFILLER_47_216 VPWR VGND sg13cmos5l_decap_4
XFILLER_101_195 VPWR VGND sg13cmos5l_decap_8
XFILLER_303_59 VPWR VGND sg13cmos5l_fill_2
XFILLER_46_32 VPWR VGND sg13cmos5l_decap_8
XANTENNA__0655__A1 Tile_X0Y3_W2MID[2] VPWR VGND sg13cmos5l_antennanp
XANTENNA__1924__GATE Tile_X0Y5_FrameStrobe[7] VPWR VGND sg13cmos5l_antennanp
XANTENNA__3778__A Tile_X0Y4_FrameData[0] VPWR VGND sg13cmos5l_antennanp
XFILLER_55_293 VPWR VGND sg13cmos5l_fill_2
XFILLER_15_157 VPWR VGND sg13cmos5l_decap_8
XFILLER_203_225 VPWR VGND sg13cmos5l_fill_2
XFILLER_270_180 VPWR VGND sg13cmos5l_decap_4
XFILLER_70_230 VPWR VGND sg13cmos5l_fill_1
XFILLER_141_0 VPWR VGND sg13cmos5l_decap_8
XFILLER_62_42 VPWR VGND sg13cmos5l_decap_8
XANTENNA__1939__GATE Tile_X0Y5_FrameStrobe[7] VPWR VGND sg13cmos5l_antennanp
XANTENNA__2832__D Tile_X0Y4_FrameData[16] VPWR VGND sg13cmos5l_antennanp
XFILLER_239_0 VPWR VGND sg13cmos5l_fill_2
XFILLER_7_26 VPWR VGND sg13cmos5l_decap_8
XFILLER_328_56 VPWR VGND sg13cmos5l_fill_2
XFILLER_183_165 VPWR VGND sg13cmos5l_decap_8
XANTENNA__2279__D Tile_X0Y2_FrameData[25] VPWR VGND sg13cmos5l_antennanp
XFILLER_87_72 VPWR VGND sg13cmos5l_fill_1
XFILLER_213_15 VPWR VGND sg13cmos5l_fill_1
X_2150_ _2150_/Q Tile_X0Y1_FrameData[10] Tile_X0Y5_FrameStrobe[5] VPWR VGND sg13cmos5l_dlhq_1
XANTENNA__0894__A1 Tile_X0Y5_W6END[11] VPWR VGND sg13cmos5l_antennanp
XANTENNA__1911__D Tile_X0Y0_FrameData[9] VPWR VGND sg13cmos5l_antennanp
XFILLER_238_199 VPWR VGND sg13cmos5l_fill_2
X_2081_ _2081_/Q Tile_X0Y1_FrameData[15] Tile_X0Y5_FrameStrobe[3] VPWR VGND sg13cmos5l_dlhq_1
X_1101_ _3530_/A Tile_X0Y1_W2MID[6] Tile_X0Y1_W2END[6] Tile_X0Y1_W6END[6] _1105_/X
+ _2230_/Q _2229_/Q VPWR VGND sg13cmos5l_mux4_1
X_1032_ _1032_/Y _3029_/Q _1046_/X VPWR VGND sg13cmos5l_nor2b_1
XANTENNA__0646__A1 Tile_X0Y5_N4END[1] VPWR VGND sg13cmos5l_antennanp
XFILLER_46_293 VPWR VGND sg13cmos5l_fill_2
XFILLER_21_105 VPWR VGND sg13cmos5l_fill_2
X_2983_ _2983_/Q Tile_X0Y4_FrameData[25] Tile_X0Y5_FrameStrobe[6] VPWR VGND sg13cmos5l_dlhq_1
XANTENNA__2742__D Tile_X0Y3_FrameData[26] VPWR VGND sg13cmos5l_antennanp
X_1934_ _1934_/Q Tile_X0Y0_FrameData[18] Tile_X0Y5_FrameStrobe[7] VPWR VGND sg13cmos5l_dlhq_1
XANTENNA__1071__A1 Tile_X0Y2_W2END[7] VPWR VGND sg13cmos5l_antennanp
XANTENNA__2071__GATE Tile_X0Y5_FrameStrobe[3] VPWR VGND sg13cmos5l_antennanp
XFILLER_308_137 VPWR VGND sg13cmos5l_decap_8
XFILLER_308_148 VPWR VGND sg13cmos5l_fill_2
X_1865_ _1865_/Q Tile_X0Y0_FrameData[23] Tile_X0Y5_FrameStrobe[5] VPWR VGND sg13cmos5l_dlhq_1
X_3604_ Tile_X0Y0_EE4BEG[3] _3604_/A VPWR VGND sg13cmos5l_buf_1
X_1796_ _1796_/Q Tile_X0Y0_FrameData[28] Tile_X0Y5_FrameStrobe[3] VPWR VGND sg13cmos5l_dlhq_1
X_0816_ _3851_/A Tile_X0Y5_WW4END[7] _0741_/X AXI_M_SOC_RLAST _0563_/X _3199_/Q _3200_/Q
+ VPWR VGND sg13cmos5l_mux4_1
XANTENNA__2086__GATE Tile_X0Y5_FrameStrobe[3] VPWR VGND sg13cmos5l_antennanp
X_3535_ Tile_X0Y0_N2BEGb[6] _3535_/A VPWR VGND sg13cmos5l_buf_1
X_0747_ _0747_/X Tile_X0Y5_W1END[3] Tile_X0Y5_WW4END[15] _3259_/Q VPWR VGND sg13cmos5l_mux2_1
X_3466_ Tile_X0Y1_EE4BEG[2] _3466_/A VPWR VGND sg13cmos5l_buf_1
XANTENNA__2189__D Tile_X0Y1_FrameData[3] VPWR VGND sg13cmos5l_antennanp
XFILLER_107_49 VPWR VGND sg13cmos5l_decap_8
X_2417_ _2417_/Q Tile_X0Y2_FrameData[15] Tile_X0Y5_FrameStrobe[5] VPWR VGND sg13cmos5l_dlhq_1
X_0678_ _0678_/X Tile_X0Y2_W1END[2] Tile_X0Y2_W6END[10] _0976_/X _0677_/X _2472_/Q
+ _2471_/Q VPWR VGND sg13cmos5l_mux4_1
XANTENNA__0839__X AXI_M_SOC_ARBURST0 VPWR VGND sg13cmos5l_antennanp
XANTENNA__1126__A2 Tile_X0Y5_N4END[7] VPWR VGND sg13cmos5l_antennanp
X_3397_ Tile_X0Y2_EE4BEG[15] _3397_/A VPWR VGND sg13cmos5l_buf_1
X_2348_ _2348_/Q Tile_X0Y2_FrameData[20] Tile_X0Y5_FrameStrobe[3] VPWR VGND sg13cmos5l_dlhq_1
XANTENNA__1821__D Tile_X0Y0_FrameData[3] VPWR VGND sg13cmos5l_antennanp
XANTENNA__2917__D Tile_X0Y4_FrameData[27] VPWR VGND sg13cmos5l_antennanp
XFILLER_123_48 VPWR VGND sg13cmos5l_decap_4
X_2279_ _2279_/Q Tile_X0Y2_FrameData[25] Tile_X0Y5_FrameStrobe[1] VPWR VGND sg13cmos5l_dlhq_1
XFILLER_244_125 VPWR VGND sg13cmos5l_decap_8
XANTENNA__2024__GATE Tile_X0Y5_FrameStrobe[1] VPWR VGND sg13cmos5l_antennanp
XANTENNA__3598__A Tile_X0Y0_FrameData[29] VPWR VGND sg13cmos5l_antennanp
XANTENNA__2654__GATE Tile_X0Y5_FrameStrobe[4] VPWR VGND sg13cmos5l_antennanp
XFILLER_16_46 VPWR VGND sg13cmos5l_fill_1
XFILLER_279_30 VPWR VGND sg13cmos5l_decap_4
XFILLER_52_252 VPWR VGND sg13cmos5l_fill_2
XANTENNA__2039__GATE Tile_X0Y5_FrameStrobe[2] VPWR VGND sg13cmos5l_antennanp
XANTENNA__2652__D Tile_X0Y3_FrameData[20] VPWR VGND sg13cmos5l_antennanp
XANTENNA__3885__X Tile_X0Y5_FrameData_O[26] VPWR VGND sg13cmos5l_antennanp
XFILLER_12_149 VPWR VGND sg13cmos5l_decap_8
XANTENNA__2669__GATE Tile_X0Y5_FrameStrobe[4] VPWR VGND sg13cmos5l_antennanp
XFILLER_148_12 VPWR VGND sg13cmos5l_decap_8
XFILLER_20_171 VPWR VGND sg13cmos5l_fill_1
XFILLER_165_165 VPWR VGND sg13cmos5l_decap_8
XANTENNA__2099__D Tile_X0Y1_FrameData[29] VPWR VGND sg13cmos5l_antennanp
XFILLER_106_276 VPWR VGND sg13cmos5l_fill_1
XFILLER_121_224 VPWR VGND sg13cmos5l_fill_1
XFILLER_79_127 VPWR VGND sg13cmos5l_decap_8
XANTENNA__1117__A2 Tile_X0Y3_W6END[11] VPWR VGND sg13cmos5l_antennanp
XFILLER_267_228 VPWR VGND sg13cmos5l_fill_1
XANTENNA__1668__A3 AXI_M_SOC_RDATA2 VPWR VGND sg13cmos5l_antennanp
XANTENNA__2607__GATE Tile_X0Y5_FrameStrobe[2] VPWR VGND sg13cmos5l_antennanp
XFILLER_282_209 VPWR VGND sg13cmos5l_decap_4
XFILLER_87_160 VPWR VGND sg13cmos5l_fill_1
XFILLER_57_42 VPWR VGND sg13cmos5l_decap_8
XANTENNA__1731__D Tile_X0Y0_FrameData[29] VPWR VGND sg13cmos5l_antennanp
XANTENNA__2827__D Tile_X0Y4_FrameData[21] VPWR VGND sg13cmos5l_antennanp
XFILLER_189_0 VPWR VGND sg13cmos5l_decap_4
XANTENNA__1863__GATE Tile_X0Y5_FrameStrobe[5] VPWR VGND sg13cmos5l_antennanp
XFILLER_180_87 VPWR VGND sg13cmos5l_decap_8
XFILLER_28_293 VPWR VGND sg13cmos5l_fill_2
XFILLER_43_230 VPWR VGND sg13cmos5l_decap_8
XANTENNA__1878__GATE Tile_X0Y5_FrameStrobe[5] VPWR VGND sg13cmos5l_antennanp
XANTENNA__2562__D Tile_X0Y3_FrameData[14] VPWR VGND sg13cmos5l_antennanp
XANTENNA__3795__X Tile_X0Y4_FrameData_O[17] VPWR VGND sg13cmos5l_antennanp
XFILLER_189_85 VPWR VGND sg13cmos5l_decap_4
XANTENNA__1053__A1 Tile_X0Y5_W6END[0] VPWR VGND sg13cmos5l_antennanp
XANTENNA__1801__GATE Tile_X0Y5_FrameStrobe[3] VPWR VGND sg13cmos5l_antennanp
XFILLER_196_290 VPWR VGND sg13cmos5l_decap_4
XFILLER_156_165 VPWR VGND sg13cmos5l_decap_8
X_1650_ AXI_M_SOC_ARADDR16 Tile_X0Y4_W2MID[0] Tile_X0Y4_W2END[0] Tile_X0Y4_W6END[0]
+ _1073_/X _2856_/Q _2855_/Q VPWR VGND sg13cmos5l_mux4_1
XANTENNA__1906__D Tile_X0Y0_FrameData[14] VPWR VGND sg13cmos5l_antennanp
X_1581_ _3515_/A _1580_/X _1579_/X _2752_/Q VPWR VGND sg13cmos5l_mux2_1
X_0601_ _0601_/Y _0601_/A VPWR VGND sg13cmos5l_inv_1
XFILLER_171_168 VPWR VGND sg13cmos5l_decap_8
X_3320_ _3320_/Q Tile_X0Y5_FrameData[24] Tile_X0Y5_FrameStrobe[8] VPWR VGND sg13cmos5l_dlhq_1
X_0532_ _0532_/Y _3265_/Q VPWR VGND sg13cmos5l_inv_1
XFILLER_98_71 VPWR VGND sg13cmos5l_decap_8
XANTENNA__0564__A0 Tile_X0Y5_W1END[3] VPWR VGND sg13cmos5l_antennanp
XANTENNA__1816__GATE Tile_X0Y5_FrameStrobe[3] VPWR VGND sg13cmos5l_antennanp
XFILLER_313_162 VPWR VGND sg13cmos5l_fill_2
XANTENNA__1108__A2 Tile_X0Y0_W6END[8] VPWR VGND sg13cmos5l_antennanp
X_3251_ _3251_/Q Tile_X0Y5_FrameData[29] Tile_X0Y5_FrameStrobe[6] VPWR VGND sg13cmos5l_dlhq_1
X_3182_ _3182_/Q Tile_X0Y5_FrameData[2] Tile_X0Y5_FrameStrobe[3] VPWR VGND sg13cmos5l_dlhq_1
X_2202_ _2202_/Q Tile_X0Y1_FrameData[22] Tile_X0Y5_FrameStrobe[7] VPWR VGND sg13cmos5l_dlhq_1
XANTENNA__2737__D Tile_X0Y3_FrameData[31] VPWR VGND sg13cmos5l_antennanp
XFILLER_266_250 VPWR VGND sg13cmos5l_fill_1
X_2133_ _2133_/Q Tile_X0Y1_FrameData[27] Tile_X0Y5_FrameStrobe[5] VPWR VGND sg13cmos5l_dlhq_1
XFILLER_93_130 VPWR VGND sg13cmos5l_decap_8
XFILLER_78_182 VPWR VGND sg13cmos5l_decap_8
XFILLER_304_80 VPWR VGND sg13cmos5l_decap_8
XFILLER_19_293 VPWR VGND sg13cmos5l_fill_2
XFILLER_281_253 VPWR VGND sg13cmos5l_decap_8
X_2064_ _2064_/Q Tile_X0Y1_FrameData[0] Tile_X0Y5_FrameStrobe[2] VPWR VGND sg13cmos5l_dlhq_1
XFILLER_281_286 VPWR VGND sg13cmos5l_fill_1
X_1015_ _1015_/X Tile_X0Y5_W2MID[5] Tile_X0Y5_W2END[5] Tile_X0Y5_W6END[5] _0790_/X
+ _3316_/Q _3315_/Q VPWR VGND sg13cmos5l_mux4_1
XFILLER_34_230 VPWR VGND sg13cmos5l_fill_2
XANTENNA__1292__A1 AXI_M_SOC_RDATA22 VPWR VGND sg13cmos5l_antennanp
XFILLER_179_235 VPWR VGND sg13cmos5l_decap_8
XANTENNA__2472__D Tile_X0Y2_FrameData[24] VPWR VGND sg13cmos5l_antennanp
XANTENNA__1044__A1 Tile_X0Y1_W2END[2] VPWR VGND sg13cmos5l_antennanp
X_2966_ _2966_/Q Tile_X0Y4_FrameData[10] Tile_X0Y5_FrameStrobe[5] VPWR VGND sg13cmos5l_dlhq_1
XANTENNA__0841__Y AXI_M_SOC_ARBURST1 VPWR VGND sg13cmos5l_antennanp
X_2897_ _2897_/Q Tile_X0Y4_FrameData[15] Tile_X0Y5_FrameStrobe[3] VPWR VGND sg13cmos5l_dlhq_1
X_1917_ _1917_/Q Tile_X0Y0_FrameData[3] Tile_X0Y5_FrameStrobe[6] VPWR VGND sg13cmos5l_dlhq_1
XANTENNA__0570__A Tile_X0Y1_W6END[0] VPWR VGND sg13cmos5l_antennanp
XANTENNA__1595__A2 Tile_X0Y3_W6END[6] VPWR VGND sg13cmos5l_antennanp
X_1848_ _1848_/Q Tile_X0Y0_FrameData[8] Tile_X0Y5_FrameStrobe[4] VPWR VGND sg13cmos5l_dlhq_1
XFILLER_336_265 VPWR VGND sg13cmos5l_fill_2
XANTENNA__1347__A2 Tile_X0Y2_W2END[1] VPWR VGND sg13cmos5l_antennanp
XANTENNA__1816__D Tile_X0Y0_FrameData[8] VPWR VGND sg13cmos5l_antennanp
XANTENNA__3322__GATE Tile_X0Y5_FrameStrobe[8] VPWR VGND sg13cmos5l_antennanp
XANTENNA__3881__A Tile_X0Y5_FrameData[22] VPWR VGND sg13cmos5l_antennanp
X_1779_ _1779_/Q Tile_X0Y0_FrameData[13] Tile_X0Y5_FrameStrobe[2] VPWR VGND sg13cmos5l_dlhq_1
XFILLER_78_19 VPWR VGND sg13cmos5l_decap_8
XFILLER_304_162 VPWR VGND sg13cmos5l_decap_4
X_3518_ Tile_X0Y0_N4BEG[5] _3518_/A VPWR VGND sg13cmos5l_buf_1
XFILLER_134_14 VPWR VGND sg13cmos5l_decap_8
XFILLER_304_195 VPWR VGND sg13cmos5l_decap_8
X_3449_ Tile_X0Y1_FrameData_O[17] Tile_X0Y1_FrameData[17] VPWR VGND sg13cmos5l_buf_1
XFILLER_134_58 VPWR VGND sg13cmos5l_decap_8
XFILLER_294_9 VPWR VGND sg13cmos5l_fill_2
XFILLER_69_160 VPWR VGND sg13cmos5l_decap_8
XANTENNA__2647__D Tile_X0Y3_FrameData[25] VPWR VGND sg13cmos5l_antennanp
XANTENNA__3337__GATE Tile_X0Y5_FrameStrobe[8] VPWR VGND sg13cmos5l_antennanp
XANTENNA__2593__GATE Tile_X0Y5_FrameStrobe[2] VPWR VGND sg13cmos5l_antennanp
XFILLER_232_139 VPWR VGND sg13cmos5l_decap_8
XFILLER_27_89 VPWR VGND sg13cmos5l_decap_4
XFILLER_25_285 VPWR VGND sg13cmos5l_fill_2
XFILLER_43_11 VPWR VGND sg13cmos5l_decap_8
XANTENNA__2382__D Tile_X0Y2_FrameData[18] VPWR VGND sg13cmos5l_antennanp
XFILLER_230_90 VPWR VGND sg13cmos5l_fill_2
XFILLER_159_44 VPWR VGND sg13cmos5l_decap_4
XFILLER_159_55 VPWR VGND sg13cmos5l_decap_8
XFILLER_159_66 VPWR VGND sg13cmos5l_fill_1
XFILLER_309_25 VPWR VGND sg13cmos5l_fill_1
XANTENNA__0794__A0 Tile_X0Y5_N2MID[3] VPWR VGND sg13cmos5l_antennanp
XANTENNA__2531__GATE Tile_X0Y5_FrameStrobe[0] VPWR VGND sg13cmos5l_antennanp
XFILLER_309_36 VPWR VGND sg13cmos5l_decap_8
XFILLER_193_293 VPWR VGND sg13cmos5l_fill_2
XANTENNA__1726__D Tile_X0Y0_FrameData[2] VPWR VGND sg13cmos5l_antennanp
XANTENNA__3791__A Tile_X0Y4_FrameData[13] VPWR VGND sg13cmos5l_antennanp
XFILLER_104_0 VPWR VGND sg13cmos5l_fill_2
XFILLER_153_157 VPWR VGND sg13cmos5l_decap_8
XANTENNA__2546__GATE Tile_X0Y5_FrameStrobe[1] VPWR VGND sg13cmos5l_antennanp
XFILLER_68_96 VPWR VGND sg13cmos5l_decap_8
XANTENNA__2557__D Tile_X0Y3_FrameData[19] VPWR VGND sg13cmos5l_antennanp
XFILLER_248_294 VPWR VGND sg13cmos5l_fill_1
XFILLER_263_242 VPWR VGND sg13cmos5l_decap_4
XFILLER_75_185 VPWR VGND sg13cmos5l_decap_8
XFILLER_16_241 VPWR VGND sg13cmos5l_fill_2
XFILLER_90_144 VPWR VGND sg13cmos5l_fill_2
XANTENNA__1274__A1 AXI_M_SOC_RDATA24 VPWR VGND sg13cmos5l_antennanp
XANTENNA__2292__D Tile_X0Y2_FrameData[12] VPWR VGND sg13cmos5l_antennanp
X_2820_ _2820_/Q Tile_X0Y4_FrameData[28] Tile_X0Y5_FrameStrobe[1] VPWR VGND sg13cmos5l_dlhq_1
XANTENNA__1740__GATE Tile_X0Y5_FrameStrobe[1] VPWR VGND sg13cmos5l_antennanp
X_2751_ _2751_/Q Tile_X0Y3_FrameData[17] Tile_X0Y5_FrameStrobe[7] VPWR VGND sg13cmos5l_dlhq_1
XANTENNA__0785__A0 Tile_X0Y4_W2MID[6] VPWR VGND sg13cmos5l_antennanp
XFILLER_219_47 VPWR VGND sg13cmos5l_fill_1
X_2682_ _2682_/Q Tile_X0Y3_FrameData[22] Tile_X0Y5_FrameStrobe[5] VPWR VGND sg13cmos5l_dlhq_1
X_1702_ _1702_/Q Tile_X0Y0_FrameData[26] Tile_X0Y5_FrameStrobe[0] VPWR VGND sg13cmos5l_dlhq_1
XFILLER_76_4 VPWR VGND sg13cmos5l_fill_1
XFILLER_144_113 VPWR VGND sg13cmos5l_decap_8
XFILLER_184_293 VPWR VGND sg13cmos5l_fill_2
X_1633_ _3761_/A AXI_M_SOC_RDATA5 _1062_/X _1065_/X _1361_/X _2889_/Q _2890_/Q VPWR
+ VGND sg13cmos5l_mux4_1
XANTENNA__1329__A2 Tile_X0Y1_WW4END[3] VPWR VGND sg13cmos5l_antennanp
XANTENNA__1755__GATE Tile_X0Y5_FrameStrobe[1] VPWR VGND sg13cmos5l_antennanp
XFILLER_333_246 VPWR VGND sg13cmos5l_fill_1
XFILLER_235_35 VPWR VGND sg13cmos5l_fill_1
X_1564_ AXI_M_SOC_WDATA5 Tile_X0Y3_W2MID[5] Tile_X0Y3_W2END[5] Tile_X0Y3_W6END[5]
+ _1342_/X _2574_/Q _2573_/Q VPWR VGND sg13cmos5l_mux4_1
XFILLER_333_279 VPWR VGND sg13cmos5l_fill_2
XFILLER_298_161 VPWR VGND sg13cmos5l_fill_1
X_3303_ _3303_/Q Tile_X0Y5_FrameData[9] Tile_X0Y5_FrameStrobe[7] VPWR VGND sg13cmos5l_dlhq_1
X_1495_ _3651_/A _0987_/X _0678_/X AXI_M_SOC_RDATA7 AXI_M_SOC_RDATA11 _2708_/Q _2707_/Q
+ VPWR VGND sg13cmos5l_mux4_1
XFILLER_100_205 VPWR VGND sg13cmos5l_fill_1
X_3234_ _3234_/Q Tile_X0Y5_FrameData[14] Tile_X0Y5_FrameStrobe[5] VPWR VGND sg13cmos5l_dlhq_1
XANTENNA__2467__D Tile_X0Y2_FrameData[29] VPWR VGND sg13cmos5l_antennanp
X_3165_ _3165_/Q Tile_X0Y5_FrameData[19] Tile_X0Y5_FrameStrobe[3] VPWR VGND sg13cmos5l_dlhq_1
XFILLER_66_141 VPWR VGND sg13cmos5l_fill_1
XFILLER_66_130 VPWR VGND sg13cmos5l_decap_8
X_3096_ _3096_/Q Tile_X0Y5_FrameData[24] Tile_X0Y5_FrameStrobe[1] VPWR VGND sg13cmos5l_dlhq_1
X_2116_ _2116_/Q Tile_X0Y1_FrameData[12] Tile_X0Y5_FrameStrobe[4] VPWR VGND sg13cmos5l_dlhq_1
XFILLER_214_117 VPWR VGND sg13cmos5l_fill_2
X_2047_ _2047_/Q Tile_X0Y1_FrameData[17] Tile_X0Y5_FrameStrobe[2] VPWR VGND sg13cmos5l_dlhq_1
XANTENNA__1265__A1 AXI_M_SOC_RDATA30 VPWR VGND sg13cmos5l_antennanp
XFILLER_81_188 VPWR VGND sg13cmos5l_decap_4
XANTENNA__3298__D Tile_X0Y5_FrameData[14] VPWR VGND sg13cmos5l_antennanp
XANTENNA__3876__A Tile_X0Y5_FrameData[17] VPWR VGND sg13cmos5l_antennanp
XFILLER_167_205 VPWR VGND sg13cmos5l_decap_8
XANTENNA__1708__GATE Tile_X0Y5_FrameStrobe[0] VPWR VGND sg13cmos5l_antennanp
XFILLER_200_60 VPWR VGND sg13cmos5l_decap_8
XANTENNA__1017__A1 Tile_X0Y4_W6END[5] VPWR VGND sg13cmos5l_antennanp
XFILLER_13_36 VPWR VGND sg13cmos5l_decap_8
X_2949_ _2949_/Q Tile_X0Y4_FrameData[27] Tile_X0Y5_FrameStrobe[5] VPWR VGND sg13cmos5l_dlhq_1
XANTENNA__2930__D Tile_X0Y4_FrameData[14] VPWR VGND sg13cmos5l_antennanp
XFILLER_182_219 VPWR VGND sg13cmos5l_fill_2
XANTENNA__3261__GATE Tile_X0Y5_FrameStrobe[6] VPWR VGND sg13cmos5l_antennanp
XFILLER_175_293 VPWR VGND sg13cmos5l_fill_2
XFILLER_276_75 VPWR VGND sg13cmos5l_fill_2
XFILLER_276_97 VPWR VGND sg13cmos5l_fill_2
XFILLER_89_29 VPWR VGND sg13cmos5l_decap_8
XANTENNA__3276__GATE Tile_X0Y5_FrameStrobe[6] VPWR VGND sg13cmos5l_antennanp
XFILLER_38_11 VPWR VGND sg13cmos5l_decap_8
XANTENNA__2377__D Tile_X0Y2_FrameData[23] VPWR VGND sg13cmos5l_antennanp
XANTENNA__3403__X Tile_X0Y2_FrameData_O[5] VPWR VGND sg13cmos5l_antennanp
XFILLER_57_174 VPWR VGND sg13cmos5l_decap_4
XFILLER_72_155 VPWR VGND sg13cmos5l_decap_4
XFILLER_54_32 VPWR VGND sg13cmos5l_decap_8
XANTENNA__1256__A1 AXI_M_SOC_ARREADY VPWR VGND sg13cmos5l_antennanp
XANTENNA__3214__GATE Tile_X0Y5_FrameStrobe[4] VPWR VGND sg13cmos5l_antennanp
XANTENNA__3786__A Tile_X0Y4_FrameData[8] VPWR VGND sg13cmos5l_antennanp
XANTENNA__3001__D Tile_X0Y4_FrameData[7] VPWR VGND sg13cmos5l_antennanp
XFILLER_110_71 VPWR VGND sg13cmos5l_fill_1
XFILLER_13_266 VPWR VGND sg13cmos5l_decap_8
XFILLER_9_215 VPWR VGND sg13cmos5l_decap_8
XANTENNA__1008__A1 Tile_X0Y2_W2END[1] VPWR VGND sg13cmos5l_antennanp
XFILLER_70_53 VPWR VGND sg13cmos5l_decap_8
XANTENNA__1559__A2 Tile_X0Y3_W6END[1] VPWR VGND sg13cmos5l_antennanp
XANTENNA__2470__GATE Tile_X0Y5_FrameStrobe[7] VPWR VGND sg13cmos5l_antennanp
XANTENNA__2840__D Tile_X0Y4_FrameData[8] VPWR VGND sg13cmos5l_antennanp
XFILLER_173_208 VPWR VGND sg13cmos5l_fill_2
XFILLER_221_0 VPWR VGND sg13cmos5l_fill_2
XANTENNA__0767__A0 Tile_X0Y5_WW4END[1] VPWR VGND sg13cmos5l_antennanp
XANTENNA__3229__GATE Tile_X0Y5_FrameStrobe[5] VPWR VGND sg13cmos5l_antennanp
XFILLER_166_271 VPWR VGND sg13cmos5l_fill_2
XFILLER_315_268 VPWR VGND sg13cmos5l_decap_4
XANTENNA__2485__GATE Tile_X0Y5_FrameStrobe[7] VPWR VGND sg13cmos5l_antennanp
XFILLER_141_105 VPWR VGND sg13cmos5l_decap_8
XFILLER_287_109 VPWR VGND sg13cmos5l_decap_4
XANTENNA__1192__A0 Tile_X0Y0_WW4END[3] VPWR VGND sg13cmos5l_antennanp
XFILLER_79_84 VPWR VGND sg13cmos5l_decap_8
XFILLER_95_203 VPWR VGND sg13cmos5l_decap_8
XANTENNA__2287__D Tile_X0Y2_FrameData[17] VPWR VGND sg13cmos5l_antennanp
X_1280_ _3497_/A Tile_X0Y1_W2END[2] AXI_M_SOC_RDATA24 _1100_/X _1086_/X _2134_/Q _2133_/Q
+ VPWR VGND sg13cmos5l_mux4_1
XFILLER_221_37 VPWR VGND sg13cmos5l_fill_1
XFILLER_48_196 VPWR VGND sg13cmos5l_decap_8
XANTENNA__2423__GATE Tile_X0Y5_FrameStrobe[5] VPWR VGND sg13cmos5l_antennanp
X_3921_ Tile_X0Y5_S4BEG[10] _3921_/A VPWR VGND sg13cmos5l_buf_1
X_3852_ Tile_X0Y5_EE4BEG[9] _3852_/A VPWR VGND sg13cmos5l_buf_1
XANTENNA__2438__GATE Tile_X0Y5_FrameStrobe[6] VPWR VGND sg13cmos5l_antennanp
XFILLER_149_249 VPWR VGND sg13cmos5l_decap_8
X_2803_ _2803_/Q Tile_X0Y4_FrameData[13] Tile_X0Y5_FrameStrobe[0] VPWR VGND sg13cmos5l_dlhq_1
XANTENNA__2750__D Tile_X0Y3_FrameData[18] VPWR VGND sg13cmos5l_antennanp
XFILLER_164_208 VPWR VGND sg13cmos5l_decap_8
X_3783_ Tile_X0Y4_FrameData_O[5] Tile_X0Y4_FrameData[5] VPWR VGND sg13cmos5l_buf_1
X_0995_ _0995_/X _0994_/X _0993_/X _1901_/Q VPWR VGND sg13cmos5l_mux2_1
XANTENNA__0758__A0 Tile_X0Y5_WW4END[6] VPWR VGND sg13cmos5l_antennanp
XFILLER_157_293 VPWR VGND sg13cmos5l_fill_2
X_2734_ _2734_/Q Tile_X0Y3_FrameData[2] Tile_X0Y5_FrameStrobe[6] VPWR VGND sg13cmos5l_dlhq_1
XFILLER_67_0 VPWR VGND sg13cmos5l_fill_2
XFILLER_246_23 VPWR VGND sg13cmos5l_decap_8
XFILLER_306_257 VPWR VGND sg13cmos5l_fill_2
X_2665_ _2665_/Q Tile_X0Y3_FrameData[7] Tile_X0Y5_FrameStrobe[4] VPWR VGND sg13cmos5l_dlhq_1
XANTENNA__0773__A3 AXI_M_SOC_AWVALID VPWR VGND sg13cmos5l_antennanp
XFILLER_117_179 VPWR VGND sg13cmos5l_decap_4
XFILLER_132_127 VPWR VGND sg13cmos5l_fill_1
XFILLER_172_274 VPWR VGND sg13cmos5l_decap_8
X_2596_ _2596_/Q Tile_X0Y3_FrameData[12] Tile_X0Y5_FrameStrobe[2] VPWR VGND sg13cmos5l_dlhq_1
X_1616_ _3773_/A Tile_X0Y4_WW4END[4] AXI_M_SOC_RDATA2 _1062_/X _1319_/X _2922_/Q _2921_/Q
+ VPWR VGND sg13cmos5l_mux4_1
X_1547_ _3680_/A AXI_M_SOC_RDATA13 _1436_/X _1539_/X _1351_/X _2617_/Q _2618_/Q VPWR
+ VGND sg13cmos5l_mux4_1
XFILLER_5_92 VPWR VGND sg13cmos5l_fill_2
XANTENNA__2197__D Tile_X0Y1_FrameData[27] VPWR VGND sg13cmos5l_antennanp
XFILLER_140_182 VPWR VGND sg13cmos5l_fill_1
X_1478_ _1478_/Y _2444_/Q _1478_/B VPWR VGND sg13cmos5l_nand2b_1
XFILLER_286_186 VPWR VGND sg13cmos5l_fill_2
X_3217_ _3217_/Q Tile_X0Y5_FrameData[31] Tile_X0Y5_FrameStrobe[5] VPWR VGND sg13cmos5l_dlhq_1
XFILLER_39_152 VPWR VGND sg13cmos5l_fill_2
X_3148_ _3148_/Q Tile_X0Y5_FrameData[4] Tile_X0Y5_FrameStrobe[2] VPWR VGND sg13cmos5l_dlhq_1
XANTENNA__2925__D Tile_X0Y4_FrameData[19] VPWR VGND sg13cmos5l_antennanp
XFILLER_54_122 VPWR VGND sg13cmos5l_decap_8
X_3079_ _3079_/Q Tile_X0Y5_FrameData[9] Tile_X0Y5_FrameStrobe[0] VPWR VGND sg13cmos5l_dlhq_1
XFILLER_54_188 VPWR VGND sg13cmos5l_decap_8
XFILLER_54_177 VPWR VGND sg13cmos5l_decap_4
XANTENNA__0997__A0 Tile_X0Y4_W1END[2] VPWR VGND sg13cmos5l_antennanp
XFILLER_24_46 VPWR VGND sg13cmos5l_fill_1
XFILLER_210_131 VPWR VGND sg13cmos5l_fill_1
XANTENNA__2660__D Tile_X0Y3_FrameData[12] VPWR VGND sg13cmos5l_antennanp
XANTENNA__3893__X Tile_X0Y5_S1BEG[2] VPWR VGND sg13cmos5l_antennanp
XFILLER_155_208 VPWR VGND sg13cmos5l_decap_8
XFILLER_155_219 VPWR VGND sg13cmos5l_fill_1
XFILLER_148_293 VPWR VGND sg13cmos5l_fill_2
XANTENNA__1410__A1 Tile_X0Y2_WW4END[13] VPWR VGND sg13cmos5l_antennanp
XFILLER_163_252 VPWR VGND sg13cmos5l_fill_2
XFILLER_123_116 VPWR VGND sg13cmos5l_decap_8
XFILLER_123_127 VPWR VGND sg13cmos5l_fill_2
XFILLER_156_56 VPWR VGND sg13cmos5l_decap_8
XFILLER_156_67 VPWR VGND sg13cmos5l_fill_2
XFILLER_40_89 VPWR VGND sg13cmos5l_decap_4
XFILLER_306_37 VPWR VGND sg13cmos5l_decap_8
XFILLER_312_227 VPWR VGND sg13cmos5l_fill_1
XANTENNA__1174__A0 Tile_X0Y4_W2MID[1] VPWR VGND sg13cmos5l_antennanp
XFILLER_172_11 VPWR VGND sg13cmos5l_decap_4
XFILLER_49_54 VPWR VGND sg13cmos5l_decap_8
XFILLER_77_236 VPWR VGND sg13cmos5l_fill_1
XFILLER_105_60 VPWR VGND sg13cmos5l_decap_4
XFILLER_320_293 VPWR VGND sg13cmos5l_fill_2
XANTENNA__1477__A1 Tile_X0Y2_W6END[6] VPWR VGND sg13cmos5l_antennanp
XFILLER_322_36 VPWR VGND sg13cmos5l_fill_2
XANTENNA__2835__D Tile_X0Y4_FrameData[13] VPWR VGND sg13cmos5l_antennanp
XFILLER_171_0 VPWR VGND sg13cmos5l_fill_2
XFILLER_269_0 VPWR VGND sg13cmos5l_fill_2
XFILLER_292_189 VPWR VGND sg13cmos5l_decap_8
XFILLER_45_133 VPWR VGND sg13cmos5l_decap_8
XANTENNA__3153__GATE Tile_X0Y5_FrameStrobe[3] VPWR VGND sg13cmos5l_antennanp
XFILLER_60_136 VPWR VGND sg13cmos5l_fill_2
XFILLER_45_188 VPWR VGND sg13cmos5l_decap_4
XFILLER_198_171 VPWR VGND sg13cmos5l_decap_8
XFILLER_60_158 VPWR VGND sg13cmos5l_fill_1
XANTENNA__2570__D Tile_X0Y3_FrameData[6] VPWR VGND sg13cmos5l_antennanp
XANTENNA__3168__GATE Tile_X0Y5_FrameStrobe[3] VPWR VGND sg13cmos5l_antennanp
XFILLER_139_293 VPWR VGND sg13cmos5l_fill_2
X_0780_ _0780_/X Tile_X0Y3_W2MID[7] Tile_X0Y3_W2END[7] Tile_X0Y3_W6END[8] _1267_/X
+ _2740_/Q _2739_/Q VPWR VGND sg13cmos5l_mux4_1
XANTENNA__1401__A1 AXI_M_SOC_RDATA14 VPWR VGND sg13cmos5l_antennanp
X_2450_ _2450_/Q Tile_X0Y2_FrameData[14] Tile_X0Y5_FrameStrobe[6] VPWR VGND sg13cmos5l_dlhq_1
X_1401_ _3397_/A Tile_X0Y2_WW4END[0] AXI_M_SOC_RDATA14 _1357_/X _1157_/X _2370_/Q
+ _2369_/Q VPWR VGND sg13cmos5l_mux4_1
XANTENNA__1914__D Tile_X0Y0_FrameData[6] VPWR VGND sg13cmos5l_antennanp
X_2381_ _2381_/Q Tile_X0Y2_FrameData[19] Tile_X0Y5_FrameStrobe[4] VPWR VGND sg13cmos5l_dlhq_1
X_1332_ _3508_/A _1138_/X _0568_/X AXI_M_SOC_RDATA25 AXI_M_SOC_RDATA29 _2168_/Q _2167_/Q
+ VPWR VGND sg13cmos5l_mux4_1
XANTENNA__3106__GATE Tile_X0Y5_FrameStrobe[1] VPWR VGND sg13cmos5l_antennanp
XFILLER_311_293 VPWR VGND sg13cmos5l_fill_2
X_1263_ _3634_/A Tile_X0Y0_W2END[2] _1147_/X AXI_M_SOC_ARREADY _1045_/X _1861_/Q _1862_/Q
+ VPWR VGND sg13cmos5l_mux4_1
XANTENNA__1468__A1 AXI_M_SOC_RDATA20 VPWR VGND sg13cmos5l_antennanp
XFILLER_232_58 VPWR VGND sg13cmos5l_decap_8
XFILLER_283_156 VPWR VGND sg13cmos5l_fill_1
X_3002_ _3002_/Q Tile_X0Y4_FrameData[6] Tile_X0Y5_FrameStrobe[6] VPWR VGND sg13cmos5l_dlhq_1
XFILLER_83_239 VPWR VGND sg13cmos5l_decap_8
XANTENNA__2362__GATE Tile_X0Y5_FrameStrobe[3] VPWR VGND sg13cmos5l_antennanp
XANTENNA__2745__D Tile_X0Y3_FrameData[23] VPWR VGND sg13cmos5l_antennanp
XFILLER_283_178 VPWR VGND sg13cmos5l_fill_2
X_1194_ AXI_M_SOC_AWADDR14 Tile_X0Y0_WW4END[6] Tile_X0Y0_W6END[6] Tile_X0Y0_WW4END[14]
+ _1004_/X _1787_/Q _1788_/Q VPWR VGND sg13cmos5l_mux4_1
XANTENNA__2992__GATE Tile_X0Y5_FrameStrobe[6] VPWR VGND sg13cmos5l_antennanp
XFILLER_224_234 VPWR VGND sg13cmos5l_fill_1
XFILLER_91_250 VPWR VGND sg13cmos5l_decap_4
XFILLER_36_177 VPWR VGND sg13cmos5l_decap_4
XFILLER_224_267 VPWR VGND sg13cmos5l_fill_2
XANTENNA__2377__GATE Tile_X0Y5_FrameStrobe[4] VPWR VGND sg13cmos5l_antennanp
X_3904_ Tile_X0Y5_S2BEGb[1] _3904_/A VPWR VGND sg13cmos5l_buf_1
XANTENNA__0979__A0 Tile_X0Y0_W1END[3] VPWR VGND sg13cmos5l_antennanp
XANTENNA__1640__A1 Tile_X0Y4_WW4END[13] VPWR VGND sg13cmos5l_antennanp
XANTENNA__2480__D Tile_X0Y2_FrameData[16] VPWR VGND sg13cmos5l_antennanp
X_3835_ Tile_X0Y5_E6BEG[4] _3835_/A VPWR VGND sg13cmos5l_buf_1
XANTENNA__2300__GATE Tile_X0Y5_FrameStrobe[1] VPWR VGND sg13cmos5l_antennanp
X_3766_ Tile_X0Y4_EE4BEG[4] _3766_/A VPWR VGND sg13cmos5l_buf_1
X_0978_ _0978_/X Tile_X0Y0_W6END[7] _1124_/X _1080_/X _1136_/X _1897_/Q _1899_/Q VPWR
+ VGND sg13cmos5l_mux4_1
XANTENNA__2930__GATE Tile_X0Y5_FrameStrobe[4] VPWR VGND sg13cmos5l_antennanp
X_2717_ _2717_/Q Tile_X0Y3_FrameData[19] Tile_X0Y5_FrameStrobe[6] VPWR VGND sg13cmos5l_dlhq_1
XFILLER_10_26 VPWR VGND sg13cmos5l_fill_2
X_3697_ Tile_X0Y3_FrameData_O[0] Tile_X0Y3_FrameData[0] VPWR VGND sg13cmos5l_buf_1
XFILLER_10_59 VPWR VGND sg13cmos5l_fill_1
X_2648_ _2648_/Q Tile_X0Y3_FrameData[24] Tile_X0Y5_FrameStrobe[4] VPWR VGND sg13cmos5l_dlhq_1
XANTENNA__1156__A0 Tile_X0Y4_W2MID[7] VPWR VGND sg13cmos5l_antennanp
XANTENNA__1824__D Tile_X0Y0_FrameData[0] VPWR VGND sg13cmos5l_antennanp
XANTENNA__2315__GATE Tile_X0Y5_FrameStrobe[2] VPWR VGND sg13cmos5l_antennanp
X_2579_ _2579_/Q Tile_X0Y3_FrameData[29] Tile_X0Y5_FrameStrobe[2] VPWR VGND sg13cmos5l_dlhq_1
XANTENNA__2945__GATE Tile_X0Y5_FrameStrobe[5] VPWR VGND sg13cmos5l_antennanp
XFILLER_113_160 VPWR VGND sg13cmos5l_decap_8
XFILLER_19_24 VPWR VGND sg13cmos5l_fill_1
XFILLER_302_293 VPWR VGND sg13cmos5l_fill_2
XFILLER_59_258 VPWR VGND sg13cmos5l_fill_2
XANTENNA__1459__A1 AXI_M_SOC_RDATA20 VPWR VGND sg13cmos5l_antennanp
XFILLER_274_167 VPWR VGND sg13cmos5l_fill_2
XFILLER_74_206 VPWR VGND sg13cmos5l_fill_2
XANTENNA__2655__D Tile_X0Y3_FrameData[17] VPWR VGND sg13cmos5l_antennanp
XANTENNA__3888__X Tile_X0Y5_FrameData_O[29] VPWR VGND sg13cmos5l_antennanp
XFILLER_67_280 VPWR VGND sg13cmos5l_fill_1
XFILLER_27_155 VPWR VGND sg13cmos5l_decap_8
XFILLER_42_103 VPWR VGND sg13cmos5l_decap_8
XFILLER_35_78 VPWR VGND sg13cmos5l_decap_8
XANTENNA__1201__X AXI_M_SOC_AWADDR17 VPWR VGND sg13cmos5l_antennanp
XANTENNA__1631__A1 Tile_X0Y4_W6END[1] VPWR VGND sg13cmos5l_antennanp
XANTENNA__2390__D Tile_X0Y2_FrameData[10] VPWR VGND sg13cmos5l_antennanp
XANTENNA__0985__A3 Tile_X0Y0_S4END[3] VPWR VGND sg13cmos5l_antennanp
XFILLER_195_185 VPWR VGND sg13cmos5l_decap_8
XFILLER_51_88 VPWR VGND sg13cmos5l_decap_8
XFILLER_136_230 VPWR VGND sg13cmos5l_fill_1
XFILLER_136_252 VPWR VGND sg13cmos5l_decap_8
XFILLER_167_77 VPWR VGND sg13cmos5l_decap_8
XFILLER_2_210 VPWR VGND sg13cmos5l_decap_8
XANTENNA__1734__D Tile_X0Y0_FrameData[26] VPWR VGND sg13cmos5l_antennanp
XFILLER_183_54 VPWR VGND sg13cmos5l_decap_8
XFILLER_2_276 VPWR VGND sg13cmos5l_fill_1
XFILLER_116_81 VPWR VGND sg13cmos5l_fill_2
XFILLER_65_217 VPWR VGND sg13cmos5l_fill_1
XANTENNA__2565__D Tile_X0Y3_FrameData[11] VPWR VGND sg13cmos5l_antennanp
XANTENNA__3798__X Tile_X0Y4_FrameData_O[20] VPWR VGND sg13cmos5l_antennanp
XFILLER_206_201 VPWR VGND sg13cmos5l_fill_2
XFILLER_280_104 VPWR VGND sg13cmos5l_fill_2
XFILLER_76_96 VPWR VGND sg13cmos5l_decap_4
XANTENNA__3092__GATE Tile_X0Y5_FrameStrobe[1] VPWR VGND sg13cmos5l_antennanp
XFILLER_221_226 VPWR VGND sg13cmos5l_decap_8
XFILLER_221_237 VPWR VGND sg13cmos5l_fill_2
XFILLER_92_84 VPWR VGND sg13cmos5l_decap_8
XFILLER_33_158 VPWR VGND sg13cmos5l_decap_8
X_1950_ _1950_/Q Tile_X0Y0_FrameData[2] Tile_X0Y5_FrameStrobe[7] VPWR VGND sg13cmos5l_dlhq_1
XANTENNA__1909__D Tile_X0Y0_FrameData[11] VPWR VGND sg13cmos5l_antennanp
X_1881_ _1881_/Q Tile_X0Y0_FrameData[7] Tile_X0Y5_FrameStrobe[5] VPWR VGND sg13cmos5l_dlhq_1
X_0901_ _0901_/Y _3295_/Q _0741_/X _0900_/Y VPWR VGND sg13cmos5l_o21ai_1
XANTENNA__0976__A3 Tile_X0Y0_S4END[10] VPWR VGND sg13cmos5l_antennanp
X_3620_ Tile_X0Y0_E6BEG[3] _3620_/A VPWR VGND sg13cmos5l_buf_1
X_0832_ _3839_/A _0778_/X _0741_/X _0743_/X _0607_/X _3167_/Q _3168_/Q VPWR VGND sg13cmos5l_mux4_1
XANTENNA__3030__GATE Tile_X0Y5_FrameStrobe[7] VPWR VGND sg13cmos5l_antennanp
X_3551_ Tile_X0Y0_FrameStrobe_O[2] Tile_X0Y5_FrameStrobe[2] VPWR VGND sg13cmos5l_buf_1
XFILLER_335_149 VPWR VGND sg13cmos5l_fill_1
XFILLER_127_274 VPWR VGND sg13cmos5l_decap_4
X_2502_ _2502_/Q Tile_X0Y2_FrameData[26] Tile_X0Y5_FrameStrobe[8] VPWR VGND sg13cmos5l_dlhq_1
X_0763_ _0763_/X Tile_X0Y5_WW4END[5] Tile_X0Y5_WW4END[13] Tile_X0Y5_W6END[5] _0646_/X
+ _3150_/Q _3149_/Q VPWR VGND sg13cmos5l_mux4_1
XFILLER_227_69 VPWR VGND sg13cmos5l_fill_1
XFILLER_288_215 VPWR VGND sg13cmos5l_fill_1
X_3482_ Tile_X0Y1_E6BEG[2] _3482_/A VPWR VGND sg13cmos5l_buf_1
X_0694_ _0694_/X Tile_X0Y5_N1END[2] Tile_X0Y5_N4END[2] _0990_/B _0693_/X _3084_/Q
+ _3083_/Q VPWR VGND sg13cmos5l_mux4_1
XANTENNA__1138__A0 Tile_X0Y2_W1END[0] VPWR VGND sg13cmos5l_antennanp
XFILLER_142_255 VPWR VGND sg13cmos5l_decap_8
X_2433_ _2433_/Q Tile_X0Y2_FrameData[31] Tile_X0Y5_FrameStrobe[6] VPWR VGND sg13cmos5l_dlhq_1
XANTENNA__3045__GATE Tile_X0Y5_FrameStrobe[8] VPWR VGND sg13cmos5l_antennanp
XFILLER_243_24 VPWR VGND sg13cmos5l_decap_4
X_2364_ _2364_/Q Tile_X0Y2_FrameData[4] Tile_X0Y5_FrameStrobe[3] VPWR VGND sg13cmos5l_dlhq_1
XFILLER_296_281 VPWR VGND sg13cmos5l_fill_1
X_1315_ _1315_/X _1018_/X _0623_/X Tile_X0Y5_N4END[13] Tile_X0Y0_S4END[9] _2285_/Q
+ _2286_/Q VPWR VGND sg13cmos5l_mux4_1
XANTENNA__0867__B_N Tile_X0Y5_W6END[5] VPWR VGND sg13cmos5l_antennanp
XFILLER_110_174 VPWR VGND sg13cmos5l_fill_1
XFILLER_256_134 VPWR VGND sg13cmos5l_decap_8
X_2295_ _2295_/Q Tile_X0Y2_FrameData[9] Tile_X0Y5_FrameStrobe[1] VPWR VGND sg13cmos5l_dlhq_1
XANTENNA__2475__D Tile_X0Y2_FrameData[21] VPWR VGND sg13cmos5l_antennanp
XFILLER_110_196 VPWR VGND sg13cmos5l_decap_8
XFILLER_271_104 VPWR VGND sg13cmos5l_decap_8
XFILLER_271_115 VPWR VGND sg13cmos5l_fill_2
X_1246_ _3622_/A AXI_M_SOC_RDATA31 _1005_/X _1004_/X _1140_/X _1813_/Q _1814_/Q VPWR
+ VGND sg13cmos5l_mux4_1
XANTENNA__1310__A0 Tile_X0Y1_W2MID[6] VPWR VGND sg13cmos5l_antennanp
XANTENNA__3501__X Tile_X0Y1_E2BEG[1] VPWR VGND sg13cmos5l_antennanp
XFILLER_112_17 VPWR VGND sg13cmos5l_decap_8
X_1177_ _1177_/X Tile_X0Y1_W1END[3] Tile_X0Y1_W2MID[0] Tile_X0Y1_W2END[0] _1115_/X
+ _2182_/Q _2181_/Q VPWR VGND sg13cmos5l_mux4_1
XFILLER_64_283 VPWR VGND sg13cmos5l_fill_1
XFILLER_268_21 VPWR VGND sg13cmos5l_decap_4
XANTENNA__1819__D Tile_X0Y0_FrameData[5] VPWR VGND sg13cmos5l_antennanp
XANTENNA__3884__A Tile_X0Y5_FrameData[25] VPWR VGND sg13cmos5l_antennanp
XFILLER_177_185 VPWR VGND sg13cmos5l_decap_8
X_3818_ Tile_X0Y5_E2BEG[3] _3818_/A VPWR VGND sg13cmos5l_buf_1
XFILLER_21_14 VPWR VGND sg13cmos5l_fill_2
XFILLER_326_149 VPWR VGND sg13cmos5l_fill_1
XFILLER_118_263 VPWR VGND sg13cmos5l_decap_4
XFILLER_137_36 VPWR VGND sg13cmos5l_decap_4
X_3749_ Tile_X0Y4_E2BEGb[7] _3749_/A VPWR VGND sg13cmos5l_buf_1
XFILLER_334_160 VPWR VGND sg13cmos5l_fill_1
XANTENNA__2254__GATE Tile_X0Y5_FrameStrobe[0] VPWR VGND sg13cmos5l_antennanp
XFILLER_118_285 VPWR VGND sg13cmos5l_fill_2
XFILLER_284_53 VPWR VGND sg13cmos5l_fill_2
XANTENNA__1129__A0 Tile_X0Y5_W2MID[4] VPWR VGND sg13cmos5l_antennanp
XANTENNA__2884__GATE Tile_X0Y5_FrameStrobe[3] VPWR VGND sg13cmos5l_antennanp
XFILLER_294_207 VPWR VGND sg13cmos5l_decap_8
XANTENNA__2269__GATE Tile_X0Y5_FrameStrobe[0] VPWR VGND sg13cmos5l_antennanp
XFILLER_101_174 VPWR VGND sg13cmos5l_decap_8
XANTENNA__2899__GATE Tile_X0Y5_FrameStrobe[3] VPWR VGND sg13cmos5l_antennanp
XFILLER_247_167 VPWR VGND sg13cmos5l_fill_1
XFILLER_247_189 VPWR VGND sg13cmos5l_decap_8
XFILLER_46_11 VPWR VGND sg13cmos5l_decap_8
XANTENNA__1301__A0 Tile_X0Y1_W2MID[0] VPWR VGND sg13cmos5l_antennanp
XANTENNA__2385__D Tile_X0Y2_FrameData[15] VPWR VGND sg13cmos5l_antennanp
XANTENNA__0655__A2 Tile_X0Y3_W2END[2] VPWR VGND sg13cmos5l_antennanp
XANTENNA__3411__X Tile_X0Y2_FrameData_O[13] VPWR VGND sg13cmos5l_antennanp
XFILLER_55_283 VPWR VGND sg13cmos5l_fill_1
XANTENNA__2822__GATE Tile_X0Y5_FrameStrobe[1] VPWR VGND sg13cmos5l_antennanp
XFILLER_102_61 VPWR VGND sg13cmos5l_decap_8
XFILLER_102_72 VPWR VGND sg13cmos5l_fill_1
XFILLER_62_21 VPWR VGND sg13cmos5l_decap_8
XFILLER_30_128 VPWR VGND sg13cmos5l_fill_2
XANTENNA__1729__D Tile_X0Y0_FrameData[31] VPWR VGND sg13cmos5l_antennanp
XANTENNA__2207__GATE Tile_X0Y5_FrameStrobe[7] VPWR VGND sg13cmos5l_antennanp
XFILLER_168_141 VPWR VGND sg13cmos5l_decap_8
XANTENNA__1080__A2 Tile_X0Y0_S1END[3] VPWR VGND sg13cmos5l_antennanp
XANTENNA__2837__GATE Tile_X0Y5_FrameStrobe[1] VPWR VGND sg13cmos5l_antennanp
XANTENNA__3794__A Tile_X0Y4_FrameData[16] VPWR VGND sg13cmos5l_antennanp
XFILLER_134_0 VPWR VGND sg13cmos5l_fill_2
XFILLER_7_16 VPWR VGND sg13cmos5l_fill_1
XFILLER_328_35 VPWR VGND sg13cmos5l_decap_4
XFILLER_194_20 VPWR VGND sg13cmos5l_decap_8
XFILLER_301_0 VPWR VGND sg13cmos5l_fill_2
XFILLER_109_285 VPWR VGND sg13cmos5l_fill_2
XFILLER_124_222 VPWR VGND sg13cmos5l_fill_2
XFILLER_285_218 VPWR VGND sg13cmos5l_fill_1
XFILLER_97_117 VPWR VGND sg13cmos5l_fill_2
XANTENNA__0929__Y AXI_M_SOC_AWSIZE0 VPWR VGND sg13cmos5l_antennanp
XFILLER_238_112 VPWR VGND sg13cmos5l_decap_8
XFILLER_285_229 VPWR VGND sg13cmos5l_fill_2
XANTENNA__1540__A0 Tile_X0Y3_WW4END[0] VPWR VGND sg13cmos5l_antennanp
X_1100_ _1100_/X _1097_/X _1098_/X _1099_/X Tile_X0Y0_S2MID[2] _1988_/Q _1987_/Q VPWR
+ VGND sg13cmos5l_mux4_1
XFILLER_238_167 VPWR VGND sg13cmos5l_decap_8
X_2080_ _2080_/Q Tile_X0Y1_FrameData[16] Tile_X0Y5_FrameStrobe[3] VPWR VGND sg13cmos5l_dlhq_1
XANTENNA__2295__D Tile_X0Y2_FrameData[9] VPWR VGND sg13cmos5l_antennanp
X_1031_ _1031_/X _1039_/X _1040_/X _3029_/Q VPWR VGND sg13cmos5l_mux2_1
X_2982_ _2982_/Q Tile_X0Y4_FrameData[26] Tile_X0Y5_FrameStrobe[6] VPWR VGND sg13cmos5l_dlhq_1
XFILLER_61_264 VPWR VGND sg13cmos5l_decap_4
XFILLER_159_152 VPWR VGND sg13cmos5l_fill_2
X_1933_ _1933_/Q Tile_X0Y0_FrameData[19] Tile_X0Y5_FrameStrobe[7] VPWR VGND sg13cmos5l_dlhq_1
XANTENNA__1071__A2 Tile_X0Y2_W6END[8] VPWR VGND sg13cmos5l_antennanp
XFILLER_238_46 VPWR VGND sg13cmos5l_fill_1
X_3603_ Tile_X0Y0_EE4BEG[2] _3603_/A VPWR VGND sg13cmos5l_buf_1
X_1864_ _1864_/Q Tile_X0Y0_FrameData[24] Tile_X0Y5_FrameStrobe[5] VPWR VGND sg13cmos5l_dlhq_1
X_1795_ _1795_/Q Tile_X0Y0_FrameData[29] Tile_X0Y5_FrameStrobe[3] VPWR VGND sg13cmos5l_dlhq_1
X_0815_ _3850_/A Tile_X0Y5_WW4END[8] _0598_/X AXI_M_SOC_RLAST _0782_/X _3201_/Q _3202_/Q
+ VPWR VGND sg13cmos5l_mux4_1
XFILLER_115_211 VPWR VGND sg13cmos5l_fill_1
X_3534_ Tile_X0Y0_N2BEGb[5] _3534_/A VPWR VGND sg13cmos5l_buf_1
X_0746_ _0746_/Y _0535_/Y _0743_/X _0745_/Y VPWR VGND sg13cmos5l_o21ai_1
XFILLER_316_182 VPWR VGND sg13cmos5l_fill_1
XFILLER_254_23 VPWR VGND sg13cmos5l_fill_2
X_3465_ Tile_X0Y1_EE4BEG[1] _3465_/A VPWR VGND sg13cmos5l_buf_1
XFILLER_331_141 VPWR VGND sg13cmos5l_decap_4
X_2416_ _2416_/Q Tile_X0Y2_FrameData[16] Tile_X0Y5_FrameStrobe[5] VPWR VGND sg13cmos5l_dlhq_1
X_0677_ _0677_/X _0672_/X _0673_/Y _0676_/Y VPWR VGND sg13cmos5l_a21o_1
XFILLER_331_185 VPWR VGND sg13cmos5l_fill_1
XFILLER_130_236 VPWR VGND sg13cmos5l_fill_1
XFILLER_130_258 VPWR VGND sg13cmos5l_decap_4
X_3396_ Tile_X0Y2_EE4BEG[14] _3396_/A VPWR VGND sg13cmos5l_buf_1
XANTENNA__1531__A0 Tile_X0Y3_WW4END[1] VPWR VGND sg13cmos5l_antennanp
X_2347_ _2347_/Q Tile_X0Y2_FrameData[21] Tile_X0Y5_FrameStrobe[3] VPWR VGND sg13cmos5l_dlhq_1
XFILLER_96_172 VPWR VGND sg13cmos5l_fill_1
XANTENNA__0885__A2 Tile_X0Y5_N4END[9] VPWR VGND sg13cmos5l_antennanp
X_2278_ _2278_/Q Tile_X0Y2_FrameData[26] Tile_X0Y5_FrameStrobe[1] VPWR VGND sg13cmos5l_dlhq_1
XANTENNA__3879__A Tile_X0Y5_FrameData[20] VPWR VGND sg13cmos5l_antennanp
XFILLER_270_66 VPWR VGND sg13cmos5l_fill_1
X_1229_ _3614_/A Tile_X0Y0_WW4END[2] _1007_/X AXI_M_SOC_ARREADY _1147_/X _1829_/Q
+ _1830_/Q VPWR VGND sg13cmos5l_mux4_1
XFILLER_244_159 VPWR VGND sg13cmos5l_decap_8
XANTENNA__2933__D Tile_X0Y4_FrameData[11] VPWR VGND sg13cmos5l_antennanp
XFILLER_197_203 VPWR VGND sg13cmos5l_decap_4
XFILLER_197_247 VPWR VGND sg13cmos5l_decap_8
XFILLER_52_286 VPWR VGND sg13cmos5l_fill_1
XFILLER_12_128 VPWR VGND sg13cmos5l_decap_8
XANTENNA__1062__A2 Tile_X0Y5_N4END[4] VPWR VGND sg13cmos5l_antennanp
XFILLER_165_100 VPWR VGND sg13cmos5l_decap_8
XANTENNA__2193__GATE Tile_X0Y5_FrameStrobe[7] VPWR VGND sg13cmos5l_antennanp
XFILLER_307_160 VPWR VGND sg13cmos5l_fill_2
XFILLER_164_23 VPWR VGND sg13cmos5l_decap_8
XFILLER_322_141 VPWR VGND sg13cmos5l_decap_8
XANTENNA__3406__X Tile_X0Y2_FrameData_O[8] VPWR VGND sg13cmos5l_antennanp
XANTENNA__1522__A0 Tile_X0Y3_WW4END[9] VPWR VGND sg13cmos5l_antennanp
XFILLER_196_2 VPWR VGND sg13cmos5l_fill_1
XFILLER_57_21 VPWR VGND sg13cmos5l_decap_8
XANTENNA__2131__GATE Tile_X0Y5_FrameStrobe[5] VPWR VGND sg13cmos5l_antennanp
XANTENNA__3789__A Tile_X0Y4_FrameData[11] VPWR VGND sg13cmos5l_antennanp
XFILLER_180_66 VPWR VGND sg13cmos5l_decap_8
XFILLER_57_98 VPWR VGND sg13cmos5l_decap_4
XANTENNA__2761__GATE Tile_X0Y5_FrameStrobe[7] VPWR VGND sg13cmos5l_antennanp
XANTENNA__3004__D Tile_X0Y4_FrameData[4] VPWR VGND sg13cmos5l_antennanp
XFILLER_28_283 VPWR VGND sg13cmos5l_fill_1
XANTENNA__2843__D Tile_X0Y4_FrameData[5] VPWR VGND sg13cmos5l_antennanp
XFILLER_188_203 VPWR VGND sg13cmos5l_decap_8
XFILLER_250_118 VPWR VGND sg13cmos5l_fill_1
XFILLER_251_0 VPWR VGND sg13cmos5l_fill_2
XFILLER_73_64 VPWR VGND sg13cmos5l_fill_2
XANTENNA__2146__GATE Tile_X0Y5_FrameStrobe[5] VPWR VGND sg13cmos5l_antennanp
XFILLER_73_97 VPWR VGND sg13cmos5l_decap_8
XANTENNA__2776__GATE Tile_X0Y5_FrameStrobe[8] VPWR VGND sg13cmos5l_antennanp
XFILLER_196_280 VPWR VGND sg13cmos5l_fill_1
XFILLER_156_144 VPWR VGND sg13cmos5l_decap_8
XANTENNA__0800__A2 AXI_M_SOC_RLAST VPWR VGND sg13cmos5l_antennanp
XFILLER_208_38 VPWR VGND sg13cmos5l_decap_4
X_1580_ _1580_/X Tile_X0Y3_W1END[2] Tile_X0Y3_W6END[10] Tile_X0Y3_WW4END[2] _1524_/X
+ _2753_/Q _2754_/Q VPWR VGND sg13cmos5l_mux4_1
X_0600_ _0601_/A _3268_/Q Tile_X0Y5_W6END[4] _3267_/Q VPWR VGND sg13cmos5l_o21ai_1
X_0531_ _0531_/Y _3267_/Q VPWR VGND sg13cmos5l_inv_1
XFILLER_98_50 VPWR VGND sg13cmos5l_decap_8
XANTENNA__0564__A1 Tile_X0Y5_W2MID[0] VPWR VGND sg13cmos5l_antennanp
XANTENNA__2714__GATE Tile_X0Y5_FrameStrobe[6] VPWR VGND sg13cmos5l_antennanp
XFILLER_112_236 VPWR VGND sg13cmos5l_decap_8
X_3250_ _3250_/Q Tile_X0Y5_FrameData[30] Tile_X0Y5_FrameStrobe[6] VPWR VGND sg13cmos5l_dlhq_1
XANTENNA__1513__A0 Tile_X0Y3_WW4END[11] VPWR VGND sg13cmos5l_antennanp
XANTENNA__1922__D Tile_X0Y0_FrameData[30] VPWR VGND sg13cmos5l_antennanp
X_3181_ _3181_/Q Tile_X0Y5_FrameData[3] Tile_X0Y5_FrameStrobe[3] VPWR VGND sg13cmos5l_dlhq_1
X_2201_ _2201_/Q Tile_X0Y1_FrameData[23] Tile_X0Y5_FrameStrobe[7] VPWR VGND sg13cmos5l_dlhq_1
XFILLER_85_109 VPWR VGND sg13cmos5l_decap_8
XANTENNA__1970__GATE Tile_X0Y5_FrameStrobe[0] VPWR VGND sg13cmos5l_antennanp
X_2132_ _2132_/Q Tile_X0Y1_FrameData[28] Tile_X0Y5_FrameStrobe[5] VPWR VGND sg13cmos5l_dlhq_1
XANTENNA__2729__GATE Tile_X0Y5_FrameStrobe[6] VPWR VGND sg13cmos5l_antennanp
XANTENNA__3699__A Tile_X0Y3_FrameData[2] VPWR VGND sg13cmos5l_antennanp
XFILLER_19_261 VPWR VGND sg13cmos5l_fill_1
XFILLER_19_272 VPWR VGND sg13cmos5l_decap_4
X_2063_ _2063_/Q Tile_X0Y1_FrameData[1] Tile_X0Y5_FrameStrobe[2] VPWR VGND sg13cmos5l_dlhq_1
XFILLER_234_170 VPWR VGND sg13cmos5l_fill_2
XFILLER_240_69 VPWR VGND sg13cmos5l_fill_2
X_1014_ _1014_/X Tile_X0Y2_W2MID[5] Tile_X0Y2_W2END[5] Tile_X0Y2_W6END[10] _1151_/X
+ _2464_/Q _2463_/Q VPWR VGND sg13cmos5l_mux4_1
XANTENNA__1985__GATE Tile_X0Y5_FrameStrobe[0] VPWR VGND sg13cmos5l_antennanp
XANTENNA__2753__D Tile_X0Y3_FrameData[15] VPWR VGND sg13cmos5l_antennanp
XFILLER_179_214 VPWR VGND sg13cmos5l_decap_8
XFILLER_194_206 VPWR VGND sg13cmos5l_decap_8
XFILLER_97_0 VPWR VGND sg13cmos5l_fill_2
XFILLER_147_100 VPWR VGND sg13cmos5l_decap_8
XFILLER_194_239 VPWR VGND sg13cmos5l_decap_8
X_2965_ _2965_/Q Tile_X0Y4_FrameData[11] Tile_X0Y5_FrameStrobe[5] VPWR VGND sg13cmos5l_dlhq_1
XANTENNA__1044__A2 Tile_X0Y1_W6END[2] VPWR VGND sg13cmos5l_antennanp
X_2896_ _2896_/Q Tile_X0Y4_FrameData[16] Tile_X0Y5_FrameStrobe[3] VPWR VGND sg13cmos5l_dlhq_1
X_1916_ _1916_/Q Tile_X0Y0_FrameData[4] Tile_X0Y5_FrameStrobe[6] VPWR VGND sg13cmos5l_dlhq_1
X_1847_ _1847_/Q Tile_X0Y0_FrameData[9] Tile_X0Y5_FrameStrobe[4] VPWR VGND sg13cmos5l_dlhq_1
XANTENNA__1923__GATE Tile_X0Y5_FrameStrobe[7] VPWR VGND sg13cmos5l_antennanp
XFILLER_265_55 VPWR VGND sg13cmos5l_fill_2
X_3517_ Tile_X0Y0_N4BEG[4] _3517_/A VPWR VGND sg13cmos5l_buf_1
X_1778_ _1778_/Q Tile_X0Y0_FrameData[14] Tile_X0Y5_FrameStrobe[2] VPWR VGND sg13cmos5l_dlhq_1
XFILLER_103_225 VPWR VGND sg13cmos5l_fill_2
X_0729_ _0729_/X _0724_/X _0725_/Y _0728_/Y VPWR VGND sg13cmos5l_a21o_1
X_3448_ Tile_X0Y1_FrameData_O[16] Tile_X0Y1_FrameData[16] VPWR VGND sg13cmos5l_buf_1
XANTENNA__1504__A0 Tile_X0Y3_W2MID[0] VPWR VGND sg13cmos5l_antennanp
XANTENNA__1832__D Tile_X0Y0_FrameData[24] VPWR VGND sg13cmos5l_antennanp
XANTENNA__2928__D Tile_X0Y4_FrameData[16] VPWR VGND sg13cmos5l_antennanp
XFILLER_103_269 VPWR VGND sg13cmos5l_fill_2
XFILLER_281_54 VPWR VGND sg13cmos5l_fill_2
X_3379_ Tile_X0Y2_E6BEG[9] _3379_/A VPWR VGND sg13cmos5l_buf_1
XANTENNA__1938__GATE Tile_X0Y5_FrameStrobe[7] VPWR VGND sg13cmos5l_antennanp
XFILLER_84_153 VPWR VGND sg13cmos5l_decap_8
XANTENNA__3402__A Tile_X0Y2_FrameData[4] VPWR VGND sg13cmos5l_antennanp
XFILLER_150_47 VPWR VGND sg13cmos5l_fill_2
XFILLER_232_107 VPWR VGND sg13cmos5l_decap_4
XANTENNA__3896__X Tile_X0Y5_S2BEG[1] VPWR VGND sg13cmos5l_antennanp
XANTENNA__1283__A2 Tile_X0Y0_S4END[4] VPWR VGND sg13cmos5l_antennanp
XANTENNA__2663__D Tile_X0Y3_FrameData[9] VPWR VGND sg13cmos5l_antennanp
XFILLER_159_23 VPWR VGND sg13cmos5l_decap_8
XFILLER_43_45 VPWR VGND sg13cmos5l_fill_1
XFILLER_43_78 VPWR VGND sg13cmos5l_fill_2
XFILLER_40_245 VPWR VGND sg13cmos5l_decap_8
XFILLER_159_78 VPWR VGND sg13cmos5l_decap_4
XFILLER_138_166 VPWR VGND sg13cmos5l_decap_8
XANTENNA__0794__A1 Tile_X0Y5_N2END[3] VPWR VGND sg13cmos5l_antennanp
XFILLER_4_124 VPWR VGND sg13cmos5l_fill_1
XFILLER_175_88 VPWR VGND sg13cmos5l_decap_8
XFILLER_325_69 VPWR VGND sg13cmos5l_fill_2
XANTENNA__1742__D Tile_X0Y0_FrameData[18] VPWR VGND sg13cmos5l_antennanp
XANTENNA__2838__D Tile_X0Y4_FrameData[10] VPWR VGND sg13cmos5l_antennanp
XFILLER_299_0 VPWR VGND sg13cmos5l_fill_2
XFILLER_68_75 VPWR VGND sg13cmos5l_decap_8
XFILLER_67_109 VPWR VGND sg13cmos5l_fill_2
XANTENNA__2070__GATE Tile_X0Y5_FrameStrobe[3] VPWR VGND sg13cmos5l_antennanp
XFILLER_102_280 VPWR VGND sg13cmos5l_fill_1
XFILLER_191_87 VPWR VGND sg13cmos5l_fill_2
XFILLER_310_188 VPWR VGND sg13cmos5l_decap_8
XFILLER_124_81 VPWR VGND sg13cmos5l_decap_8
XFILLER_84_41 VPWR VGND sg13cmos5l_decap_8
XFILLER_75_153 VPWR VGND sg13cmos5l_fill_1
XFILLER_84_96 VPWR VGND sg13cmos5l_fill_1
XANTENNA__2085__GATE Tile_X0Y5_FrameStrobe[3] VPWR VGND sg13cmos5l_antennanp
XANTENNA__2573__D Tile_X0Y3_FrameData[3] VPWR VGND sg13cmos5l_antennanp
XFILLER_210_17 VPWR VGND sg13cmos5l_decap_8
XFILLER_90_178 VPWR VGND sg13cmos5l_fill_2
XFILLER_231_151 VPWR VGND sg13cmos5l_fill_2
XFILLER_31_212 VPWR VGND sg13cmos5l_decap_8
X_2750_ _2750_/Q Tile_X0Y3_FrameData[18] Tile_X0Y5_FrameStrobe[7] VPWR VGND sg13cmos5l_dlhq_1
XANTENNA__1917__D Tile_X0Y0_FrameData[3] VPWR VGND sg13cmos5l_antennanp
XFILLER_219_26 VPWR VGND sg13cmos5l_decap_8
X_2681_ _2681_/Q Tile_X0Y3_FrameData[23] Tile_X0Y5_FrameStrobe[5] VPWR VGND sg13cmos5l_dlhq_1
X_1701_ _1701_/Q Tile_X0Y0_FrameData[27] Tile_X0Y5_FrameStrobe[0] VPWR VGND sg13cmos5l_dlhq_1
XFILLER_318_244 VPWR VGND sg13cmos5l_decap_8
XANTENNA__0785__A1 Tile_X0Y4_W2END[6] VPWR VGND sg13cmos5l_antennanp
X_1632_ AXI_M_SOC_ARADDR0 Tile_X0Y4_WW4END[0] Tile_X0Y4_W6END[0] Tile_X0Y4_WW4END[8]
+ _1065_/X _2887_/Q _2888_/Q VPWR VGND sg13cmos5l_mux4_1
XANTENNA__2023__GATE Tile_X0Y5_FrameStrobe[1] VPWR VGND sg13cmos5l_antennanp
XFILLER_144_169 VPWR VGND sg13cmos5l_decap_4
XANTENNA__2653__GATE Tile_X0Y5_FrameStrobe[4] VPWR VGND sg13cmos5l_antennanp
X_1563_ AXI_M_SOC_WDATA6 Tile_X0Y3_W2MID[6] Tile_X0Y3_W2END[6] Tile_X0Y3_W6END[6]
+ _1348_/X _2572_/Q _2571_/Q VPWR VGND sg13cmos5l_mux4_1
XFILLER_152_191 VPWR VGND sg13cmos5l_decap_8
XFILLER_301_122 VPWR VGND sg13cmos5l_fill_1
X_3302_ _3302_/Q Tile_X0Y5_FrameData[10] Tile_X0Y5_FrameStrobe[7] VPWR VGND sg13cmos5l_dlhq_1
X_1494_ _3652_/A _1119_/X _0724_/X AXI_M_SOC_RDATA6 AXI_M_SOC_RDATA10 _2706_/Q _2705_/Q
+ VPWR VGND sg13cmos5l_mux4_1
XANTENNA__2748__D Tile_X0Y3_FrameData[20] VPWR VGND sg13cmos5l_antennanp
XFILLER_301_144 VPWR VGND sg13cmos5l_decap_8
X_3233_ _3233_/Q Tile_X0Y5_FrameData[15] Tile_X0Y5_FrameStrobe[5] VPWR VGND sg13cmos5l_dlhq_1
XANTENNA__2038__GATE Tile_X0Y5_FrameStrobe[2] VPWR VGND sg13cmos5l_antennanp
XFILLER_104_18 VPWR VGND sg13cmos5l_decap_8
XANTENNA__2668__GATE Tile_X0Y5_FrameStrobe[4] VPWR VGND sg13cmos5l_antennanp
XFILLER_104_29 VPWR VGND sg13cmos5l_fill_2
XFILLER_12_0 VPWR VGND sg13cmos5l_fill_2
XFILLER_251_24 VPWR VGND sg13cmos5l_decap_4
X_3164_ _3164_/Q Tile_X0Y5_FrameData[20] Tile_X0Y5_FrameStrobe[3] VPWR VGND sg13cmos5l_dlhq_1
X_3095_ _3095_/Q Tile_X0Y5_FrameData[25] Tile_X0Y5_FrameStrobe[1] VPWR VGND sg13cmos5l_dlhq_1
X_2115_ _2115_/Q Tile_X0Y1_FrameData[13] Tile_X0Y5_FrameStrobe[4] VPWR VGND sg13cmos5l_dlhq_1
XANTENNA__0565__B Tile_X0Y0_W6END[0] VPWR VGND sg13cmos5l_antennanp
X_2046_ _2046_/Q Tile_X0Y1_FrameData[18] Tile_X0Y5_FrameStrobe[2] VPWR VGND sg13cmos5l_dlhq_1
XANTENNA__2483__D Tile_X0Y2_FrameData[13] VPWR VGND sg13cmos5l_antennanp
XFILLER_22_234 VPWR VGND sg13cmos5l_decap_8
XFILLER_22_267 VPWR VGND sg13cmos5l_fill_2
XANTENNA__2606__GATE Tile_X0Y5_FrameStrobe[2] VPWR VGND sg13cmos5l_antennanp
X_2948_ _2948_/Q Tile_X0Y4_FrameData[28] Tile_X0Y5_FrameStrobe[5] VPWR VGND sg13cmos5l_dlhq_1
XANTENNA__1827__D Tile_X0Y0_FrameData[29] VPWR VGND sg13cmos5l_antennanp
XFILLER_129_37 VPWR VGND sg13cmos5l_fill_1
XFILLER_13_59 VPWR VGND sg13cmos5l_decap_8
XANTENNA__1862__GATE Tile_X0Y5_FrameStrobe[5] VPWR VGND sg13cmos5l_antennanp
XFILLER_309_277 VPWR VGND sg13cmos5l_decap_4
X_2879_ _2879_/Q Tile_X0Y4_FrameData[1] Tile_X0Y5_FrameStrobe[2] VPWR VGND sg13cmos5l_dlhq_1
XFILLER_145_58 VPWR VGND sg13cmos5l_fill_2
XFILLER_1_138 VPWR VGND sg13cmos5l_decap_4
XFILLER_1_149 VPWR VGND sg13cmos5l_decap_4
XANTENNA__1877__GATE Tile_X0Y5_FrameStrobe[5] VPWR VGND sg13cmos5l_antennanp
XANTENNA__2658__D Tile_X0Y3_FrameData[14] VPWR VGND sg13cmos5l_antennanp
XFILLER_57_120 VPWR VGND sg13cmos5l_decap_8
XFILLER_38_67 VPWR VGND sg13cmos5l_decap_8
XANTENNA__1204__X AXI_M_SOC_AWADDR25 VPWR VGND sg13cmos5l_antennanp
XANTENNA__1800__GATE Tile_X0Y5_FrameStrobe[3] VPWR VGND sg13cmos5l_antennanp
XFILLER_311_16 VPWR VGND sg13cmos5l_fill_2
XFILLER_72_112 VPWR VGND sg13cmos5l_fill_1
XFILLER_260_202 VPWR VGND sg13cmos5l_decap_8
XFILLER_72_145 VPWR VGND sg13cmos5l_decap_4
XFILLER_72_123 VPWR VGND sg13cmos5l_decap_4
XFILLER_54_11 VPWR VGND sg13cmos5l_decap_8
XANTENNA__2393__D Tile_X0Y2_FrameData[7] VPWR VGND sg13cmos5l_antennanp
XANTENNA__1815__GATE Tile_X0Y5_FrameStrobe[3] VPWR VGND sg13cmos5l_antennanp
XFILLER_260_279 VPWR VGND sg13cmos5l_fill_2
XFILLER_13_256 VPWR VGND sg13cmos5l_fill_1
XANTENNA__1008__A2 Tile_X0Y2_W6END[1] VPWR VGND sg13cmos5l_antennanp
XFILLER_70_21 VPWR VGND sg13cmos5l_decap_4
XFILLER_70_87 VPWR VGND sg13cmos5l_decap_8
XANTENNA__0767__A1 Tile_X0Y5_W6END[1] VPWR VGND sg13cmos5l_antennanp
XANTENNA__1737__D Tile_X0Y0_FrameData[23] VPWR VGND sg13cmos5l_antennanp
XFILLER_166_294 VPWR VGND sg13cmos5l_fill_1
XFILLER_214_0 VPWR VGND sg13cmos5l_fill_2
XFILLER_119_70 VPWR VGND sg13cmos5l_fill_2
XFILLER_181_275 VPWR VGND sg13cmos5l_decap_4
XFILLER_181_286 VPWR VGND sg13cmos5l_fill_1
XFILLER_79_63 VPWR VGND sg13cmos5l_decap_8
XFILLER_141_139 VPWR VGND sg13cmos5l_fill_1
XANTENNA__1192__A1 Tile_X0Y0_WW4END[11] VPWR VGND sg13cmos5l_antennanp
XANTENNA__2568__D Tile_X0Y3_FrameData[8] VPWR VGND sg13cmos5l_antennanp
XFILLER_295_176 VPWR VGND sg13cmos5l_fill_1
XFILLER_295_198 VPWR VGND sg13cmos5l_decap_4
XFILLER_95_84 VPWR VGND sg13cmos5l_decap_8
XANTENNA__1495__A2 AXI_M_SOC_RDATA7 VPWR VGND sg13cmos5l_antennanp
XFILLER_48_175 VPWR VGND sg13cmos5l_decap_8
X_3920_ Tile_X0Y5_S4BEG[9] _3920_/A VPWR VGND sg13cmos5l_buf_1
XFILLER_63_167 VPWR VGND sg13cmos5l_decap_8
XANTENNA__3321__GATE Tile_X0Y5_FrameStrobe[8] VPWR VGND sg13cmos5l_antennanp
X_3851_ Tile_X0Y5_EE4BEG[8] _3851_/A VPWR VGND sg13cmos5l_buf_1
X_2802_ _2802_/Q Tile_X0Y4_FrameData[14] Tile_X0Y5_FrameStrobe[0] VPWR VGND sg13cmos5l_dlhq_1
X_3782_ Tile_X0Y4_FrameData_O[4] Tile_X0Y4_FrameData[4] VPWR VGND sg13cmos5l_buf_1
XANTENNA__3336__GATE Tile_X0Y5_FrameStrobe[8] VPWR VGND sg13cmos5l_antennanp
X_2733_ _2733_/Q Tile_X0Y3_FrameData[3] Tile_X0Y5_FrameStrobe[6] VPWR VGND sg13cmos5l_dlhq_1
X_0994_ _0994_/X Tile_X0Y0_W1END[2] Tile_X0Y0_WW4END[14] _1004_/X _1005_/X _1902_/Q
+ _1900_/Q VPWR VGND sg13cmos5l_mux4_1
XANTENNA__0758__A1 Tile_X0Y5_WW4END[14] VPWR VGND sg13cmos5l_antennanp
XFILLER_117_125 VPWR VGND sg13cmos5l_fill_2
XFILLER_8_271 VPWR VGND sg13cmos5l_fill_2
XFILLER_8_260 VPWR VGND sg13cmos5l_decap_8
XANTENNA__2592__GATE Tile_X0Y5_FrameStrobe[2] VPWR VGND sg13cmos5l_antennanp
XFILLER_117_147 VPWR VGND sg13cmos5l_fill_2
X_2664_ _2664_/Q Tile_X0Y3_FrameData[8] Tile_X0Y5_FrameStrobe[4] VPWR VGND sg13cmos5l_dlhq_1
X_2595_ _2595_/Q Tile_X0Y3_FrameData[13] Tile_X0Y5_FrameStrobe[2] VPWR VGND sg13cmos5l_dlhq_1
X_1615_ _3766_/A Tile_X0Y4_WW4END[11] _1126_/X AXI_M_SOC_RDATA2 _1130_/X _2935_/Q
+ _2936_/Q VPWR VGND sg13cmos5l_mux4_1
X_1546_ _3677_/A AXI_M_SOC_RDATA10 _1435_/X _1526_/X _1271_/X _2623_/Q _2624_/Q VPWR
+ VGND sg13cmos5l_mux4_1
XANTENNA__2478__D Tile_X0Y2_FrameData[18] VPWR VGND sg13cmos5l_antennanp
XFILLER_262_23 VPWR VGND sg13cmos5l_fill_1
XANTENNA__0930__A1 Tile_X0Y5_W6END[10] VPWR VGND sg13cmos5l_antennanp
XANTENNA__3504__X Tile_X0Y1_E2BEG[4] VPWR VGND sg13cmos5l_antennanp
X_1477_ _1478_/B Tile_X0Y2_W1END[2] Tile_X0Y2_W6END[6] Tile_X0Y2_WW4END[14] _1380_/X
+ _2445_/Q _2446_/Q VPWR VGND sg13cmos5l_mux4_1
XFILLER_86_248 VPWR VGND sg13cmos5l_decap_8
XANTENNA__0847__Y AXI_M_SOC_ARSIZE2 VPWR VGND sg13cmos5l_antennanp
XFILLER_227_210 VPWR VGND sg13cmos5l_fill_1
X_3216_ _3216_/Q Tile_X0Y5_FrameData[0] Tile_X0Y5_FrameStrobe[4] VPWR VGND sg13cmos5l_dlhq_1
XFILLER_39_131 VPWR VGND sg13cmos5l_decap_8
XANTENNA__0576__A Tile_X0Y2_W6END[0] VPWR VGND sg13cmos5l_antennanp
XFILLER_227_232 VPWR VGND sg13cmos5l_decap_4
X_3147_ _3147_/Q Tile_X0Y5_FrameData[5] Tile_X0Y5_FrameStrobe[2] VPWR VGND sg13cmos5l_dlhq_1
XANTENNA__0694__A0 Tile_X0Y5_N1END[2] VPWR VGND sg13cmos5l_antennanp
XANTENNA__2530__GATE Tile_X0Y5_FrameStrobe[0] VPWR VGND sg13cmos5l_antennanp
XANTENNA__3887__A Tile_X0Y5_FrameData[28] VPWR VGND sg13cmos5l_antennanp
X_3078_ _3078_/Q Tile_X0Y5_FrameData[10] Tile_X0Y5_FrameStrobe[0] VPWR VGND sg13cmos5l_dlhq_1
XANTENNA__3102__D Tile_X0Y5_FrameData[18] VPWR VGND sg13cmos5l_antennanp
XFILLER_24_14 VPWR VGND sg13cmos5l_fill_2
X_2029_ _2029_/Q Tile_X0Y1_FrameData[3] Tile_X0Y5_FrameStrobe[1] VPWR VGND sg13cmos5l_dlhq_1
XANTENNA__2545__GATE Tile_X0Y5_FrameStrobe[1] VPWR VGND sg13cmos5l_antennanp
XANTENNA__0997__A1 Tile_X0Y4_WW4END[2] VPWR VGND sg13cmos5l_antennanp
XANTENNA__2941__D Tile_X0Y4_FrameData[3] VPWR VGND sg13cmos5l_antennanp
XFILLER_24_69 VPWR VGND sg13cmos5l_decap_4
XFILLER_287_42 VPWR VGND sg13cmos5l_fill_2
XFILLER_138_7 VPWR VGND sg13cmos5l_decap_8
XANTENNA__1410__A2 Tile_X0Y2_W6END[5] VPWR VGND sg13cmos5l_antennanp
XFILLER_156_35 VPWR VGND sg13cmos5l_decap_8
XFILLER_163_231 VPWR VGND sg13cmos5l_decap_8
XFILLER_40_68 VPWR VGND sg13cmos5l_decap_8
XANTENNA__1174__A1 Tile_X0Y4_W2END[1] VPWR VGND sg13cmos5l_antennanp
XANTENNA__2388__D Tile_X0Y2_FrameData[12] VPWR VGND sg13cmos5l_antennanp
XFILLER_77_204 VPWR VGND sg13cmos5l_decap_8
XFILLER_49_33 VPWR VGND sg13cmos5l_decap_8
XANTENNA__3414__X Tile_X0Y2_FrameData_O[16] VPWR VGND sg13cmos5l_antennanp
XFILLER_292_135 VPWR VGND sg13cmos5l_fill_1
XANTENNA__1477__A2 Tile_X0Y2_WW4END[14] VPWR VGND sg13cmos5l_antennanp
XFILLER_105_83 VPWR VGND sg13cmos5l_fill_2
XFILLER_322_48 VPWR VGND sg13cmos5l_fill_1
XFILLER_45_112 VPWR VGND sg13cmos5l_decap_8
XANTENNA__3797__A Tile_X0Y4_FrameData[19] VPWR VGND sg13cmos5l_antennanp
XFILLER_164_0 VPWR VGND sg13cmos5l_fill_2
XFILLER_65_87 VPWR VGND sg13cmos5l_decap_8
XFILLER_45_167 VPWR VGND sg13cmos5l_decap_8
XANTENNA__1229__A2 AXI_M_SOC_ARREADY VPWR VGND sg13cmos5l_antennanp
XANTENNA__1754__GATE Tile_X0Y5_FrameStrobe[1] VPWR VGND sg13cmos5l_antennanp
XANTENNA__3012__D Tile_X0Y4_FrameData[28] VPWR VGND sg13cmos5l_antennanp
XANTENNA__2851__D Tile_X0Y4_FrameData[29] VPWR VGND sg13cmos5l_antennanp
XFILLER_331_0 VPWR VGND sg13cmos5l_fill_2
XANTENNA__1769__GATE Tile_X0Y5_FrameStrobe[2] VPWR VGND sg13cmos5l_antennanp
XFILLER_197_75 VPWR VGND sg13cmos5l_decap_8
XFILLER_139_283 VPWR VGND sg13cmos5l_fill_1
XFILLER_154_242 VPWR VGND sg13cmos5l_fill_1
XFILLER_60_8 VPWR VGND sg13cmos5l_fill_2
XFILLER_53_7 VPWR VGND sg13cmos5l_decap_8
X_1400_ _3370_/A Tile_X0Y5_N4END[12] _1370_/X Tile_X0Y0_S4END[8] _1121_/X _2367_/Q
+ _2368_/Q VPWR VGND sg13cmos5l_mux4_1
XANTENNA__2298__D Tile_X0Y2_FrameData[6] VPWR VGND sg13cmos5l_antennanp
X_2380_ _2380_/Q Tile_X0Y2_FrameData[20] Tile_X0Y5_FrameStrobe[4] VPWR VGND sg13cmos5l_dlhq_1
XFILLER_268_165 VPWR VGND sg13cmos5l_decap_4
X_1331_ _3509_/A _1139_/X _0617_/X AXI_M_SOC_RDATA24 AXI_M_SOC_RDATA28 _2166_/Q _2165_/Q
+ VPWR VGND sg13cmos5l_mux4_1
XANTENNA__1707__GATE Tile_X0Y5_FrameStrobe[0] VPWR VGND sg13cmos5l_antennanp
XFILLER_268_198 VPWR VGND sg13cmos5l_decap_4
X_1262_ _3632_/A Tile_X0Y0_W2END[4] AXI_M_SOC_BRESP0 _1148_/X _1078_/X _1866_/Q _1865_/Q
+ VPWR VGND sg13cmos5l_mux4_1
XANTENNA__1930__D Tile_X0Y0_FrameData[22] VPWR VGND sg13cmos5l_antennanp
XFILLER_232_37 VPWR VGND sg13cmos5l_decap_8
X_3001_ _3001_/Q Tile_X0Y4_FrameData[7] Tile_X0Y5_FrameStrobe[6] VPWR VGND sg13cmos5l_dlhq_1
XFILLER_209_265 VPWR VGND sg13cmos5l_fill_2
X_1193_ AXI_M_SOC_AWADDR15 Tile_X0Y0_WW4END[7] Tile_X0Y0_WW4END[15] Tile_X0Y0_W6END[7]
+ _0985_/X _1786_/Q _1785_/Q VPWR VGND sg13cmos5l_mux4_1
XANTENNA__3260__GATE Tile_X0Y5_FrameStrobe[6] VPWR VGND sg13cmos5l_antennanp
XFILLER_36_156 VPWR VGND sg13cmos5l_decap_8
XFILLER_224_279 VPWR VGND sg13cmos5l_fill_2
X_3903_ Tile_X0Y5_S2BEGb[0] _3903_/A VPWR VGND sg13cmos5l_buf_1
XANTENNA__0979__A1 Tile_X0Y0_WW4END[15] VPWR VGND sg13cmos5l_antennanp
XANTENNA__2761__D Tile_X0Y3_FrameData[7] VPWR VGND sg13cmos5l_antennanp
XANTENNA__3275__GATE Tile_X0Y5_FrameStrobe[6] VPWR VGND sg13cmos5l_antennanp
X_3834_ Tile_X0Y5_E6BEG[3] _3834_/A VPWR VGND sg13cmos5l_buf_1
XFILLER_338_125 VPWR VGND sg13cmos5l_fill_2
XANTENNA__1640__A2 Tile_X0Y4_W6END[5] VPWR VGND sg13cmos5l_antennanp
XFILLER_338_169 VPWR VGND sg13cmos5l_decap_8
X_3765_ Tile_X0Y4_EE4BEG[3] _3765_/A VPWR VGND sg13cmos5l_buf_1
X_0977_ _0977_/X Tile_X0Y3_W1END[2] Tile_X0Y3_W6END[6] _0888_/X _0683_/X _2780_/Q
+ _2779_/Q VPWR VGND sg13cmos5l_mux4_1
X_2716_ _2716_/Q Tile_X0Y3_FrameData[20] Tile_X0Y5_FrameStrobe[6] VPWR VGND sg13cmos5l_dlhq_1
X_3696_ Tile_X0Y3_EE4BEG[15] _3696_/A VPWR VGND sg13cmos5l_buf_1
X_2647_ _2647_/Q Tile_X0Y3_FrameData[25] Tile_X0Y5_FrameStrobe[4] VPWR VGND sg13cmos5l_dlhq_1
XANTENNA__1156__A1 Tile_X0Y4_W2END[7] VPWR VGND sg13cmos5l_antennanp
X_2578_ _2578_/Q Tile_X0Y3_FrameData[30] Tile_X0Y5_FrameStrobe[2] VPWR VGND sg13cmos5l_dlhq_1
XANTENNA__2001__D Tile_X0Y1_FrameData[31] VPWR VGND sg13cmos5l_antennanp
XANTENNA__3213__GATE Tile_X0Y5_FrameStrobe[4] VPWR VGND sg13cmos5l_antennanp
XFILLER_273_99 VPWR VGND sg13cmos5l_decap_4
X_1529_ _3691_/A Tile_X0Y3_WW4END[5] AXI_M_SOC_RDATA11 _1437_/X _1342_/X _2652_/Q
+ _2651_/Q VPWR VGND sg13cmos5l_mux4_1
XFILLER_59_237 VPWR VGND sg13cmos5l_decap_8
XFILLER_142_15 VPWR VGND sg13cmos5l_decap_8
XANTENNA__1840__D Tile_X0Y0_FrameData[16] VPWR VGND sg13cmos5l_antennanp
XANTENNA__2936__D Tile_X0Y4_FrameData[8] VPWR VGND sg13cmos5l_antennanp
XFILLER_274_135 VPWR VGND sg13cmos5l_fill_1
XANTENNA__3228__GATE Tile_X0Y5_FrameStrobe[5] VPWR VGND sg13cmos5l_antennanp
XFILLER_215_213 VPWR VGND sg13cmos5l_decap_8
XFILLER_27_134 VPWR VGND sg13cmos5l_decap_8
XFILLER_222_81 VPWR VGND sg13cmos5l_fill_1
XFILLER_215_268 VPWR VGND sg13cmos5l_fill_1
XFILLER_222_92 VPWR VGND sg13cmos5l_decap_4
XFILLER_35_57 VPWR VGND sg13cmos5l_decap_8
XANTENNA__2484__GATE Tile_X0Y5_FrameStrobe[7] VPWR VGND sg13cmos5l_antennanp
XANTENNA__3410__A Tile_X0Y2_FrameData[12] VPWR VGND sg13cmos5l_antennanp
XFILLER_42_148 VPWR VGND sg13cmos5l_fill_2
XANTENNA__1092__A0 Tile_X0Y2_W2MID[4] VPWR VGND sg13cmos5l_antennanp
XANTENNA__2671__D Tile_X0Y3_FrameData[1] VPWR VGND sg13cmos5l_antennanp
XFILLER_329_114 VPWR VGND sg13cmos5l_fill_2
XANTENNA__1631__A2 Tile_X0Y4_WW4END[9] VPWR VGND sg13cmos5l_antennanp
XFILLER_195_164 VPWR VGND sg13cmos5l_decap_8
XFILLER_50_181 VPWR VGND sg13cmos5l_decap_8
XANTENNA__2499__GATE Tile_X0Y5_FrameStrobe[8] VPWR VGND sg13cmos5l_antennanp
XANTENNA__3409__X Tile_X0Y2_FrameData_O[11] VPWR VGND sg13cmos5l_antennanp
XFILLER_51_56 VPWR VGND sg13cmos5l_decap_8
XFILLER_167_56 VPWR VGND sg13cmos5l_decap_8
XFILLER_317_48 VPWR VGND sg13cmos5l_fill_1
XANTENNA__2422__GATE Tile_X0Y5_FrameStrobe[5] VPWR VGND sg13cmos5l_antennanp
XFILLER_151_234 VPWR VGND sg13cmos5l_decap_8
XFILLER_151_245 VPWR VGND sg13cmos5l_fill_1
XFILLER_297_238 VPWR VGND sg13cmos5l_fill_1
XANTENNA__3007__D Tile_X0Y4_FrameData[1] VPWR VGND sg13cmos5l_antennanp
XFILLER_104_161 VPWR VGND sg13cmos5l_decap_4
XFILLER_265_102 VPWR VGND sg13cmos5l_decap_4
XANTENNA__2437__GATE Tile_X0Y5_FrameStrobe[6] VPWR VGND sg13cmos5l_antennanp
XANTENNA__2846__D Tile_X0Y4_FrameData[2] VPWR VGND sg13cmos5l_antennanp
XFILLER_281_0 VPWR VGND sg13cmos5l_fill_2
XFILLER_76_53 VPWR VGND sg13cmos5l_decap_4
XANTENNA__1750__D Tile_X0Y0_FrameData[10] VPWR VGND sg13cmos5l_antennanp
XFILLER_18_134 VPWR VGND sg13cmos5l_decap_8
XFILLER_280_138 VPWR VGND sg13cmos5l_decap_8
XFILLER_73_251 VPWR VGND sg13cmos5l_fill_2
XFILLER_73_240 VPWR VGND sg13cmos5l_decap_8
XFILLER_92_63 VPWR VGND sg13cmos5l_decap_8
XANTENNA__0663__B Tile_X0Y0_S1END[2] VPWR VGND sg13cmos5l_antennanp
XANTENNA__2581__D Tile_X0Y3_FrameData[27] VPWR VGND sg13cmos5l_antennanp
X_0900_ _0900_/Y _0742_/X _3295_/Q VPWR VGND sg13cmos5l_nand2b_1
XFILLER_186_142 VPWR VGND sg13cmos5l_decap_8
X_1880_ _1880_/Q Tile_X0Y0_FrameData[8] Tile_X0Y5_FrameStrobe[5] VPWR VGND sg13cmos5l_dlhq_1
X_0831_ _3838_/A _0759_/X _0597_/X _0598_/X _0794_/X _3170_/Q _3169_/Q VPWR VGND sg13cmos5l_mux4_1
X_3550_ Tile_X0Y0_FrameStrobe_O[1] Tile_X0Y5_FrameStrobe[1] VPWR VGND sg13cmos5l_buf_1
X_0762_ _0762_/X Tile_X0Y5_WW4END[0] Tile_X0Y5_W6END[8] Tile_X0Y5_WW4END[8] _0598_/X
+ _3143_/Q _3144_/Q VPWR VGND sg13cmos5l_mux4_1
X_2501_ _2501_/Q Tile_X0Y2_FrameData[27] Tile_X0Y5_FrameStrobe[8] VPWR VGND sg13cmos5l_dlhq_1
XANTENNA__1925__D Tile_X0Y0_FrameData[27] VPWR VGND sg13cmos5l_antennanp
X_3481_ Tile_X0Y1_E6BEG[1] _3481_/A VPWR VGND sg13cmos5l_buf_1
X_0693_ _0693_/X _0692_/X _0691_/X _2173_/Q VPWR VGND sg13cmos5l_mux2_1
XANTENNA__1138__A1 Tile_X0Y2_W6END[4] VPWR VGND sg13cmos5l_antennanp
X_2432_ _2432_/Q Tile_X0Y2_FrameData[0] Tile_X0Y5_FrameStrobe[5] VPWR VGND sg13cmos5l_dlhq_1
X_2363_ _2363_/Q Tile_X0Y2_FrameData[5] Tile_X0Y5_FrameStrobe[3] VPWR VGND sg13cmos5l_dlhq_1
XANTENNA__0897__A0 Tile_X0Y5_W1END[3] VPWR VGND sg13cmos5l_antennanp
XFILLER_110_131 VPWR VGND sg13cmos5l_decap_8
XFILLER_243_47 VPWR VGND sg13cmos5l_fill_2
XFILLER_296_293 VPWR VGND sg13cmos5l_fill_2
X_1314_ _1314_/X _1120_/X _0718_/X Tile_X0Y5_N4END[15] Tile_X0Y0_S4END[11] _2281_/Q
+ _2282_/Q VPWR VGND sg13cmos5l_mux4_1
XANTENNA__2756__D Tile_X0Y3_FrameData[12] VPWR VGND sg13cmos5l_antennanp
X_2294_ _2294_/Q Tile_X0Y2_FrameData[10] Tile_X0Y5_FrameStrobe[1] VPWR VGND sg13cmos5l_dlhq_1
XFILLER_2_83 VPWR VGND sg13cmos5l_fill_1
X_1245_ _3621_/A AXI_M_SOC_RDATA30 _1137_/X _0985_/X _1145_/X _1815_/Q _1816_/Q VPWR
+ VGND sg13cmos5l_mux4_1
XANTENNA__1310__A1 Tile_X0Y1_W2END[6] VPWR VGND sg13cmos5l_antennanp
X_1176_ _3543_/A Tile_X0Y0_W2MID[1] Tile_X0Y0_W2END[1] Tile_X0Y0_W6END[1] _1010_/X
+ _1948_/Q _1947_/Q VPWR VGND sg13cmos5l_mux4_1
XFILLER_64_251 VPWR VGND sg13cmos5l_fill_1
XFILLER_24_148 VPWR VGND sg13cmos5l_decap_8
XANTENNA__2491__D Tile_X0Y2_FrameData[5] VPWR VGND sg13cmos5l_antennanp
XFILLER_177_120 VPWR VGND sg13cmos5l_fill_1
XANTENNA__1613__A2 AXI_M_SOC_RDATA4 VPWR VGND sg13cmos5l_antennanp
XANTENNA__0821__A0 Tile_X0Y5_WW4END[2] VPWR VGND sg13cmos5l_antennanp
XFILLER_177_164 VPWR VGND sg13cmos5l_decap_8
XFILLER_192_112 VPWR VGND sg13cmos5l_fill_2
XFILLER_220_293 VPWR VGND sg13cmos5l_fill_2
X_3817_ Tile_X0Y5_E2BEG[2] _3817_/A VPWR VGND sg13cmos5l_buf_1
X_3748_ Tile_X0Y4_E2BEGb[6] _3748_/A VPWR VGND sg13cmos5l_buf_1
XFILLER_115_9 VPWR VGND sg13cmos5l_fill_2
XFILLER_118_275 VPWR VGND sg13cmos5l_fill_2
XFILLER_284_21 VPWR VGND sg13cmos5l_fill_2
XFILLER_284_32 VPWR VGND sg13cmos5l_fill_2
XANTENNA__1835__D Tile_X0Y0_FrameData[21] VPWR VGND sg13cmos5l_antennanp
XFILLER_284_65 VPWR VGND sg13cmos5l_fill_1
XFILLER_284_76 VPWR VGND sg13cmos5l_fill_2
X_3679_ Tile_X0Y3_E6BEG[10] _3679_/A VPWR VGND sg13cmos5l_buf_1
XANTENNA__1129__A1 Tile_X0Y5_W2END[4] VPWR VGND sg13cmos5l_antennanp
XANTENNA__3152__GATE Tile_X0Y5_FrameStrobe[2] VPWR VGND sg13cmos5l_antennanp
XFILLER_133_256 VPWR VGND sg13cmos5l_fill_1
XFILLER_217_70 VPWR VGND sg13cmos5l_decap_4
XFILLER_284_87 VPWR VGND sg13cmos5l_fill_2
XFILLER_153_14 VPWR VGND sg13cmos5l_fill_2
XANTENNA__3405__A Tile_X0Y2_FrameData[7] VPWR VGND sg13cmos5l_antennanp
XANTENNA__2666__D Tile_X0Y3_FrameData[6] VPWR VGND sg13cmos5l_antennanp
XANTENNA__3899__X Tile_X0Y5_S2BEG[4] VPWR VGND sg13cmos5l_antennanp
XFILLER_101_153 VPWR VGND sg13cmos5l_decap_8
XFILLER_153_69 VPWR VGND sg13cmos5l_decap_8
XFILLER_287_293 VPWR VGND sg13cmos5l_fill_2
XFILLER_303_17 VPWR VGND sg13cmos5l_fill_1
XANTENNA__3167__GATE Tile_X0Y5_FrameStrobe[3] VPWR VGND sg13cmos5l_antennanp
XFILLER_262_105 VPWR VGND sg13cmos5l_decap_4
XANTENNA__1301__A1 Tile_X0Y1_W2END[0] VPWR VGND sg13cmos5l_antennanp
XFILLER_46_67 VPWR VGND sg13cmos5l_decap_8
XANTENNA__1212__X AXI_M_SOC_AWADDR27 VPWR VGND sg13cmos5l_antennanp
XFILLER_203_227 VPWR VGND sg13cmos5l_fill_1
XFILLER_62_77 VPWR VGND sg13cmos5l_decap_8
XANTENNA__0812__A0 Tile_X0Y5_WW4END[11] VPWR VGND sg13cmos5l_antennanp
XANTENNA__1080__A3 Tile_X0Y0_S4END[3] VPWR VGND sg13cmos5l_antennanp
XANTENNA__3105__GATE Tile_X0Y5_FrameStrobe[1] VPWR VGND sg13cmos5l_antennanp
XFILLER_168_186 VPWR VGND sg13cmos5l_decap_8
XFILLER_178_88 VPWR VGND sg13cmos5l_decap_4
XFILLER_211_271 VPWR VGND sg13cmos5l_fill_1
XFILLER_211_293 VPWR VGND sg13cmos5l_fill_2
XFILLER_328_14 VPWR VGND sg13cmos5l_fill_2
XFILLER_127_0 VPWR VGND sg13cmos5l_fill_2
XANTENNA__2361__GATE Tile_X0Y5_FrameStrobe[3] VPWR VGND sg13cmos5l_antennanp
XANTENNA__1745__D Tile_X0Y0_FrameData[15] VPWR VGND sg13cmos5l_antennanp
XANTENNA__2991__GATE Tile_X0Y5_FrameStrobe[6] VPWR VGND sg13cmos5l_antennanp
XFILLER_325_183 VPWR VGND sg13cmos5l_fill_1
XANTENNA__2376__GATE Tile_X0Y5_FrameStrobe[4] VPWR VGND sg13cmos5l_antennanp
XFILLER_278_260 VPWR VGND sg13cmos5l_fill_2
XFILLER_87_63 VPWR VGND sg13cmos5l_decap_8
XANTENNA__2576__D Tile_X0Y3_FrameData[0] VPWR VGND sg13cmos5l_antennanp
XFILLER_278_293 VPWR VGND sg13cmos5l_fill_2
XANTENNA__3602__X Tile_X0Y0_EE4BEG[1] VPWR VGND sg13cmos5l_antennanp
XFILLER_293_274 VPWR VGND sg13cmos5l_fill_2
X_1030_ _1030_/X Tile_X0Y4_W1END[1] Tile_X0Y4_WW4END[1] Tile_X0Y4_W6END[9] _1029_/X
+ _3029_/Q _3028_/Q VPWR VGND sg13cmos5l_mux4_1
XANTENNA__0674__A Tile_X0Y2_W6END[2] VPWR VGND sg13cmos5l_antennanp
XFILLER_261_160 VPWR VGND sg13cmos5l_fill_2
XANTENNA__1056__A0 Tile_X0Y5_W1END[0] VPWR VGND sg13cmos5l_antennanp
XANTENNA__2314__GATE Tile_X0Y5_FrameStrobe[2] VPWR VGND sg13cmos5l_antennanp
X_2981_ _2981_/Q Tile_X0Y4_FrameData[27] Tile_X0Y5_FrameStrobe[6] VPWR VGND sg13cmos5l_dlhq_1
XANTENNA__2944__GATE Tile_X0Y5_FrameStrobe[4] VPWR VGND sg13cmos5l_antennanp
XANTENNA__3200__D Tile_X0Y5_FrameData[16] VPWR VGND sg13cmos5l_antennanp
X_1932_ _1932_/Q Tile_X0Y0_FrameData[20] Tile_X0Y5_FrameStrobe[7] VPWR VGND sg13cmos5l_dlhq_1
XANTENNA__0803__A0 Tile_X0Y5_W2END[4] VPWR VGND sg13cmos5l_antennanp
XFILLER_159_186 VPWR VGND sg13cmos5l_decap_8
XFILLER_202_293 VPWR VGND sg13cmos5l_fill_2
X_1863_ _1863_/Q Tile_X0Y0_FrameData[25] Tile_X0Y5_FrameStrobe[5] VPWR VGND sg13cmos5l_dlhq_1
X_3602_ Tile_X0Y0_EE4BEG[1] _3602_/A VPWR VGND sg13cmos5l_buf_1
X_0814_ _3849_/A Tile_X0Y5_WW4END[9] _0647_/X AXI_M_SOC_RVALID _0786_/X _3203_/Q _3204_/Q
+ VPWR VGND sg13cmos5l_mux4_1
XANTENNA__2329__GATE Tile_X0Y5_FrameStrobe[2] VPWR VGND sg13cmos5l_antennanp
X_1794_ _1794_/Q Tile_X0Y0_FrameData[30] Tile_X0Y5_FrameStrobe[3] VPWR VGND sg13cmos5l_dlhq_1
XANTENNA__2959__GATE Tile_X0Y5_FrameStrobe[5] VPWR VGND sg13cmos5l_antennanp
X_3533_ Tile_X0Y0_N2BEGb[4] _3533_/A VPWR VGND sg13cmos5l_buf_1
X_0745_ _0745_/Y _0745_/A VPWR VGND sg13cmos5l_inv_1
XFILLER_107_18 VPWR VGND sg13cmos5l_decap_8
X_3464_ Tile_X0Y1_EE4BEG[0] _3464_/A VPWR VGND sg13cmos5l_buf_1
X_0676_ _0676_/Y _2243_/Q _0676_/B _0676_/C VPWR VGND sg13cmos5l_nor3_1
XFILLER_42_0 VPWR VGND sg13cmos5l_decap_4
X_2415_ _2415_/Q Tile_X0Y2_FrameData[17] Tile_X0Y5_FrameStrobe[5] VPWR VGND sg13cmos5l_dlhq_1
X_3395_ Tile_X0Y2_EE4BEG[13] _3395_/A VPWR VGND sg13cmos5l_buf_1
XANTENNA__2486__D Tile_X0Y2_FrameData[10] VPWR VGND sg13cmos5l_antennanp
XFILLER_269_293 VPWR VGND sg13cmos5l_fill_2
X_2346_ _2346_/Q Tile_X0Y2_FrameData[22] Tile_X0Y5_FrameStrobe[3] VPWR VGND sg13cmos5l_dlhq_1
XFILLER_96_151 VPWR VGND sg13cmos5l_decap_8
XANTENNA__0885__A3 Tile_X0Y0_S4END[13] VPWR VGND sg13cmos5l_antennanp
XANTENNA__3512__X Tile_X0Y0_UserCLKo VPWR VGND sg13cmos5l_antennanp
XFILLER_284_263 VPWR VGND sg13cmos5l_decap_4
X_2277_ _2277_/Q Tile_X0Y2_FrameData[27] Tile_X0Y5_FrameStrobe[1] VPWR VGND sg13cmos5l_dlhq_1
X_1228_ _3607_/A Tile_X0Y0_WW4END[9] _1038_/X AXI_M_SOC_WREADY _1140_/X _1843_/Q _1844_/Q
+ VPWR VGND sg13cmos5l_mux4_1
XANTENNA__1295__A0 AXI_M_SOC_RDATA24 VPWR VGND sg13cmos5l_antennanp
XFILLER_37_284 VPWR VGND sg13cmos5l_fill_2
XFILLER_279_21 VPWR VGND sg13cmos5l_fill_1
X_1159_ _3646_/A _1057_/X AXI_M_SOC_ARREADY Tile_X0Y0_S1END[1] AXI_M_SOC_WREADY _1893_/Q
+ _1894_/Q VPWR VGND sg13cmos5l_mux4_1
XANTENNA__1047__A0 Tile_X0Y2_W2MID[6] VPWR VGND sg13cmos5l_antennanp
XANTENNA__3110__D Tile_X0Y5_FrameData[10] VPWR VGND sg13cmos5l_antennanp
XFILLER_148_47 VPWR VGND sg13cmos5l_decap_8
XANTENNA__3091__GATE Tile_X0Y5_FrameStrobe[1] VPWR VGND sg13cmos5l_antennanp
XFILLER_164_68 VPWR VGND sg13cmos5l_decap_8
XANTENNA__1207__X AXI_M_SOC_AWADDR23 VPWR VGND sg13cmos5l_antennanp
XFILLER_164_79 VPWR VGND sg13cmos5l_fill_1
XANTENNA__2396__D Tile_X0Y2_FrameData[4] VPWR VGND sg13cmos5l_antennanp
XANTENNA__3422__X Tile_X0Y2_FrameData_O[24] VPWR VGND sg13cmos5l_antennanp
XFILLER_180_23 VPWR VGND sg13cmos5l_decap_8
XFILLER_57_77 VPWR VGND sg13cmos5l_decap_4
XANTENNA__1286__A0 Tile_X0Y1_WW4END[3] VPWR VGND sg13cmos5l_antennanp
XFILLER_188_237 VPWR VGND sg13cmos5l_fill_2
XFILLER_189_54 VPWR VGND sg13cmos5l_fill_2
XANTENNA__3020__D Tile_X0Y4_FrameData[20] VPWR VGND sg13cmos5l_antennanp
XANTENNA__3044__GATE Tile_X0Y5_FrameStrobe[8] VPWR VGND sg13cmos5l_antennanp
XFILLER_244_0 VPWR VGND sg13cmos5l_fill_2
XANTENNA__0857__B_N Tile_X0Y5_W6END[3] VPWR VGND sg13cmos5l_antennanp
XFILLER_11_151 VPWR VGND sg13cmos5l_decap_8
XFILLER_11_184 VPWR VGND sg13cmos5l_decap_8
XANTENNA__3059__GATE Tile_X0Y5_FrameStrobe[0] VPWR VGND sg13cmos5l_antennanp
XANTENNA__1210__A0 Tile_X0Y0_W1END[0] VPWR VGND sg13cmos5l_antennanp
X_0530_ _0530_/Y _3268_/Q VPWR VGND sg13cmos5l_inv_1
XANTENNA__0564__A2 Tile_X0Y5_W2END[0] VPWR VGND sg13cmos5l_antennanp
XFILLER_112_215 VPWR VGND sg13cmos5l_decap_8
XFILLER_313_164 VPWR VGND sg13cmos5l_fill_1
XFILLER_313_186 VPWR VGND sg13cmos5l_decap_8
XFILLER_313_197 VPWR VGND sg13cmos5l_fill_1
X_2200_ _2200_/Q Tile_X0Y1_FrameData[24] Tile_X0Y5_FrameStrobe[7] VPWR VGND sg13cmos5l_dlhq_1
XANTENNA__1513__A1 AXI_M_SOC_RDATA10 VPWR VGND sg13cmos5l_antennanp
X_3180_ _3180_/Q Tile_X0Y5_FrameData[4] Tile_X0Y5_FrameStrobe[3] VPWR VGND sg13cmos5l_dlhq_1
X_2131_ _2131_/Q Tile_X0Y1_FrameData[29] Tile_X0Y5_FrameStrobe[5] VPWR VGND sg13cmos5l_dlhq_1
XFILLER_19_240 VPWR VGND sg13cmos5l_decap_8
XFILLER_226_127 VPWR VGND sg13cmos5l_decap_8
X_2062_ _2062_/Q Tile_X0Y1_FrameData[2] Tile_X0Y5_FrameStrobe[2] VPWR VGND sg13cmos5l_dlhq_1
XANTENNA__1277__A0 Tile_X0Y1_WW4END[15] VPWR VGND sg13cmos5l_antennanp
X_1013_ _1013_/X _0992_/X _0684_/X Tile_X0Y5_N4END[6] _0995_/X _2811_/Q _2812_/Q VPWR
+ VGND sg13cmos5l_mux4_1
XFILLER_93_165 VPWR VGND sg13cmos5l_fill_2
XANTENNA__2253__GATE Tile_X0Y5_FrameStrobe[0] VPWR VGND sg13cmos5l_antennanp
XFILLER_320_70 VPWR VGND sg13cmos5l_decap_8
XANTENNA__2883__GATE Tile_X0Y5_FrameStrobe[3] VPWR VGND sg13cmos5l_antennanp
X_2964_ _2964_/Q Tile_X0Y4_FrameData[12] Tile_X0Y5_FrameStrobe[5] VPWR VGND sg13cmos5l_dlhq_1
XFILLER_320_81 VPWR VGND sg13cmos5l_fill_1
XFILLER_249_35 VPWR VGND sg13cmos5l_fill_2
X_1915_ _1915_/Q Tile_X0Y0_FrameData[5] Tile_X0Y5_FrameStrobe[6] VPWR VGND sg13cmos5l_dlhq_1
XANTENNA__2268__GATE Tile_X0Y5_FrameStrobe[0] VPWR VGND sg13cmos5l_antennanp
X_2895_ _2895_/Q Tile_X0Y4_FrameData[17] Tile_X0Y5_FrameStrobe[3] VPWR VGND sg13cmos5l_dlhq_1
XANTENNA__2898__GATE Tile_X0Y5_FrameStrobe[3] VPWR VGND sg13cmos5l_antennanp
XFILLER_147_178 VPWR VGND sg13cmos5l_decap_4
X_1846_ _1846_/Q Tile_X0Y0_FrameData[10] Tile_X0Y5_FrameStrobe[4] VPWR VGND sg13cmos5l_dlhq_1
XFILLER_8_71 VPWR VGND sg13cmos5l_fill_2
XFILLER_336_245 VPWR VGND sg13cmos5l_fill_1
X_1777_ _1777_/Q Tile_X0Y0_FrameData[15] Tile_X0Y5_FrameStrobe[2] VPWR VGND sg13cmos5l_dlhq_1
XANTENNA__1201__A0 Tile_X0Y0_WW4END[1] VPWR VGND sg13cmos5l_antennanp
XANTENNA__3507__X Tile_X0Y1_E2BEG[7] VPWR VGND sg13cmos5l_antennanp
XFILLER_265_78 VPWR VGND sg13cmos5l_fill_2
X_3516_ Tile_X0Y0_N4BEG[3] _3516_/A VPWR VGND sg13cmos5l_buf_1
X_0728_ _0728_/Y _2785_/Q _0728_/B _0728_/C VPWR VGND sg13cmos5l_nor3_1
XANTENNA__2821__GATE Tile_X0Y5_FrameStrobe[1] VPWR VGND sg13cmos5l_antennanp
XFILLER_103_204 VPWR VGND sg13cmos5l_decap_8
XFILLER_170_170 VPWR VGND sg13cmos5l_decap_4
X_3447_ Tile_X0Y1_FrameData_O[15] Tile_X0Y1_FrameData[15] VPWR VGND sg13cmos5l_buf_1
X_0659_ _0659_/Y _3265_/Q _0646_/X _0658_/Y VPWR VGND sg13cmos5l_o21ai_1
XANTENNA__1504__A1 AXI_M_SOC_RDATA13 VPWR VGND sg13cmos5l_antennanp
X_3378_ Tile_X0Y2_E6BEG[8] _3378_/A VPWR VGND sg13cmos5l_buf_1
XANTENNA__2206__GATE Tile_X0Y5_FrameStrobe[7] VPWR VGND sg13cmos5l_antennanp
XANTENNA__3105__D Tile_X0Y5_FrameData[15] VPWR VGND sg13cmos5l_antennanp
XFILLER_257_263 VPWR VGND sg13cmos5l_decap_8
XFILLER_281_88 VPWR VGND sg13cmos5l_fill_2
X_2329_ _2329_/Q Tile_X0Y2_FrameData[7] Tile_X0Y5_FrameStrobe[2] VPWR VGND sg13cmos5l_dlhq_1
XFILLER_84_121 VPWR VGND sg13cmos5l_decap_8
XANTENNA__2836__GATE Tile_X0Y5_FrameStrobe[1] VPWR VGND sg13cmos5l_antennanp
XFILLER_217_127 VPWR VGND sg13cmos5l_fill_2
XANTENNA__2944__D Tile_X0Y4_FrameData[0] VPWR VGND sg13cmos5l_antennanp
XFILLER_27_47 VPWR VGND sg13cmos5l_decap_4
XFILLER_25_221 VPWR VGND sg13cmos5l_fill_1
XFILLER_272_277 VPWR VGND sg13cmos5l_fill_1
XFILLER_159_13 VPWR VGND sg13cmos5l_decap_8
XFILLER_230_92 VPWR VGND sg13cmos5l_fill_1
XFILLER_43_24 VPWR VGND sg13cmos5l_decap_8
XFILLER_193_262 VPWR VGND sg13cmos5l_decap_8
XANTENNA__3417__X Tile_X0Y2_FrameData_O[19] VPWR VGND sg13cmos5l_antennanp
XFILLER_175_67 VPWR VGND sg13cmos5l_decap_8
XFILLER_325_15 VPWR VGND sg13cmos5l_fill_1
XFILLER_161_170 VPWR VGND sg13cmos5l_decap_4
XFILLER_161_192 VPWR VGND sg13cmos5l_decap_8
XFILLER_68_54 VPWR VGND sg13cmos5l_decap_8
XFILLER_325_48 VPWR VGND sg13cmos5l_fill_2
XANTENNA__3015__D Tile_X0Y4_FrameData[25] VPWR VGND sg13cmos5l_antennanp
XFILLER_194_0 VPWR VGND sg13cmos5l_fill_2
XFILLER_124_60 VPWR VGND sg13cmos5l_decap_8
XANTENNA__1259__A0 Tile_X0Y0_W2MID[2] VPWR VGND sg13cmos5l_antennanp
XANTENNA__2854__D Tile_X0Y4_FrameData[26] VPWR VGND sg13cmos5l_antennanp
XFILLER_263_255 VPWR VGND sg13cmos5l_fill_1
XFILLER_90_146 VPWR VGND sg13cmos5l_fill_1
XFILLER_90_124 VPWR VGND sg13cmos5l_fill_2
XANTENNA__1431__A0 Tile_X0Y2_W2MID[3] VPWR VGND sg13cmos5l_antennanp
X_2680_ _2680_/Q Tile_X0Y3_FrameData[24] Tile_X0Y5_FrameStrobe[5] VPWR VGND sg13cmos5l_dlhq_1
X_1700_ _1700_/Q Tile_X0Y0_FrameData[28] Tile_X0Y5_FrameStrobe[0] VPWR VGND sg13cmos5l_dlhq_1
XFILLER_318_267 VPWR VGND sg13cmos5l_fill_1
XANTENNA__0785__A2 Tile_X0Y4_W6END[9] VPWR VGND sg13cmos5l_antennanp
XFILLER_129_189 VPWR VGND sg13cmos5l_decap_4
X_1631_ AXI_M_SOC_ARADDR1 Tile_X0Y4_WW4END[1] Tile_X0Y4_W6END[1] Tile_X0Y4_WW4END[9]
+ _1029_/X _2885_/Q _2886_/Q VPWR VGND sg13cmos5l_mux4_1
X_3301_ _3301_/Q Tile_X0Y5_FrameData[11] Tile_X0Y5_FrameStrobe[7] VPWR VGND sg13cmos5l_dlhq_1
X_1562_ AXI_M_SOC_BREADY Tile_X0Y3_WW4END[1] Tile_X0Y3_WW4END[9] Tile_X0Y3_W6END[9]
+ _1523_/X _2598_/Q _2597_/Q VPWR VGND sg13cmos5l_mux4_1
XANTENNA__1933__D Tile_X0Y0_FrameData[19] VPWR VGND sg13cmos5l_antennanp
X_1493_ _3656_/A Tile_X0Y3_W2MID[4] AXI_M_SOC_RDATA9 _1587_/B _1271_/X _2698_/Q _2697_/Q
+ VPWR VGND sg13cmos5l_mux4_1
X_3232_ _3232_/Q Tile_X0Y5_FrameData[16] Tile_X0Y5_FrameStrobe[5] VPWR VGND sg13cmos5l_dlhq_1
XFILLER_98_279 VPWR VGND sg13cmos5l_fill_2
XANTENNA__1498__A0 Tile_X0Y3_W2MID[6] VPWR VGND sg13cmos5l_antennanp
XFILLER_239_241 VPWR VGND sg13cmos5l_decap_4
XFILLER_239_263 VPWR VGND sg13cmos5l_decap_8
XFILLER_251_14 VPWR VGND sg13cmos5l_fill_1
X_3163_ _3163_/Q Tile_X0Y5_FrameData[21] Tile_X0Y5_FrameStrobe[3] VPWR VGND sg13cmos5l_dlhq_1
X_2114_ _2114_/Q Tile_X0Y1_FrameData[14] Tile_X0Y5_FrameStrobe[4] VPWR VGND sg13cmos5l_dlhq_1
XANTENNA__2764__D Tile_X0Y3_FrameData[4] VPWR VGND sg13cmos5l_antennanp
X_3094_ _3094_/Q Tile_X0Y5_FrameData[26] Tile_X0Y5_FrameStrobe[1] VPWR VGND sg13cmos5l_dlhq_1
XANTENNA__2192__GATE Tile_X0Y5_FrameStrobe[6] VPWR VGND sg13cmos5l_antennanp
X_2045_ _2045_/Q Tile_X0Y1_FrameData[19] Tile_X0Y5_FrameStrobe[2] VPWR VGND sg13cmos5l_dlhq_1
XFILLER_120_18 VPWR VGND sg13cmos5l_decap_4
XFILLER_120_29 VPWR VGND sg13cmos5l_decap_8
XFILLER_331_91 VPWR VGND sg13cmos5l_decap_4
XANTENNA__1670__A0 Tile_X0Y4_W2MID[6] VPWR VGND sg13cmos5l_antennanp
XFILLER_22_213 VPWR VGND sg13cmos5l_decap_4
XANTENNA__1310__X AXI_M_SOC_AWADDR6 VPWR VGND sg13cmos5l_antennanp
X_2947_ _2947_/Q Tile_X0Y4_FrameData[29] Tile_X0Y5_FrameStrobe[5] VPWR VGND sg13cmos5l_dlhq_1
XANTENNA__1422__A0 Tile_X0Y2_WW4END[7] VPWR VGND sg13cmos5l_antennanp
XFILLER_276_33 VPWR VGND sg13cmos5l_fill_2
XANTENNA__2130__GATE Tile_X0Y5_FrameStrobe[5] VPWR VGND sg13cmos5l_antennanp
XFILLER_175_273 VPWR VGND sg13cmos5l_decap_4
X_2878_ _2878_/Q Tile_X0Y4_FrameData[2] Tile_X0Y5_FrameStrobe[2] VPWR VGND sg13cmos5l_dlhq_1
XANTENNA__2004__D Tile_X0Y1_FrameData[28] VPWR VGND sg13cmos5l_antennanp
XANTENNA__2760__GATE Tile_X0Y5_FrameStrobe[7] VPWR VGND sg13cmos5l_antennanp
XFILLER_135_137 VPWR VGND sg13cmos5l_decap_8
X_1829_ _1829_/Q Tile_X0Y0_FrameData[27] Tile_X0Y5_FrameStrobe[4] VPWR VGND sg13cmos5l_dlhq_1
XFILLER_1_106 VPWR VGND sg13cmos5l_fill_2
XANTENNA__1843__D Tile_X0Y0_FrameData[13] VPWR VGND sg13cmos5l_antennanp
XANTENNA__2939__D Tile_X0Y4_FrameData[5] VPWR VGND sg13cmos5l_antennanp
XFILLER_143_170 VPWR VGND sg13cmos5l_decap_8
XFILLER_289_174 VPWR VGND sg13cmos5l_decap_8
XANTENNA__2145__GATE Tile_X0Y5_FrameStrobe[5] VPWR VGND sg13cmos5l_antennanp
XANTENNA__2775__GATE Tile_X0Y5_FrameStrobe[8] VPWR VGND sg13cmos5l_antennanp
XANTENNA__3413__A Tile_X0Y2_FrameData[15] VPWR VGND sg13cmos5l_antennanp
XFILLER_161_25 VPWR VGND sg13cmos5l_decap_8
XFILLER_245_222 VPWR VGND sg13cmos5l_fill_2
XFILLER_38_46 VPWR VGND sg13cmos5l_decap_8
XFILLER_161_58 VPWR VGND sg13cmos5l_decap_8
XANTENNA__2674__D Tile_X0Y3_FrameData[30] VPWR VGND sg13cmos5l_antennanp
XFILLER_311_28 VPWR VGND sg13cmos5l_fill_2
XANTENNA__3700__X Tile_X0Y3_FrameData_O[3] VPWR VGND sg13cmos5l_antennanp
XFILLER_241_91 VPWR VGND sg13cmos5l_decap_8
XANTENNA__1661__A0 Tile_X0Y4_W2MID[4] VPWR VGND sg13cmos5l_antennanp
XFILLER_13_213 VPWR VGND sg13cmos5l_decap_4
XFILLER_54_67 VPWR VGND sg13cmos5l_decap_8
XANTENNA__2713__GATE Tile_X0Y5_FrameStrobe[6] VPWR VGND sg13cmos5l_antennanp
XFILLER_110_62 VPWR VGND sg13cmos5l_decap_8
XFILLER_213_174 VPWR VGND sg13cmos5l_decap_8
XFILLER_70_33 VPWR VGND sg13cmos5l_fill_2
XFILLER_70_11 VPWR VGND sg13cmos5l_decap_4
XANTENNA__1413__A0 Tile_X0Y2_WW4END[0] VPWR VGND sg13cmos5l_antennanp
XANTENNA__0767__A2 Tile_X0Y5_WW4END[9] VPWR VGND sg13cmos5l_antennanp
XFILLER_126_104 VPWR VGND sg13cmos5l_decap_8
XFILLER_166_273 VPWR VGND sg13cmos5l_fill_1
XANTENNA__2728__GATE Tile_X0Y5_FrameStrobe[6] VPWR VGND sg13cmos5l_antennanp
XFILLER_126_159 VPWR VGND sg13cmos5l_decap_8
XFILLER_181_232 VPWR VGND sg13cmos5l_fill_2
XFILLER_207_0 VPWR VGND sg13cmos5l_fill_2
XFILLER_336_14 VPWR VGND sg13cmos5l_fill_2
XFILLER_79_42 VPWR VGND sg13cmos5l_decap_8
XANTENNA__1753__D Tile_X0Y0_FrameData[7] VPWR VGND sg13cmos5l_antennanp
XANTENNA__1984__GATE Tile_X0Y5_FrameStrobe[0] VPWR VGND sg13cmos5l_antennanp
XANTENNA__2849__D Tile_X0Y4_FrameData[31] VPWR VGND sg13cmos5l_antennanp
XANTENNA__1192__A2 Tile_X0Y0_W6END[11] VPWR VGND sg13cmos5l_antennanp
XFILLER_205_18 VPWR VGND sg13cmos5l_decap_8
XFILLER_0_150 VPWR VGND sg13cmos5l_decap_4
XFILLER_95_63 VPWR VGND sg13cmos5l_decap_8
XANTENNA__1495__A3 AXI_M_SOC_RDATA11 VPWR VGND sg13cmos5l_antennanp
XANTENNA__1999__GATE Tile_X0Y5_FrameStrobe[0] VPWR VGND sg13cmos5l_antennanp
XFILLER_63_102 VPWR VGND sg13cmos5l_decap_8
XFILLER_48_154 VPWR VGND sg13cmos5l_decap_8
XANTENNA__2584__D Tile_X0Y3_FrameData[24] VPWR VGND sg13cmos5l_antennanp
XANTENNA__3610__X Tile_X0Y0_EE4BEG[9] VPWR VGND sg13cmos5l_antennanp
XANTENNA__1652__A0 Tile_X0Y4_W1END[2] VPWR VGND sg13cmos5l_antennanp
XANTENNA__1922__GATE Tile_X0Y5_FrameStrobe[7] VPWR VGND sg13cmos5l_antennanp
X_3850_ Tile_X0Y5_EE4BEG[7] _3850_/A VPWR VGND sg13cmos5l_buf_1
XANTENNA__1928__D Tile_X0Y0_FrameData[24] VPWR VGND sg13cmos5l_antennanp
X_2801_ _2801_/Q Tile_X0Y4_FrameData[15] Tile_X0Y5_FrameStrobe[0] VPWR VGND sg13cmos5l_dlhq_1
X_3781_ Tile_X0Y4_FrameData_O[3] Tile_X0Y4_FrameData[3] VPWR VGND sg13cmos5l_buf_1
X_0993_ _0993_/X Tile_X0Y0_W6END[6] _1006_/X _1007_/X _1010_/X _1900_/Q _1902_/Q VPWR
+ VGND sg13cmos5l_mux4_1
XANTENNA__1404__A0 AXI_M_SOC_RDATA14 VPWR VGND sg13cmos5l_antennanp
XANTENNA__1937__GATE Tile_X0Y5_FrameStrobe[7] VPWR VGND sg13cmos5l_antennanp
XFILLER_157_251 VPWR VGND sg13cmos5l_decap_8
X_2732_ _2732_/Q Tile_X0Y3_FrameData[4] Tile_X0Y5_FrameStrobe[6] VPWR VGND sg13cmos5l_dlhq_1
XANTENNA__0758__A2 Tile_X0Y5_W6END[6] VPWR VGND sg13cmos5l_antennanp
XFILLER_157_262 VPWR VGND sg13cmos5l_decap_4
X_2663_ _2663_/Q Tile_X0Y3_FrameData[9] Tile_X0Y5_FrameStrobe[4] VPWR VGND sg13cmos5l_dlhq_1
XFILLER_8_294 VPWR VGND sg13cmos5l_fill_1
X_2594_ _2594_/Q Tile_X0Y3_FrameData[14] Tile_X0Y5_FrameStrobe[2] VPWR VGND sg13cmos5l_dlhq_1
X_1614_ _3767_/A Tile_X0Y4_WW4END[10] _1012_/X AXI_M_SOC_RDATA3 _1016_/X _2933_/Q
+ _2934_/Q VPWR VGND sg13cmos5l_mux4_1
XANTENNA__2759__D Tile_X0Y3_FrameData[9] VPWR VGND sg13cmos5l_antennanp
X_1545_ _3678_/A AXI_M_SOC_RDATA11 _1434_/X _1524_/X _1342_/X _2621_/Q _2622_/Q VPWR
+ VGND sg13cmos5l_mux4_1
XFILLER_5_61 VPWR VGND sg13cmos5l_fill_1
XFILLER_321_229 VPWR VGND sg13cmos5l_fill_1
XFILLER_115_29 VPWR VGND sg13cmos5l_decap_8
XFILLER_140_173 VPWR VGND sg13cmos5l_decap_8
X_3215_ _3215_/Q Tile_X0Y5_FrameData[1] Tile_X0Y5_FrameStrobe[4] VPWR VGND sg13cmos5l_dlhq_1
X_1476_ _3351_/A _1018_/X _0623_/X AXI_M_SOC_RDATA16 AXI_M_SOC_RDATA20 _2438_/Q _2437_/Q
+ VPWR VGND sg13cmos5l_mux4_1
XFILLER_86_216 VPWR VGND sg13cmos5l_decap_8
XFILLER_227_255 VPWR VGND sg13cmos5l_fill_2
X_3146_ _3146_/Q Tile_X0Y5_FrameData[6] Tile_X0Y5_FrameStrobe[2] VPWR VGND sg13cmos5l_dlhq_1
XFILLER_39_154 VPWR VGND sg13cmos5l_fill_1
XANTENNA__0694__A1 Tile_X0Y5_N4END[2] VPWR VGND sg13cmos5l_antennanp
XANTENNA__2494__D Tile_X0Y2_FrameData[2] VPWR VGND sg13cmos5l_antennanp
XFILLER_131_28 VPWR VGND sg13cmos5l_fill_2
X_3077_ _3077_/Q Tile_X0Y5_FrameData[11] Tile_X0Y5_FrameStrobe[0] VPWR VGND sg13cmos5l_dlhq_1
XANTENNA__3520__X Tile_X0Y0_N4BEG[7] VPWR VGND sg13cmos5l_antennanp
XFILLER_242_225 VPWR VGND sg13cmos5l_fill_2
X_2028_ _2028_/Q Tile_X0Y1_FrameData[4] Tile_X0Y5_FrameStrobe[1] VPWR VGND sg13cmos5l_dlhq_1
XANTENNA__1643__A0 Tile_X0Y4_WW4END[3] VPWR VGND sg13cmos5l_antennanp
XFILLER_250_280 VPWR VGND sg13cmos5l_fill_1
XFILLER_287_21 VPWR VGND sg13cmos5l_decap_8
XANTENNA__0997__A2 Tile_X0Y4_W6END[10] VPWR VGND sg13cmos5l_antennanp
XANTENNA__1838__D Tile_X0Y0_FrameData[18] VPWR VGND sg13cmos5l_antennanp
XFILLER_287_32 VPWR VGND sg13cmos5l_fill_1
XFILLER_287_54 VPWR VGND sg13cmos5l_fill_1
XFILLER_148_240 VPWR VGND sg13cmos5l_fill_1
XFILLER_210_188 VPWR VGND sg13cmos5l_fill_1
XFILLER_40_25 VPWR VGND sg13cmos5l_decap_8
XANTENNA__3408__A Tile_X0Y2_FrameData[10] VPWR VGND sg13cmos5l_antennanp
XFILLER_108_126 VPWR VGND sg13cmos5l_fill_2
XFILLER_156_14 VPWR VGND sg13cmos5l_decap_8
XFILLER_40_47 VPWR VGND sg13cmos5l_decap_8
XANTENNA__2084__GATE Tile_X0Y5_FrameStrobe[3] VPWR VGND sg13cmos5l_antennanp
XANTENNA__2669__D Tile_X0Y3_FrameData[3] VPWR VGND sg13cmos5l_antennanp
XFILLER_49_12 VPWR VGND sg13cmos5l_decap_8
XANTENNA__1174__A2 Tile_X0Y4_W6END[1] VPWR VGND sg13cmos5l_antennanp
XFILLER_172_57 VPWR VGND sg13cmos5l_decap_8
XFILLER_320_273 VPWR VGND sg13cmos5l_fill_1
XFILLER_172_68 VPWR VGND sg13cmos5l_fill_2
XFILLER_277_177 VPWR VGND sg13cmos5l_fill_2
XANTENNA__2099__GATE Tile_X0Y5_FrameStrobe[4] VPWR VGND sg13cmos5l_antennanp
XFILLER_218_255 VPWR VGND sg13cmos5l_decap_8
XFILLER_85_293 VPWR VGND sg13cmos5l_fill_2
XFILLER_65_44 VPWR VGND sg13cmos5l_fill_2
XANTENNA__3430__X Tile_X0Y2_UserCLKo VPWR VGND sg13cmos5l_antennanp
XFILLER_233_225 VPWR VGND sg13cmos5l_decap_8
XFILLER_45_146 VPWR VGND sg13cmos5l_fill_2
XANTENNA__2022__GATE Tile_X0Y5_FrameStrobe[1] VPWR VGND sg13cmos5l_antennanp
XANTENNA__1634__A0 Tile_X0Y4_WW4END[2] VPWR VGND sg13cmos5l_antennanp
XANTENNA__2652__GATE Tile_X0Y5_FrameStrobe[4] VPWR VGND sg13cmos5l_antennanp
XFILLER_157_0 VPWR VGND sg13cmos5l_fill_2
XFILLER_197_10 VPWR VGND sg13cmos5l_fill_1
XFILLER_81_54 VPWR VGND sg13cmos5l_decap_8
XFILLER_60_138 VPWR VGND sg13cmos5l_fill_1
XANTENNA__1748__D Tile_X0Y0_FrameData[12] VPWR VGND sg13cmos5l_antennanp
XANTENNA__2037__GATE Tile_X0Y5_FrameStrobe[2] VPWR VGND sg13cmos5l_antennanp
XANTENNA__2667__GATE Tile_X0Y5_FrameStrobe[4] VPWR VGND sg13cmos5l_antennanp
XANTENNA__2579__D Tile_X0Y3_FrameData[29] VPWR VGND sg13cmos5l_antennanp
XFILLER_303_229 VPWR VGND sg13cmos5l_fill_2
XANTENNA__3605__X Tile_X0Y0_EE4BEG[4] VPWR VGND sg13cmos5l_antennanp
XFILLER_268_133 VPWR VGND sg13cmos5l_decap_8
X_1330_ _3524_/A _1329_/X _1328_/X _2206_/Q VPWR VGND sg13cmos5l_mux2_1
X_1261_ _3633_/A Tile_X0Y0_W2END[3] _1148_/X AXI_M_SOC_BVALID _1078_/X _1863_/Q _1864_/Q
+ VPWR VGND sg13cmos5l_mux4_1
XANTENNA__2605__GATE Tile_X0Y5_FrameStrobe[2] VPWR VGND sg13cmos5l_antennanp
XFILLER_209_244 VPWR VGND sg13cmos5l_fill_1
X_3000_ _3000_/Q Tile_X0Y4_FrameData[8] Tile_X0Y5_FrameStrobe[6] VPWR VGND sg13cmos5l_dlhq_1
X_1192_ AXI_M_SOC_AWADDR19 Tile_X0Y0_WW4END[3] Tile_X0Y0_WW4END[11] Tile_X0Y0_W6END[11]
+ _1137_/X _1778_/Q _1777_/Q VPWR VGND sg13cmos5l_mux4_1
XANTENNA__1861__GATE Tile_X0Y5_FrameStrobe[5] VPWR VGND sg13cmos5l_antennanp
XANTENNA__3203__D Tile_X0Y5_FrameData[13] VPWR VGND sg13cmos5l_antennanp
XFILLER_291_180 VPWR VGND sg13cmos5l_decap_4
XFILLER_224_258 VPWR VGND sg13cmos5l_decap_4
XANTENNA__1625__A0 AXI_M_SOC_RDATA2 VPWR VGND sg13cmos5l_antennanp
X_3902_ Tile_X0Y5_S2BEG[7] _3902_/A VPWR VGND sg13cmos5l_buf_1
X_3833_ Tile_X0Y5_E6BEG[2] _3833_/A VPWR VGND sg13cmos5l_buf_1
XANTENNA__1876__GATE Tile_X0Y5_FrameStrobe[5] VPWR VGND sg13cmos5l_antennanp
XFILLER_338_137 VPWR VGND sg13cmos5l_decap_4
X_3764_ Tile_X0Y4_EE4BEG[2] _3764_/A VPWR VGND sg13cmos5l_buf_1
X_0976_ _0976_/X _0977_/X _0672_/X Tile_X0Y5_N4END[14] Tile_X0Y0_S4END[10] _2267_/Q
+ _2268_/Q VPWR VGND sg13cmos5l_mux4_1
XFILLER_72_0 VPWR VGND sg13cmos5l_fill_2
XFILLER_257_79 VPWR VGND sg13cmos5l_decap_8
X_2715_ _2715_/Q Tile_X0Y3_FrameData[21] Tile_X0Y5_FrameStrobe[6] VPWR VGND sg13cmos5l_dlhq_1
X_3695_ Tile_X0Y3_EE4BEG[14] _3695_/A VPWR VGND sg13cmos5l_buf_1
XFILLER_10_17 VPWR VGND sg13cmos5l_decap_4
XFILLER_10_28 VPWR VGND sg13cmos5l_fill_1
X_2646_ _2646_/Q Tile_X0Y3_FrameData[26] Tile_X0Y5_FrameStrobe[4] VPWR VGND sg13cmos5l_dlhq_1
XANTENNA__2489__D Tile_X0Y2_FrameData[7] VPWR VGND sg13cmos5l_antennanp
XANTENNA__1156__A2 Tile_X0Y4_W6END[7] VPWR VGND sg13cmos5l_antennanp
XANTENNA__3515__X Tile_X0Y0_N4BEG[2] VPWR VGND sg13cmos5l_antennanp
X_2577_ _2577_/Q Tile_X0Y3_FrameData[31] Tile_X0Y5_FrameStrobe[2] VPWR VGND sg13cmos5l_dlhq_1
XANTENNA__1814__GATE Tile_X0Y5_FrameStrobe[3] VPWR VGND sg13cmos5l_antennanp
X_1528_ _3692_/A Tile_X0Y3_WW4END[4] AXI_M_SOC_RDATA10 _1436_/X _1271_/X _2650_/Q
+ _2649_/Q VPWR VGND sg13cmos5l_mux4_1
XFILLER_59_205 VPWR VGND sg13cmos5l_decap_4
X_1459_ _3360_/A Tile_X0Y2_W2MID[1] AXI_M_SOC_RDATA20 _1143_/X _1175_/X _2420_/Q _2419_/Q
+ VPWR VGND sg13cmos5l_mux4_1
XFILLER_74_208 VPWR VGND sg13cmos5l_fill_1
XFILLER_274_169 VPWR VGND sg13cmos5l_fill_1
XFILLER_67_293 VPWR VGND sg13cmos5l_fill_2
XANTENNA__1829__GATE Tile_X0Y5_FrameStrobe[4] VPWR VGND sg13cmos5l_antennanp
XANTENNA__3113__D Tile_X0Y5_FrameData[7] VPWR VGND sg13cmos5l_antennanp
XFILLER_282_180 VPWR VGND sg13cmos5l_fill_1
X_3129_ _3129_/Q Tile_X0Y5_FrameData[23] Tile_X0Y5_FrameStrobe[2] VPWR VGND sg13cmos5l_dlhq_1
XFILLER_35_14 VPWR VGND sg13cmos5l_fill_2
XANTENNA__1616__A0 Tile_X0Y4_WW4END[4] VPWR VGND sg13cmos5l_antennanp
XANTENNA__2952__D Tile_X0Y4_FrameData[24] VPWR VGND sg13cmos5l_antennanp
XFILLER_298_31 VPWR VGND sg13cmos5l_decap_8
XFILLER_35_190 VPWR VGND sg13cmos5l_decap_8
XANTENNA__1092__A1 Tile_X0Y2_W2END[4] VPWR VGND sg13cmos5l_antennanp
XFILLER_298_97 VPWR VGND sg13cmos5l_decap_4
XFILLER_51_35 VPWR VGND sg13cmos5l_decap_8
XANTENNA__2399__D Tile_X0Y2_FrameData[1] VPWR VGND sg13cmos5l_antennanp
XANTENNA__1147__A2 Tile_X0Y0_S2MID[2] VPWR VGND sg13cmos5l_antennanp
XANTENNA__3320__GATE Tile_X0Y5_FrameStrobe[8] VPWR VGND sg13cmos5l_antennanp
XANTENNA__3425__X Tile_X0Y2_FrameData_O[27] VPWR VGND sg13cmos5l_antennanp
XFILLER_104_140 VPWR VGND sg13cmos5l_decap_8
XFILLER_183_89 VPWR VGND sg13cmos5l_decap_4
XFILLER_104_184 VPWR VGND sg13cmos5l_decap_8
XFILLER_76_32 VPWR VGND sg13cmos5l_decap_8
XFILLER_65_208 VPWR VGND sg13cmos5l_decap_8
XANTENNA__3335__GATE Tile_X0Y5_FrameStrobe[8] VPWR VGND sg13cmos5l_antennanp
XFILLER_274_0 VPWR VGND sg13cmos5l_fill_2
XFILLER_280_106 VPWR VGND sg13cmos5l_fill_1
XFILLER_58_293 VPWR VGND sg13cmos5l_fill_2
XANTENNA__3023__D Tile_X0Y4_FrameData[17] VPWR VGND sg13cmos5l_antennanp
XFILLER_132_71 VPWR VGND sg13cmos5l_fill_1
XFILLER_273_191 VPWR VGND sg13cmos5l_fill_1
XANTENNA__2591__GATE Tile_X0Y5_FrameStrobe[2] VPWR VGND sg13cmos5l_antennanp
XFILLER_92_42 VPWR VGND sg13cmos5l_decap_8
XFILLER_73_274 VPWR VGND sg13cmos5l_decap_8
XANTENNA__2862__D Tile_X0Y4_FrameData[18] VPWR VGND sg13cmos5l_antennanp
XFILLER_41_193 VPWR VGND sg13cmos5l_fill_2
X_0830_ _3837_/A _0765_/X _0646_/X _0647_/X _0790_/X _3172_/Q _3171_/Q VPWR VGND sg13cmos5l_mux4_1
XFILLER_335_118 VPWR VGND sg13cmos5l_fill_2
X_0761_ _0761_/X Tile_X0Y5_WW4END[2] Tile_X0Y5_W6END[2] Tile_X0Y5_WW4END[10] _0698_/A
+ _3155_/Q _3156_/Q VPWR VGND sg13cmos5l_mux4_1
X_2500_ _2500_/Q Tile_X0Y2_FrameData[28] Tile_X0Y5_FrameStrobe[8] VPWR VGND sg13cmos5l_dlhq_1
X_3480_ Tile_X0Y1_E6BEG[0] _3480_/A VPWR VGND sg13cmos5l_buf_1
XANTENNA__0594__A0 Tile_X0Y1_W1END[0] VPWR VGND sg13cmos5l_antennanp
XFILLER_157_90 VPWR VGND sg13cmos5l_decap_8
X_2431_ _2431_/Q Tile_X0Y2_FrameData[1] Tile_X0Y5_FrameStrobe[5] VPWR VGND sg13cmos5l_dlhq_1
X_0692_ _0692_/X Tile_X0Y1_W1END[2] _0941_/X Tile_X0Y1_WW4END[14] _0953_/X _2172_/Q
+ _2174_/Q VPWR VGND sg13cmos5l_mux4_1
XANTENNA__2102__D Tile_X0Y1_FrameData[26] VPWR VGND sg13cmos5l_antennanp
X_2362_ _2362_/Q Tile_X0Y2_FrameData[6] Tile_X0Y5_FrameStrobe[3] VPWR VGND sg13cmos5l_dlhq_1
XANTENNA__0897__A1 Tile_X0Y5_WW4END[3] VPWR VGND sg13cmos5l_antennanp
XANTENNA__1941__D Tile_X0Y0_FrameData[11] VPWR VGND sg13cmos5l_antennanp
XANTENNA__2544__GATE Tile_X0Y5_FrameStrobe[0] VPWR VGND sg13cmos5l_antennanp
XFILLER_110_110 VPWR VGND sg13cmos5l_decap_8
X_2293_ _2293_/Q Tile_X0Y2_FrameData[11] Tile_X0Y5_FrameStrobe[1] VPWR VGND sg13cmos5l_dlhq_1
X_1313_ _1313_/X _0977_/X _0672_/X Tile_X0Y5_N4END[14] Tile_X0Y0_S4END[10] _2283_/Q
+ _2284_/Q VPWR VGND sg13cmos5l_mux4_1
X_1244_ _3625_/A AXI_M_SOC_BRESP0 _0985_/X _1080_/X _1078_/X _1807_/Q _1808_/Q VPWR
+ VGND sg13cmos5l_mux4_1
XFILLER_49_293 VPWR VGND sg13cmos5l_fill_2
XFILLER_49_282 VPWR VGND sg13cmos5l_fill_2
XFILLER_323_70 VPWR VGND sg13cmos5l_decap_8
XANTENNA__1310__A2 Tile_X0Y1_W6END[6] VPWR VGND sg13cmos5l_antennanp
X_1175_ _1175_/X _1082_/X _1173_/X _1174_/X _1081_/X _2251_/Q _2252_/Q VPWR VGND sg13cmos5l_mux4_1
XFILLER_323_92 VPWR VGND sg13cmos5l_decap_8
XANTENNA__2559__GATE Tile_X0Y5_FrameStrobe[1] VPWR VGND sg13cmos5l_antennanp
XANTENNA__2772__D Tile_X0Y3_FrameData[28] VPWR VGND sg13cmos5l_antennanp
XFILLER_32_171 VPWR VGND sg13cmos5l_fill_2
XFILLER_32_160 VPWR VGND sg13cmos5l_decap_8
X_3816_ Tile_X0Y5_E2BEG[1] _3816_/A VPWR VGND sg13cmos5l_buf_1
XFILLER_21_16 VPWR VGND sg13cmos5l_fill_1
XFILLER_21_27 VPWR VGND sg13cmos5l_fill_2
X_3747_ Tile_X0Y4_E2BEGb[5] _3747_/A VPWR VGND sg13cmos5l_buf_1
X_0959_ _0959_/X _1138_/X _0568_/X _0918_/Y Tile_X0Y0_S4END[4] _1999_/Q _2000_/Q VPWR
+ VGND sg13cmos5l_mux4_1
XFILLER_284_55 VPWR VGND sg13cmos5l_fill_1
X_3678_ Tile_X0Y3_E6BEG[9] _3678_/A VPWR VGND sg13cmos5l_buf_1
XANTENNA__1129__A2 Tile_X0Y5_W6END[4] VPWR VGND sg13cmos5l_antennanp
XANTENNA__1753__GATE Tile_X0Y5_FrameStrobe[1] VPWR VGND sg13cmos5l_antennanp
XANTENNA__2012__D Tile_X0Y1_FrameData[20] VPWR VGND sg13cmos5l_antennanp
XANTENNA__3108__D Tile_X0Y5_FrameData[12] VPWR VGND sg13cmos5l_antennanp
X_2629_ _2629_/Q Tile_X0Y3_FrameData[11] Tile_X0Y5_FrameStrobe[3] VPWR VGND sg13cmos5l_dlhq_1
XANTENNA__1851__D Tile_X0Y0_FrameData[5] VPWR VGND sg13cmos5l_antennanp
XANTENNA__2947__D Tile_X0Y4_FrameData[29] VPWR VGND sg13cmos5l_antennanp
XFILLER_101_132 VPWR VGND sg13cmos5l_decap_8
XFILLER_153_48 VPWR VGND sg13cmos5l_decap_8
XFILLER_247_114 VPWR VGND sg13cmos5l_decap_8
XANTENNA__1768__GATE Tile_X0Y5_FrameStrobe[2] VPWR VGND sg13cmos5l_antennanp
XANTENNA__3421__A Tile_X0Y2_FrameData[23] VPWR VGND sg13cmos5l_antennanp
XFILLER_262_139 VPWR VGND sg13cmos5l_decap_8
XFILLER_55_252 VPWR VGND sg13cmos5l_fill_2
XFILLER_55_241 VPWR VGND sg13cmos5l_fill_2
XFILLER_46_46 VPWR VGND sg13cmos5l_decap_8
XANTENNA__1301__A2 Tile_X0Y1_W6END[0] VPWR VGND sg13cmos5l_antennanp
XANTENNA__2682__D Tile_X0Y3_FrameData[22] VPWR VGND sg13cmos5l_antennanp
XFILLER_15_138 VPWR VGND sg13cmos5l_decap_8
XFILLER_70_266 VPWR VGND sg13cmos5l_decap_8
XFILLER_211_250 VPWR VGND sg13cmos5l_fill_1
XFILLER_211_261 VPWR VGND sg13cmos5l_decap_4
XFILLER_62_56 VPWR VGND sg13cmos5l_decap_8
XANTENNA__1706__GATE Tile_X0Y5_FrameStrobe[0] VPWR VGND sg13cmos5l_antennanp
XFILLER_178_67 VPWR VGND sg13cmos5l_decap_8
XFILLER_317_118 VPWR VGND sg13cmos5l_decap_8
XFILLER_109_221 VPWR VGND sg13cmos5l_decap_8
XFILLER_194_11 VPWR VGND sg13cmos5l_decap_4
XFILLER_124_224 VPWR VGND sg13cmos5l_fill_1
XANTENNA__3018__D Tile_X0Y4_FrameData[22] VPWR VGND sg13cmos5l_antennanp
XFILLER_191_190 VPWR VGND sg13cmos5l_decap_8
XFILLER_2_0 VPWR VGND sg13cmos5l_fill_1
XFILLER_97_119 VPWR VGND sg13cmos5l_fill_1
XFILLER_87_42 VPWR VGND sg13cmos5l_decap_8
XANTENNA__1761__D Tile_X0Y0_FrameData[31] VPWR VGND sg13cmos5l_antennanp
XANTENNA__2857__D Tile_X0Y4_FrameData[23] VPWR VGND sg13cmos5l_antennanp
XANTENNA__1540__A2 AXI_M_SOC_RDATA6 VPWR VGND sg13cmos5l_antennanp
XANTENNA__3274__GATE Tile_X0Y5_FrameStrobe[6] VPWR VGND sg13cmos5l_antennanp
XFILLER_293_242 VPWR VGND sg13cmos5l_fill_1
XFILLER_87_97 VPWR VGND sg13cmos5l_decap_8
XFILLER_213_29 VPWR VGND sg13cmos5l_decap_8
XFILLER_61_200 VPWR VGND sg13cmos5l_decap_8
XANTENNA__2592__D Tile_X0Y3_FrameData[16] VPWR VGND sg13cmos5l_antennanp
XANTENNA__3289__GATE Tile_X0Y5_FrameStrobe[7] VPWR VGND sg13cmos5l_antennanp
X_2980_ _2980_/Q Tile_X0Y4_FrameData[28] Tile_X0Y5_FrameStrobe[6] VPWR VGND sg13cmos5l_dlhq_1
XANTENNA__0961__Y AXI_M_SOC_AWLEN4 VPWR VGND sg13cmos5l_antennanp
XANTENNA__3212__GATE Tile_X0Y5_FrameStrobe[4] VPWR VGND sg13cmos5l_antennanp
X_1931_ _1931_/Q Tile_X0Y0_FrameData[21] Tile_X0Y5_FrameStrobe[7] VPWR VGND sg13cmos5l_dlhq_1
XFILLER_159_154 VPWR VGND sg13cmos5l_fill_1
X_1862_ _1862_/Q Tile_X0Y0_FrameData[26] Tile_X0Y5_FrameStrobe[5] VPWR VGND sg13cmos5l_dlhq_1
XFILLER_238_37 VPWR VGND sg13cmos5l_decap_8
XFILLER_308_118 VPWR VGND sg13cmos5l_fill_2
X_3601_ Tile_X0Y0_EE4BEG[0] _3601_/A VPWR VGND sg13cmos5l_buf_1
X_0813_ _3848_/A Tile_X0Y5_WW4END[10] _0773_/X _0696_/X _0790_/X _3206_/Q _3205_/Q
+ VPWR VGND sg13cmos5l_mux4_1
XANTENNA__1936__D Tile_X0Y0_FrameData[16] VPWR VGND sg13cmos5l_antennanp
XFILLER_174_157 VPWR VGND sg13cmos5l_decap_8
X_1793_ _1793_/Q Tile_X0Y0_FrameData[31] Tile_X0Y5_FrameStrobe[3] VPWR VGND sg13cmos5l_dlhq_1
XANTENNA__3227__GATE Tile_X0Y5_FrameStrobe[5] VPWR VGND sg13cmos5l_antennanp
X_3532_ Tile_X0Y0_N2BEGb[3] _3532_/A VPWR VGND sg13cmos5l_buf_1
X_0744_ _0745_/A _3259_/Q Tile_X0Y5_W6END[7] _3258_/Q VPWR VGND sg13cmos5l_o21ai_1
XFILLER_316_162 VPWR VGND sg13cmos5l_fill_2
XFILLER_115_246 VPWR VGND sg13cmos5l_decap_8
XFILLER_182_190 VPWR VGND sg13cmos5l_decap_8
X_3463_ Tile_X0Y1_FrameData_O[31] Tile_X0Y1_FrameData[31] VPWR VGND sg13cmos5l_buf_1
X_0675_ _0676_/C _2244_/Q _0977_/X VPWR VGND sg13cmos5l_nor2_1
XANTENNA__2483__GATE Tile_X0Y5_FrameStrobe[7] VPWR VGND sg13cmos5l_antennanp
XFILLER_115_279 VPWR VGND sg13cmos5l_fill_1
X_2414_ _2414_/Q Tile_X0Y2_FrameData[18] Tile_X0Y5_FrameStrobe[5] VPWR VGND sg13cmos5l_dlhq_1
XFILLER_331_176 VPWR VGND sg13cmos5l_decap_8
XFILLER_331_154 VPWR VGND sg13cmos5l_fill_1
XANTENNA__2767__D Tile_X0Y3_FrameData[1] VPWR VGND sg13cmos5l_antennanp
X_3394_ Tile_X0Y2_EE4BEG[12] _3394_/A VPWR VGND sg13cmos5l_buf_1
XFILLER_35_0 VPWR VGND sg13cmos5l_fill_2
XANTENNA__1531__A2 AXI_M_SOC_RDATA7 VPWR VGND sg13cmos5l_antennanp
X_2345_ _2345_/Q Tile_X0Y2_FrameData[23] Tile_X0Y5_FrameStrobe[3] VPWR VGND sg13cmos5l_dlhq_1
XFILLER_270_24 VPWR VGND sg13cmos5l_fill_2
X_2276_ _2276_/Q Tile_X0Y2_FrameData[28] Tile_X0Y5_FrameStrobe[1] VPWR VGND sg13cmos5l_dlhq_1
XANTENNA__2498__GATE Tile_X0Y5_FrameStrobe[8] VPWR VGND sg13cmos5l_antennanp
X_1227_ _3606_/A Tile_X0Y0_WW4END[10] AXI_M_SOC_BRESP1 _1005_/X _1147_/X _1846_/Q
+ _1845_/Q VPWR VGND sg13cmos5l_mux4_1
XFILLER_203_73 VPWR VGND sg13cmos5l_decap_8
X_1158_ _3537_/A Tile_X0Y0_W2MID[7] Tile_X0Y0_W2END[7] Tile_X0Y0_W6END[7] _1145_/X
+ _1960_/Q _1959_/Q VPWR VGND sg13cmos5l_mux4_1
XFILLER_52_200 VPWR VGND sg13cmos5l_decap_4
XFILLER_52_244 VPWR VGND sg13cmos5l_decap_4
XANTENNA__2421__GATE Tile_X0Y5_FrameStrobe[5] VPWR VGND sg13cmos5l_antennanp
X_1089_ _1089_/X _1076_/X _1087_/X _1088_/X Tile_X0Y0_S2MID[4] _1984_/Q _1983_/Q VPWR
+ VGND sg13cmos5l_mux4_1
XANTENNA__0871__Y AXI_M_SOC_ARLEN5 VPWR VGND sg13cmos5l_antennanp
XANTENNA__1047__A1 Tile_X0Y2_W2END[6] VPWR VGND sg13cmos5l_antennanp
XANTENNA__2007__D Tile_X0Y1_FrameData[25] VPWR VGND sg13cmos5l_antennanp
XANTENNA__2436__GATE Tile_X0Y5_FrameStrobe[6] VPWR VGND sg13cmos5l_antennanp
XFILLER_148_26 VPWR VGND sg13cmos5l_decap_8
XANTENNA__1846__D Tile_X0Y0_FrameData[10] VPWR VGND sg13cmos5l_antennanp
XFILLER_295_54 VPWR VGND sg13cmos5l_fill_2
XANTENNA__0558__A0 Tile_X0Y3_W1END[2] VPWR VGND sg13cmos5l_antennanp
XFILLER_180_116 VPWR VGND sg13cmos5l_decap_4
XFILLER_307_162 VPWR VGND sg13cmos5l_fill_1
XFILLER_106_235 VPWR VGND sg13cmos5l_fill_1
XFILLER_173_190 VPWR VGND sg13cmos5l_decap_4
XFILLER_307_184 VPWR VGND sg13cmos5l_decap_8
XFILLER_307_195 VPWR VGND sg13cmos5l_fill_1
XANTENNA__3416__A Tile_X0Y2_FrameData[18] VPWR VGND sg13cmos5l_antennanp
XFILLER_121_216 VPWR VGND sg13cmos5l_decap_4
XFILLER_164_36 VPWR VGND sg13cmos5l_decap_8
XFILLER_322_176 VPWR VGND sg13cmos5l_decap_8
XANTENNA__2677__D Tile_X0Y3_FrameData[27] VPWR VGND sg13cmos5l_antennanp
XANTENNA__1522__A2 AXI_M_SOC_RDATA12 VPWR VGND sg13cmos5l_antennanp
XANTENNA__3703__X Tile_X0Y3_FrameData_O[6] VPWR VGND sg13cmos5l_antennanp
XFILLER_244_80 VPWR VGND sg13cmos5l_decap_8
XANTENNA__0730__A0 Tile_X0Y3_W1END[3] VPWR VGND sg13cmos5l_antennanp
XFILLER_275_264 VPWR VGND sg13cmos5l_decap_4
XFILLER_57_56 VPWR VGND sg13cmos5l_decap_8
XANTENNA__1286__A1 AXI_M_SOC_RDATA25 VPWR VGND sg13cmos5l_antennanp
XFILLER_113_51 VPWR VGND sg13cmos5l_decap_8
XFILLER_228_180 VPWR VGND sg13cmos5l_decap_8
XFILLER_290_256 VPWR VGND sg13cmos5l_fill_1
XFILLER_73_22 VPWR VGND sg13cmos5l_decap_8
XFILLER_330_16 VPWR VGND sg13cmos5l_fill_1
XANTENNA__3301__D Tile_X0Y5_FrameData[11] VPWR VGND sg13cmos5l_antennanp
XFILLER_43_244 VPWR VGND sg13cmos5l_decap_8
XFILLER_237_0 VPWR VGND sg13cmos5l_fill_1
XFILLER_339_58 VPWR VGND sg13cmos5l_fill_2
XANTENNA__0797__A0 Tile_X0Y5_W2MID[2] VPWR VGND sg13cmos5l_antennanp
XANTENNA__1756__D Tile_X0Y0_FrameData[4] VPWR VGND sg13cmos5l_antennanp
XFILLER_7_156 VPWR VGND sg13cmos5l_fill_1
XFILLER_156_179 VPWR VGND sg13cmos5l_decap_8
XFILLER_171_105 VPWR VGND sg13cmos5l_decap_8
XFILLER_7_178 VPWR VGND sg13cmos5l_decap_8
XANTENNA__1210__A1 Tile_X0Y0_WW4END[12] VPWR VGND sg13cmos5l_antennanp
XFILLER_313_121 VPWR VGND sg13cmos5l_decap_4
XFILLER_98_85 VPWR VGND sg13cmos5l_decap_4
XANTENNA__2587__D Tile_X0Y3_FrameData[21] VPWR VGND sg13cmos5l_antennanp
XANTENNA__3613__X Tile_X0Y0_EE4BEG[12] VPWR VGND sg13cmos5l_antennanp
XFILLER_266_220 VPWR VGND sg13cmos5l_decap_4
X_2130_ _2130_/Q Tile_X0Y1_FrameData[30] Tile_X0Y5_FrameStrobe[5] VPWR VGND sg13cmos5l_dlhq_1
XFILLER_120_293 VPWR VGND sg13cmos5l_fill_2
X_2061_ _2061_/Q Tile_X0Y1_FrameData[3] Tile_X0Y5_FrameStrobe[2] VPWR VGND sg13cmos5l_dlhq_1
XFILLER_93_144 VPWR VGND sg13cmos5l_decap_8
XANTENNA__1277__A1 AXI_M_SOC_RDATA22 VPWR VGND sg13cmos5l_antennanp
XFILLER_304_94 VPWR VGND sg13cmos5l_decap_4
X_1012_ _1012_/X _0992_/X _0684_/X Tile_X0Y5_N4END[6] _0995_/X _2819_/Q _2820_/Q VPWR
+ VGND sg13cmos5l_mux4_1
XFILLER_19_285 VPWR VGND sg13cmos5l_fill_2
XANTENNA__3211__D Tile_X0Y5_FrameData[5] VPWR VGND sg13cmos5l_antennanp
XANTENNA__3151__GATE Tile_X0Y5_FrameStrobe[2] VPWR VGND sg13cmos5l_antennanp
X_2963_ _2963_/Q Tile_X0Y4_FrameData[13] Tile_X0Y5_FrameStrobe[5] VPWR VGND sg13cmos5l_dlhq_1
XFILLER_34_277 VPWR VGND sg13cmos5l_decap_4
XFILLER_249_25 VPWR VGND sg13cmos5l_fill_1
X_1914_ _1914_/Q Tile_X0Y0_FrameData[6] Tile_X0Y5_FrameStrobe[6] VPWR VGND sg13cmos5l_dlhq_1
XANTENNA__0788__A0 Tile_X0Y3_W2MID[5] VPWR VGND sg13cmos5l_antennanp
XFILLER_187_293 VPWR VGND sg13cmos5l_fill_2
X_2894_ _2894_/Q Tile_X0Y4_FrameData[18] Tile_X0Y5_FrameStrobe[3] VPWR VGND sg13cmos5l_dlhq_1
XFILLER_336_213 VPWR VGND sg13cmos5l_fill_2
XANTENNA__3166__GATE Tile_X0Y5_FrameStrobe[3] VPWR VGND sg13cmos5l_antennanp
X_1845_ _1845_/Q Tile_X0Y0_FrameData[11] Tile_X0Y5_FrameStrobe[4] VPWR VGND sg13cmos5l_dlhq_1
X_1776_ _1776_/Q Tile_X0Y0_FrameData[16] Tile_X0Y5_FrameStrobe[2] VPWR VGND sg13cmos5l_dlhq_1
XANTENNA__1201__A1 Tile_X0Y0_WW4END[9] VPWR VGND sg13cmos5l_antennanp
XFILLER_265_57 VPWR VGND sg13cmos5l_fill_1
X_3515_ Tile_X0Y0_N4BEG[2] _3515_/A VPWR VGND sg13cmos5l_buf_1
X_0727_ _0728_/C _2514_/Q _1119_/X VPWR VGND sg13cmos5l_nor2_1
XANTENNA__1308__X AXI_M_SOC_AWADDR2 VPWR VGND sg13cmos5l_antennanp
XFILLER_304_143 VPWR VGND sg13cmos5l_fill_2
XANTENNA__0960__A0 Tile_X0Y1_W1END[0] VPWR VGND sg13cmos5l_antennanp
XANTENNA__2497__D Tile_X0Y2_FrameData[31] VPWR VGND sg13cmos5l_antennanp
XFILLER_170_193 VPWR VGND sg13cmos5l_decap_4
X_3446_ Tile_X0Y1_FrameData_O[14] Tile_X0Y1_FrameData[14] VPWR VGND sg13cmos5l_buf_1
X_0658_ _0658_/Y _0647_/X _3265_/Q VPWR VGND sg13cmos5l_nand2b_1
XANTENNA__3523__X Tile_X0Y0_N4BEG[10] VPWR VGND sg13cmos5l_antennanp
XFILLER_134_28 VPWR VGND sg13cmos5l_decap_8
XFILLER_134_39 VPWR VGND sg13cmos5l_fill_2
X_3377_ Tile_X0Y2_E6BEG[7] _3377_/A VPWR VGND sg13cmos5l_buf_1
X_0589_ _0590_/C _2792_/Q _1056_/X VPWR VGND sg13cmos5l_nor2_1
XANTENNA__0712__A0 Tile_X0Y0_W1END[3] VPWR VGND sg13cmos5l_antennanp
XANTENNA__0866__Y AXI_M_SOC_ARLEN4 VPWR VGND sg13cmos5l_antennanp
X_2328_ _2328_/Q Tile_X0Y2_FrameData[8] Tile_X0Y5_FrameStrobe[2] VPWR VGND sg13cmos5l_dlhq_1
XFILLER_69_174 VPWR VGND sg13cmos5l_decap_8
XANTENNA__3104__GATE Tile_X0Y5_FrameStrobe[1] VPWR VGND sg13cmos5l_antennanp
XFILLER_111_293 VPWR VGND sg13cmos5l_fill_2
XFILLER_27_15 VPWR VGND sg13cmos5l_fill_1
XFILLER_25_200 VPWR VGND sg13cmos5l_decap_8
X_2259_ _2259_/Q Tile_X0Y2_FrameData[13] Tile_X0Y5_FrameStrobe[0] VPWR VGND sg13cmos5l_dlhq_1
XFILLER_84_188 VPWR VGND sg13cmos5l_decap_8
XANTENNA__2360__GATE Tile_X0Y5_FrameStrobe[3] VPWR VGND sg13cmos5l_antennanp
XFILLER_225_150 VPWR VGND sg13cmos5l_decap_8
XANTENNA__2990__GATE Tile_X0Y5_FrameStrobe[6] VPWR VGND sg13cmos5l_antennanp
XANTENNA__3119__GATE Tile_X0Y5_FrameStrobe[1] VPWR VGND sg13cmos5l_antennanp
XANTENNA__3121__D Tile_X0Y5_FrameData[31] VPWR VGND sg13cmos5l_antennanp
XANTENNA__2960__D Tile_X0Y4_FrameData[16] VPWR VGND sg13cmos5l_antennanp
XFILLER_43_58 VPWR VGND sg13cmos5l_fill_2
XANTENNA__0779__A0 Tile_X0Y5_N1END[3] VPWR VGND sg13cmos5l_antennanp
XANTENNA__2375__GATE Tile_X0Y5_FrameStrobe[4] VPWR VGND sg13cmos5l_antennanp
XFILLER_138_135 VPWR VGND sg13cmos5l_decap_8
XFILLER_178_293 VPWR VGND sg13cmos5l_fill_2
XFILLER_327_224 VPWR VGND sg13cmos5l_decap_4
XFILLER_327_246 VPWR VGND sg13cmos5l_fill_2
XFILLER_153_105 VPWR VGND sg13cmos5l_decap_8
XFILLER_175_24 VPWR VGND sg13cmos5l_fill_1
XANTENNA__0951__A0 Tile_X0Y1_WW4END[1] VPWR VGND sg13cmos5l_antennanp
XFILLER_68_33 VPWR VGND sg13cmos5l_decap_8
XFILLER_68_22 VPWR VGND sg13cmos5l_decap_8
XANTENNA__2313__GATE Tile_X0Y5_FrameStrobe[2] VPWR VGND sg13cmos5l_antennanp
XANTENNA__3433__X Tile_X0Y1_FrameData_O[1] VPWR VGND sg13cmos5l_antennanp
XFILLER_191_23 VPWR VGND sg13cmos5l_decap_8
XFILLER_191_34 VPWR VGND sg13cmos5l_fill_1
XANTENNA__2200__D Tile_X0Y1_FrameData[24] VPWR VGND sg13cmos5l_antennanp
XANTENNA__2943__GATE Tile_X0Y5_FrameStrobe[4] VPWR VGND sg13cmos5l_antennanp
XFILLER_102_293 VPWR VGND sg13cmos5l_fill_2
XFILLER_187_0 VPWR VGND sg13cmos5l_decap_4
XFILLER_208_117 VPWR VGND sg13cmos5l_fill_1
XANTENNA__1259__A1 AXI_M_SOC_BRESP1 VPWR VGND sg13cmos5l_antennanp
XANTENNA__2328__GATE Tile_X0Y5_FrameStrobe[2] VPWR VGND sg13cmos5l_antennanp
XFILLER_223_109 VPWR VGND sg13cmos5l_decap_8
XFILLER_84_76 VPWR VGND sg13cmos5l_fill_1
XFILLER_75_199 VPWR VGND sg13cmos5l_fill_2
XANTENNA__2958__GATE Tile_X0Y5_FrameStrobe[5] VPWR VGND sg13cmos5l_antennanp
XANTENNA__3031__D Tile_X0Y4_FrameData[9] VPWR VGND sg13cmos5l_antennanp
XFILLER_140_71 VPWR VGND sg13cmos5l_fill_2
XANTENNA__2870__D Tile_X0Y4_FrameData[10] VPWR VGND sg13cmos5l_antennanp
XFILLER_31_247 VPWR VGND sg13cmos5l_decap_8
XFILLER_129_113 VPWR VGND sg13cmos5l_decap_8
XANTENNA__1431__A1 Tile_X0Y2_W2END[3] VPWR VGND sg13cmos5l_antennanp
XFILLER_129_168 VPWR VGND sg13cmos5l_decap_8
XFILLER_219_17 VPWR VGND sg13cmos5l_decap_4
XFILLER_33_80 VPWR VGND sg13cmos5l_decap_4
XANTENNA__3608__X Tile_X0Y0_EE4BEG[7] VPWR VGND sg13cmos5l_antennanp
XFILLER_144_127 VPWR VGND sg13cmos5l_decap_4
X_1630_ _3759_/A AXI_M_SOC_RDATA3 _1011_/X _0996_/X _1318_/X _2893_/Q _2894_/Q VPWR
+ VGND sg13cmos5l_mux4_1
XANTENNA__1195__A0 Tile_X0Y0_WW4END[5] VPWR VGND sg13cmos5l_antennanp
XFILLER_298_142 VPWR VGND sg13cmos5l_fill_2
X_3300_ _3300_/Q Tile_X0Y5_FrameData[12] Tile_X0Y5_FrameStrobe[7] VPWR VGND sg13cmos5l_dlhq_1
X_1561_ AXI_M_SOC_WVALID Tile_X0Y3_WW4END[2] Tile_X0Y3_WW4END[10] Tile_X0Y3_W6END[10]
+ _1512_/X _2596_/Q _2595_/Q VPWR VGND sg13cmos5l_mux4_1
XANTENNA__0942__A0 Tile_X0Y1_WW4END[6] VPWR VGND sg13cmos5l_antennanp
X_1492_ _3353_/A _1120_/X _0718_/X AXI_M_SOC_RDATA14 AXI_M_SOC_RDATA18 _2434_/Q _2433_/Q
+ VPWR VGND sg13cmos5l_mux4_1
XFILLER_98_225 VPWR VGND sg13cmos5l_decap_4
XANTENNA__3206__D Tile_X0Y5_FrameData[10] VPWR VGND sg13cmos5l_antennanp
X_3231_ _3231_/Q Tile_X0Y5_FrameData[17] Tile_X0Y5_FrameStrobe[5] VPWR VGND sg13cmos5l_dlhq_1
XANTENNA__1498__A1 AXI_M_SOC_RDATA7 VPWR VGND sg13cmos5l_antennanp
XANTENNA__2110__D Tile_X0Y1_FrameData[18] VPWR VGND sg13cmos5l_antennanp
XFILLER_301_179 VPWR VGND sg13cmos5l_decap_4
X_3162_ _3162_/Q Tile_X0Y5_FrameData[22] Tile_X0Y5_FrameStrobe[3] VPWR VGND sg13cmos5l_dlhq_1
XFILLER_66_111 VPWR VGND sg13cmos5l_fill_2
XFILLER_254_201 VPWR VGND sg13cmos5l_fill_2
X_2113_ _2113_/Q Tile_X0Y1_FrameData[15] Tile_X0Y5_FrameStrobe[4] VPWR VGND sg13cmos5l_dlhq_1
X_3093_ _3093_/Q Tile_X0Y5_FrameData[27] Tile_X0Y5_FrameStrobe[1] VPWR VGND sg13cmos5l_dlhq_1
XFILLER_66_166 VPWR VGND sg13cmos5l_decap_4
X_2044_ _2044_/Q Tile_X0Y1_FrameData[20] Tile_X0Y5_FrameStrobe[2] VPWR VGND sg13cmos5l_dlhq_1
XANTENNA__3090__GATE Tile_X0Y5_FrameStrobe[1] VPWR VGND sg13cmos5l_antennanp
XANTENNA__1670__A1 AXI_M_SOC_RRESP1 VPWR VGND sg13cmos5l_antennanp
XFILLER_222_131 VPWR VGND sg13cmos5l_decap_8
XFILLER_222_142 VPWR VGND sg13cmos5l_fill_2
XANTENNA__2780__D Tile_X0Y3_FrameData[20] VPWR VGND sg13cmos5l_antennanp
XFILLER_13_28 VPWR VGND sg13cmos5l_fill_2
X_2946_ _2946_/Q Tile_X0Y4_FrameData[30] Tile_X0Y5_FrameStrobe[5] VPWR VGND sg13cmos5l_dlhq_1
XANTENNA__1422__A1 Tile_X0Y2_WW4END[15] VPWR VGND sg13cmos5l_antennanp
XFILLER_129_17 VPWR VGND sg13cmos5l_decap_8
XFILLER_175_252 VPWR VGND sg13cmos5l_decap_8
XFILLER_309_235 VPWR VGND sg13cmos5l_decap_8
X_2877_ _2877_/Q Tile_X0Y4_FrameData[3] Tile_X0Y5_FrameStrobe[2] VPWR VGND sg13cmos5l_dlhq_1
XANTENNA__3518__X Tile_X0Y0_N4BEG[5] VPWR VGND sg13cmos5l_antennanp
X_1828_ _1828_/Q Tile_X0Y0_FrameData[28] Tile_X0Y5_FrameStrobe[4] VPWR VGND sg13cmos5l_dlhq_1
XFILLER_190_255 VPWR VGND sg13cmos5l_fill_2
XANTENNA__1186__A0 Tile_X0Y4_W2MID[4] VPWR VGND sg13cmos5l_antennanp
XFILLER_150_119 VPWR VGND sg13cmos5l_fill_2
XFILLER_292_22 VPWR VGND sg13cmos5l_fill_2
X_1759_ _1759_/Q Tile_X0Y0_FrameData[1] Tile_X0Y5_FrameStrobe[1] VPWR VGND sg13cmos5l_dlhq_1
XFILLER_89_203 VPWR VGND sg13cmos5l_decap_4
XANTENNA__0933__A0 Tile_X0Y5_W1END[2] VPWR VGND sg13cmos5l_antennanp
XFILLER_292_33 VPWR VGND sg13cmos5l_decap_4
XFILLER_292_44 VPWR VGND sg13cmos5l_decap_8
XFILLER_89_247 VPWR VGND sg13cmos5l_decap_4
XANTENNA__3116__D Tile_X0Y5_FrameData[4] VPWR VGND sg13cmos5l_antennanp
X_3429_ Tile_X0Y2_FrameData_O[31] Tile_X0Y2_FrameData[31] VPWR VGND sg13cmos5l_buf_1
XANTENNA__2020__D Tile_X0Y1_FrameData[12] VPWR VGND sg13cmos5l_antennanp
XANTENNA__3043__GATE Tile_X0Y5_FrameStrobe[8] VPWR VGND sg13cmos5l_antennanp
XFILLER_38_25 VPWR VGND sg13cmos5l_decap_8
XANTENNA__2955__D Tile_X0Y4_FrameData[21] VPWR VGND sg13cmos5l_antennanp
XFILLER_285_8 VPWR VGND sg13cmos5l_fill_2
XFILLER_300_190 VPWR VGND sg13cmos5l_fill_2
XFILLER_57_199 VPWR VGND sg13cmos5l_decap_4
XFILLER_57_188 VPWR VGND sg13cmos5l_fill_1
XANTENNA__3058__GATE Tile_X0Y5_FrameStrobe[0] VPWR VGND sg13cmos5l_antennanp
XFILLER_54_46 VPWR VGND sg13cmos5l_decap_8
XANTENNA__1661__A1 AXI_M_SOC_RDATA1 VPWR VGND sg13cmos5l_antennanp
XANTENNA__2690__D Tile_X0Y3_FrameData[14] VPWR VGND sg13cmos5l_antennanp
XFILLER_110_41 VPWR VGND sg13cmos5l_decap_8
XFILLER_13_247 VPWR VGND sg13cmos5l_decap_8
XANTENNA__1413__A1 Tile_X0Y2_WW4END[8] VPWR VGND sg13cmos5l_antennanp
XFILLER_110_96 VPWR VGND sg13cmos5l_decap_8
XFILLER_186_23 VPWR VGND sg13cmos5l_decap_8
XFILLER_21_280 VPWR VGND sg13cmos5l_fill_1
XFILLER_70_67 VPWR VGND sg13cmos5l_decap_8
XANTENNA__3428__X Tile_X0Y2_FrameData_O[30] VPWR VGND sg13cmos5l_antennanp
XFILLER_166_263 VPWR VGND sg13cmos5l_decap_4
XFILLER_181_200 VPWR VGND sg13cmos5l_decap_4
XANTENNA__1177__A0 Tile_X0Y1_W1END[3] VPWR VGND sg13cmos5l_antennanp
XFILLER_102_0 VPWR VGND sg13cmos5l_fill_2
XFILLER_79_21 VPWR VGND sg13cmos5l_decap_8
XANTENNA__2252__GATE Tile_X0Y5_FrameStrobe[0] VPWR VGND sg13cmos5l_antennanp
XFILLER_295_101 VPWR VGND sg13cmos5l_decap_4
XANTENNA__2882__GATE Tile_X0Y5_FrameStrobe[3] VPWR VGND sg13cmos5l_antennanp
XANTENNA__3026__D Tile_X0Y4_FrameData[14] VPWR VGND sg13cmos5l_antennanp
XFILLER_79_98 VPWR VGND sg13cmos5l_decap_4
XFILLER_323_293 VPWR VGND sg13cmos5l_fill_2
XFILLER_95_228 VPWR VGND sg13cmos5l_fill_2
XFILLER_95_217 VPWR VGND sg13cmos5l_decap_8
XANTENNA__2865__D Tile_X0Y4_FrameData[15] VPWR VGND sg13cmos5l_antennanp
XFILLER_95_42 VPWR VGND sg13cmos5l_decap_8
XFILLER_48_133 VPWR VGND sg13cmos5l_decap_8
XANTENNA__2267__GATE Tile_X0Y5_FrameStrobe[0] VPWR VGND sg13cmos5l_antennanp
XANTENNA__2897__GATE Tile_X0Y5_FrameStrobe[3] VPWR VGND sg13cmos5l_antennanp
XFILLER_236_267 VPWR VGND sg13cmos5l_decap_8
XANTENNA__1101__A0 Tile_X0Y1_W2MID[6] VPWR VGND sg13cmos5l_antennanp
XANTENNA__1411__X AXI_M_SOC_WDATA10 VPWR VGND sg13cmos5l_antennanp
XFILLER_204_153 VPWR VGND sg13cmos5l_fill_1
XANTENNA__1652__A1 Tile_X0Y4_WW4END[6] VPWR VGND sg13cmos5l_antennanp
XANTENNA__2820__GATE Tile_X0Y5_FrameStrobe[1] VPWR VGND sg13cmos5l_antennanp
XFILLER_149_219 VPWR VGND sg13cmos5l_decap_8
XFILLER_301_84 VPWR VGND sg13cmos5l_fill_2
X_2800_ _2800_/Q Tile_X0Y4_FrameData[16] Tile_X0Y5_FrameStrobe[0] VPWR VGND sg13cmos5l_dlhq_1
X_3780_ Tile_X0Y4_FrameData_O[2] Tile_X0Y4_FrameData[2] VPWR VGND sg13cmos5l_buf_1
X_0992_ _0992_/X Tile_X0Y5_W1END[2] _0694_/X Tile_X0Y5_W6END[6] _0991_/Y _3323_/Q
+ _3324_/Q VPWR VGND sg13cmos5l_mux4_1
XANTENNA__2205__GATE Tile_X0Y5_FrameStrobe[7] VPWR VGND sg13cmos5l_antennanp
XFILLER_12_280 VPWR VGND sg13cmos5l_fill_1
X_2731_ _2731_/Q Tile_X0Y3_FrameData[5] Tile_X0Y5_FrameStrobe[6] VPWR VGND sg13cmos5l_dlhq_1
XANTENNA__2105__D Tile_X0Y1_FrameData[23] VPWR VGND sg13cmos5l_antennanp
XANTENNA__2835__GATE Tile_X0Y5_FrameStrobe[1] VPWR VGND sg13cmos5l_antennanp
XFILLER_157_285 VPWR VGND sg13cmos5l_fill_2
XFILLER_306_205 VPWR VGND sg13cmos5l_decap_8
XFILLER_117_127 VPWR VGND sg13cmos5l_fill_1
X_2662_ _2662_/Q Tile_X0Y3_FrameData[10] Tile_X0Y5_FrameStrobe[4] VPWR VGND sg13cmos5l_dlhq_1
XFILLER_8_284 VPWR VGND sg13cmos5l_fill_1
XANTENNA__1168__A0 Tile_X0Y0_W1END[0] VPWR VGND sg13cmos5l_antennanp
XANTENNA__1944__D Tile_X0Y0_FrameData[8] VPWR VGND sg13cmos5l_antennanp
X_2593_ _2593_/Q Tile_X0Y3_FrameData[15] Tile_X0Y5_FrameStrobe[2] VPWR VGND sg13cmos5l_dlhq_1
X_1613_ _3768_/A Tile_X0Y4_WW4END[9] _1040_/X AXI_M_SOC_RDATA4 _1049_/X _2931_/Q _2932_/Q
+ VPWR VGND sg13cmos5l_mux4_1
XFILLER_5_40 VPWR VGND sg13cmos5l_fill_1
X_1544_ _3679_/A AXI_M_SOC_RDATA12 _1437_/X _1530_/X _1348_/X _2619_/Q _2620_/Q VPWR
+ VGND sg13cmos5l_mux4_1
XFILLER_286_123 VPWR VGND sg13cmos5l_decap_8
XFILLER_314_293 VPWR VGND sg13cmos5l_fill_2
XFILLER_140_152 VPWR VGND sg13cmos5l_decap_8
X_3214_ _3214_/Q Tile_X0Y5_FrameData[2] Tile_X0Y5_FrameStrobe[4] VPWR VGND sg13cmos5l_dlhq_1
X_1475_ _3350_/A _1051_/X _0574_/X AXI_M_SOC_RDATA17 AXI_M_SOC_RDATA21 _2440_/Q _2439_/Q
+ VPWR VGND sg13cmos5l_mux4_1
XANTENNA__2775__D Tile_X0Y3_FrameData[25] VPWR VGND sg13cmos5l_antennanp
XANTENNA__1340__A0 Tile_X0Y1_W2MID[3] VPWR VGND sg13cmos5l_antennanp
XANTENNA__3801__X Tile_X0Y4_FrameData_O[23] VPWR VGND sg13cmos5l_antennanp
X_3145_ _3145_/Q Tile_X0Y5_FrameData[7] Tile_X0Y5_FrameStrobe[2] VPWR VGND sg13cmos5l_dlhq_1
XFILLER_94_250 VPWR VGND sg13cmos5l_decap_8
X_3076_ _3076_/Q Tile_X0Y5_FrameData[12] Tile_X0Y5_FrameStrobe[0] VPWR VGND sg13cmos5l_dlhq_1
XFILLER_54_136 VPWR VGND sg13cmos5l_decap_8
X_2027_ _2027_/Q Tile_X0Y1_FrameData[5] Tile_X0Y5_FrameStrobe[1] VPWR VGND sg13cmos5l_dlhq_1
XFILLER_211_62 VPWR VGND sg13cmos5l_fill_2
XANTENNA__1643__A1 Tile_X0Y4_WW4END[11] VPWR VGND sg13cmos5l_antennanp
XFILLER_24_16 VPWR VGND sg13cmos5l_fill_1
XFILLER_287_44 VPWR VGND sg13cmos5l_fill_1
XFILLER_210_167 VPWR VGND sg13cmos5l_decap_8
X_2929_ _2929_/Q Tile_X0Y4_FrameData[15] Tile_X0Y5_FrameStrobe[4] VPWR VGND sg13cmos5l_dlhq_1
XANTENNA__2015__D Tile_X0Y1_FrameData[17] VPWR VGND sg13cmos5l_antennanp
XFILLER_40_15 VPWR VGND sg13cmos5l_decap_4
XANTENNA__1854__D Tile_X0Y0_FrameData[2] VPWR VGND sg13cmos5l_antennanp
XANTENNA__0906__A0 Tile_X0Y1_WW4END[3] VPWR VGND sg13cmos5l_antennanp
XFILLER_305_293 VPWR VGND sg13cmos5l_fill_2
XANTENNA__3424__A Tile_X0Y2_FrameData[26] VPWR VGND sg13cmos5l_antennanp
XFILLER_172_36 VPWR VGND sg13cmos5l_decap_8
XFILLER_49_68 VPWR VGND sg13cmos5l_decap_8
XANTENNA__2685__D Tile_X0Y3_FrameData[19] VPWR VGND sg13cmos5l_antennanp
XANTENNA__3711__X Tile_X0Y3_FrameData_O[14] VPWR VGND sg13cmos5l_antennanp
XFILLER_65_23 VPWR VGND sg13cmos5l_decap_4
XFILLER_105_85 VPWR VGND sg13cmos5l_fill_1
XANTENNA__1634__A1 Tile_X0Y4_W6END[2] VPWR VGND sg13cmos5l_antennanp
XFILLER_81_22 VPWR VGND sg13cmos5l_decap_4
XFILLER_81_99 VPWR VGND sg13cmos5l_fill_1
XANTENNA__1398__A0 Tile_X0Y5_N4END[13] VPWR VGND sg13cmos5l_antennanp
XFILLER_317_0 VPWR VGND sg13cmos5l_fill_2
XANTENNA__1764__D Tile_X0Y0_FrameData[28] VPWR VGND sg13cmos5l_antennanp
XFILLER_154_277 VPWR VGND sg13cmos5l_fill_2
XANTENNA__2191__GATE Tile_X0Y5_FrameStrobe[6] VPWR VGND sg13cmos5l_antennanp
XFILLER_107_182 VPWR VGND sg13cmos5l_decap_8
XFILLER_303_219 VPWR VGND sg13cmos5l_fill_2
XFILLER_146_81 VPWR VGND sg13cmos5l_decap_8
XFILLER_122_152 VPWR VGND sg13cmos5l_decap_8
XFILLER_283_104 VPWR VGND sg13cmos5l_fill_2
X_1260_ _3643_/A Tile_X0Y0_W2MID[1] _1140_/X AXI_M_SOC_WREADY _1010_/X _1875_/Q _1876_/Q
+ VPWR VGND sg13cmos5l_mux4_1
XANTENNA__1322__A0 Tile_X0Y1_W2MID[6] VPWR VGND sg13cmos5l_antennanp
XANTENNA__2595__D Tile_X0Y3_FrameData[13] VPWR VGND sg13cmos5l_antennanp
X_1191_ _1191_/X _1087_/X _1189_/X _1190_/X _1088_/X _2256_/Q _2255_/Q VPWR VGND sg13cmos5l_mux4_1
XANTENNA__0964__Y AXI_M_SOC_AWLEN5 VPWR VGND sg13cmos5l_antennanp
XANTENNA__3621__X Tile_X0Y0_E6BEG[4] VPWR VGND sg13cmos5l_antennanp
XFILLER_162_91 VPWR VGND sg13cmos5l_decap_8
XFILLER_91_286 VPWR VGND sg13cmos5l_fill_1
XANTENNA__1939__D Tile_X0Y0_FrameData[13] VPWR VGND sg13cmos5l_antennanp
XFILLER_189_141 VPWR VGND sg13cmos5l_decap_8
X_3901_ Tile_X0Y5_S2BEG[6] _3901_/A VPWR VGND sg13cmos5l_buf_1
X_3832_ Tile_X0Y5_E6BEG[1] _3832_/A VPWR VGND sg13cmos5l_buf_1
XFILLER_338_116 VPWR VGND sg13cmos5l_fill_1
XANTENNA__2144__GATE Tile_X0Y5_FrameStrobe[5] VPWR VGND sg13cmos5l_antennanp
XANTENNA__1389__A0 Tile_X0Y2_W1END[1] VPWR VGND sg13cmos5l_antennanp
XANTENNA__2774__GATE Tile_X0Y5_FrameStrobe[8] VPWR VGND sg13cmos5l_antennanp
X_3763_ Tile_X0Y4_EE4BEG[1] _3763_/A VPWR VGND sg13cmos5l_buf_1
X_0975_ _3900_/A Tile_X0Y5_W1END[1] Tile_X0Y5_W2MID[2] Tile_X0Y5_W2END[2] _0656_/X
+ _3274_/Q _3273_/Q VPWR VGND sg13cmos5l_mux4_1
XFILLER_257_58 VPWR VGND sg13cmos5l_decap_8
X_2714_ _2714_/Q Tile_X0Y3_FrameData[22] Tile_X0Y5_FrameStrobe[6] VPWR VGND sg13cmos5l_dlhq_1
X_3694_ Tile_X0Y3_EE4BEG[13] _3694_/A VPWR VGND sg13cmos5l_buf_1
XFILLER_65_0 VPWR VGND sg13cmos5l_decap_4
XANTENNA__0600__A2 Tile_X0Y5_W6END[4] VPWR VGND sg13cmos5l_antennanp
XANTENNA__2159__GATE Tile_X0Y5_FrameStrobe[5] VPWR VGND sg13cmos5l_antennanp
X_2645_ _2645_/Q Tile_X0Y3_FrameData[27] Tile_X0Y5_FrameStrobe[4] VPWR VGND sg13cmos5l_dlhq_1
XANTENNA__2789__GATE Tile_X0Y5_FrameStrobe[0] VPWR VGND sg13cmos5l_antennanp
XFILLER_126_29 VPWR VGND sg13cmos5l_fill_2
XFILLER_259_112 VPWR VGND sg13cmos5l_fill_2
X_2576_ _2576_/Q Tile_X0Y3_FrameData[0] Tile_X0Y5_FrameStrobe[1] VPWR VGND sg13cmos5l_dlhq_1
XANTENNA__1561__A0 Tile_X0Y3_WW4END[2] VPWR VGND sg13cmos5l_antennanp
XFILLER_259_156 VPWR VGND sg13cmos5l_decap_4
XFILLER_273_68 VPWR VGND sg13cmos5l_decap_4
XFILLER_302_252 VPWR VGND sg13cmos5l_fill_1
X_1527_ _3693_/A Tile_X0Y3_WW4END[3] AXI_M_SOC_RDATA9 _1526_/X _1587_/B _2648_/Q _2647_/Q
+ VPWR VGND sg13cmos5l_mux4_1
XANTENNA__2712__GATE Tile_X0Y5_FrameStrobe[6] VPWR VGND sg13cmos5l_antennanp
XFILLER_19_38 VPWR VGND sg13cmos5l_decap_8
XFILLER_206_84 VPWR VGND sg13cmos5l_decap_8
X_1458_ _3359_/A Tile_X0Y2_W2MID[2] AXI_M_SOC_RDATA19 _1151_/X _1183_/X _2422_/Q _2421_/Q
+ VPWR VGND sg13cmos5l_mux4_1
XFILLER_19_49 VPWR VGND sg13cmos5l_fill_1
XFILLER_274_126 VPWR VGND sg13cmos5l_decap_8
XANTENNA__3531__X Tile_X0Y0_N2BEGb[2] VPWR VGND sg13cmos5l_antennanp
X_3128_ _3128_/Q Tile_X0Y5_FrameData[24] Tile_X0Y5_FrameStrobe[2] VPWR VGND sg13cmos5l_dlhq_1
X_1389_ _1390_/B Tile_X0Y2_W1END[1] Tile_X0Y2_W6END[9] Tile_X0Y2_WW4END[1] _1388_/X
+ _2484_/Q _2485_/Q VPWR VGND sg13cmos5l_mux4_1
XFILLER_222_72 VPWR VGND sg13cmos5l_decap_8
XANTENNA__2727__GATE Tile_X0Y5_FrameStrobe[6] VPWR VGND sg13cmos5l_antennanp
XFILLER_27_169 VPWR VGND sg13cmos5l_decap_8
X_3059_ _3059_/Q Tile_X0Y5_FrameData[29] Tile_X0Y5_FrameStrobe[0] VPWR VGND sg13cmos5l_dlhq_1
XFILLER_42_117 VPWR VGND sg13cmos5l_decap_8
XANTENNA__1616__A1 AXI_M_SOC_RDATA2 VPWR VGND sg13cmos5l_antennanp
XANTENNA__1849__D Tile_X0Y0_FrameData[7] VPWR VGND sg13cmos5l_antennanp
XFILLER_150_8 VPWR VGND sg13cmos5l_decap_4
XANTENNA__0890__X AXI_M_SOC_WSTRB2 VPWR VGND sg13cmos5l_antennanp
XANTENNA__1092__A2 Tile_X0Y2_W6END[4] VPWR VGND sg13cmos5l_antennanp
XANTENNA__1983__GATE Tile_X0Y5_FrameStrobe[0] VPWR VGND sg13cmos5l_antennanp
XFILLER_143_7 VPWR VGND sg13cmos5l_decap_4
XFILLER_51_14 VPWR VGND sg13cmos5l_decap_8
XANTENNA__3419__A Tile_X0Y2_FrameData[21] VPWR VGND sg13cmos5l_antennanp
XANTENNA__1998__GATE Tile_X0Y5_FrameStrobe[0] VPWR VGND sg13cmos5l_antennanp
XANTENNA__3706__X Tile_X0Y3_FrameData_O[9] VPWR VGND sg13cmos5l_antennanp
XFILLER_151_214 VPWR VGND sg13cmos5l_fill_2
XANTENNA__1147__A3 Tile_X0Y0_S2END[2] VPWR VGND sg13cmos5l_antennanp
XANTENNA__1921__GATE Tile_X0Y5_FrameStrobe[7] VPWR VGND sg13cmos5l_antennanp
XFILLER_183_35 VPWR VGND sg13cmos5l_decap_4
XANTENNA__1552__A0 Tile_X0Y3_WW4END[6] VPWR VGND sg13cmos5l_antennanp
XFILLER_183_68 VPWR VGND sg13cmos5l_decap_8
XFILLER_76_11 VPWR VGND sg13cmos5l_decap_8
XANTENNA__1304__A0 AXI_M_SOC_RDATA27 VPWR VGND sg13cmos5l_antennanp
XANTENNA__3304__D Tile_X0Y5_FrameData[8] VPWR VGND sg13cmos5l_antennanp
XANTENNA__1936__GATE Tile_X0Y5_FrameStrobe[7] VPWR VGND sg13cmos5l_antennanp
XANTENNA__3441__X Tile_X0Y1_FrameData_O[9] VPWR VGND sg13cmos5l_antennanp
XFILLER_267_0 VPWR VGND sg13cmos5l_fill_2
XFILLER_92_21 VPWR VGND sg13cmos5l_decap_8
XANTENNA__1759__D Tile_X0Y0_FrameData[1] VPWR VGND sg13cmos5l_antennanp
XFILLER_92_98 VPWR VGND sg13cmos5l_decap_8
XFILLER_127_233 VPWR VGND sg13cmos5l_fill_2
XFILLER_186_199 VPWR VGND sg13cmos5l_decap_4
X_0760_ _3811_/A Tile_X0Y5_N1END[0] _0759_/X _1054_/B AXI_M_SOC_RLAST _3255_/Q _3256_/Q
+ VPWR VGND sg13cmos5l_mux4_1
XFILLER_127_255 VPWR VGND sg13cmos5l_fill_2
XANTENNA__3616__X Tile_X0Y0_EE4BEG[15] VPWR VGND sg13cmos5l_antennanp
X_2430_ _2430_/Q Tile_X0Y2_FrameData[2] Tile_X0Y5_FrameStrobe[5] VPWR VGND sg13cmos5l_dlhq_1
X_0691_ _0691_/X Tile_X0Y1_W6END[6] _0965_/X _1217_/X _1083_/X _2172_/Q _2174_/Q VPWR
+ VGND sg13cmos5l_mux4_1
XANTENNA__1543__A0 Tile_X0Y3_WW4END[0] VPWR VGND sg13cmos5l_antennanp
X_2361_ _2361_/Q Tile_X0Y2_FrameData[7] Tile_X0Y5_FrameStrobe[3] VPWR VGND sg13cmos5l_dlhq_1
XFILLER_150_291 VPWR VGND sg13cmos5l_decap_4
XFILLER_243_49 VPWR VGND sg13cmos5l_fill_1
X_2292_ _2292_/Q Tile_X0Y2_FrameData[12] Tile_X0Y5_FrameStrobe[1] VPWR VGND sg13cmos5l_dlhq_1
X_1312_ _1312_/X _1051_/X _0574_/X Tile_X0Y5_N4END[12] Tile_X0Y0_S4END[8] _2287_/Q
+ _2288_/Q VPWR VGND sg13cmos5l_mux4_1
X_1243_ _3624_/A AXI_M_SOC_BVALID _1068_/X _1069_/X _1148_/X _1810_/Q _1809_/Q VPWR
+ VGND sg13cmos5l_mux4_1
XANTENNA__3214__D Tile_X0Y5_FrameData[2] VPWR VGND sg13cmos5l_antennanp
XANTENNA__3351__X Tile_X0Y2_E1BEG[1] VPWR VGND sg13cmos5l_antennanp
XFILLER_2_74 VPWR VGND sg13cmos5l_fill_2
XANTENNA__0649__A2 Tile_X0Y5_W6END[5] VPWR VGND sg13cmos5l_antennanp
X_1174_ _1174_/X Tile_X0Y4_W2MID[1] Tile_X0Y4_W2END[1] Tile_X0Y4_W6END[1] _1360_/X
+ _3036_/Q _3035_/Q VPWR VGND sg13cmos5l_mux4_1
XANTENNA__2083__GATE Tile_X0Y5_FrameStrobe[3] VPWR VGND sg13cmos5l_antennanp
XANTENNA__1074__A2 Tile_X0Y0_S1END[0] VPWR VGND sg13cmos5l_antennanp
X_3815_ Tile_X0Y5_E2BEG[0] _3815_/A VPWR VGND sg13cmos5l_buf_1
XANTENNA__2098__GATE Tile_X0Y5_FrameStrobe[4] VPWR VGND sg13cmos5l_antennanp
XFILLER_177_199 VPWR VGND sg13cmos5l_decap_8
XFILLER_192_114 VPWR VGND sg13cmos5l_fill_1
XFILLER_192_136 VPWR VGND sg13cmos5l_decap_8
XFILLER_192_147 VPWR VGND sg13cmos5l_fill_1
X_3746_ Tile_X0Y4_E2BEGb[4] _3746_/A VPWR VGND sg13cmos5l_buf_1
X_0958_ AXI_M_SOC_AWLEN3 _3337_/Q _0957_/X VPWR VGND sg13cmos5l_nor2b_1
XFILLER_326_119 VPWR VGND sg13cmos5l_decap_8
XFILLER_319_193 VPWR VGND sg13cmos5l_decap_4
XANTENNA__3526__X Tile_X0Y0_N4BEG[13] VPWR VGND sg13cmos5l_antennanp
X_3677_ Tile_X0Y3_E6BEG[8] _3677_/A VPWR VGND sg13cmos5l_buf_1
X_0889_ _0890_/B Tile_X0Y3_W1END[2] Tile_X0Y3_WW4END[14] Tile_X0Y3_WW4END[6] _0888_/X
+ _2587_/Q _2588_/Q VPWR VGND sg13cmos5l_mux4_1
XANTENNA__2021__GATE Tile_X0Y5_FrameStrobe[1] VPWR VGND sg13cmos5l_antennanp
XFILLER_284_89 VPWR VGND sg13cmos5l_fill_1
X_2628_ _2628_/Q Tile_X0Y3_FrameData[12] Tile_X0Y5_FrameStrobe[3] VPWR VGND sg13cmos5l_dlhq_1
XANTENNA__1534__A0 AXI_M_SOC_RDATA6 VPWR VGND sg13cmos5l_antennanp
XANTENNA__2651__GATE Tile_X0Y5_FrameStrobe[4] VPWR VGND sg13cmos5l_antennanp
XFILLER_153_16 VPWR VGND sg13cmos5l_fill_1
X_2559_ _2559_/Q Tile_X0Y3_FrameData[17] Tile_X0Y5_FrameStrobe[1] VPWR VGND sg13cmos5l_dlhq_1
XFILLER_99_150 VPWR VGND sg13cmos5l_fill_1
XANTENNA__0888__A2 Tile_X0Y5_N4END[10] VPWR VGND sg13cmos5l_antennanp
XFILLER_101_111 VPWR VGND sg13cmos5l_decap_8
XFILLER_198_8 VPWR VGND sg13cmos5l_decap_8
XANTENNA__2036__GATE Tile_X0Y5_FrameStrobe[2] VPWR VGND sg13cmos5l_antennanp
XANTENNA__3124__D Tile_X0Y5_FrameData[28] VPWR VGND sg13cmos5l_antennanp
XANTENNA__3702__A Tile_X0Y3_FrameData[5] VPWR VGND sg13cmos5l_antennanp
XFILLER_101_188 VPWR VGND sg13cmos5l_decap_8
XFILLER_46_25 VPWR VGND sg13cmos5l_decap_8
XANTENNA__2666__GATE Tile_X0Y5_FrameStrobe[4] VPWR VGND sg13cmos5l_antennanp
XFILLER_233_93 VPWR VGND sg13cmos5l_fill_1
XFILLER_55_231 VPWR VGND sg13cmos5l_fill_2
XANTENNA__2963__D Tile_X0Y4_FrameData[13] VPWR VGND sg13cmos5l_antennanp
XFILLER_70_201 VPWR VGND sg13cmos5l_decap_8
XFILLER_55_264 VPWR VGND sg13cmos5l_decap_4
XFILLER_270_173 VPWR VGND sg13cmos5l_decap_8
XFILLER_62_35 VPWR VGND sg13cmos5l_decap_8
XANTENNA__1065__A2 Tile_X0Y5_N4END[4] VPWR VGND sg13cmos5l_antennanp
XFILLER_23_172 VPWR VGND sg13cmos5l_decap_8
XFILLER_23_183 VPWR VGND sg13cmos5l_fill_2
XANTENNA__2604__GATE Tile_X0Y5_FrameStrobe[2] VPWR VGND sg13cmos5l_antennanp
XFILLER_109_200 VPWR VGND sg13cmos5l_decap_8
XFILLER_328_27 VPWR VGND sg13cmos5l_fill_2
XANTENNA__2203__D Tile_X0Y1_FrameData[21] VPWR VGND sg13cmos5l_antennanp
XANTENNA__3436__X Tile_X0Y1_FrameData_O[4] VPWR VGND sg13cmos5l_antennanp
XFILLER_109_277 VPWR VGND sg13cmos5l_fill_1
XFILLER_11_50 VPWR VGND sg13cmos5l_fill_1
XANTENNA__1860__GATE Tile_X0Y5_FrameStrobe[5] VPWR VGND sg13cmos5l_antennanp
XANTENNA__1525__A0 Tile_X0Y3_WW4END[2] VPWR VGND sg13cmos5l_antennanp
XANTENNA__2619__GATE Tile_X0Y5_FrameStrobe[3] VPWR VGND sg13cmos5l_antennanp
XFILLER_87_21 VPWR VGND sg13cmos5l_decap_8
XANTENNA__1875__GATE Tile_X0Y5_FrameStrobe[5] VPWR VGND sg13cmos5l_antennanp
XANTENNA__3034__D Tile_X0Y4_FrameData[6] VPWR VGND sg13cmos5l_antennanp
XFILLER_293_276 VPWR VGND sg13cmos5l_fill_1
XFILLER_46_220 VPWR VGND sg13cmos5l_decap_8
XANTENNA__2873__D Tile_X0Y4_FrameData[7] VPWR VGND sg13cmos5l_antennanp
XANTENNA__1056__A2 Tile_X0Y5_W6END[4] VPWR VGND sg13cmos5l_antennanp
X_1930_ _1930_/Q Tile_X0Y0_FrameData[22] Tile_X0Y5_FrameStrobe[7] VPWR VGND sg13cmos5l_dlhq_1
XANTENNA__1813__GATE Tile_X0Y5_FrameStrobe[3] VPWR VGND sg13cmos5l_antennanp
X_1861_ _1861_/Q Tile_X0Y0_FrameData[27] Tile_X0Y5_FrameStrobe[5] VPWR VGND sg13cmos5l_dlhq_1
X_3600_ Tile_X0Y0_FrameData_O[31] Tile_X0Y0_FrameData[31] VPWR VGND sg13cmos5l_buf_1
X_0812_ _3847_/A Tile_X0Y5_WW4END[11] _0778_/X _0742_/X _0794_/X _3208_/Q _3207_/Q
+ VPWR VGND sg13cmos5l_mux4_1
XFILLER_52_90 VPWR VGND sg13cmos5l_fill_2
X_3531_ Tile_X0Y0_N2BEGb[2] _3531_/A VPWR VGND sg13cmos5l_buf_1
X_1792_ _1792_/Q Tile_X0Y0_FrameData[0] Tile_X0Y5_FrameStrobe[2] VPWR VGND sg13cmos5l_dlhq_1
XANTENNA__1828__GATE Tile_X0Y5_FrameStrobe[4] VPWR VGND sg13cmos5l_antennanp
XANTENNA__2113__D Tile_X0Y1_FrameData[15] VPWR VGND sg13cmos5l_antennanp
XANTENNA__3209__D Tile_X0Y5_FrameData[7] VPWR VGND sg13cmos5l_antennanp
X_0743_ _0743_/X Tile_X0Y5_N1END[3] Tile_X0Y5_N4END[3] _1133_/B _0739_/X _3106_/Q
+ _3105_/Q VPWR VGND sg13cmos5l_mux4_1
XFILLER_331_100 VPWR VGND sg13cmos5l_fill_1
X_3462_ Tile_X0Y1_FrameData_O[30] Tile_X0Y1_FrameData[30] VPWR VGND sg13cmos5l_buf_1
X_0674_ _0676_/B Tile_X0Y2_W6END[2] _2244_/Q VPWR VGND sg13cmos5l_nor2b_1
XANTENNA__1516__A0 Tile_X0Y3_WW4END[14] VPWR VGND sg13cmos5l_antennanp
XANTENNA__1952__D Tile_X0Y0_FrameData[0] VPWR VGND sg13cmos5l_antennanp
X_2413_ _2413_/Q Tile_X0Y2_FrameData[19] Tile_X0Y5_FrameStrobe[5] VPWR VGND sg13cmos5l_dlhq_1
X_3393_ Tile_X0Y2_EE4BEG[11] _3393_/A VPWR VGND sg13cmos5l_buf_1
XFILLER_130_228 VPWR VGND sg13cmos5l_fill_1
X_2344_ _2344_/Q Tile_X0Y2_FrameData[24] Tile_X0Y5_FrameStrobe[3] VPWR VGND sg13cmos5l_dlhq_1
XFILLER_96_131 VPWR VGND sg13cmos5l_fill_2
X_2275_ _2275_/Q Tile_X0Y2_FrameData[29] Tile_X0Y5_FrameStrobe[1] VPWR VGND sg13cmos5l_dlhq_1
X_1226_ _3605_/A Tile_X0Y0_WW4END[11] AXI_M_SOC_BRESP0 _1137_/X _1148_/X _1848_/Q
+ _1847_/Q VPWR VGND sg13cmos5l_mux4_1
XANTENNA__2783__D Tile_X0Y3_FrameData[17] VPWR VGND sg13cmos5l_antennanp
XFILLER_203_52 VPWR VGND sg13cmos5l_decap_8
X_1157_ _1157_/X _1107_/X _1155_/X _1156_/X _1108_/X _2263_/Q _2264_/Q VPWR VGND sg13cmos5l_mux4_1
XFILLER_16_39 VPWR VGND sg13cmos5l_decap_8
XFILLER_252_151 VPWR VGND sg13cmos5l_decap_8
X_1088_ _1088_/X Tile_X0Y0_W1END[0] Tile_X0Y0_W2MID[3] Tile_X0Y0_W2END[3] _1078_/X
+ _1916_/Q _1915_/Q VPWR VGND sg13cmos5l_mux4_1
XANTENNA__1047__A2 Tile_X0Y2_W6END[9] VPWR VGND sg13cmos5l_antennanp
XFILLER_52_278 VPWR VGND sg13cmos5l_fill_1
XFILLER_20_120 VPWR VGND sg13cmos5l_decap_8
XFILLER_20_164 VPWR VGND sg13cmos5l_decap_8
XANTENNA__3334__GATE Tile_X0Y5_FrameStrobe[8] VPWR VGND sg13cmos5l_antennanp
XANTENNA__0558__A1 Tile_X0Y3_W2MID[1] VPWR VGND sg13cmos5l_antennanp
XANTENNA__2023__D Tile_X0Y1_FrameData[9] VPWR VGND sg13cmos5l_antennanp
XANTENNA__3119__D Tile_X0Y5_FrameData[1] VPWR VGND sg13cmos5l_antennanp
XFILLER_307_141 VPWR VGND sg13cmos5l_fill_2
X_3729_ Tile_X0Y3_UserCLKo Tile_X0Y3_UserCLK VPWR VGND sg13cmos5l_buf_1
XANTENNA__2590__GATE Tile_X0Y5_FrameStrobe[2] VPWR VGND sg13cmos5l_antennanp
XANTENNA__1507__A0 Tile_X0Y3_W2MID[3] VPWR VGND sg13cmos5l_antennanp
XANTENNA__1862__D Tile_X0Y0_FrameData[26] VPWR VGND sg13cmos5l_antennanp
XANTENNA__2958__D Tile_X0Y4_FrameData[18] VPWR VGND sg13cmos5l_antennanp
XANTENNA__3349__GATE Tile_X0Y5_FrameStrobe[8] VPWR VGND sg13cmos5l_antennanp
XFILLER_87_153 VPWR VGND sg13cmos5l_decap_8
XFILLER_57_35 VPWR VGND sg13cmos5l_decap_8
XANTENNA__0730__A1 Tile_X0Y3_W6END[11] VPWR VGND sg13cmos5l_antennanp
XANTENNA__3432__A Tile_X0Y1_FrameData[0] VPWR VGND sg13cmos5l_antennanp
XFILLER_113_30 VPWR VGND sg13cmos5l_decap_8
XFILLER_189_4 VPWR VGND sg13cmos5l_fill_1
XANTENNA__2693__D Tile_X0Y3_FrameData[11] VPWR VGND sg13cmos5l_antennanp
XFILLER_28_242 VPWR VGND sg13cmos5l_decap_8
XFILLER_28_253 VPWR VGND sg13cmos5l_fill_2
XFILLER_188_217 VPWR VGND sg13cmos5l_fill_2
XFILLER_189_56 VPWR VGND sg13cmos5l_fill_1
XANTENNA__1038__A2 Tile_X0Y0_S1END[1] VPWR VGND sg13cmos5l_antennanp
XFILLER_189_78 VPWR VGND sg13cmos5l_decap_8
XFILLER_189_89 VPWR VGND sg13cmos5l_fill_2
XANTENNA__2543__GATE Tile_X0Y5_FrameStrobe[0] VPWR VGND sg13cmos5l_antennanp
XFILLER_132_0 VPWR VGND sg13cmos5l_fill_2
XFILLER_156_114 VPWR VGND sg13cmos5l_fill_2
XFILLER_196_294 VPWR VGND sg13cmos5l_fill_1
XFILLER_156_158 VPWR VGND sg13cmos5l_decap_8
XFILLER_22_60 VPWR VGND sg13cmos5l_decap_4
XANTENNA__3029__D Tile_X0Y4_FrameData[11] VPWR VGND sg13cmos5l_antennanp
XFILLER_138_60 VPWR VGND sg13cmos5l_decap_8
XANTENNA__1210__A2 Tile_X0Y0_WW4END[4] VPWR VGND sg13cmos5l_antennanp
XANTENNA__2558__GATE Tile_X0Y5_FrameStrobe[1] VPWR VGND sg13cmos5l_antennanp
XFILLER_138_71 VPWR VGND sg13cmos5l_fill_1
XFILLER_138_93 VPWR VGND sg13cmos5l_fill_1
XFILLER_164_180 VPWR VGND sg13cmos5l_decap_8
XANTENNA__1772__D Tile_X0Y0_FrameData[20] VPWR VGND sg13cmos5l_antennanp
XANTENNA__2868__D Tile_X0Y4_FrameData[12] VPWR VGND sg13cmos5l_antennanp
XFILLER_313_155 VPWR VGND sg13cmos5l_decap_8
XFILLER_98_64 VPWR VGND sg13cmos5l_decap_8
XFILLER_224_18 VPWR VGND sg13cmos5l_fill_2
XANTENNA__1414__X AXI_M_SOC_WDATA12 VPWR VGND sg13cmos5l_antennanp
XFILLER_78_175 VPWR VGND sg13cmos5l_decap_8
XFILLER_304_62 VPWR VGND sg13cmos5l_fill_1
X_2060_ _2060_/Q Tile_X0Y1_FrameData[4] Tile_X0Y5_FrameStrobe[2] VPWR VGND sg13cmos5l_dlhq_1
XFILLER_93_123 VPWR VGND sg13cmos5l_decap_8
X_1011_ _1011_/X _0992_/X _0684_/X Tile_X0Y5_N4END[6] _0995_/X _2827_/Q _2828_/Q VPWR
+ VGND sg13cmos5l_mux4_1
XFILLER_34_223 VPWR VGND sg13cmos5l_decap_8
XFILLER_179_228 VPWR VGND sg13cmos5l_decap_8
XFILLER_320_50 VPWR VGND sg13cmos5l_decap_4
XANTENNA__1029__A2 Tile_X0Y5_N4END[5] VPWR VGND sg13cmos5l_antennanp
XANTENNA__1752__GATE Tile_X0Y5_FrameStrobe[1] VPWR VGND sg13cmos5l_antennanp
XANTENNA__2108__D Tile_X0Y1_FrameData[20] VPWR VGND sg13cmos5l_antennanp
X_2962_ _2962_/Q Tile_X0Y4_FrameData[14] Tile_X0Y5_FrameStrobe[5] VPWR VGND sg13cmos5l_dlhq_1
X_1913_ _1913_/Q Tile_X0Y0_FrameData[7] Tile_X0Y5_FrameStrobe[6] VPWR VGND sg13cmos5l_dlhq_1
XANTENNA__0788__A1 Tile_X0Y3_W2END[5] VPWR VGND sg13cmos5l_antennanp
XANTENNA__1947__D Tile_X0Y0_FrameData[5] VPWR VGND sg13cmos5l_antennanp
XFILLER_147_114 VPWR VGND sg13cmos5l_fill_2
XFILLER_187_283 VPWR VGND sg13cmos5l_fill_1
X_2893_ _2893_/Q Tile_X0Y4_FrameData[19] Tile_X0Y5_FrameStrobe[3] VPWR VGND sg13cmos5l_dlhq_1
XFILLER_8_51 VPWR VGND sg13cmos5l_fill_1
XANTENNA__1767__GATE Tile_X0Y5_FrameStrobe[2] VPWR VGND sg13cmos5l_antennanp
X_1844_ _1844_/Q Tile_X0Y0_FrameData[12] Tile_X0Y5_FrameStrobe[4] VPWR VGND sg13cmos5l_dlhq_1
X_1775_ _1775_/Q Tile_X0Y0_FrameData[17] Tile_X0Y5_FrameStrobe[2] VPWR VGND sg13cmos5l_dlhq_1
XANTENNA__1201__A2 Tile_X0Y0_W6END[9] VPWR VGND sg13cmos5l_antennanp
XFILLER_304_122 VPWR VGND sg13cmos5l_decap_8
X_3514_ Tile_X0Y0_N4BEG[1] _3514_/A VPWR VGND sg13cmos5l_buf_1
X_0726_ _0728_/B Tile_X0Y3_W6END[3] _2514_/Q VPWR VGND sg13cmos5l_nor2b_1
XANTENNA__2778__D Tile_X0Y3_FrameData[22] VPWR VGND sg13cmos5l_antennanp
X_3445_ Tile_X0Y1_FrameData_O[13] Tile_X0Y1_FrameData[13] VPWR VGND sg13cmos5l_buf_1
XANTENNA__0960__A1 Tile_X0Y1_WW4END[12] VPWR VGND sg13cmos5l_antennanp
XANTENNA__3804__X Tile_X0Y4_FrameData_O[26] VPWR VGND sg13cmos5l_antennanp
XFILLER_304_166 VPWR VGND sg13cmos5l_fill_2
X_0657_ _0657_/X _0645_/X _0656_/X _3265_/Q VPWR VGND sg13cmos5l_mux2_1
X_3376_ Tile_X0Y2_E6BEG[6] _3376_/A VPWR VGND sg13cmos5l_buf_1
X_0588_ _0590_/B Tile_X0Y4_W6END[0] _2792_/Q VPWR VGND sg13cmos5l_nor2b_1
XFILLER_69_153 VPWR VGND sg13cmos5l_decap_8
XFILLER_69_131 VPWR VGND sg13cmos5l_decap_4
XANTENNA__0712__A1 Tile_X0Y0_W6END[11] VPWR VGND sg13cmos5l_antennanp
XFILLER_214_40 VPWR VGND sg13cmos5l_decap_8
X_2327_ _2327_/Q Tile_X0Y2_FrameData[9] Tile_X0Y5_FrameStrobe[2] VPWR VGND sg13cmos5l_dlhq_1
XANTENNA__1705__GATE Tile_X0Y5_FrameStrobe[0] VPWR VGND sg13cmos5l_antennanp
X_2258_ _2258_/Q Tile_X0Y2_FrameData[14] Tile_X0Y5_FrameStrobe[0] VPWR VGND sg13cmos5l_dlhq_1
XFILLER_272_246 VPWR VGND sg13cmos5l_decap_4
X_1209_ AXI_M_SOC_AWADDR21 Tile_X0Y0_W1END[1] Tile_X0Y0_WW4END[13] Tile_X0Y0_WW4END[5]
+ _1041_/X _1773_/Q _1774_/Q VPWR VGND sg13cmos5l_mux4_1
X_2189_ _2189_/Q Tile_X0Y1_FrameData[3] Tile_X0Y5_FrameStrobe[6] VPWR VGND sg13cmos5l_dlhq_1
XANTENNA__2018__D Tile_X0Y1_FrameData[14] VPWR VGND sg13cmos5l_antennanp
XFILLER_240_132 VPWR VGND sg13cmos5l_decap_8
XFILLER_159_37 VPWR VGND sg13cmos5l_decap_8
XFILLER_159_48 VPWR VGND sg13cmos5l_fill_2
XFILLER_230_8 VPWR VGND sg13cmos5l_fill_2
XANTENNA__1857__D Tile_X0Y0_FrameData[31] VPWR VGND sg13cmos5l_antennanp
XANTENNA__3273__GATE Tile_X0Y5_FrameStrobe[6] VPWR VGND sg13cmos5l_antennanp
XFILLER_193_231 VPWR VGND sg13cmos5l_decap_8
XFILLER_309_29 VPWR VGND sg13cmos5l_decap_8
XANTENNA__3427__A Tile_X0Y2_FrameData[29] VPWR VGND sg13cmos5l_antennanp
XFILLER_146_191 VPWR VGND sg13cmos5l_decap_8
XANTENNA__2688__D Tile_X0Y3_FrameData[16] VPWR VGND sg13cmos5l_antennanp
XANTENNA__3288__GATE Tile_X0Y5_FrameStrobe[7] VPWR VGND sg13cmos5l_antennanp
XANTENNA__0951__A1 Tile_X0Y1_WW4END[9] VPWR VGND sg13cmos5l_antennanp
XANTENNA__3714__X Tile_X0Y3_FrameData_O[17] VPWR VGND sg13cmos5l_antennanp
XANTENNA__3211__GATE Tile_X0Y5_FrameStrobe[4] VPWR VGND sg13cmos5l_antennanp
XFILLER_68_89 VPWR VGND sg13cmos5l_decap_8
XFILLER_263_202 VPWR VGND sg13cmos5l_fill_2
XFILLER_84_22 VPWR VGND sg13cmos5l_fill_2
XFILLER_124_95 VPWR VGND sg13cmos5l_decap_8
XFILLER_263_246 VPWR VGND sg13cmos5l_fill_1
XFILLER_75_178 VPWR VGND sg13cmos5l_decap_8
XANTENNA__3312__D Tile_X0Y5_FrameData[0] VPWR VGND sg13cmos5l_antennanp
XFILLER_90_126 VPWR VGND sg13cmos5l_fill_1
XANTENNA__3226__GATE Tile_X0Y5_FrameStrobe[5] VPWR VGND sg13cmos5l_antennanp
XFILLER_17_71 VPWR VGND sg13cmos5l_fill_2
XANTENNA__2482__GATE Tile_X0Y5_FrameStrobe[7] VPWR VGND sg13cmos5l_antennanp
XANTENNA__1767__D Tile_X0Y0_FrameData[25] VPWR VGND sg13cmos5l_antennanp
XFILLER_169_294 VPWR VGND sg13cmos5l_fill_1
XANTENNA__1431__A2 Tile_X0Y2_W6END[3] VPWR VGND sg13cmos5l_antennanp
XFILLER_184_253 VPWR VGND sg13cmos5l_decap_4
XFILLER_318_258 VPWR VGND sg13cmos5l_fill_2
XANTENNA__2497__GATE Tile_X0Y5_FrameStrobe[8] VPWR VGND sg13cmos5l_antennanp
XFILLER_149_81 VPWR VGND sg13cmos5l_decap_8
XFILLER_184_275 VPWR VGND sg13cmos5l_fill_2
XFILLER_184_286 VPWR VGND sg13cmos5l_fill_1
XFILLER_69_7 VPWR VGND sg13cmos5l_decap_8
X_1560_ AXI_M_SOC_WDATA0 Tile_X0Y3_W2MID[0] Tile_X0Y3_W2END[0] Tile_X0Y3_W6END[0]
+ _1267_/X _2584_/Q _2583_/Q VPWR VGND sg13cmos5l_mux4_1
XANTENNA__1195__A1 Tile_X0Y0_W6END[5] VPWR VGND sg13cmos5l_antennanp
XANTENNA__2598__D Tile_X0Y3_FrameData[10] VPWR VGND sg13cmos5l_antennanp
XFILLER_152_150 VPWR VGND sg13cmos5l_fill_2
XANTENNA__0942__A1 Tile_X0Y1_W6END[6] VPWR VGND sg13cmos5l_antennanp
XANTENNA__2420__GATE Tile_X0Y5_FrameStrobe[5] VPWR VGND sg13cmos5l_antennanp
XANTENNA__3624__X Tile_X0Y0_E6BEG[7] VPWR VGND sg13cmos5l_antennanp
X_1491_ _3352_/A _0977_/X _0672_/X AXI_M_SOC_RDATA15 AXI_M_SOC_RDATA19 _2436_/Q _2435_/Q
+ VPWR VGND sg13cmos5l_mux4_1
XFILLER_98_215 VPWR VGND sg13cmos5l_decap_4
XANTENNA__0967__Y AXI_M_SOC_AWLEN6 VPWR VGND sg13cmos5l_antennanp
X_3230_ _3230_/Q Tile_X0Y5_FrameData[18] Tile_X0Y5_FrameStrobe[5] VPWR VGND sg13cmos5l_dlhq_1
X_3161_ _3161_/Q Tile_X0Y5_FrameData[23] Tile_X0Y5_FrameStrobe[3] VPWR VGND sg13cmos5l_dlhq_1
X_2112_ _2112_/Q Tile_X0Y1_FrameData[16] Tile_X0Y5_FrameStrobe[4] VPWR VGND sg13cmos5l_dlhq_1
XANTENNA__2435__GATE Tile_X0Y5_FrameStrobe[6] VPWR VGND sg13cmos5l_antennanp
X_3092_ _3092_/Q Tile_X0Y5_FrameData[28] Tile_X0Y5_FrameStrobe[1] VPWR VGND sg13cmos5l_dlhq_1
XANTENNA__3222__D Tile_X0Y5_FrameData[26] VPWR VGND sg13cmos5l_antennanp
XANTENNA__3800__A Tile_X0Y4_FrameData[22] VPWR VGND sg13cmos5l_antennanp
X_2043_ _2043_/Q Tile_X0Y1_FrameData[21] Tile_X0Y5_FrameStrobe[2] VPWR VGND sg13cmos5l_dlhq_1
XFILLER_200_53 VPWR VGND sg13cmos5l_decap_8
XFILLER_22_248 VPWR VGND sg13cmos5l_fill_2
XFILLER_95_0 VPWR VGND sg13cmos5l_fill_2
X_2945_ _2945_/Q Tile_X0Y4_FrameData[31] Tile_X0Y5_FrameStrobe[5] VPWR VGND sg13cmos5l_dlhq_1
XANTENNA__1422__A2 Tile_X0Y2_W6END[7] VPWR VGND sg13cmos5l_antennanp
XFILLER_175_231 VPWR VGND sg13cmos5l_decap_8
XFILLER_276_24 VPWR VGND sg13cmos5l_fill_2
XFILLER_276_35 VPWR VGND sg13cmos5l_fill_1
XFILLER_30_281 VPWR VGND sg13cmos5l_fill_2
X_2876_ _2876_/Q Tile_X0Y4_FrameData[4] Tile_X0Y5_FrameStrobe[2] VPWR VGND sg13cmos5l_dlhq_1
X_1827_ _1827_/Q Tile_X0Y0_FrameData[29] Tile_X0Y5_FrameStrobe[4] VPWR VGND sg13cmos5l_dlhq_1
XANTENNA__1186__A1 Tile_X0Y4_W2END[4] VPWR VGND sg13cmos5l_antennanp
XFILLER_190_278 VPWR VGND sg13cmos5l_fill_2
X_1758_ _1758_/Q Tile_X0Y0_FrameData[2] Tile_X0Y5_FrameStrobe[1] VPWR VGND sg13cmos5l_dlhq_1
XANTENNA__0933__A1 Tile_X0Y5_WW4END[2] VPWR VGND sg13cmos5l_antennanp
XANTENNA__2301__D Tile_X0Y2_FrameData[3] VPWR VGND sg13cmos5l_antennanp
XANTENNA__3534__X Tile_X0Y0_N2BEGb[5] VPWR VGND sg13cmos5l_antennanp
X_1689_ _1689_/X _1011_/X _1012_/X _1013_/X _1360_/X _2990_/Q _2989_/Q VPWR VGND sg13cmos5l_mux4_1
X_0709_ _0709_/Y _1969_/Q Tile_X0Y0_W6END[3] VPWR VGND sg13cmos5l_nand2b_1
X_3428_ Tile_X0Y2_FrameData_O[30] Tile_X0Y2_FrameData[30] VPWR VGND sg13cmos5l_buf_1
X_3359_ Tile_X0Y2_E2BEG[5] _3359_/A VPWR VGND sg13cmos5l_buf_1
XANTENNA__0697__A0 Tile_X0Y5_N1END[2] VPWR VGND sg13cmos5l_antennanp
XFILLER_245_224 VPWR VGND sg13cmos5l_fill_1
XFILLER_245_246 VPWR VGND sg13cmos5l_decap_4
XFILLER_57_178 VPWR VGND sg13cmos5l_fill_1
XFILLER_57_167 VPWR VGND sg13cmos5l_decap_8
XFILLER_57_145 VPWR VGND sg13cmos5l_fill_1
XANTENNA__0893__X AXI_M_SOC_WSTRB3 VPWR VGND sg13cmos5l_antennanp
XANTENNA__3132__D Tile_X0Y5_FrameData[20] VPWR VGND sg13cmos5l_antennanp
XANTENNA__3710__A Tile_X0Y3_FrameData[13] VPWR VGND sg13cmos5l_antennanp
XFILLER_241_60 VPWR VGND sg13cmos5l_fill_2
XFILLER_54_25 VPWR VGND sg13cmos5l_decap_8
XANTENNA__2971__D Tile_X0Y4_FrameData[5] VPWR VGND sg13cmos5l_antennanp
XFILLER_80_181 VPWR VGND sg13cmos5l_decap_8
XANTENNA__3709__X Tile_X0Y3_FrameData_O[12] VPWR VGND sg13cmos5l_antennanp
XFILLER_9_208 VPWR VGND sg13cmos5l_decap_8
XFILLER_70_35 VPWR VGND sg13cmos5l_fill_1
XANTENNA__1413__A2 Tile_X0Y2_W6END[0] VPWR VGND sg13cmos5l_antennanp
XFILLER_119_40 VPWR VGND sg13cmos5l_decap_8
XFILLER_181_234 VPWR VGND sg13cmos5l_fill_1
XFILLER_181_245 VPWR VGND sg13cmos5l_fill_1
XFILLER_308_280 VPWR VGND sg13cmos5l_fill_1
XFILLER_315_217 VPWR VGND sg13cmos5l_decap_4
XANTENNA__1177__A1 Tile_X0Y1_W2MID[0] VPWR VGND sg13cmos5l_antennanp
XANTENNA__2211__D Tile_X0Y1_FrameData[13] VPWR VGND sg13cmos5l_antennanp
XANTENNA__3307__D Tile_X0Y5_FrameData[5] VPWR VGND sg13cmos5l_antennanp
XANTENNA__3444__X Tile_X0Y1_FrameData_O[12] VPWR VGND sg13cmos5l_antennanp
XFILLER_79_77 VPWR VGND sg13cmos5l_decap_8
XANTENNA__3150__GATE Tile_X0Y5_FrameStrobe[2] VPWR VGND sg13cmos5l_antennanp
XFILLER_295_135 VPWR VGND sg13cmos5l_decap_4
XFILLER_297_0 VPWR VGND sg13cmos5l_fill_2
XFILLER_95_21 VPWR VGND sg13cmos5l_decap_8
XFILLER_135_94 VPWR VGND sg13cmos5l_decap_8
XFILLER_48_112 VPWR VGND sg13cmos5l_decap_8
XFILLER_95_98 VPWR VGND sg13cmos5l_decap_8
XANTENNA__3042__D Tile_X0Y4_FrameData[30] VPWR VGND sg13cmos5l_antennanp
XANTENNA__3165__GATE Tile_X0Y5_FrameStrobe[3] VPWR VGND sg13cmos5l_antennanp
XFILLER_28_92 VPWR VGND sg13cmos5l_decap_8
XFILLER_63_115 VPWR VGND sg13cmos5l_decap_8
XFILLER_48_189 VPWR VGND sg13cmos5l_decap_8
XANTENNA__1101__A1 Tile_X0Y1_W2END[6] VPWR VGND sg13cmos5l_antennanp
XANTENNA__2881__D Tile_X0Y4_FrameData[31] VPWR VGND sg13cmos5l_antennanp
XANTENNA__1652__A2 Tile_X0Y4_WW4END[14] VPWR VGND sg13cmos5l_antennanp
XANTENNA__3619__X Tile_X0Y0_E6BEG[2] VPWR VGND sg13cmos5l_antennanp
X_0991_ _0991_/Y _3059_/Q _0989_/Y _0990_/Y VPWR VGND sg13cmos5l_o21ai_1
X_2730_ _2730_/Q Tile_X0Y3_FrameData[6] Tile_X0Y5_FrameStrobe[6] VPWR VGND sg13cmos5l_dlhq_1
XANTENNA__3103__GATE Tile_X0Y5_FrameStrobe[1] VPWR VGND sg13cmos5l_antennanp
X_2661_ _2661_/Q Tile_X0Y3_FrameData[11] Tile_X0Y5_FrameStrobe[4] VPWR VGND sg13cmos5l_dlhq_1
XFILLER_172_223 VPWR VGND sg13cmos5l_decap_8
X_1612_ _3769_/A Tile_X0Y4_WW4END[8] _1063_/X AXI_M_SOC_RDATA5 _1073_/X _2929_/Q _2930_/Q
+ VPWR VGND sg13cmos5l_mux4_1
XANTENNA__1168__A1 Tile_X0Y0_WW4END[0] VPWR VGND sg13cmos5l_antennanp
X_2592_ _2592_/Q Tile_X0Y3_FrameData[16] Tile_X0Y5_FrameStrobe[2] VPWR VGND sg13cmos5l_dlhq_1
XANTENNA__3217__D Tile_X0Y5_FrameData[31] VPWR VGND sg13cmos5l_antennanp
XANTENNA__3354__X Tile_X0Y2_E2BEG[0] VPWR VGND sg13cmos5l_antennanp
X_1543_ AXI_M_SOC_ARADDR24 Tile_X0Y3_WW4END[0] Tile_X0Y3_WW4END[8] Tile_X0Y3_W6END[0]
+ _1539_/X _2616_/Q _2615_/Q VPWR VGND sg13cmos5l_mux4_1
XANTENNA__2121__D Tile_X0Y1_FrameData[7] VPWR VGND sg13cmos5l_antennanp
XANTENNA__3118__GATE Tile_X0Y5_FrameStrobe[1] VPWR VGND sg13cmos5l_antennanp
XFILLER_140_131 VPWR VGND sg13cmos5l_decap_8
XFILLER_286_102 VPWR VGND sg13cmos5l_fill_2
X_1474_ _3393_/A Tile_X0Y2_WW4END[4] _1312_/X AXI_M_SOC_RDATA18 _1191_/X _2377_/Q
+ _2378_/Q VPWR VGND sg13cmos5l_mux4_1
X_3213_ _3213_/Q Tile_X0Y5_FrameData[3] Tile_X0Y5_FrameStrobe[4] VPWR VGND sg13cmos5l_dlhq_1
XANTENNA__1960__D Tile_X0Y0_FrameData[24] VPWR VGND sg13cmos5l_antennanp
XANTENNA__2374__GATE Tile_X0Y5_FrameStrobe[4] VPWR VGND sg13cmos5l_antennanp
XANTENNA__1340__A1 AXI_M_SOC_RDATA26 VPWR VGND sg13cmos5l_antennanp
XFILLER_10_0 VPWR VGND sg13cmos5l_fill_2
X_3144_ _3144_/Q Tile_X0Y5_FrameData[8] Tile_X0Y5_FrameStrobe[2] VPWR VGND sg13cmos5l_dlhq_1
XFILLER_39_167 VPWR VGND sg13cmos5l_fill_2
XFILLER_39_145 VPWR VGND sg13cmos5l_decap_8
XFILLER_227_257 VPWR VGND sg13cmos5l_fill_1
XFILLER_227_279 VPWR VGND sg13cmos5l_fill_2
X_3075_ _3075_/Q Tile_X0Y5_FrameData[13] Tile_X0Y5_FrameStrobe[0] VPWR VGND sg13cmos5l_dlhq_1
X_2026_ _2026_/Q Tile_X0Y1_FrameData[6] Tile_X0Y5_FrameStrobe[1] VPWR VGND sg13cmos5l_dlhq_1
XANTENNA__2389__GATE Tile_X0Y5_FrameStrobe[4] VPWR VGND sg13cmos5l_antennanp
XANTENNA__2791__D Tile_X0Y4_FrameData[25] VPWR VGND sg13cmos5l_antennanp
XANTENNA__1643__A2 Tile_X0Y4_W6END[11] VPWR VGND sg13cmos5l_antennanp
XFILLER_24_39 VPWR VGND sg13cmos5l_decap_8
XFILLER_250_293 VPWR VGND sg13cmos5l_fill_2
XANTENNA__2312__GATE Tile_X0Y5_FrameStrobe[2] VPWR VGND sg13cmos5l_antennanp
XANTENNA__3529__X Tile_X0Y0_N2BEGb[0] VPWR VGND sg13cmos5l_antennanp
X_2928_ _2928_/Q Tile_X0Y4_FrameData[16] Tile_X0Y5_FrameStrobe[4] VPWR VGND sg13cmos5l_dlhq_1
XANTENNA__0603__A0 Tile_X0Y5_W1END[0] VPWR VGND sg13cmos5l_antennanp
XANTENNA__2942__GATE Tile_X0Y5_FrameStrobe[4] VPWR VGND sg13cmos5l_antennanp
XFILLER_163_212 VPWR VGND sg13cmos5l_fill_2
X_2859_ _2859_/Q Tile_X0Y4_FrameData[21] Tile_X0Y5_FrameStrobe[2] VPWR VGND sg13cmos5l_dlhq_1
XANTENNA__1159__A1 AXI_M_SOC_ARREADY VPWR VGND sg13cmos5l_antennanp
XANTENNA__2327__GATE Tile_X0Y5_FrameStrobe[2] VPWR VGND sg13cmos5l_antennanp
XFILLER_123_109 VPWR VGND sg13cmos5l_decap_8
XFILLER_156_49 VPWR VGND sg13cmos5l_decap_8
XFILLER_163_245 VPWR VGND sg13cmos5l_decap_8
XANTENNA__0906__A1 Tile_X0Y1_W6END[3] VPWR VGND sg13cmos5l_antennanp
XANTENNA__2957__GATE Tile_X0Y5_FrameStrobe[5] VPWR VGND sg13cmos5l_antennanp
XANTENNA__3127__D Tile_X0Y5_FrameData[25] VPWR VGND sg13cmos5l_antennanp
XANTENNA__2031__D Tile_X0Y1_FrameData[1] VPWR VGND sg13cmos5l_antennanp
XANTENNA__3705__A Tile_X0Y3_FrameData[8] VPWR VGND sg13cmos5l_antennanp
XFILLER_131_120 VPWR VGND sg13cmos5l_fill_1
XFILLER_236_82 VPWR VGND sg13cmos5l_decap_8
XANTENNA__2966__D Tile_X0Y4_FrameData[10] VPWR VGND sg13cmos5l_antennanp
XFILLER_172_15 VPWR VGND sg13cmos5l_fill_1
XFILLER_172_26 VPWR VGND sg13cmos5l_fill_1
XFILLER_277_157 VPWR VGND sg13cmos5l_fill_2
XFILLER_77_218 VPWR VGND sg13cmos5l_fill_1
XFILLER_49_47 VPWR VGND sg13cmos5l_decap_8
XFILLER_320_264 VPWR VGND sg13cmos5l_fill_2
XFILLER_320_253 VPWR VGND sg13cmos5l_fill_1
XANTENNA__1870__D Tile_X0Y0_FrameData[18] VPWR VGND sg13cmos5l_antennanp
XFILLER_218_202 VPWR VGND sg13cmos5l_fill_1
XFILLER_105_53 VPWR VGND sg13cmos5l_decap_8
XFILLER_105_64 VPWR VGND sg13cmos5l_fill_2
XFILLER_322_29 VPWR VGND sg13cmos5l_fill_1
XFILLER_65_57 VPWR VGND sg13cmos5l_decap_4
XFILLER_65_46 VPWR VGND sg13cmos5l_fill_1
XFILLER_45_126 VPWR VGND sg13cmos5l_decap_8
XANTENNA__3440__A Tile_X0Y1_FrameData[8] VPWR VGND sg13cmos5l_antennanp
XFILLER_65_79 VPWR VGND sg13cmos5l_fill_2
XANTENNA__1095__A0 Tile_X0Y0_W1END[0] VPWR VGND sg13cmos5l_antennanp
XANTENNA__1634__A2 Tile_X0Y4_WW4END[10] VPWR VGND sg13cmos5l_antennanp
XFILLER_121_63 VPWR VGND sg13cmos5l_fill_1
XFILLER_201_102 VPWR VGND sg13cmos5l_decap_8
XFILLER_60_129 VPWR VGND sg13cmos5l_decap_8
XANTENNA__0842__A0 Tile_X0Y5_W1END[1] VPWR VGND sg13cmos5l_antennanp
XFILLER_198_164 VPWR VGND sg13cmos5l_decap_8
XFILLER_241_293 VPWR VGND sg13cmos5l_fill_2
XANTENNA__2206__D Tile_X0Y1_FrameData[18] VPWR VGND sg13cmos5l_antennanp
XANTENNA__3439__X Tile_X0Y1_FrameData_O[7] VPWR VGND sg13cmos5l_antennanp
XFILLER_212_0 VPWR VGND sg13cmos5l_fill_2
XANTENNA__3037__D Tile_X0Y4_FrameData[3] VPWR VGND sg13cmos5l_antennanp
XFILLER_107_161 VPWR VGND sg13cmos5l_decap_8
XFILLER_30_71 VPWR VGND sg13cmos5l_fill_1
XANTENNA__2876__D Tile_X0Y4_FrameData[4] VPWR VGND sg13cmos5l_antennanp
XANTENNA__1780__D Tile_X0Y0_FrameData[12] VPWR VGND sg13cmos5l_antennanp
XANTENNA__3902__X Tile_X0Y5_S2BEG[7] VPWR VGND sg13cmos5l_antennanp
XFILLER_122_197 VPWR VGND sg13cmos5l_fill_2
XANTENNA__1322__A1 AXI_M_SOC_RDATA23 VPWR VGND sg13cmos5l_antennanp
X_1190_ _1190_/X Tile_X0Y1_W1END[0] Tile_X0Y1_W2MID[3] Tile_X0Y1_W2END[3] _1089_/X
+ _2188_/Q _2187_/Q VPWR VGND sg13cmos5l_mux4_1
XFILLER_76_251 VPWR VGND sg13cmos5l_decap_8
XFILLER_76_262 VPWR VGND sg13cmos5l_fill_2
XANTENNA__1422__X AXI_M_SOC_WDATA15 VPWR VGND sg13cmos5l_antennanp
XFILLER_91_254 VPWR VGND sg13cmos5l_fill_2
XFILLER_224_249 VPWR VGND sg13cmos5l_decap_4
X_3900_ Tile_X0Y5_S2BEG[5] _3900_/A VPWR VGND sg13cmos5l_buf_1
XFILLER_189_186 VPWR VGND sg13cmos5l_decap_4
XFILLER_232_293 VPWR VGND sg13cmos5l_fill_2
X_3831_ Tile_X0Y5_E6BEG[0] _3831_/A VPWR VGND sg13cmos5l_buf_1
XANTENNA__2116__D Tile_X0Y1_FrameData[12] VPWR VGND sg13cmos5l_antennanp
X_3762_ Tile_X0Y4_EE4BEG[0] _3762_/A VPWR VGND sg13cmos5l_buf_1
XANTENNA__1389__A1 Tile_X0Y2_W6END[9] VPWR VGND sg13cmos5l_antennanp
XANTENNA__3042__GATE Tile_X0Y5_FrameStrobe[8] VPWR VGND sg13cmos5l_antennanp
X_0974_ _3897_/A Tile_X0Y5_W2MID[5] Tile_X0Y5_W2END[5] Tile_X0Y5_W6END[10] _0790_/X
+ _3280_/Q _3279_/Q VPWR VGND sg13cmos5l_mux4_1
XFILLER_72_2 VPWR VGND sg13cmos5l_fill_1
XANTENNA__1955__D Tile_X0Y0_FrameData[29] VPWR VGND sg13cmos5l_antennanp
XFILLER_145_212 VPWR VGND sg13cmos5l_decap_8
XFILLER_145_223 VPWR VGND sg13cmos5l_fill_2
X_2713_ _2713_/Q Tile_X0Y3_FrameData[23] Tile_X0Y5_FrameStrobe[6] VPWR VGND sg13cmos5l_dlhq_1
X_3693_ Tile_X0Y3_EE4BEG[12] _3693_/A VPWR VGND sg13cmos5l_buf_1
X_2644_ _2644_/Q Tile_X0Y3_FrameData[28] Tile_X0Y5_FrameStrobe[4] VPWR VGND sg13cmos5l_dlhq_1
XANTENNA__3057__GATE Tile_X0Y5_FrameStrobe[0] VPWR VGND sg13cmos5l_antennanp
XFILLER_273_14 VPWR VGND sg13cmos5l_fill_2
X_2575_ _2575_/Q Tile_X0Y3_FrameData[1] Tile_X0Y5_FrameStrobe[1] VPWR VGND sg13cmos5l_dlhq_1
XFILLER_58_0 VPWR VGND sg13cmos5l_fill_1
XFILLER_337_81 VPWR VGND sg13cmos5l_fill_2
X_1526_ _1526_/X _1119_/X _0724_/X Tile_X0Y5_N4END[11] Tile_X0Y0_S4END[15] _2561_/Q
+ _2562_/Q VPWR VGND sg13cmos5l_mux4_1
XANTENNA__1561__A1 Tile_X0Y3_WW4END[10] VPWR VGND sg13cmos5l_antennanp
XANTENNA__2786__D Tile_X0Y4_FrameData[30] VPWR VGND sg13cmos5l_antennanp
XFILLER_113_153 VPWR VGND sg13cmos5l_decap_8
XFILLER_206_41 VPWR VGND sg13cmos5l_decap_8
XFILLER_299_293 VPWR VGND sg13cmos5l_fill_2
XANTENNA__3812__X Tile_X0Y5_E1BEG[1] VPWR VGND sg13cmos5l_antennanp
XFILLER_113_186 VPWR VGND sg13cmos5l_fill_1
XFILLER_19_17 VPWR VGND sg13cmos5l_decap_4
XFILLER_274_116 VPWR VGND sg13cmos5l_fill_1
X_1457_ _3358_/A Tile_X0Y2_W2MID[3] AXI_M_SOC_RDATA18 _1187_/X _1191_/X _2424_/Q _2423_/Q
+ VPWR VGND sg13cmos5l_mux4_1
X_1388_ _1388_/X _1018_/X _0623_/X Tile_X0Y5_N4END[13] Tile_X0Y0_S4END[9] _2293_/Q
+ _2294_/Q VPWR VGND sg13cmos5l_mux4_1
X_3127_ _3127_/Q Tile_X0Y5_FrameData[25] Tile_X0Y5_FrameStrobe[2] VPWR VGND sg13cmos5l_dlhq_1
XFILLER_82_210 VPWR VGND sg13cmos5l_decap_4
XFILLER_27_148 VPWR VGND sg13cmos5l_decap_8
XFILLER_35_16 VPWR VGND sg13cmos5l_fill_1
XANTENNA__1077__A0 Tile_X0Y1_W2MID[3] VPWR VGND sg13cmos5l_antennanp
X_3058_ _3058_/Q Tile_X0Y5_FrameData[30] Tile_X0Y5_FrameStrobe[0] VPWR VGND sg13cmos5l_dlhq_1
X_2009_ _2009_/Q Tile_X0Y1_FrameData[23] Tile_X0Y5_FrameStrobe[1] VPWR VGND sg13cmos5l_dlhq_1
XANTENNA__0824__A0 Tile_X0Y5_N4END[0] VPWR VGND sg13cmos5l_antennanp
XANTENNA__2251__GATE Tile_X0Y5_FrameStrobe[0] VPWR VGND sg13cmos5l_antennanp
XFILLER_195_101 VPWR VGND sg13cmos5l_decap_8
XFILLER_223_293 VPWR VGND sg13cmos5l_fill_2
XANTENNA__2026__D Tile_X0Y1_FrameData[6] VPWR VGND sg13cmos5l_antennanp
XANTENNA__2881__GATE Tile_X0Y5_FrameStrobe[3] VPWR VGND sg13cmos5l_antennanp
XFILLER_136_7 VPWR VGND sg13cmos5l_decap_8
XFILLER_167_26 VPWR VGND sg13cmos5l_fill_1
XFILLER_50_195 VPWR VGND sg13cmos5l_decap_8
XANTENNA__1865__D Tile_X0Y0_FrameData[23] VPWR VGND sg13cmos5l_antennanp
XANTENNA__2266__GATE Tile_X0Y5_FrameStrobe[0] VPWR VGND sg13cmos5l_antennanp
XFILLER_136_201 VPWR VGND sg13cmos5l_fill_1
XANTENNA__2896__GATE Tile_X0Y5_FrameStrobe[3] VPWR VGND sg13cmos5l_antennanp
XFILLER_337_194 VPWR VGND sg13cmos5l_fill_2
XFILLER_136_278 VPWR VGND sg13cmos5l_fill_2
XFILLER_2_203 VPWR VGND sg13cmos5l_fill_2
XANTENNA__3435__A Tile_X0Y1_FrameData[3] VPWR VGND sg13cmos5l_antennanp
XFILLER_183_47 VPWR VGND sg13cmos5l_decap_8
XANTENNA__1552__A1 Tile_X0Y3_WW4END[14] VPWR VGND sg13cmos5l_antennanp
XANTENNA__2696__D Tile_X0Y3_FrameData[8] VPWR VGND sg13cmos5l_antennanp
XANTENNA__3722__X Tile_X0Y3_FrameData_O[25] VPWR VGND sg13cmos5l_antennanp
XFILLER_116_74 VPWR VGND sg13cmos5l_decap_8
XANTENNA__2204__GATE Tile_X0Y5_FrameStrobe[7] VPWR VGND sg13cmos5l_antennanp
XANTENNA__2834__GATE Tile_X0Y5_FrameStrobe[1] VPWR VGND sg13cmos5l_antennanp
XANTENNA__3320__D Tile_X0Y5_FrameData[24] VPWR VGND sg13cmos5l_antennanp
XFILLER_92_77 VPWR VGND sg13cmos5l_decap_8
XANTENNA__0815__A0 Tile_X0Y5_WW4END[8] VPWR VGND sg13cmos5l_antennanp
XANTENNA__2219__GATE Tile_X0Y5_FrameStrobe[7] VPWR VGND sg13cmos5l_antennanp
XANTENNA__2849__GATE Tile_X0Y5_FrameStrobe[2] VPWR VGND sg13cmos5l_antennanp
XFILLER_214_293 VPWR VGND sg13cmos5l_fill_2
XANTENNA__1083__A3 Tile_X0Y0_S2MID[6] VPWR VGND sg13cmos5l_antennanp
XFILLER_25_93 VPWR VGND sg13cmos5l_decap_8
XFILLER_41_195 VPWR VGND sg13cmos5l_fill_1
XANTENNA__1775__D Tile_X0Y0_FrameData[17] VPWR VGND sg13cmos5l_antennanp
XFILLER_328_161 VPWR VGND sg13cmos5l_fill_2
XANTENNA__1240__A0 AXI_M_SOC_BRESP1 VPWR VGND sg13cmos5l_antennanp
X_0690_ _0990_/B Tile_X0Y4_W1END[2] _1013_/X Tile_X0Y4_W6END[10] _0689_/X _3015_/Q
+ _3016_/Q VPWR VGND sg13cmos5l_mux4_1
XANTENNA__0594__A2 Tile_X0Y1_WW4END[12] VPWR VGND sg13cmos5l_antennanp
XFILLER_51_7 VPWR VGND sg13cmos5l_decap_8
XANTENNA__1417__X AXI_M_SOC_WDATA20 VPWR VGND sg13cmos5l_antennanp
XANTENNA__1543__A1 Tile_X0Y3_WW4END[8] VPWR VGND sg13cmos5l_antennanp
X_2360_ _2360_/Q Tile_X0Y2_FrameData[8] Tile_X0Y5_FrameStrobe[3] VPWR VGND sg13cmos5l_dlhq_1
XANTENNA__3632__X Tile_X0Y0_E2BEGb[3] VPWR VGND sg13cmos5l_antennanp
XFILLER_243_28 VPWR VGND sg13cmos5l_fill_2
X_2291_ _2291_/Q Tile_X0Y2_FrameData[13] Tile_X0Y5_FrameStrobe[1] VPWR VGND sg13cmos5l_dlhq_1
X_1311_ AXI_M_SOC_AWADDR5 Tile_X0Y1_W2MID[5] Tile_X0Y1_W2END[5] Tile_X0Y1_W6END[5]
+ _1086_/X _2030_/Q _2029_/Q VPWR VGND sg13cmos5l_mux4_1
XFILLER_110_145 VPWR VGND sg13cmos5l_decap_4
X_1242_ _3620_/A _0984_/X _1069_/X Tile_X0Y0_S4END[3] _1074_/X _1817_/Q _1818_/Q VPWR
+ VGND sg13cmos5l_mux4_1
XFILLER_49_240 VPWR VGND sg13cmos5l_fill_2
XFILLER_110_167 VPWR VGND sg13cmos5l_decap_8
XFILLER_2_64 VPWR VGND sg13cmos5l_fill_1
X_1173_ _1173_/X Tile_X0Y1_W1END[2] Tile_X0Y1_W2MID[1] Tile_X0Y1_W2END[1] _1083_/X
+ _2184_/Q _2183_/Q VPWR VGND sg13cmos5l_mux4_1
XANTENNA__1059__A0 Tile_X0Y0_W6END[4] VPWR VGND sg13cmos5l_antennanp
XANTENNA__3230__D Tile_X0Y5_FrameData[18] VPWR VGND sg13cmos5l_antennanp
XANTENNA__0806__A0 Tile_X0Y5_W2END[1] VPWR VGND sg13cmos5l_antennanp
XANTENNA__1074__A3 Tile_X0Y0_S4END[0] VPWR VGND sg13cmos5l_antennanp
XFILLER_177_145 VPWR VGND sg13cmos5l_fill_2
XFILLER_177_178 VPWR VGND sg13cmos5l_decap_8
X_3814_ Tile_X0Y5_E1BEG[3] _3814_/A VPWR VGND sg13cmos5l_buf_1
X_3745_ Tile_X0Y4_E2BEGb[3] _3745_/A VPWR VGND sg13cmos5l_buf_1
X_0957_ _0957_/X Tile_X0Y1_WW4END[3] Tile_X0Y1_W6END[11] Tile_X0Y1_WW4END[11] _0956_/X
+ _2049_/Q _2050_/Q VPWR VGND sg13cmos5l_mux4_1
XFILLER_319_161 VPWR VGND sg13cmos5l_decap_4
XANTENNA__1231__A0 Tile_X0Y0_WW4END[0] VPWR VGND sg13cmos5l_antennanp
XANTENNA__3807__X Tile_X0Y4_FrameData_O[29] VPWR VGND sg13cmos5l_antennanp
XFILLER_137_29 VPWR VGND sg13cmos5l_decap_8
XFILLER_118_267 VPWR VGND sg13cmos5l_fill_2
XFILLER_284_46 VPWR VGND sg13cmos5l_fill_1
X_3676_ Tile_X0Y3_E6BEG[7] _3676_/A VPWR VGND sg13cmos5l_buf_1
X_0888_ _0888_/X _0987_/X _0678_/X Tile_X0Y5_N4END[10] Tile_X0Y0_S4END[14] _2539_/Q
+ _2540_/Q VPWR VGND sg13cmos5l_mux4_1
X_2627_ _2627_/Q Tile_X0Y3_FrameData[13] Tile_X0Y5_FrameStrobe[3] VPWR VGND sg13cmos5l_dlhq_1
XFILLER_217_62 VPWR VGND sg13cmos5l_fill_2
X_2558_ _2558_/Q Tile_X0Y3_FrameData[18] Tile_X0Y5_FrameStrobe[1] VPWR VGND sg13cmos5l_dlhq_1
XANTENNA__0888__A3 Tile_X0Y0_S4END[14] VPWR VGND sg13cmos5l_antennanp
X_2489_ _2489_/Q Tile_X0Y2_FrameData[7] Tile_X0Y5_FrameStrobe[7] VPWR VGND sg13cmos5l_dlhq_1
X_1509_ _3664_/A Tile_X0Y3_W2END[4] AXI_M_SOC_RDATA10 _1587_/B _1271_/X _2682_/Q _2681_/Q
+ VPWR VGND sg13cmos5l_mux4_1
XANTENNA__3542__X Tile_X0Y0_N2BEG[5] VPWR VGND sg13cmos5l_antennanp
XFILLER_141_292 VPWR VGND sg13cmos5l_fill_2
XFILLER_287_285 VPWR VGND sg13cmos5l_fill_2
XANTENNA__1298__A0 AXI_M_SOC_RDATA22 VPWR VGND sg13cmos5l_antennanp
XFILLER_101_167 VPWR VGND sg13cmos5l_decap_8
XFILLER_255_160 VPWR VGND sg13cmos5l_decap_8
XFILLER_255_171 VPWR VGND sg13cmos5l_fill_2
XFILLER_55_210 VPWR VGND sg13cmos5l_decap_8
XANTENNA__2190__GATE Tile_X0Y5_FrameStrobe[6] VPWR VGND sg13cmos5l_antennanp
XANTENNA__3140__D Tile_X0Y5_FrameData[12] VPWR VGND sg13cmos5l_antennanp
XFILLER_102_54 VPWR VGND sg13cmos5l_decap_8
XFILLER_23_140 VPWR VGND sg13cmos5l_decap_8
XFILLER_62_14 VPWR VGND sg13cmos5l_decap_8
XANTENNA__1470__A0 Tile_X0Y2_WW4END[2] VPWR VGND sg13cmos5l_antennanp
XFILLER_328_39 VPWR VGND sg13cmos5l_fill_2
XANTENNA__3717__X Tile_X0Y3_FrameData_O[20] VPWR VGND sg13cmos5l_antennanp
XFILLER_124_215 VPWR VGND sg13cmos5l_decap_8
XFILLER_11_73 VPWR VGND sg13cmos5l_fill_1
XANTENNA__3315__D Tile_X0Y5_FrameData[29] VPWR VGND sg13cmos5l_antennanp
XFILLER_132_270 VPWR VGND sg13cmos5l_fill_2
XFILLER_278_274 VPWR VGND sg13cmos5l_fill_2
XANTENNA__2143__GATE Tile_X0Y5_FrameStrobe[5] VPWR VGND sg13cmos5l_antennanp
XANTENNA__3452__X Tile_X0Y1_FrameData_O[20] VPWR VGND sg13cmos5l_antennanp
XFILLER_132_292 VPWR VGND sg13cmos5l_fill_2
XANTENNA__1289__A0 Tile_X0Y1_WW4END[6] VPWR VGND sg13cmos5l_antennanp
XANTENNA__2773__GATE Tile_X0Y5_FrameStrobe[8] VPWR VGND sg13cmos5l_antennanp
XFILLER_246_160 VPWR VGND sg13cmos5l_decap_4
XANTENNA__2158__GATE Tile_X0Y5_FrameStrobe[5] VPWR VGND sg13cmos5l_antennanp
XANTENNA__3050__D Tile_X0Y4_FrameData[22] VPWR VGND sg13cmos5l_antennanp
XFILLER_36_81 VPWR VGND sg13cmos5l_fill_2
XANTENNA__2788__GATE Tile_X0Y5_FrameStrobe[0] VPWR VGND sg13cmos5l_antennanp
XFILLER_61_268 VPWR VGND sg13cmos5l_fill_1
XFILLER_61_257 VPWR VGND sg13cmos5l_decap_8
XANTENNA__1461__A0 Tile_X0Y2_W2END[2] VPWR VGND sg13cmos5l_antennanp
XFILLER_159_145 VPWR VGND sg13cmos5l_decap_8
X_1860_ _1860_/Q Tile_X0Y0_FrameData[28] Tile_X0Y5_FrameStrobe[5] VPWR VGND sg13cmos5l_dlhq_1
XANTENNA__2711__GATE Tile_X0Y5_FrameStrobe[6] VPWR VGND sg13cmos5l_antennanp
X_1791_ _1791_/Q Tile_X0Y0_FrameData[1] Tile_X0Y5_FrameStrobe[2] VPWR VGND sg13cmos5l_dlhq_1
X_0811_ _3846_/A Tile_X0Y5_WW4END[12] _0596_/X _0759_/X _0607_/X _3209_/Q _3210_/Q
+ VPWR VGND sg13cmos5l_mux4_1
XANTENNA__1213__A0 Tile_X0Y0_W2MID[7] VPWR VGND sg13cmos5l_antennanp
XANTENNA__3627__X Tile_X0Y0_E6BEG[10] VPWR VGND sg13cmos5l_antennanp
X_3530_ Tile_X0Y0_N2BEGb[1] _3530_/A VPWR VGND sg13cmos5l_buf_1
X_0742_ _0742_/X Tile_X0Y5_N1END[3] Tile_X0Y5_N4END[3] _1133_/B _0739_/X _3090_/Q
+ _3089_/Q VPWR VGND sg13cmos5l_mux4_1
XFILLER_316_164 VPWR VGND sg13cmos5l_fill_1
XANTENNA__2726__GATE Tile_X0Y5_FrameStrobe[6] VPWR VGND sg13cmos5l_antennanp
X_3461_ Tile_X0Y1_FrameData_O[29] Tile_X0Y1_FrameData[29] VPWR VGND sg13cmos5l_buf_1
X_0673_ _0673_/Y _2244_/Q _2243_/Q VPWR VGND sg13cmos5l_nor2b_1
XANTENNA__1516__A1 AXI_M_SOC_RDATA7 VPWR VGND sg13cmos5l_antennanp
XFILLER_115_259 VPWR VGND sg13cmos5l_decap_4
X_2412_ _2412_/Q Tile_X0Y2_FrameData[20] Tile_X0Y5_FrameStrobe[5] VPWR VGND sg13cmos5l_dlhq_1
X_3392_ Tile_X0Y2_EE4BEG[10] _3392_/A VPWR VGND sg13cmos5l_buf_1
XFILLER_331_145 VPWR VGND sg13cmos5l_fill_1
XANTENNA__1982__GATE Tile_X0Y5_FrameStrobe[0] VPWR VGND sg13cmos5l_antennanp
XANTENNA__3225__D Tile_X0Y5_FrameData[23] VPWR VGND sg13cmos5l_antennanp
X_2343_ _2343_/Q Tile_X0Y2_FrameData[25] Tile_X0Y5_FrameStrobe[3] VPWR VGND sg13cmos5l_dlhq_1
XANTENNA__3362__X Tile_X0Y2_E2BEGb[0] VPWR VGND sg13cmos5l_antennanp
XANTENNA__3803__A Tile_X0Y4_FrameData[25] VPWR VGND sg13cmos5l_antennanp
XFILLER_229_105 VPWR VGND sg13cmos5l_decap_4
XFILLER_269_274 VPWR VGND sg13cmos5l_decap_4
XFILLER_334_71 VPWR VGND sg13cmos5l_fill_1
XFILLER_284_255 VPWR VGND sg13cmos5l_decap_4
X_2274_ _2274_/Q Tile_X0Y2_FrameData[30] Tile_X0Y5_FrameStrobe[1] VPWR VGND sg13cmos5l_dlhq_1
XFILLER_96_165 VPWR VGND sg13cmos5l_decap_8
XFILLER_203_31 VPWR VGND sg13cmos5l_decap_8
X_1225_ _3604_/A Tile_X0Y0_WW4END[12] AXI_M_SOC_BVALID _1074_/X _1078_/X _1850_/Q
+ _1849_/Q VPWR VGND sg13cmos5l_mux4_1
XANTENNA__1997__GATE Tile_X0Y5_FrameStrobe[0] VPWR VGND sg13cmos5l_antennanp
X_1156_ _1156_/X Tile_X0Y4_W2MID[7] Tile_X0Y4_W2END[7] Tile_X0Y4_W6END[7] _1073_/X
+ _3048_/Q _3047_/Q VPWR VGND sg13cmos5l_mux4_1
XFILLER_279_13 VPWR VGND sg13cmos5l_fill_1
XFILLER_197_207 VPWR VGND sg13cmos5l_fill_2
XFILLER_252_185 VPWR VGND sg13cmos5l_decap_4
X_1087_ _1087_/X Tile_X0Y3_W2MID[3] Tile_X0Y3_W2END[3] Tile_X0Y3_W6END[3] _1271_/X
+ _2768_/Q _2767_/Q VPWR VGND sg13cmos5l_mux4_1
XANTENNA__1920__GATE Tile_X0Y5_FrameStrobe[6] VPWR VGND sg13cmos5l_antennanp
XANTENNA__1452__A0 Tile_X0Y2_WW4END[12] VPWR VGND sg13cmos5l_antennanp
XANTENNA__1204__A0 Tile_X0Y0_W2MID[1] VPWR VGND sg13cmos5l_antennanp
XANTENNA__1935__GATE Tile_X0Y5_FrameStrobe[7] VPWR VGND sg13cmos5l_antennanp
XANTENNA__2304__D Tile_X0Y2_FrameData[0] VPWR VGND sg13cmos5l_antennanp
XANTENNA__3537__X Tile_X0Y0_N2BEG[0] VPWR VGND sg13cmos5l_antennanp
X_1989_ _1989_/Q Tile_X0Y1_FrameData[11] Tile_X0Y5_FrameStrobe[0] VPWR VGND sg13cmos5l_dlhq_1
XANTENNA__0558__A2 Tile_X0Y3_W2END[1] VPWR VGND sg13cmos5l_antennanp
XFILLER_228_50 VPWR VGND sg13cmos5l_fill_2
X_3728_ Tile_X0Y3_FrameData_O[31] Tile_X0Y3_FrameData[31] VPWR VGND sg13cmos5l_buf_1
X_3659_ Tile_X0Y3_E2BEG[6] _3659_/A VPWR VGND sg13cmos5l_buf_1
XANTENNA__1507__A1 AXI_M_SOC_RDATA10 VPWR VGND sg13cmos5l_antennanp
XANTENNA__3135__D Tile_X0Y5_FrameData[17] VPWR VGND sg13cmos5l_antennanp
XANTENNA__3713__A Tile_X0Y3_FrameData[16] VPWR VGND sg13cmos5l_antennanp
XFILLER_87_132 VPWR VGND sg13cmos5l_decap_8
XFILLER_57_14 VPWR VGND sg13cmos5l_decap_8
XANTENNA__2974__D Tile_X0Y4_FrameData[2] VPWR VGND sg13cmos5l_antennanp
XFILLER_180_48 VPWR VGND sg13cmos5l_fill_2
XFILLER_180_59 VPWR VGND sg13cmos5l_decap_8
XFILLER_235_108 VPWR VGND sg13cmos5l_decap_4
XFILLER_275_277 VPWR VGND sg13cmos5l_fill_2
XFILLER_243_141 VPWR VGND sg13cmos5l_decap_4
XFILLER_28_276 VPWR VGND sg13cmos5l_decap_8
XFILLER_73_57 VPWR VGND sg13cmos5l_decap_8
XANTENNA__1038__A3 Tile_X0Y0_S4END[1] VPWR VGND sg13cmos5l_antennanp
XFILLER_11_132 VPWR VGND sg13cmos5l_decap_8
XFILLER_11_165 VPWR VGND sg13cmos5l_fill_2
XFILLER_196_273 VPWR VGND sg13cmos5l_decap_8
XFILLER_269_90 VPWR VGND sg13cmos5l_fill_1
XANTENNA__2214__D Tile_X0Y1_FrameData[10] VPWR VGND sg13cmos5l_antennanp
XANTENNA__3447__X Tile_X0Y1_FrameData_O[15] VPWR VGND sg13cmos5l_antennanp
XFILLER_125_0 VPWR VGND sg13cmos5l_decap_4
XFILLER_156_137 VPWR VGND sg13cmos5l_decap_8
XFILLER_98_43 VPWR VGND sg13cmos5l_decap_8
XANTENNA__2082__GATE Tile_X0Y5_FrameStrobe[3] VPWR VGND sg13cmos5l_antennanp
XFILLER_112_229 VPWR VGND sg13cmos5l_decap_8
XANTENNA__3045__D Tile_X0Y4_FrameData[27] VPWR VGND sg13cmos5l_antennanp
XFILLER_154_93 VPWR VGND sg13cmos5l_decap_8
XFILLER_266_255 VPWR VGND sg13cmos5l_fill_1
XANTENNA__2884__D Tile_X0Y4_FrameData[28] VPWR VGND sg13cmos5l_antennanp
XFILLER_266_277 VPWR VGND sg13cmos5l_decap_4
XANTENNA__2097__GATE Tile_X0Y5_FrameStrobe[4] VPWR VGND sg13cmos5l_antennanp
XANTENNA__3910__X Tile_X0Y5_S2BEGb[7] VPWR VGND sg13cmos5l_antennanp
XFILLER_19_265 VPWR VGND sg13cmos5l_decap_8
X_1010_ _1010_/X _3535_/A _1008_/X Tile_X0Y0_S2MID[6] Tile_X0Y0_S2END[6] _1708_/Q
+ _1707_/Q VPWR VGND sg13cmos5l_mux4_1
XANTENNA__1682__A0 Tile_X0Y4_W2END[2] VPWR VGND sg13cmos5l_antennanp
XFILLER_19_276 VPWR VGND sg13cmos5l_fill_2
XFILLER_234_152 VPWR VGND sg13cmos5l_decap_8
XFILLER_34_202 VPWR VGND sg13cmos5l_decap_8
XANTENNA__1430__X AXI_M_SOC_WDATA28 VPWR VGND sg13cmos5l_antennanp
XFILLER_234_196 VPWR VGND sg13cmos5l_decap_8
XANTENNA__2020__GATE Tile_X0Y5_FrameStrobe[1] VPWR VGND sg13cmos5l_antennanp
X_2961_ _2961_/Q Tile_X0Y4_FrameData[15] Tile_X0Y5_FrameStrobe[5] VPWR VGND sg13cmos5l_dlhq_1
XANTENNA__2650__GATE Tile_X0Y5_FrameStrobe[4] VPWR VGND sg13cmos5l_antennanp
X_1912_ _1912_/Q Tile_X0Y0_FrameData[8] Tile_X0Y5_FrameStrobe[6] VPWR VGND sg13cmos5l_dlhq_1
XANTENNA__0788__A2 Tile_X0Y3_W6END[10] VPWR VGND sg13cmos5l_antennanp
XFILLER_187_273 VPWR VGND sg13cmos5l_fill_2
X_2892_ _2892_/Q Tile_X0Y4_FrameData[20] Tile_X0Y5_FrameStrobe[3] VPWR VGND sg13cmos5l_dlhq_1
XFILLER_336_215 VPWR VGND sg13cmos5l_fill_1
XANTENNA__2035__GATE Tile_X0Y5_FrameStrobe[2] VPWR VGND sg13cmos5l_antennanp
XANTENNA__2124__D Tile_X0Y1_FrameData[4] VPWR VGND sg13cmos5l_antennanp
XANTENNA__3357__X Tile_X0Y2_E2BEG[3] VPWR VGND sg13cmos5l_antennanp
X_1843_ _1843_/Q Tile_X0Y0_FrameData[13] Tile_X0Y5_FrameStrobe[4] VPWR VGND sg13cmos5l_dlhq_1
XFILLER_8_63 VPWR VGND sg13cmos5l_fill_2
XANTENNA__2665__GATE Tile_X0Y5_FrameStrobe[4] VPWR VGND sg13cmos5l_antennanp
X_1774_ _1774_/Q Tile_X0Y0_FrameData[18] Tile_X0Y5_FrameStrobe[2] VPWR VGND sg13cmos5l_dlhq_1
XANTENNA__1963__D Tile_X0Y0_FrameData[21] VPWR VGND sg13cmos5l_antennanp
XFILLER_155_181 VPWR VGND sg13cmos5l_decap_4
X_3513_ Tile_X0Y0_N4BEG[0] _3513_/A VPWR VGND sg13cmos5l_buf_1
X_0725_ _0725_/Y _2514_/Q _2785_/Q VPWR VGND sg13cmos5l_nor2b_1
X_3444_ Tile_X0Y1_FrameData_O[12] Tile_X0Y1_FrameData[12] VPWR VGND sg13cmos5l_buf_1
X_0656_ _0656_/X Tile_X0Y5_N2MID[5] Tile_X0Y5_N2END[5] _3908_/A _0655_/X _3070_/Q
+ _3069_/Q VPWR VGND sg13cmos5l_mux4_1
XANTENNA__0960__A2 Tile_X0Y1_WW4END[4] VPWR VGND sg13cmos5l_antennanp
XFILLER_103_218 VPWR VGND sg13cmos5l_decap_8
XFILLER_40_0 VPWR VGND sg13cmos5l_decap_4
X_3375_ Tile_X0Y2_E6BEG[5] _3375_/A VPWR VGND sg13cmos5l_buf_1
X_0587_ _0587_/Y _2792_/Q _2791_/Q VPWR VGND sg13cmos5l_nor2b_1
XFILLER_257_233 VPWR VGND sg13cmos5l_decap_4
X_2326_ _2326_/Q Tile_X0Y2_FrameData[10] Tile_X0Y5_FrameStrobe[2] VPWR VGND sg13cmos5l_dlhq_1
XANTENNA__2794__D Tile_X0Y4_FrameData[22] VPWR VGND sg13cmos5l_antennanp
XFILLER_257_277 VPWR VGND sg13cmos5l_fill_1
X_2257_ _2257_/Q Tile_X0Y2_FrameData[15] Tile_X0Y5_FrameStrobe[0] VPWR VGND sg13cmos5l_dlhq_1
XFILLER_84_146 VPWR VGND sg13cmos5l_decap_8
XANTENNA__2603__GATE Tile_X0Y5_FrameStrobe[2] VPWR VGND sg13cmos5l_antennanp
XANTENNA__3820__X Tile_X0Y5_E2BEG[5] VPWR VGND sg13cmos5l_antennanp
XFILLER_150_29 VPWR VGND sg13cmos5l_fill_2
XFILLER_214_85 VPWR VGND sg13cmos5l_decap_8
X_1208_ AXI_M_SOC_AWADDR22 Tile_X0Y0_W1END[2] Tile_X0Y0_WW4END[14] Tile_X0Y0_WW4END[6]
+ _1006_/X _1771_/Q _1772_/Q VPWR VGND sg13cmos5l_mux4_1
XANTENNA__1268__A3 Tile_X0Y0_S4END[4] VPWR VGND sg13cmos5l_antennanp
XANTENNA__1673__A0 Tile_X0Y4_WW4END[13] VPWR VGND sg13cmos5l_antennanp
X_2188_ _2188_/Q Tile_X0Y1_FrameData[4] Tile_X0Y5_FrameStrobe[6] VPWR VGND sg13cmos5l_dlhq_1
XFILLER_230_40 VPWR VGND sg13cmos5l_decap_8
XFILLER_25_246 VPWR VGND sg13cmos5l_fill_1
X_1139_ _1139_/X Tile_X0Y2_W1END[1] Tile_X0Y2_W6END[5] _1025_/X _0628_/X _2510_/Q
+ _2509_/Q VPWR VGND sg13cmos5l_mux4_1
XFILLER_92_190 VPWR VGND sg13cmos5l_decap_8
XFILLER_230_73 VPWR VGND sg13cmos5l_fill_2
XFILLER_43_38 VPWR VGND sg13cmos5l_decap_8
XFILLER_40_216 VPWR VGND sg13cmos5l_fill_1
XANTENNA__1425__A0 Tile_X0Y2_W1END[2] VPWR VGND sg13cmos5l_antennanp
XANTENNA__2618__GATE Tile_X0Y5_FrameStrobe[3] VPWR VGND sg13cmos5l_antennanp
XFILLER_40_238 VPWR VGND sg13cmos5l_decap_8
XFILLER_178_262 VPWR VGND sg13cmos5l_decap_8
XANTENNA__1874__GATE Tile_X0Y5_FrameStrobe[5] VPWR VGND sg13cmos5l_antennanp
XANTENNA__2034__D Tile_X0Y1_FrameData[30] VPWR VGND sg13cmos5l_antennanp
XANTENNA__3708__A Tile_X0Y3_FrameData[11] VPWR VGND sg13cmos5l_antennanp
XFILLER_138_159 VPWR VGND sg13cmos5l_decap_8
XFILLER_327_248 VPWR VGND sg13cmos5l_fill_1
XFILLER_193_276 VPWR VGND sg13cmos5l_decap_4
XANTENNA__1873__D Tile_X0Y0_FrameData[15] VPWR VGND sg13cmos5l_antennanp
XANTENNA__2969__D Tile_X0Y4_FrameData[7] VPWR VGND sg13cmos5l_antennanp
XFILLER_146_170 VPWR VGND sg13cmos5l_decap_8
XANTENNA__1889__GATE Tile_X0Y5_FrameStrobe[6] VPWR VGND sg13cmos5l_antennanp
XANTENNA__0951__A2 Tile_X0Y1_W6END[9] VPWR VGND sg13cmos5l_antennanp
XANTENNA__3443__A Tile_X0Y1_FrameData[11] VPWR VGND sg13cmos5l_antennanp
XFILLER_68_68 VPWR VGND sg13cmos5l_decap_8
XANTENNA__1812__GATE Tile_X0Y5_FrameStrobe[3] VPWR VGND sg13cmos5l_antennanp
XFILLER_102_240 VPWR VGND sg13cmos5l_fill_2
XFILLER_124_74 VPWR VGND sg13cmos5l_decap_8
XANTENNA__3730__X Tile_X0Y4_E1BEG[0] VPWR VGND sg13cmos5l_antennanp
XANTENNA__2209__D Tile_X0Y1_FrameData[15] VPWR VGND sg13cmos5l_antennanp
XANTENNA__1827__GATE Tile_X0Y5_FrameStrobe[4] VPWR VGND sg13cmos5l_antennanp
XFILLER_140_73 VPWR VGND sg13cmos5l_fill_1
XANTENNA__1416__A0 Tile_X0Y2_W2MID[0] VPWR VGND sg13cmos5l_antennanp
XFILLER_140_95 VPWR VGND sg13cmos5l_decap_8
XFILLER_242_0 VPWR VGND sg13cmos5l_fill_2
XFILLER_184_210 VPWR VGND sg13cmos5l_decap_4
XFILLER_149_60 VPWR VGND sg13cmos5l_decap_4
XFILLER_184_221 VPWR VGND sg13cmos5l_fill_1
XFILLER_318_237 VPWR VGND sg13cmos5l_decap_8
XANTENNA__1783__D Tile_X0Y0_FrameData[9] VPWR VGND sg13cmos5l_antennanp
XANTENNA__2879__D Tile_X0Y4_FrameData[1] VPWR VGND sg13cmos5l_antennanp
XFILLER_326_281 VPWR VGND sg13cmos5l_fill_2
XFILLER_326_270 VPWR VGND sg13cmos5l_fill_1
XANTENNA__1195__A2 Tile_X0Y0_WW4END[13] VPWR VGND sg13cmos5l_antennanp
XANTENNA__3905__X Tile_X0Y5_S2BEGb[2] VPWR VGND sg13cmos5l_antennanp
XANTENNA__0942__A2 Tile_X0Y1_WW4END[14] VPWR VGND sg13cmos5l_antennanp
X_1490_ _3914_/A _1487_/Y _1489_/Y _1485_/Y VPWR VGND sg13cmos5l_o21ai_1
XFILLER_3_161 VPWR VGND sg13cmos5l_fill_1
XANTENNA__1425__X AXI_M_SOC_WDATA22 VPWR VGND sg13cmos5l_antennanp
X_3160_ _3160_/Q Tile_X0Y5_FrameData[24] Tile_X0Y5_FrameStrobe[3] VPWR VGND sg13cmos5l_dlhq_1
XFILLER_315_62 VPWR VGND sg13cmos5l_fill_2
XFILLER_239_277 VPWR VGND sg13cmos5l_fill_1
XFILLER_251_28 VPWR VGND sg13cmos5l_fill_2
X_3091_ _3091_/Q Tile_X0Y5_FrameData[29] Tile_X0Y5_FrameStrobe[1] VPWR VGND sg13cmos5l_dlhq_1
X_2111_ _2111_/Q Tile_X0Y1_FrameData[17] Tile_X0Y5_FrameStrobe[4] VPWR VGND sg13cmos5l_dlhq_1
XFILLER_58_90 VPWR VGND sg13cmos5l_decap_8
XANTENNA__3640__X Tile_X0Y0_E2BEG[3] VPWR VGND sg13cmos5l_antennanp
X_2042_ _2042_/Q Tile_X0Y1_FrameData[22] Tile_X0Y5_FrameStrobe[2] VPWR VGND sg13cmos5l_dlhq_1
XANTENNA__2119__D Tile_X0Y1_FrameData[9] VPWR VGND sg13cmos5l_antennanp
XANTENNA__3333__GATE Tile_X0Y5_FrameStrobe[9] VPWR VGND sg13cmos5l_antennanp
XANTENNA__1655__A0 Tile_X0Y4_W2MID[5] VPWR VGND sg13cmos5l_antennanp
XFILLER_331_83 VPWR VGND sg13cmos5l_fill_2
XANTENNA__1958__D Tile_X0Y0_FrameData[26] VPWR VGND sg13cmos5l_antennanp
XANTENNA__1407__A0 AXI_M_SOC_RDATA18 VPWR VGND sg13cmos5l_antennanp
XANTENNA__3348__GATE Tile_X0Y5_FrameStrobe[8] VPWR VGND sg13cmos5l_antennanp
XFILLER_200_32 VPWR VGND sg13cmos5l_decap_8
XFILLER_175_210 VPWR VGND sg13cmos5l_decap_8
X_2944_ _2944_/Q Tile_X0Y4_FrameData[0] Tile_X0Y5_FrameStrobe[4] VPWR VGND sg13cmos5l_dlhq_1
XFILLER_88_0 VPWR VGND sg13cmos5l_decap_8
X_2875_ _2875_/Q Tile_X0Y4_FrameData[5] Tile_X0Y5_FrameStrobe[2] VPWR VGND sg13cmos5l_dlhq_1
XFILLER_209_30 VPWR VGND sg13cmos5l_decap_8
XFILLER_30_293 VPWR VGND sg13cmos5l_fill_2
X_1826_ _1826_/Q Tile_X0Y0_FrameData[30] Tile_X0Y5_FrameStrobe[4] VPWR VGND sg13cmos5l_dlhq_1
XANTENNA__2789__D Tile_X0Y4_FrameData[27] VPWR VGND sg13cmos5l_antennanp
XANTENNA__1186__A2 Tile_X0Y4_W6END[4] VPWR VGND sg13cmos5l_antennanp
XANTENNA__3815__X Tile_X0Y5_E2BEG[0] VPWR VGND sg13cmos5l_antennanp
X_1757_ _1757_/Q Tile_X0Y0_FrameData[3] Tile_X0Y5_FrameStrobe[1] VPWR VGND sg13cmos5l_dlhq_1
X_1688_ _3920_/A _1687_/X _1686_/X _2991_/Q VPWR VGND sg13cmos5l_mux2_1
X_0708_ _3925_/A _0700_/X _0702_/Y _0707_/Y VPWR VGND sg13cmos5l_a21oi_1
XFILLER_332_273 VPWR VGND sg13cmos5l_fill_2
X_3427_ Tile_X0Y2_FrameData_O[29] Tile_X0Y2_FrameData[29] VPWR VGND sg13cmos5l_buf_1
X_0639_ _0639_/Y _2789_/Q _0639_/B _0639_/C VPWR VGND sg13cmos5l_nor3_1
XFILLER_225_84 VPWR VGND sg13cmos5l_fill_2
X_3358_ Tile_X0Y2_E2BEG[4] _3358_/A VPWR VGND sg13cmos5l_buf_1
XFILLER_57_102 VPWR VGND sg13cmos5l_fill_1
XANTENNA__0697__A1 Tile_X0Y5_N4END[2] VPWR VGND sg13cmos5l_antennanp
XANTENNA__2542__GATE Tile_X0Y5_FrameStrobe[0] VPWR VGND sg13cmos5l_antennanp
X_2309_ _2309_/Q Tile_X0Y2_FrameData[27] Tile_X0Y5_FrameStrobe[2] VPWR VGND sg13cmos5l_dlhq_1
XFILLER_97_293 VPWR VGND sg13cmos5l_fill_2
XFILLER_97_271 VPWR VGND sg13cmos5l_decap_8
XANTENNA__3550__X Tile_X0Y0_FrameStrobe_O[1] VPWR VGND sg13cmos5l_antennanp
XFILLER_161_39 VPWR VGND sg13cmos5l_fill_2
XFILLER_180_9 VPWR VGND sg13cmos5l_fill_1
XFILLER_300_192 VPWR VGND sg13cmos5l_fill_1
X_3289_ _3289_/Q Tile_X0Y5_FrameData[23] Tile_X0Y5_FrameStrobe[7] VPWR VGND sg13cmos5l_dlhq_1
XFILLER_72_127 VPWR VGND sg13cmos5l_fill_1
XFILLER_72_116 VPWR VGND sg13cmos5l_decap_8
XFILLER_72_105 VPWR VGND sg13cmos5l_decap_4
XANTENNA__1646__A0 Tile_X0Y4_W2MID[4] VPWR VGND sg13cmos5l_antennanp
XANTENNA__2029__D Tile_X0Y1_FrameData[3] VPWR VGND sg13cmos5l_antennanp
XFILLER_72_149 VPWR VGND sg13cmos5l_fill_2
XANTENNA__2557__GATE Tile_X0Y5_FrameStrobe[1] VPWR VGND sg13cmos5l_antennanp
XANTENNA__1868__D Tile_X0Y0_FrameData[20] VPWR VGND sg13cmos5l_antennanp
XFILLER_70_25 VPWR VGND sg13cmos5l_fill_1
XANTENNA__3438__A Tile_X0Y1_FrameData[6] VPWR VGND sg13cmos5l_antennanp
XFILLER_21_293 VPWR VGND sg13cmos5l_fill_2
XANTENNA__2699__D Tile_X0Y3_FrameData[5] VPWR VGND sg13cmos5l_antennanp
XANTENNA__1177__A2 Tile_X0Y1_W2END[0] VPWR VGND sg13cmos5l_antennanp
XANTENNA__3725__X Tile_X0Y3_FrameData_O[28] VPWR VGND sg13cmos5l_antennanp
XFILLER_134_162 VPWR VGND sg13cmos5l_decap_8
XFILLER_79_56 VPWR VGND sg13cmos5l_decap_8
XANTENNA__1751__GATE Tile_X0Y5_FrameStrobe[1] VPWR VGND sg13cmos5l_antennanp
XFILLER_295_158 VPWR VGND sg13cmos5l_fill_1
XFILLER_0_175 VPWR VGND sg13cmos5l_fill_2
XFILLER_192_0 VPWR VGND sg13cmos5l_fill_2
XANTENNA__3323__D Tile_X0Y5_FrameData[21] VPWR VGND sg13cmos5l_antennanp
XANTENNA__3460__X Tile_X0Y1_FrameData_O[28] VPWR VGND sg13cmos5l_antennanp
XFILLER_95_77 VPWR VGND sg13cmos5l_decap_8
XFILLER_48_168 VPWR VGND sg13cmos5l_decap_8
XANTENNA__1766__GATE Tile_X0Y5_FrameStrobe[2] VPWR VGND sg13cmos5l_antennanp
XFILLER_28_71 VPWR VGND sg13cmos5l_decap_8
XANTENNA__1637__A0 Tile_X0Y4_WW4END[7] VPWR VGND sg13cmos5l_antennanp
XFILLER_151_94 VPWR VGND sg13cmos5l_fill_2
XFILLER_301_20 VPWR VGND sg13cmos5l_fill_1
XANTENNA__1101__A2 Tile_X0Y1_W6END[6] VPWR VGND sg13cmos5l_antennanp
XFILLER_244_280 VPWR VGND sg13cmos5l_fill_1
XANTENNA__1778__D Tile_X0Y0_FrameData[14] VPWR VGND sg13cmos5l_antennanp
XANTENNA__0860__A1 Tile_X0Y5_W2END[3] VPWR VGND sg13cmos5l_antennanp
X_0990_ _0990_/Y _3060_/Q _0990_/B _3059_/Q VPWR VGND sg13cmos5l_nand3b_1
XFILLER_44_81 VPWR VGND sg13cmos5l_decap_8
XFILLER_157_210 VPWR VGND sg13cmos5l_fill_1
XFILLER_157_232 VPWR VGND sg13cmos5l_fill_2
XFILLER_12_293 VPWR VGND sg13cmos5l_fill_2
XFILLER_172_202 VPWR VGND sg13cmos5l_decap_8
X_2660_ _2660_/Q Tile_X0Y3_FrameData[12] Tile_X0Y5_FrameStrobe[4] VPWR VGND sg13cmos5l_dlhq_1
XFILLER_8_231 VPWR VGND sg13cmos5l_decap_8
XANTENNA__1704__GATE Tile_X0Y5_FrameStrobe[0] VPWR VGND sg13cmos5l_antennanp
X_1611_ _3774_/A Tile_X0Y4_WW4END[3] AXI_M_SOC_RDATA1 _0981_/X _1130_/X _2920_/Q _2919_/Q
+ VPWR VGND sg13cmos5l_mux4_1
XFILLER_60_80 VPWR VGND sg13cmos5l_decap_8
XANTENNA__2402__D Tile_X0Y2_FrameData[30] VPWR VGND sg13cmos5l_antennanp
XANTENNA__3635__X Tile_X0Y0_E2BEGb[6] VPWR VGND sg13cmos5l_antennanp
XFILLER_172_268 VPWR VGND sg13cmos5l_fill_2
X_2591_ _2591_/Q Tile_X0Y3_FrameData[17] Tile_X0Y5_FrameStrobe[2] VPWR VGND sg13cmos5l_dlhq_1
XFILLER_5_31 VPWR VGND sg13cmos5l_decap_8
XFILLER_314_240 VPWR VGND sg13cmos5l_fill_2
X_1542_ _3675_/A AXI_M_SOC_RDATA8 _1437_/X _1523_/X _1216_/X _2628_/Q _2627_/Q VPWR
+ VGND sg13cmos5l_mux4_1
XANTENNA__1719__GATE Tile_X0Y5_FrameStrobe[0] VPWR VGND sg13cmos5l_antennanp
XFILLER_125_195 VPWR VGND sg13cmos5l_decap_8
X_1473_ _3392_/A Tile_X0Y2_WW4END[5] _1315_/X AXI_M_SOC_RDATA19 _1183_/X _2379_/Q
+ _2380_/Q VPWR VGND sg13cmos5l_mux4_1
XFILLER_5_97 VPWR VGND sg13cmos5l_decap_4
XFILLER_262_27 VPWR VGND sg13cmos5l_fill_1
X_3212_ _3212_/Q Tile_X0Y5_FrameData[4] Tile_X0Y5_FrameStrobe[4] VPWR VGND sg13cmos5l_dlhq_1
XFILLER_39_113 VPWR VGND sg13cmos5l_fill_1
XFILLER_39_102 VPWR VGND sg13cmos5l_decap_8
XANTENNA__3233__D Tile_X0Y5_FrameData[15] VPWR VGND sg13cmos5l_antennanp
XANTENNA__3272__GATE Tile_X0Y5_FrameStrobe[6] VPWR VGND sg13cmos5l_antennanp
XANTENNA__3370__X Tile_X0Y2_E6BEG[0] VPWR VGND sg13cmos5l_antennanp
XFILLER_227_236 VPWR VGND sg13cmos5l_fill_2
X_3143_ _3143_/Q Tile_X0Y5_FrameData[9] Tile_X0Y5_FrameStrobe[2] VPWR VGND sg13cmos5l_dlhq_1
X_3074_ _3074_/Q Tile_X0Y5_FrameData[14] Tile_X0Y5_FrameStrobe[0] VPWR VGND sg13cmos5l_dlhq_1
XFILLER_39_179 VPWR VGND sg13cmos5l_decap_4
XANTENNA__1628__A0 AXI_M_SOC_RRESP1 VPWR VGND sg13cmos5l_antennanp
X_2025_ _2025_/Q Tile_X0Y1_FrameData[7] Tile_X0Y5_FrameStrobe[1] VPWR VGND sg13cmos5l_dlhq_1
XANTENNA__3287__GATE Tile_X0Y5_FrameStrobe[7] VPWR VGND sg13cmos5l_antennanp
XFILLER_148_210 VPWR VGND sg13cmos5l_decap_8
X_2927_ _2927_/Q Tile_X0Y4_FrameData[17] Tile_X0Y5_FrameStrobe[4] VPWR VGND sg13cmos5l_dlhq_1
XANTENNA__0603__A1 Tile_X0Y5_WW4END[12] VPWR VGND sg13cmos5l_antennanp
XANTENNA__3210__GATE Tile_X0Y5_FrameStrobe[4] VPWR VGND sg13cmos5l_antennanp
X_2858_ _2858_/Q Tile_X0Y4_FrameData[22] Tile_X0Y5_FrameStrobe[2] VPWR VGND sg13cmos5l_dlhq_1
XFILLER_40_39 VPWR VGND sg13cmos5l_decap_4
XANTENNA__1159__A2 Tile_X0Y0_S1END[1] VPWR VGND sg13cmos5l_antennanp
XANTENNA__2312__D Tile_X0Y2_FrameData[24] VPWR VGND sg13cmos5l_antennanp
XANTENNA__3545__X Tile_X0Y0_N1BEG[0] VPWR VGND sg13cmos5l_antennanp
XFILLER_156_28 VPWR VGND sg13cmos5l_decap_8
X_2789_ _2789_/Q Tile_X0Y4_FrameData[27] Tile_X0Y5_FrameStrobe[0] VPWR VGND sg13cmos5l_dlhq_1
X_1809_ _1809_/Q Tile_X0Y0_FrameData[15] Tile_X0Y5_FrameStrobe[3] VPWR VGND sg13cmos5l_dlhq_1
XANTENNA__3225__GATE Tile_X0Y5_FrameStrobe[5] VPWR VGND sg13cmos5l_antennanp
XFILLER_116_151 VPWR VGND sg13cmos5l_decap_8
XANTENNA__0906__A2 Tile_X0Y1_WW4END[11] VPWR VGND sg13cmos5l_antennanp
XFILLER_116_184 VPWR VGND sg13cmos5l_decap_4
XFILLER_49_26 VPWR VGND sg13cmos5l_decap_8
XANTENNA__2481__GATE Tile_X0Y5_FrameStrobe[7] VPWR VGND sg13cmos5l_antennanp
XFILLER_131_165 VPWR VGND sg13cmos5l_fill_1
XFILLER_277_125 VPWR VGND sg13cmos5l_fill_2
XFILLER_277_136 VPWR VGND sg13cmos5l_decap_4
XFILLER_105_32 VPWR VGND sg13cmos5l_decap_8
XFILLER_131_187 VPWR VGND sg13cmos5l_decap_8
XFILLER_131_198 VPWR VGND sg13cmos5l_fill_2
XANTENNA__1331__A2 AXI_M_SOC_RDATA24 VPWR VGND sg13cmos5l_antennanp
XANTENNA__3143__D Tile_X0Y5_FrameData[9] VPWR VGND sg13cmos5l_antennanp
XANTENNA__3721__A Tile_X0Y3_FrameData[24] VPWR VGND sg13cmos5l_antennanp
XFILLER_45_105 VPWR VGND sg13cmos5l_decap_8
XANTENNA__1619__A0 Tile_X0Y4_WW4END[0] VPWR VGND sg13cmos5l_antennanp
XANTENNA__2496__GATE Tile_X0Y5_FrameStrobe[7] VPWR VGND sg13cmos5l_antennanp
XANTENNA__2982__D Tile_X0Y4_FrameData[26] VPWR VGND sg13cmos5l_antennanp
XFILLER_65_69 VPWR VGND sg13cmos5l_decap_8
XANTENNA__1095__A1 Tile_X0Y0_W6END[4] VPWR VGND sg13cmos5l_antennanp
XFILLER_53_193 VPWR VGND sg13cmos5l_decap_8
XANTENNA__0842__A1 Tile_X0Y5_WW4END[13] VPWR VGND sg13cmos5l_antennanp
XFILLER_201_136 VPWR VGND sg13cmos5l_decap_4
XFILLER_201_158 VPWR VGND sg13cmos5l_decap_4
XANTENNA__1398__A2 Tile_X0Y0_S4END[9] VPWR VGND sg13cmos5l_antennanp
XFILLER_139_254 VPWR VGND sg13cmos5l_fill_1
XFILLER_14_95 VPWR VGND sg13cmos5l_decap_8
XANTENNA__2434__GATE Tile_X0Y5_FrameStrobe[6] VPWR VGND sg13cmos5l_antennanp
XFILLER_139_276 VPWR VGND sg13cmos5l_decap_8
XANTENNA__2222__D Tile_X0Y1_FrameData[2] VPWR VGND sg13cmos5l_antennanp
XANTENNA__3318__D Tile_X0Y5_FrameData[26] VPWR VGND sg13cmos5l_antennanp
XANTENNA__3455__X Tile_X0Y1_FrameData_O[23] VPWR VGND sg13cmos5l_antennanp
XFILLER_205_0 VPWR VGND sg13cmos5l_fill_2
XANTENNA__2449__GATE Tile_X0Y5_FrameStrobe[6] VPWR VGND sg13cmos5l_antennanp
XFILLER_68_208 VPWR VGND sg13cmos5l_decap_4
XFILLER_268_169 VPWR VGND sg13cmos5l_fill_1
XANTENNA__3053__D Tile_X0Y4_FrameData[19] VPWR VGND sg13cmos5l_antennanp
XFILLER_39_81 VPWR VGND sg13cmos5l_decap_8
XFILLER_36_116 VPWR VGND sg13cmos5l_decap_4
XANTENNA__2892__D Tile_X0Y4_FrameData[20] VPWR VGND sg13cmos5l_antennanp
XFILLER_36_149 VPWR VGND sg13cmos5l_decap_8
XFILLER_36_138 VPWR VGND sg13cmos5l_decap_4
XFILLER_91_277 VPWR VGND sg13cmos5l_fill_2
XFILLER_55_91 VPWR VGND sg13cmos5l_decap_8
X_3830_ Tile_X0Y5_E2BEGb[7] _3830_/A VPWR VGND sg13cmos5l_buf_1
X_3761_ Tile_X0Y4_E6BEG[11] _3761_/A VPWR VGND sg13cmos5l_buf_1
XANTENNA__1389__A2 Tile_X0Y2_WW4END[1] VPWR VGND sg13cmos5l_antennanp
X_2712_ _2712_/Q Tile_X0Y3_FrameData[24] Tile_X0Y5_FrameStrobe[6] VPWR VGND sg13cmos5l_dlhq_1
X_0973_ _3898_/A Tile_X0Y5_W2MID[4] Tile_X0Y5_W2END[4] Tile_X0Y5_W6END[11] _0794_/X
+ _3278_/Q _3277_/Q VPWR VGND sg13cmos5l_mux4_1
XANTENNA__0597__A0 Tile_X0Y5_N1END[0] VPWR VGND sg13cmos5l_antennanp
XFILLER_200_180 VPWR VGND sg13cmos5l_decap_8
XFILLER_200_191 VPWR VGND sg13cmos5l_fill_1
X_3692_ Tile_X0Y3_EE4BEG[11] _3692_/A VPWR VGND sg13cmos5l_buf_1
XANTENNA__2132__D Tile_X0Y1_FrameData[28] VPWR VGND sg13cmos5l_antennanp
XANTENNA__3228__D Tile_X0Y5_FrameData[20] VPWR VGND sg13cmos5l_antennanp
XANTENNA__3365__X Tile_X0Y2_E2BEGb[3] VPWR VGND sg13cmos5l_antennanp
XFILLER_145_246 VPWR VGND sg13cmos5l_fill_2
X_2643_ _2643_/Q Tile_X0Y3_FrameData[29] Tile_X0Y5_FrameStrobe[4] VPWR VGND sg13cmos5l_dlhq_1
XANTENNA__3806__A Tile_X0Y4_FrameData[28] VPWR VGND sg13cmos5l_antennanp
X_2574_ _2574_/Q Tile_X0Y3_FrameData[2] Tile_X0Y5_FrameStrobe[1] VPWR VGND sg13cmos5l_dlhq_1
XFILLER_337_93 VPWR VGND sg13cmos5l_decap_8
XANTENNA__1971__D Tile_X0Y1_FrameData[29] VPWR VGND sg13cmos5l_antennanp
XFILLER_259_114 VPWR VGND sg13cmos5l_fill_1
X_1525_ _3694_/A Tile_X0Y3_WW4END[2] _1524_/X AXI_M_SOC_RDATA8 _1216_/X _2645_/Q _2646_/Q
+ VPWR VGND sg13cmos5l_mux4_1
XANTENNA__1561__A2 Tile_X0Y3_W6END[10] VPWR VGND sg13cmos5l_antennanp
XFILLER_206_20 VPWR VGND sg13cmos5l_decap_8
X_1456_ _3357_/A Tile_X0Y2_W2MID[4] AXI_M_SOC_RDATA17 _1187_/X _1191_/X _2426_/Q _2425_/Q
+ VPWR VGND sg13cmos5l_mux4_1
X_1387_ _3519_/A _1384_/Y _1386_/Y _1382_/Y VPWR VGND sg13cmos5l_o21ai_1
XANTENNA__1313__A2 Tile_X0Y5_N4END[14] VPWR VGND sg13cmos5l_antennanp
X_3126_ _3126_/Q Tile_X0Y5_FrameData[26] Tile_X0Y5_FrameStrobe[2] VPWR VGND sg13cmos5l_dlhq_1
XFILLER_215_206 VPWR VGND sg13cmos5l_decap_8
XFILLER_282_150 VPWR VGND sg13cmos5l_fill_1
XFILLER_282_161 VPWR VGND sg13cmos5l_fill_1
XFILLER_282_172 VPWR VGND sg13cmos5l_decap_4
X_3057_ _3057_/Q Tile_X0Y4_FrameData[31] Tile_X0Y5_FrameStrobe[0] VPWR VGND sg13cmos5l_dlhq_1
XANTENNA__1077__A1 Tile_X0Y1_W2END[3] VPWR VGND sg13cmos5l_antennanp
XFILLER_230_209 VPWR VGND sg13cmos5l_fill_2
X_2008_ _2008_/Q Tile_X0Y1_FrameData[24] Tile_X0Y5_FrameStrobe[1] VPWR VGND sg13cmos5l_dlhq_1
XANTENNA__2307__D Tile_X0Y2_FrameData[29] VPWR VGND sg13cmos5l_antennanp
XFILLER_50_163 VPWR VGND sg13cmos5l_fill_1
XFILLER_51_49 VPWR VGND sg13cmos5l_decap_8
XFILLER_167_49 VPWR VGND sg13cmos5l_decap_8
XANTENNA__3138__D Tile_X0Y5_FrameData[14] VPWR VGND sg13cmos5l_antennanp
XANTENNA__3164__GATE Tile_X0Y5_FrameStrobe[3] VPWR VGND sg13cmos5l_antennanp
XFILLER_337_184 VPWR VGND sg13cmos5l_decap_4
XANTENNA__2042__D Tile_X0Y1_FrameData[22] VPWR VGND sg13cmos5l_antennanp
XANTENNA__3716__A Tile_X0Y3_FrameData[19] VPWR VGND sg13cmos5l_antennanp
XFILLER_151_216 VPWR VGND sg13cmos5l_fill_1
XFILLER_247_82 VPWR VGND sg13cmos5l_fill_1
XANTENNA__1881__D Tile_X0Y0_FrameData[7] VPWR VGND sg13cmos5l_antennanp
XANTENNA__2977__D Tile_X0Y4_FrameData[31] VPWR VGND sg13cmos5l_antennanp
XANTENNA__1552__A2 Tile_X0Y3_W6END[6] VPWR VGND sg13cmos5l_antennanp
XFILLER_104_154 VPWR VGND sg13cmos5l_decap_8
XFILLER_104_165 VPWR VGND sg13cmos5l_fill_2
XANTENNA__0760__A0 Tile_X0Y5_N1END[0] VPWR VGND sg13cmos5l_antennanp
XANTENNA__3179__GATE Tile_X0Y5_FrameStrobe[3] VPWR VGND sg13cmos5l_antennanp
XFILLER_104_198 VPWR VGND sg13cmos5l_fill_1
XFILLER_263_81 VPWR VGND sg13cmos5l_decap_8
XFILLER_263_92 VPWR VGND sg13cmos5l_fill_2
XFILLER_76_57 VPWR VGND sg13cmos5l_fill_1
XFILLER_76_46 VPWR VGND sg13cmos5l_decap_8
XANTENNA__3451__A Tile_X0Y1_FrameData[19] VPWR VGND sg13cmos5l_antennanp
XFILLER_58_285 VPWR VGND sg13cmos5l_fill_2
XFILLER_58_263 VPWR VGND sg13cmos5l_decap_8
XANTENNA__3102__GATE Tile_X0Y5_FrameStrobe[1] VPWR VGND sg13cmos5l_antennanp
XFILLER_206_206 VPWR VGND sg13cmos5l_decap_4
XFILLER_214_250 VPWR VGND sg13cmos5l_fill_1
XFILLER_92_56 VPWR VGND sg13cmos5l_decap_8
XANTENNA__2217__D Tile_X0Y1_FrameData[7] VPWR VGND sg13cmos5l_antennanp
XFILLER_155_0 VPWR VGND sg13cmos5l_fill_2
XFILLER_214_272 VPWR VGND sg13cmos5l_decap_4
XANTENNA__3117__GATE Tile_X0Y5_FrameStrobe[1] VPWR VGND sg13cmos5l_antennanp
XFILLER_41_163 VPWR VGND sg13cmos5l_fill_2
XFILLER_322_0 VPWR VGND sg13cmos5l_fill_1
XANTENNA__2373__GATE Tile_X0Y5_FrameStrobe[4] VPWR VGND sg13cmos5l_antennanp
XANTENNA__3048__D Tile_X0Y4_FrameData[24] VPWR VGND sg13cmos5l_antennanp
XFILLER_328_195 VPWR VGND sg13cmos5l_fill_1
XANTENNA__2388__GATE Tile_X0Y5_FrameStrobe[4] VPWR VGND sg13cmos5l_antennanp
XANTENNA__2887__D Tile_X0Y4_FrameData[25] VPWR VGND sg13cmos5l_antennanp
XANTENNA__1543__A2 Tile_X0Y3_W6END[0] VPWR VGND sg13cmos5l_antennanp
XANTENNA__1791__D Tile_X0Y0_FrameData[1] VPWR VGND sg13cmos5l_antennanp
XANTENNA__3913__X Tile_X0Y5_S4BEG[2] VPWR VGND sg13cmos5l_antennanp
X_2290_ _2290_/Q Tile_X0Y2_FrameData[14] Tile_X0Y5_FrameStrobe[1] VPWR VGND sg13cmos5l_dlhq_1
X_1310_ AXI_M_SOC_AWADDR6 Tile_X0Y1_W2MID[6] Tile_X0Y1_W2END[6] Tile_X0Y1_W6END[6]
+ _1083_/X _2028_/Q _2027_/Q VPWR VGND sg13cmos5l_mux4_1
XANTENNA__2311__GATE Tile_X0Y5_FrameStrobe[2] VPWR VGND sg13cmos5l_antennanp
XFILLER_110_124 VPWR VGND sg13cmos5l_decap_8
XFILLER_296_286 VPWR VGND sg13cmos5l_fill_1
X_1241_ _3627_/A AXI_M_SOC_WREADY _1037_/X _1042_/X _1010_/X _1803_/Q _1804_/Q VPWR
+ VGND sg13cmos5l_mux4_1
XANTENNA__1433__X AXI_M_SOC_WDATA25 VPWR VGND sg13cmos5l_antennanp
XANTENNA__2941__GATE Tile_X0Y5_FrameStrobe[4] VPWR VGND sg13cmos5l_antennanp
XFILLER_2_76 VPWR VGND sg13cmos5l_fill_1
X_1172_ _3526_/A _1171_/X _1170_/X _1940_/Q VPWR VGND sg13cmos5l_mux2_1
XFILLER_2_87 VPWR VGND sg13cmos5l_decap_4
XFILLER_66_90 VPWR VGND sg13cmos5l_decap_8
XFILLER_64_222 VPWR VGND sg13cmos5l_decap_8
XANTENNA__2326__GATE Tile_X0Y5_FrameStrobe[2] VPWR VGND sg13cmos5l_antennanp
XANTENNA__2127__D Tile_X0Y1_FrameData[1] VPWR VGND sg13cmos5l_antennanp
XANTENNA__2956__GATE Tile_X0Y5_FrameStrobe[5] VPWR VGND sg13cmos5l_antennanp
X_3813_ Tile_X0Y5_E1BEG[2] _3813_/A VPWR VGND sg13cmos5l_buf_1
XANTENNA__1966__D Tile_X0Y0_FrameData[18] VPWR VGND sg13cmos5l_antennanp
XFILLER_220_286 VPWR VGND sg13cmos5l_fill_1
XFILLER_268_59 VPWR VGND sg13cmos5l_fill_1
XFILLER_118_202 VPWR VGND sg13cmos5l_fill_1
X_3744_ Tile_X0Y4_E2BEGb[2] _3744_/A VPWR VGND sg13cmos5l_buf_1
X_0956_ _0956_/X _1123_/X _0712_/X _0904_/Y Tile_X0Y0_S4END[7] _2001_/Q _2002_/Q VPWR
+ VGND sg13cmos5l_mux4_1
XFILLER_70_0 VPWR VGND sg13cmos5l_fill_2
XANTENNA__1231__A1 AXI_M_SOC_RDATA30 VPWR VGND sg13cmos5l_antennanp
XFILLER_118_224 VPWR VGND sg13cmos5l_fill_1
XFILLER_284_14 VPWR VGND sg13cmos5l_decap_8
X_3675_ Tile_X0Y3_E6BEG[6] _3675_/A VPWR VGND sg13cmos5l_buf_1
X_2626_ _2626_/Q Tile_X0Y3_FrameData[14] Tile_X0Y5_FrameStrobe[3] VPWR VGND sg13cmos5l_dlhq_1
X_0887_ AXI_M_SOC_WSTRB1 _3334_/Q _0887_/B VPWR VGND sg13cmos5l_or2_1
XANTENNA__0879__B Tile_X0Y5_W2MID[7] VPWR VGND sg13cmos5l_antennanp
XANTENNA__2797__D Tile_X0Y4_FrameData[19] VPWR VGND sg13cmos5l_antennanp
XFILLER_217_41 VPWR VGND sg13cmos5l_decap_4
XFILLER_284_69 VPWR VGND sg13cmos5l_fill_1
XANTENNA__3823__X Tile_X0Y5_E2BEGb[0] VPWR VGND sg13cmos5l_antennanp
XFILLER_217_74 VPWR VGND sg13cmos5l_fill_1
X_2557_ _2557_/Q Tile_X0Y3_FrameData[19] Tile_X0Y5_FrameStrobe[1] VPWR VGND sg13cmos5l_dlhq_1
XFILLER_99_141 VPWR VGND sg13cmos5l_decap_8
XANTENNA__0742__A0 Tile_X0Y5_N1END[3] VPWR VGND sg13cmos5l_antennanp
X_2488_ _2488_/Q Tile_X0Y2_FrameData[8] Tile_X0Y5_FrameStrobe[7] VPWR VGND sg13cmos5l_dlhq_1
X_1508_ _3665_/A Tile_X0Y3_W2END[3] AXI_M_SOC_RDATA9 _1587_/B _1271_/X _2680_/Q _2679_/Q
+ VPWR VGND sg13cmos5l_mux4_1
XFILLER_99_196 VPWR VGND sg13cmos5l_decap_8
XFILLER_101_146 VPWR VGND sg13cmos5l_decap_8
X_1439_ _1439_/Y _2447_/Q _1439_/B VPWR VGND sg13cmos5l_nand2b_1
XANTENNA__2909__GATE Tile_X0Y5_FrameStrobe[3] VPWR VGND sg13cmos5l_antennanp
XFILLER_262_109 VPWR VGND sg13cmos5l_fill_2
XFILLER_102_11 VPWR VGND sg13cmos5l_fill_2
XFILLER_255_194 VPWR VGND sg13cmos5l_decap_8
X_3109_ _3109_/Q Tile_X0Y5_FrameData[11] Tile_X0Y5_FrameStrobe[1] VPWR VGND sg13cmos5l_dlhq_1
XANTENNA__2037__D Tile_X0Y1_FrameData[27] VPWR VGND sg13cmos5l_antennanp
XANTENNA__1470__A1 AXI_M_SOC_RDATA16 VPWR VGND sg13cmos5l_antennanp
XANTENNA__1876__D Tile_X0Y0_FrameData[12] VPWR VGND sg13cmos5l_antennanp
XANTENNA__3446__A Tile_X0Y1_FrameData[14] VPWR VGND sg13cmos5l_antennanp
XFILLER_109_268 VPWR VGND sg13cmos5l_fill_2
XFILLER_11_41 VPWR VGND sg13cmos5l_fill_2
XFILLER_194_58 VPWR VGND sg13cmos5l_fill_2
XFILLER_325_165 VPWR VGND sg13cmos5l_fill_1
XANTENNA__2500__D Tile_X0Y2_FrameData[28] VPWR VGND sg13cmos5l_antennanp
XANTENNA__3733__X Tile_X0Y4_E1BEG[3] VPWR VGND sg13cmos5l_antennanp
XFILLER_274_80 VPWR VGND sg13cmos5l_decap_4
XANTENNA__1525__A2 AXI_M_SOC_RDATA8 VPWR VGND sg13cmos5l_antennanp
XFILLER_132_282 VPWR VGND sg13cmos5l_fill_1
XFILLER_87_56 VPWR VGND sg13cmos5l_decap_8
XANTENNA__1289__A1 AXI_M_SOC_RDATA28 VPWR VGND sg13cmos5l_antennanp
XANTENNA__3041__GATE Tile_X0Y5_FrameStrobe[8] VPWR VGND sg13cmos5l_antennanp
XFILLER_272_0 VPWR VGND sg13cmos5l_fill_2
XFILLER_293_267 VPWR VGND sg13cmos5l_decap_8
XANTENNA__3331__D Tile_X0Y5_FrameData[29] VPWR VGND sg13cmos5l_antennanp
XFILLER_46_255 VPWR VGND sg13cmos5l_decap_4
XFILLER_36_60 VPWR VGND sg13cmos5l_decap_8
XANTENNA__3056__GATE Tile_X0Y5_FrameStrobe[8] VPWR VGND sg13cmos5l_antennanp
XFILLER_14_130 VPWR VGND sg13cmos5l_fill_2
XFILLER_199_293 VPWR VGND sg13cmos5l_fill_2
XANTENNA__1461__A1 AXI_M_SOC_RDATA16 VPWR VGND sg13cmos5l_antennanp
XANTENNA__1786__D Tile_X0Y0_FrameData[6] VPWR VGND sg13cmos5l_antennanp
XANTENNA__3908__X Tile_X0Y5_S2BEGb[5] VPWR VGND sg13cmos5l_antennanp
XFILLER_14_174 VPWR VGND sg13cmos5l_fill_2
XFILLER_159_179 VPWR VGND sg13cmos5l_decap_8
XFILLER_202_286 VPWR VGND sg13cmos5l_fill_1
X_1790_ _1790_/Q Tile_X0Y0_FrameData[2] Tile_X0Y5_FrameStrobe[2] VPWR VGND sg13cmos5l_dlhq_1
X_0810_ _3845_/A Tile_X0Y5_WW4END[13] _0645_/X _0765_/X _0656_/X _3211_/Q _3212_/Q
+ VPWR VGND sg13cmos5l_mux4_1
XANTENNA__1213__A1 Tile_X0Y0_W2END[7] VPWR VGND sg13cmos5l_antennanp
X_0741_ _0741_/X Tile_X0Y5_N1END[3] Tile_X0Y5_N4END[3] _1133_/B _0739_/X _3098_/Q
+ _3097_/Q VPWR VGND sg13cmos5l_mux4_1
XANTENNA__1428__X AXI_M_SOC_WDATA30 VPWR VGND sg13cmos5l_antennanp
XANTENNA__0972__A0 Tile_X0Y5_W1END[0] VPWR VGND sg13cmos5l_antennanp
X_3460_ Tile_X0Y1_FrameData_O[28] Tile_X0Y1_FrameData[28] VPWR VGND sg13cmos5l_buf_1
X_0672_ _0672_/X Tile_X0Y1_W1END[2] _0965_/X Tile_X0Y1_W6END[10] _0671_/X _2199_/Q
+ _2200_/Q VPWR VGND sg13cmos5l_mux4_1
XANTENNA__3643__X Tile_X0Y0_E2BEG[6] VPWR VGND sg13cmos5l_antennanp
X_2411_ _2411_/Q Tile_X0Y2_FrameData[21] Tile_X0Y5_FrameStrobe[5] VPWR VGND sg13cmos5l_dlhq_1
X_3391_ Tile_X0Y2_EE4BEG[9] _3391_/A VPWR VGND sg13cmos5l_buf_1
XFILLER_42_4 VPWR VGND sg13cmos5l_fill_1
XANTENNA__0724__A0 Tile_X0Y2_W1END[3] VPWR VGND sg13cmos5l_antennanp
XANTENNA__2250__GATE Tile_X0Y5_FrameStrobe[0] VPWR VGND sg13cmos5l_antennanp
XANTENNA__2410__D Tile_X0Y2_FrameData[22] VPWR VGND sg13cmos5l_antennanp
X_2342_ _2342_/Q Tile_X0Y2_FrameData[26] Tile_X0Y5_FrameStrobe[3] VPWR VGND sg13cmos5l_dlhq_1
XANTENNA__2880__GATE Tile_X0Y5_FrameStrobe[2] VPWR VGND sg13cmos5l_antennanp
XFILLER_96_133 VPWR VGND sg13cmos5l_fill_1
XANTENNA__3009__GATE Tile_X0Y5_FrameStrobe[7] VPWR VGND sg13cmos5l_antennanp
X_2273_ _2273_/Q Tile_X0Y2_FrameData[31] Tile_X0Y5_FrameStrobe[1] VPWR VGND sg13cmos5l_dlhq_1
X_1224_ _3603_/A Tile_X0Y0_WW4END[13] AXI_M_SOC_ARREADY _1041_/X _1045_/X _1852_/Q
+ _1851_/Q VPWR VGND sg13cmos5l_mux4_1
XFILLER_37_233 VPWR VGND sg13cmos5l_decap_4
XANTENNA__2265__GATE Tile_X0Y5_FrameStrobe[0] VPWR VGND sg13cmos5l_antennanp
XANTENNA__3241__D Tile_X0Y5_FrameData[7] VPWR VGND sg13cmos5l_antennanp
XFILLER_237_194 VPWR VGND sg13cmos5l_decap_8
X_1155_ _1155_/X Tile_X0Y1_W2MID[7] Tile_X0Y1_W2END[7] Tile_X0Y1_W6END[8] _1110_/X
+ _2196_/Q _2195_/Q VPWR VGND sg13cmos5l_mux4_1
XANTENNA__2895__GATE Tile_X0Y5_FrameStrobe[3] VPWR VGND sg13cmos5l_antennanp
XFILLER_203_87 VPWR VGND sg13cmos5l_fill_2
X_1086_ _1086_/X _1043_/X _1084_/X _1085_/X Tile_X0Y0_S2MID[5] _1981_/Q _1982_/Q VPWR
+ VGND sg13cmos5l_mux4_1
XFILLER_37_277 VPWR VGND sg13cmos5l_fill_2
XFILLER_279_25 VPWR VGND sg13cmos5l_fill_2
XANTENNA__1452__A1 AXI_M_SOC_RDATA17 VPWR VGND sg13cmos5l_antennanp
XANTENNA__3818__X Tile_X0Y5_E2BEG[3] VPWR VGND sg13cmos5l_antennanp
XFILLER_339_279 VPWR VGND sg13cmos5l_fill_1
XANTENNA__1204__A1 Tile_X0Y0_W2END[1] VPWR VGND sg13cmos5l_antennanp
X_3727_ Tile_X0Y3_FrameData_O[30] Tile_X0Y3_FrameData[30] VPWR VGND sg13cmos5l_buf_1
X_1988_ _1988_/Q Tile_X0Y1_FrameData[12] Tile_X0Y5_FrameStrobe[0] VPWR VGND sg13cmos5l_dlhq_1
XANTENNA__2203__GATE Tile_X0Y5_FrameStrobe[7] VPWR VGND sg13cmos5l_antennanp
XANTENNA__2833__GATE Tile_X0Y5_FrameStrobe[1] VPWR VGND sg13cmos5l_antennanp
XFILLER_106_205 VPWR VGND sg13cmos5l_fill_2
X_0939_ _0939_/Y _3297_/Q _0935_/X _0938_/Y VPWR VGND sg13cmos5l_a21oi_1
XANTENNA__0963__A0 Tile_X0Y1_W1END[1] VPWR VGND sg13cmos5l_antennanp
X_3658_ Tile_X0Y3_E2BEG[5] _3658_/A VPWR VGND sg13cmos5l_buf_1
XANTENNA__3553__X Tile_X0Y0_FrameStrobe_O[4] VPWR VGND sg13cmos5l_antennanp
X_2609_ _2609_/Q Tile_X0Y3_FrameData[31] Tile_X0Y5_FrameStrobe[3] VPWR VGND sg13cmos5l_dlhq_1
X_3589_ Tile_X0Y0_FrameData_O[20] Tile_X0Y0_FrameData[20] VPWR VGND sg13cmos5l_buf_1
XANTENNA__2218__GATE Tile_X0Y5_FrameStrobe[7] VPWR VGND sg13cmos5l_antennanp
XANTENNA__2320__D Tile_X0Y2_FrameData[16] VPWR VGND sg13cmos5l_antennanp
XFILLER_87_111 VPWR VGND sg13cmos5l_decap_8
XANTENNA__2848__GATE Tile_X0Y5_FrameStrobe[1] VPWR VGND sg13cmos5l_antennanp
XFILLER_180_16 VPWR VGND sg13cmos5l_fill_1
XFILLER_28_222 VPWR VGND sg13cmos5l_fill_2
XFILLER_290_215 VPWR VGND sg13cmos5l_decap_4
XANTENNA__3151__D Tile_X0Y5_FrameData[1] VPWR VGND sg13cmos5l_antennanp
XFILLER_260_60 VPWR VGND sg13cmos5l_decap_4
XFILLER_290_248 VPWR VGND sg13cmos5l_decap_4
XFILLER_113_87 VPWR VGND sg13cmos5l_decap_8
XFILLER_73_36 VPWR VGND sg13cmos5l_decap_4
XANTENNA__2990__D Tile_X0Y4_FrameData[18] VPWR VGND sg13cmos5l_antennanp
XFILLER_188_219 VPWR VGND sg13cmos5l_fill_1
XFILLER_189_47 VPWR VGND sg13cmos5l_decap_8
XFILLER_43_269 VPWR VGND sg13cmos5l_decap_8
XFILLER_339_39 VPWR VGND sg13cmos5l_fill_1
XANTENNA__3728__X Tile_X0Y3_FrameData_O[31] VPWR VGND sg13cmos5l_antennanp
XFILLER_196_285 VPWR VGND sg13cmos5l_fill_2
XFILLER_11_177 VPWR VGND sg13cmos5l_decap_8
XFILLER_7_126 VPWR VGND sg13cmos5l_decap_4
XFILLER_118_0 VPWR VGND sg13cmos5l_fill_1
XANTENNA__0954__A0 Tile_X0Y1_WW4END[2] VPWR VGND sg13cmos5l_antennanp
XANTENNA__3326__D Tile_X0Y5_FrameData[18] VPWR VGND sg13cmos5l_antennanp
XANTENNA__2230__D Tile_X0Y1_FrameData[26] VPWR VGND sg13cmos5l_antennanp
XANTENNA__3463__X Tile_X0Y1_FrameData_O[31] VPWR VGND sg13cmos5l_antennanp
XFILLER_112_208 VPWR VGND sg13cmos5l_decap_8
XFILLER_105_293 VPWR VGND sg13cmos5l_fill_2
XFILLER_78_122 VPWR VGND sg13cmos5l_decap_8
XFILLER_120_263 VPWR VGND sg13cmos5l_decap_8
XANTENNA__3061__D Tile_X0Y5_FrameData[27] VPWR VGND sg13cmos5l_antennanp
XFILLER_19_233 VPWR VGND sg13cmos5l_decap_8
XFILLER_19_255 VPWR VGND sg13cmos5l_fill_1
XFILLER_93_158 VPWR VGND sg13cmos5l_decap_8
XANTENNA__1682__A1 AXI_M_SOC_RDATA0 VPWR VGND sg13cmos5l_antennanp
XFILLER_320_41 VPWR VGND sg13cmos5l_fill_2
X_2960_ _2960_/Q Tile_X0Y4_FrameData[16] Tile_X0Y5_FrameStrobe[5] VPWR VGND sg13cmos5l_dlhq_1
XFILLER_320_63 VPWR VGND sg13cmos5l_decap_8
X_2891_ _2891_/Q Tile_X0Y4_FrameData[21] Tile_X0Y5_FrameStrobe[3] VPWR VGND sg13cmos5l_dlhq_1
X_1911_ _1911_/Q Tile_X0Y0_FrameData[9] Tile_X0Y5_FrameStrobe[6] VPWR VGND sg13cmos5l_dlhq_1
XANTENNA__2405__D Tile_X0Y2_FrameData[27] VPWR VGND sg13cmos5l_antennanp
XANTENNA__3638__X Tile_X0Y0_E2BEG[1] VPWR VGND sg13cmos5l_antennanp
XFILLER_179_91 VPWR VGND sg13cmos5l_decap_8
X_1842_ _1842_/Q Tile_X0Y0_FrameData[14] Tile_X0Y5_FrameStrobe[4] VPWR VGND sg13cmos5l_dlhq_1
XFILLER_336_249 VPWR VGND sg13cmos5l_decap_4
XANTENNA__1198__A0 Tile_X0Y0_WW4END[2] VPWR VGND sg13cmos5l_antennanp
X_1773_ _1773_/Q Tile_X0Y0_FrameData[19] Tile_X0Y5_FrameStrobe[2] VPWR VGND sg13cmos5l_dlhq_1
XANTENNA__0945__A0 Tile_X0Y1_WW4END[7] VPWR VGND sg13cmos5l_antennanp
X_3512_ Tile_X0Y0_UserCLKo Tile_X0Y0_UserCLK VPWR VGND sg13cmos5l_buf_1
X_0724_ _0724_/X Tile_X0Y2_W1END[3] Tile_X0Y2_W6END[11] _1121_/X _0723_/X _2470_/Q
+ _2469_/Q VPWR VGND sg13cmos5l_mux4_1
XANTENNA__3236__D Tile_X0Y5_FrameData[12] VPWR VGND sg13cmos5l_antennanp
XFILLER_170_141 VPWR VGND sg13cmos5l_decap_8
X_3443_ Tile_X0Y1_FrameData_O[11] Tile_X0Y1_FrameData[11] VPWR VGND sg13cmos5l_buf_1
X_0655_ _0655_/X Tile_X0Y3_W1END[1] Tile_X0Y3_W2MID[2] Tile_X0Y3_W2END[2] _1342_/X
+ _2730_/Q _2729_/Q VPWR VGND sg13cmos5l_mux4_1
XANTENNA__2140__D Tile_X0Y1_FrameData[20] VPWR VGND sg13cmos5l_antennanp
XANTENNA__3373__X Tile_X0Y2_E6BEG[3] VPWR VGND sg13cmos5l_antennanp
XFILLER_170_174 VPWR VGND sg13cmos5l_fill_2
XFILLER_69_100 VPWR VGND sg13cmos5l_decap_8
X_3374_ Tile_X0Y2_E6BEG[4] _3374_/A VPWR VGND sg13cmos5l_buf_1
X_0586_ _0586_/X Tile_X0Y3_W1END[0] Tile_X0Y3_W6END[8] _0882_/X _0585_/X _2748_/Q
+ _2747_/Q VPWR VGND sg13cmos5l_mux4_1
XFILLER_111_252 VPWR VGND sg13cmos5l_fill_2
X_2325_ _2325_/Q Tile_X0Y2_FrameData[11] Tile_X0Y5_FrameStrobe[2] VPWR VGND sg13cmos5l_dlhq_1
XFILLER_111_285 VPWR VGND sg13cmos5l_fill_2
XFILLER_257_256 VPWR VGND sg13cmos5l_decap_8
X_2256_ _2256_/Q Tile_X0Y2_FrameData[16] Tile_X0Y5_FrameStrobe[0] VPWR VGND sg13cmos5l_dlhq_1
XFILLER_84_114 VPWR VGND sg13cmos5l_decap_8
XANTENNA__1122__A0 Tile_X0Y2_W1END[2] VPWR VGND sg13cmos5l_antennanp
X_1207_ AXI_M_SOC_AWADDR23 Tile_X0Y0_W1END[3] Tile_X0Y0_WW4END[15] Tile_X0Y0_WW4END[7]
+ _1124_/X _1769_/Q _1770_/Q VPWR VGND sg13cmos5l_mux4_1
XFILLER_25_214 VPWR VGND sg13cmos5l_decap_8
X_2187_ _2187_/Q Tile_X0Y1_FrameData[5] Tile_X0Y5_FrameStrobe[6] VPWR VGND sg13cmos5l_dlhq_1
X_1138_ _1138_/X Tile_X0Y2_W1END[0] Tile_X0Y2_W6END[4] _1058_/X _0579_/X _2512_/Q
+ _2511_/Q VPWR VGND sg13cmos5l_mux4_1
X_1069_ _1069_/X _1079_/X _1067_/X Tile_X0Y0_S1END[0] Tile_X0Y0_S4END[0] _1736_/Q
+ _1735_/Q VPWR VGND sg13cmos5l_mux4_1
XANTENNA__1425__A1 Tile_X0Y2_WW4END[6] VPWR VGND sg13cmos5l_antennanp
XFILLER_178_241 VPWR VGND sg13cmos5l_decap_8
XANTENNA__2315__D Tile_X0Y2_FrameData[21] VPWR VGND sg13cmos5l_antennanp
XANTENNA__3548__X Tile_X0Y0_N1BEG[3] VPWR VGND sg13cmos5l_antennanp
XFILLER_178_285 VPWR VGND sg13cmos5l_fill_2
XANTENNA__2142__GATE Tile_X0Y5_FrameStrobe[5] VPWR VGND sg13cmos5l_antennanp
XFILLER_239_61 VPWR VGND sg13cmos5l_fill_2
XANTENNA__1189__A0 Tile_X0Y4_W2MID[3] VPWR VGND sg13cmos5l_antennanp
XANTENNA__2772__GATE Tile_X0Y5_FrameStrobe[8] VPWR VGND sg13cmos5l_antennanp
XFILLER_193_255 VPWR VGND sg13cmos5l_decap_8
XANTENNA__2157__GATE Tile_X0Y5_FrameStrobe[5] VPWR VGND sg13cmos5l_antennanp
XANTENNA__3146__D Tile_X0Y5_FrameData[6] VPWR VGND sg13cmos5l_antennanp
XFILLER_335_293 VPWR VGND sg13cmos5l_fill_2
XANTENNA__2050__D Tile_X0Y1_FrameData[14] VPWR VGND sg13cmos5l_antennanp
XANTENNA__2787__GATE Tile_X0Y5_FrameStrobe[0] VPWR VGND sg13cmos5l_antennanp
XANTENNA__3724__A Tile_X0Y3_FrameData[27] VPWR VGND sg13cmos5l_antennanp
XFILLER_161_163 VPWR VGND sg13cmos5l_decap_8
XFILLER_161_174 VPWR VGND sg13cmos5l_fill_1
XANTENNA__2985__D Tile_X0Y4_FrameData[23] VPWR VGND sg13cmos5l_antennanp
XFILLER_191_15 VPWR VGND sg13cmos5l_fill_2
XFILLER_68_47 VPWR VGND sg13cmos5l_decap_8
XANTENNA__2710__GATE Tile_X0Y5_FrameStrobe[6] VPWR VGND sg13cmos5l_antennanp
XFILLER_102_274 VPWR VGND sg13cmos5l_fill_1
XFILLER_124_53 VPWR VGND sg13cmos5l_decap_8
XANTENNA__1113__A0 Tile_X0Y2_W2MID[0] VPWR VGND sg13cmos5l_antennanp
XFILLER_90_117 VPWR VGND sg13cmos5l_decap_8
XFILLER_17_73 VPWR VGND sg13cmos5l_fill_1
XFILLER_216_153 VPWR VGND sg13cmos5l_fill_2
XFILLER_231_112 VPWR VGND sg13cmos5l_fill_1
XANTENNA__2725__GATE Tile_X0Y5_FrameStrobe[6] VPWR VGND sg13cmos5l_antennanp
XANTENNA__1416__A1 Tile_X0Y2_W2END[0] VPWR VGND sg13cmos5l_antennanp
XANTENNA__1981__GATE Tile_X0Y5_FrameStrobe[0] VPWR VGND sg13cmos5l_antennanp
XANTENNA__2225__D Tile_X0Y1_FrameData[31] VPWR VGND sg13cmos5l_antennanp
XANTENNA__3458__X Tile_X0Y1_FrameData_O[26] VPWR VGND sg13cmos5l_antennanp
XFILLER_169_274 VPWR VGND sg13cmos5l_fill_1
XFILLER_235_0 VPWR VGND sg13cmos5l_decap_4
XFILLER_129_127 VPWR VGND sg13cmos5l_decap_4
XFILLER_129_149 VPWR VGND sg13cmos5l_fill_2
XFILLER_184_277 VPWR VGND sg13cmos5l_fill_1
XANTENNA__1996__GATE Tile_X0Y5_FrameStrobe[0] VPWR VGND sg13cmos5l_antennanp
XFILLER_298_101 VPWR VGND sg13cmos5l_fill_2
XFILLER_326_293 VPWR VGND sg13cmos5l_fill_2
XANTENNA__3056__D Tile_X0Y4_FrameData[16] VPWR VGND sg13cmos5l_antennanp
XFILLER_152_152 VPWR VGND sg13cmos5l_fill_1
XFILLER_235_19 VPWR VGND sg13cmos5l_fill_1
XANTENNA__2895__D Tile_X0Y4_FrameData[17] VPWR VGND sg13cmos5l_antennanp
XFILLER_165_93 VPWR VGND sg13cmos5l_decap_8
XANTENNA__1352__A0 Tile_X0Y1_W6END[9] VPWR VGND sg13cmos5l_antennanp
XANTENNA__3921__X Tile_X0Y5_S4BEG[10] VPWR VGND sg13cmos5l_antennanp
XFILLER_239_234 VPWR VGND sg13cmos5l_decap_8
XFILLER_239_245 VPWR VGND sg13cmos5l_fill_1
X_3090_ _3090_/Q Tile_X0Y5_FrameData[30] Tile_X0Y5_FrameStrobe[1] VPWR VGND sg13cmos5l_dlhq_1
X_2110_ _2110_/Q Tile_X0Y1_FrameData[18] Tile_X0Y5_FrameStrobe[4] VPWR VGND sg13cmos5l_dlhq_1
XFILLER_254_237 VPWR VGND sg13cmos5l_decap_8
X_2041_ _2041_/Q Tile_X0Y1_FrameData[23] Tile_X0Y5_FrameStrobe[2] VPWR VGND sg13cmos5l_dlhq_1
XANTENNA__1104__A0 Tile_X0Y0_W2MID[6] VPWR VGND sg13cmos5l_antennanp
XANTENNA__1934__GATE Tile_X0Y5_FrameStrobe[7] VPWR VGND sg13cmos5l_antennanp
XFILLER_207_142 VPWR VGND sg13cmos5l_fill_1
XFILLER_81_117 VPWR VGND sg13cmos5l_decap_4
XANTENNA__1655__A1 Tile_X0Y4_W2END[5] VPWR VGND sg13cmos5l_antennanp
XFILLER_207_164 VPWR VGND sg13cmos5l_fill_2
XFILLER_81_139 VPWR VGND sg13cmos5l_decap_4
XFILLER_22_206 VPWR VGND sg13cmos5l_decap_8
XFILLER_222_178 VPWR VGND sg13cmos5l_decap_4
X_2943_ _2943_/Q Tile_X0Y4_FrameData[1] Tile_X0Y5_FrameStrobe[4] VPWR VGND sg13cmos5l_dlhq_1
XANTENNA__1949__GATE Tile_X0Y5_FrameStrobe[7] VPWR VGND sg13cmos5l_antennanp
XANTENNA__2135__D Tile_X0Y1_FrameData[25] VPWR VGND sg13cmos5l_antennanp
XANTENNA__3368__X Tile_X0Y2_E2BEGb[6] VPWR VGND sg13cmos5l_antennanp
XANTENNA__3809__A Tile_X0Y4_FrameData[31] VPWR VGND sg13cmos5l_antennanp
XFILLER_276_26 VPWR VGND sg13cmos5l_fill_1
X_2874_ _2874_/Q Tile_X0Y4_FrameData[6] Tile_X0Y5_FrameStrobe[2] VPWR VGND sg13cmos5l_dlhq_1
XANTENNA__1974__D Tile_X0Y1_FrameData[26] VPWR VGND sg13cmos5l_antennanp
XFILLER_135_108 VPWR VGND sg13cmos5l_fill_1
XFILLER_175_266 VPWR VGND sg13cmos5l_decap_8
XFILLER_175_277 VPWR VGND sg13cmos5l_fill_1
XFILLER_276_48 VPWR VGND sg13cmos5l_fill_1
X_1825_ _1825_/Q Tile_X0Y0_FrameData[31] Tile_X0Y5_FrameStrobe[4] VPWR VGND sg13cmos5l_dlhq_1
X_1756_ _1756_/Q Tile_X0Y0_FrameData[4] Tile_X0Y5_FrameStrobe[1] VPWR VGND sg13cmos5l_dlhq_1
XFILLER_128_193 VPWR VGND sg13cmos5l_decap_8
XFILLER_143_141 VPWR VGND sg13cmos5l_decap_8
XFILLER_209_86 VPWR VGND sg13cmos5l_decap_4
XFILLER_292_14 VPWR VGND sg13cmos5l_decap_4
X_0707_ _0707_/Y _3261_/Q _0703_/X _0706_/Y VPWR VGND sg13cmos5l_a21oi_1
XFILLER_317_293 VPWR VGND sg13cmos5l_fill_2
XFILLER_143_152 VPWR VGND sg13cmos5l_fill_1
X_1687_ _1687_/X Tile_X0Y4_W1END[1] Tile_X0Y4_W6END[5] Tile_X0Y4_WW4END[13] _1029_/X
+ _2992_/Q _2993_/Q VPWR VGND sg13cmos5l_mux4_1
XFILLER_332_263 VPWR VGND sg13cmos5l_fill_1
XFILLER_332_241 VPWR VGND sg13cmos5l_fill_2
XFILLER_292_58 VPWR VGND sg13cmos5l_decap_4
X_3426_ Tile_X0Y2_FrameData_O[28] Tile_X0Y2_FrameData[28] VPWR VGND sg13cmos5l_buf_1
X_0638_ _0639_/C _2790_/Q _1023_/X VPWR VGND sg13cmos5l_nor2_1
XANTENNA__1343__A0 Tile_X0Y1_W6END[8] VPWR VGND sg13cmos5l_antennanp
X_3357_ Tile_X0Y2_E2BEG[3] _3357_/A VPWR VGND sg13cmos5l_buf_1
X_0569_ _0569_/Y _1976_/Q _1975_/Q VPWR VGND sg13cmos5l_nor2b_1
XANTENNA__3831__X Tile_X0Y5_E6BEG[0] VPWR VGND sg13cmos5l_antennanp
XFILLER_161_18 VPWR VGND sg13cmos5l_fill_1
XFILLER_225_96 VPWR VGND sg13cmos5l_decap_8
X_2308_ _2308_/Q Tile_X0Y2_FrameData[28] Tile_X0Y5_FrameStrobe[2] VPWR VGND sg13cmos5l_dlhq_1
XFILLER_38_39 VPWR VGND sg13cmos5l_decap_8
X_3288_ _3288_/Q Tile_X0Y5_FrameData[24] Tile_X0Y5_FrameStrobe[7] VPWR VGND sg13cmos5l_dlhq_1
XFILLER_241_62 VPWR VGND sg13cmos5l_fill_1
X_2239_ _2239_/Q Tile_X0Y1_FrameData[17] Tile_X0Y5_FrameStrobe[8] VPWR VGND sg13cmos5l_dlhq_1
XANTENNA__1646__A1 Tile_X0Y4_W2END[4] VPWR VGND sg13cmos5l_antennanp
XFILLER_241_84 VPWR VGND sg13cmos5l_decap_8
XANTENNA__1110__A3 Tile_X0Y0_S2MID[0] VPWR VGND sg13cmos5l_antennanp
XFILLER_253_281 VPWR VGND sg13cmos5l_fill_1
XFILLER_110_22 VPWR VGND sg13cmos5l_decap_4
XFILLER_13_217 VPWR VGND sg13cmos5l_fill_1
XANTENNA__2045__D Tile_X0Y1_FrameData[19] VPWR VGND sg13cmos5l_antennanp
XANTENNA__2081__GATE Tile_X0Y5_FrameStrobe[3] VPWR VGND sg13cmos5l_antennanp
XANTENNA__3719__A Tile_X0Y3_FrameData[22] VPWR VGND sg13cmos5l_antennanp
XFILLER_110_55 VPWR VGND sg13cmos5l_decap_8
XANTENNA__1884__D Tile_X0Y0_FrameData[4] VPWR VGND sg13cmos5l_antennanp
XFILLER_181_225 VPWR VGND sg13cmos5l_decap_8
XANTENNA__2096__GATE Tile_X0Y5_FrameStrobe[3] VPWR VGND sg13cmos5l_antennanp
XFILLER_119_182 VPWR VGND sg13cmos5l_decap_8
XFILLER_308_293 VPWR VGND sg13cmos5l_fill_2
XFILLER_79_35 VPWR VGND sg13cmos5l_decap_8
XANTENNA__1582__A0 Tile_X0Y3_W1END[3] VPWR VGND sg13cmos5l_antennanp
XANTENNA__3454__A Tile_X0Y1_FrameData[22] VPWR VGND sg13cmos5l_antennanp
XFILLER_323_263 VPWR VGND sg13cmos5l_decap_4
XANTENNA__1334__A0 Tile_X0Y1_W2END[7] VPWR VGND sg13cmos5l_antennanp
XANTENNA__3741__X Tile_X0Y4_E2BEG[7] VPWR VGND sg13cmos5l_antennanp
XFILLER_95_56 VPWR VGND sg13cmos5l_decap_8
XFILLER_185_0 VPWR VGND sg13cmos5l_decap_4
XFILLER_236_226 VPWR VGND sg13cmos5l_fill_2
XFILLER_28_50 VPWR VGND sg13cmos5l_decap_8
XFILLER_48_147 VPWR VGND sg13cmos5l_decap_8
XANTENNA__2034__GATE Tile_X0Y5_FrameStrobe[2] VPWR VGND sg13cmos5l_antennanp
XANTENNA__1637__A1 Tile_X0Y4_WW4END[15] VPWR VGND sg13cmos5l_antennanp
XANTENNA__2664__GATE Tile_X0Y5_FrameStrobe[4] VPWR VGND sg13cmos5l_antennanp
XFILLER_56_191 VPWR VGND sg13cmos5l_decap_8
XANTENNA__2049__GATE Tile_X0Y5_FrameStrobe[2] VPWR VGND sg13cmos5l_antennanp
XFILLER_204_178 VPWR VGND sg13cmos5l_decap_4
XANTENNA__2679__GATE Tile_X0Y5_FrameStrobe[5] VPWR VGND sg13cmos5l_antennanp
XFILLER_81_8 VPWR VGND sg13cmos5l_decap_8
XANTENNA__1794__D Tile_X0Y0_FrameData[30] VPWR VGND sg13cmos5l_antennanp
XFILLER_157_266 VPWR VGND sg13cmos5l_fill_1
XANTENNA__3916__X Tile_X0Y5_S4BEG[5] VPWR VGND sg13cmos5l_antennanp
X_1610_ _3770_/A Tile_X0Y4_WW4END[7] AXI_M_SOC_RDATA5 _1125_/X _1361_/X _2928_/Q _2927_/Q
+ VPWR VGND sg13cmos5l_mux4_1
XFILLER_8_276 VPWR VGND sg13cmos5l_decap_4
XFILLER_60_70 VPWR VGND sg13cmos5l_decap_4
XANTENNA__2602__GATE Tile_X0Y5_FrameStrobe[2] VPWR VGND sg13cmos5l_antennanp
XFILLER_176_81 VPWR VGND sg13cmos5l_fill_1
X_2590_ _2590_/Q Tile_X0Y3_FrameData[18] Tile_X0Y5_FrameStrobe[2] VPWR VGND sg13cmos5l_dlhq_1
X_1541_ _3676_/A AXI_M_SOC_RDATA9 _1436_/X _1521_/X _1587_/B _2626_/Q _2625_/Q VPWR
+ VGND sg13cmos5l_mux4_1
XFILLER_314_274 VPWR VGND sg13cmos5l_decap_4
X_1472_ _3391_/A Tile_X0Y2_WW4END[6] _1313_/X AXI_M_SOC_RDATA20 _1175_/X _2381_/Q
+ _2382_/Q VPWR VGND sg13cmos5l_mux4_1
XANTENNA__1325__A0 Tile_X0Y1_W6END[10] VPWR VGND sg13cmos5l_antennanp
XANTENNA__2617__GATE Tile_X0Y5_FrameStrobe[3] VPWR VGND sg13cmos5l_antennanp
XFILLER_140_166 VPWR VGND sg13cmos5l_decap_8
X_3211_ _3211_/Q Tile_X0Y5_FrameData[5] Tile_X0Y5_FrameStrobe[4] VPWR VGND sg13cmos5l_dlhq_1
XANTENNA__3651__X Tile_X0Y3_E1BEG[2] VPWR VGND sg13cmos5l_antennanp
X_3142_ _3142_/Q Tile_X0Y5_FrameData[10] Tile_X0Y5_FrameStrobe[2] VPWR VGND sg13cmos5l_dlhq_1
XFILLER_79_294 VPWR VGND sg13cmos5l_fill_1
XANTENNA__1873__GATE Tile_X0Y5_FrameStrobe[5] VPWR VGND sg13cmos5l_antennanp
XFILLER_294_181 VPWR VGND sg13cmos5l_decap_4
X_3073_ _3073_/Q Tile_X0Y5_FrameData[15] Tile_X0Y5_FrameStrobe[0] VPWR VGND sg13cmos5l_dlhq_1
XANTENNA__1969__D Tile_X0Y0_FrameData[31] VPWR VGND sg13cmos5l_antennanp
XFILLER_242_218 VPWR VGND sg13cmos5l_decap_8
X_2024_ _2024_/Q Tile_X0Y1_FrameData[8] Tile_X0Y5_FrameStrobe[1] VPWR VGND sg13cmos5l_dlhq_1
XANTENNA__1888__GATE Tile_X0Y5_FrameStrobe[5] VPWR VGND sg13cmos5l_antennanp
XFILLER_211_98 VPWR VGND sg13cmos5l_decap_8
XFILLER_287_14 VPWR VGND sg13cmos5l_decap_8
X_2926_ _2926_/Q Tile_X0Y4_FrameData[18] Tile_X0Y5_FrameStrobe[4] VPWR VGND sg13cmos5l_dlhq_1
XANTENNA__1811__GATE Tile_X0Y5_FrameStrobe[3] VPWR VGND sg13cmos5l_antennanp
X_2857_ _2857_/Q Tile_X0Y4_FrameData[23] Tile_X0Y5_FrameStrobe[2] VPWR VGND sg13cmos5l_dlhq_1
XANTENNA__3826__X Tile_X0Y5_E2BEGb[3] VPWR VGND sg13cmos5l_antennanp
XFILLER_108_108 VPWR VGND sg13cmos5l_fill_1
X_1808_ _1808_/Q Tile_X0Y0_FrameData[16] Tile_X0Y5_FrameStrobe[3] VPWR VGND sg13cmos5l_dlhq_1
XANTENNA__1159__A3 AXI_M_SOC_WREADY VPWR VGND sg13cmos5l_antennanp
XFILLER_163_258 VPWR VGND sg13cmos5l_fill_2
XFILLER_163_269 VPWR VGND sg13cmos5l_fill_1
X_2788_ _2788_/Q Tile_X0Y4_FrameData[28] Tile_X0Y5_FrameStrobe[0] VPWR VGND sg13cmos5l_dlhq_1
XANTENNA__1564__A0 Tile_X0Y3_W2MID[5] VPWR VGND sg13cmos5l_antennanp
XANTENNA__1826__GATE Tile_X0Y5_FrameStrobe[4] VPWR VGND sg13cmos5l_antennanp
X_1739_ _1739_/Q Tile_X0Y0_FrameData[21] Tile_X0Y5_FrameStrobe[1] VPWR VGND sg13cmos5l_dlhq_1
XFILLER_277_104 VPWR VGND sg13cmos5l_fill_1
XANTENNA__1316__A0 Tile_X0Y2_W1END[1] VPWR VGND sg13cmos5l_antennanp
X_3409_ Tile_X0Y2_FrameData_O[11] Tile_X0Y2_FrameData[11] VPWR VGND sg13cmos5l_buf_1
XANTENNA__3561__X Tile_X0Y0_FrameStrobe_O[12] VPWR VGND sg13cmos5l_antennanp
XFILLER_105_11 VPWR VGND sg13cmos5l_decap_8
XFILLER_277_159 VPWR VGND sg13cmos5l_fill_1
XFILLER_292_107 VPWR VGND sg13cmos5l_fill_2
XFILLER_320_266 VPWR VGND sg13cmos5l_fill_1
XFILLER_283_8 VPWR VGND sg13cmos5l_decap_8
XFILLER_65_15 VPWR VGND sg13cmos5l_fill_1
XANTENNA__1331__A3 AXI_M_SOC_RDATA28 VPWR VGND sg13cmos5l_antennanp
XFILLER_218_248 VPWR VGND sg13cmos5l_decap_8
XFILLER_285_192 VPWR VGND sg13cmos5l_fill_2
XFILLER_85_286 VPWR VGND sg13cmos5l_fill_1
XFILLER_85_264 VPWR VGND sg13cmos5l_decap_4
XFILLER_65_37 VPWR VGND sg13cmos5l_decap_8
XANTENNA__1619__A1 AXI_M_SOC_RRESP0 VPWR VGND sg13cmos5l_antennanp
XANTENNA__1879__D Tile_X0Y0_FrameData[9] VPWR VGND sg13cmos5l_antennanp
XFILLER_53_172 VPWR VGND sg13cmos5l_decap_8
XANTENNA__0842__A2 Tile_X0Y5_WW4END[5] VPWR VGND sg13cmos5l_antennanp
XANTENNA__3449__A Tile_X0Y1_FrameData[17] VPWR VGND sg13cmos5l_antennanp
XFILLER_121_98 VPWR VGND sg13cmos5l_fill_1
XFILLER_197_14 VPWR VGND sg13cmos5l_fill_2
XFILLER_81_47 VPWR VGND sg13cmos5l_decap_8
XFILLER_197_58 VPWR VGND sg13cmos5l_fill_2
XANTENNA__2503__D Tile_X0Y2_FrameData[25] VPWR VGND sg13cmos5l_antennanp
XANTENNA__3736__X Tile_X0Y4_E2BEG[2] VPWR VGND sg13cmos5l_antennanp
XANTENNA__3332__GATE Tile_X0Y5_FrameStrobe[9] VPWR VGND sg13cmos5l_antennanp
XANTENNA__1555__A0 Tile_X0Y3_W2MID[4] VPWR VGND sg13cmos5l_antennanp
XFILLER_100_0 VPWR VGND sg13cmos5l_fill_2
XFILLER_107_196 VPWR VGND sg13cmos5l_decap_8
XFILLER_146_51 VPWR VGND sg13cmos5l_decap_8
XFILLER_146_62 VPWR VGND sg13cmos5l_fill_2
XFILLER_122_166 VPWR VGND sg13cmos5l_decap_8
XFILLER_146_95 VPWR VGND sg13cmos5l_decap_8
XFILLER_293_90 VPWR VGND sg13cmos5l_decap_8
XANTENNA__1307__A0 Tile_X0Y1_W2MID[3] VPWR VGND sg13cmos5l_antennanp
XANTENNA__3334__D Tile_X0Y5_FrameData[0] VPWR VGND sg13cmos5l_antennanp
XANTENNA__3347__GATE Tile_X0Y5_FrameStrobe[8] VPWR VGND sg13cmos5l_antennanp
XANTENNA__3471__X Tile_X0Y1_EE4BEG[7] VPWR VGND sg13cmos5l_antennanp
XFILLER_209_226 VPWR VGND sg13cmos5l_fill_1
XANTENNA__1789__D Tile_X0Y0_FrameData[3] VPWR VGND sg13cmos5l_antennanp
XFILLER_291_151 VPWR VGND sg13cmos5l_fill_1
XFILLER_291_173 VPWR VGND sg13cmos5l_decap_8
XFILLER_55_70 VPWR VGND sg13cmos5l_decap_8
XFILLER_51_109 VPWR VGND sg13cmos5l_decap_4
XFILLER_44_194 VPWR VGND sg13cmos5l_decap_8
XFILLER_338_108 VPWR VGND sg13cmos5l_decap_4
X_3760_ Tile_X0Y4_E6BEG[10] _3760_/A VPWR VGND sg13cmos5l_buf_1
X_0972_ _3899_/A Tile_X0Y5_W1END[0] Tile_X0Y5_W2MID[3] Tile_X0Y5_W2END[3] _0607_/X
+ _3276_/Q _3275_/Q VPWR VGND sg13cmos5l_mux4_1
X_2711_ _2711_/Q Tile_X0Y3_FrameData[25] Tile_X0Y5_FrameStrobe[6] VPWR VGND sg13cmos5l_dlhq_1
XFILLER_71_91 VPWR VGND sg13cmos5l_decap_8
XANTENNA__0597__A1 Tile_X0Y5_N4END[0] VPWR VGND sg13cmos5l_antennanp
XANTENNA__2413__D Tile_X0Y2_FrameData[19] VPWR VGND sg13cmos5l_antennanp
XANTENNA__2541__GATE Tile_X0Y5_FrameStrobe[0] VPWR VGND sg13cmos5l_antennanp
XANTENNA__3646__X Tile_X0Y0_E1BEG[1] VPWR VGND sg13cmos5l_antennanp
XFILLER_187_91 VPWR VGND sg13cmos5l_decap_8
X_3691_ Tile_X0Y3_EE4BEG[10] _3691_/A VPWR VGND sg13cmos5l_buf_1
X_2642_ _2642_/Q Tile_X0Y3_FrameData[30] Tile_X0Y5_FrameStrobe[4] VPWR VGND sg13cmos5l_dlhq_1
XANTENNA__1546__A0 AXI_M_SOC_RDATA10 VPWR VGND sg13cmos5l_antennanp
X_2573_ _2573_/Q Tile_X0Y3_FrameData[3] Tile_X0Y5_FrameStrobe[1] VPWR VGND sg13cmos5l_dlhq_1
XFILLER_337_83 VPWR VGND sg13cmos5l_fill_1
XANTENNA__1010__A2 Tile_X0Y0_S2MID[6] VPWR VGND sg13cmos5l_antennanp
XANTENNA__2556__GATE Tile_X0Y5_FrameStrobe[1] VPWR VGND sg13cmos5l_antennanp
XFILLER_113_111 VPWR VGND sg13cmos5l_decap_8
X_1524_ _1524_/X _0987_/X _0678_/X Tile_X0Y5_N4END[10] Tile_X0Y0_S4END[14] _2563_/Q
+ _2564_/Q VPWR VGND sg13cmos5l_mux4_1
XANTENNA__3244__D Tile_X0Y5_FrameData[4] VPWR VGND sg13cmos5l_antennanp
XANTENNA__3381__X Tile_X0Y2_E6BEG[11] VPWR VGND sg13cmos5l_antennanp
XFILLER_302_277 VPWR VGND sg13cmos5l_decap_4
X_1455_ _3356_/A Tile_X0Y2_W2MID[5] AXI_M_SOC_RDATA16 _1151_/X _1183_/X _2428_/Q _2427_/Q
+ VPWR VGND sg13cmos5l_mux4_1
X_1386_ _1386_/Y _2481_/Q _1385_/X _2480_/Q VPWR VGND sg13cmos5l_o21ai_1
XFILLER_67_242 VPWR VGND sg13cmos5l_decap_4
XANTENNA__1313__A3 Tile_X0Y0_S4END[10] VPWR VGND sg13cmos5l_antennanp
XFILLER_222_20 VPWR VGND sg13cmos5l_fill_2
X_3125_ _3125_/Q Tile_X0Y5_FrameData[27] Tile_X0Y5_FrameStrobe[2] VPWR VGND sg13cmos5l_dlhq_1
X_3056_ _3056_/Q Tile_X0Y4_FrameData[16] Tile_X0Y5_FrameStrobe[8] VPWR VGND sg13cmos5l_dlhq_1
XANTENNA__1699__D Tile_X0Y0_FrameData[29] VPWR VGND sg13cmos5l_antennanp
X_2007_ _2007_/Q Tile_X0Y1_FrameData[25] Tile_X0Y5_FrameStrobe[1] VPWR VGND sg13cmos5l_dlhq_1
XANTENNA__1077__A2 Tile_X0Y1_W6END[3] VPWR VGND sg13cmos5l_antennanp
XFILLER_298_24 VPWR VGND sg13cmos5l_decap_8
XFILLER_35_183 VPWR VGND sg13cmos5l_decap_8
XFILLER_298_79 VPWR VGND sg13cmos5l_fill_1
XFILLER_50_142 VPWR VGND sg13cmos5l_decap_8
XANTENNA__1750__GATE Tile_X0Y5_FrameStrobe[1] VPWR VGND sg13cmos5l_antennanp
XFILLER_195_136 VPWR VGND sg13cmos5l_decap_8
XANTENNA__2509__GATE Tile_X0Y5_FrameStrobe[8] VPWR VGND sg13cmos5l_antennanp
XFILLER_51_28 VPWR VGND sg13cmos5l_decap_8
XANTENNA__2323__D Tile_X0Y2_FrameData[13] VPWR VGND sg13cmos5l_antennanp
XANTENNA__3556__X Tile_X0Y0_FrameStrobe_O[7] VPWR VGND sg13cmos5l_antennanp
X_2909_ _2909_/Q Tile_X0Y4_FrameData[3] Tile_X0Y5_FrameStrobe[3] VPWR VGND sg13cmos5l_dlhq_1
X_3889_ Tile_X0Y5_FrameData_O[30] Tile_X0Y5_FrameData[30] VPWR VGND sg13cmos5l_buf_1
XANTENNA__1537__A0 Tile_X0Y5_N4END[9] VPWR VGND sg13cmos5l_antennanp
XANTENNA__1765__GATE Tile_X0Y5_FrameStrobe[2] VPWR VGND sg13cmos5l_antennanp
XFILLER_2_205 VPWR VGND sg13cmos5l_fill_1
XFILLER_104_133 VPWR VGND sg13cmos5l_decap_8
XANTENNA__3154__D Tile_X0Y5_FrameData[30] VPWR VGND sg13cmos5l_antennanp
XFILLER_263_60 VPWR VGND sg13cmos5l_fill_1
XFILLER_76_25 VPWR VGND sg13cmos5l_decap_8
XANTENNA__2993__D Tile_X0Y4_FrameData[15] VPWR VGND sg13cmos5l_antennanp
XANTENNA__1703__GATE Tile_X0Y5_FrameStrobe[0] VPWR VGND sg13cmos5l_antennanp
XFILLER_273_162 VPWR VGND sg13cmos5l_decap_4
XFILLER_206_229 VPWR VGND sg13cmos5l_fill_2
XFILLER_92_35 VPWR VGND sg13cmos5l_decap_8
XANTENNA__1068__A2 Tile_X0Y0_S1END[0] VPWR VGND sg13cmos5l_antennanp
XANTENNA__0815__A2 AXI_M_SOC_RLAST VPWR VGND sg13cmos5l_antennanp
XANTENNA__1718__GATE Tile_X0Y5_FrameStrobe[0] VPWR VGND sg13cmos5l_antennanp
XFILLER_148_0 VPWR VGND sg13cmos5l_decap_8
XFILLER_41_142 VPWR VGND sg13cmos5l_decap_8
XFILLER_186_169 VPWR VGND sg13cmos5l_decap_4
XFILLER_41_186 VPWR VGND sg13cmos5l_decap_8
XANTENNA__2233__D Tile_X0Y1_FrameData[23] VPWR VGND sg13cmos5l_antennanp
XANTENNA__3329__D Tile_X0Y5_FrameData[31] VPWR VGND sg13cmos5l_antennanp
XANTENNA__3466__X Tile_X0Y1_EE4BEG[2] VPWR VGND sg13cmos5l_antennanp
XFILLER_127_203 VPWR VGND sg13cmos5l_fill_2
XANTENNA__3271__GATE Tile_X0Y5_FrameStrobe[6] VPWR VGND sg13cmos5l_antennanp
XFILLER_41_83 VPWR VGND sg13cmos5l_fill_2
XANTENNA__1528__A0 Tile_X0Y3_WW4END[4] VPWR VGND sg13cmos5l_antennanp
XFILLER_157_83 VPWR VGND sg13cmos5l_decap_8
XANTENNA__3286__GATE Tile_X0Y5_FrameStrobe[7] VPWR VGND sg13cmos5l_antennanp
XFILLER_44_8 VPWR VGND sg13cmos5l_decap_8
XANTENNA__3064__D Tile_X0Y5_FrameData[24] VPWR VGND sg13cmos5l_antennanp
XFILLER_110_103 VPWR VGND sg13cmos5l_decap_8
XFILLER_173_93 VPWR VGND sg13cmos5l_decap_8
XFILLER_2_44 VPWR VGND sg13cmos5l_fill_1
X_1240_ _3626_/A AXI_M_SOC_BRESP1 _1004_/X _1007_/X _1045_/X _1805_/Q _1806_/Q VPWR
+ VGND sg13cmos5l_mux4_1
XFILLER_49_242 VPWR VGND sg13cmos5l_fill_1
X_1171_ _1171_/X Tile_X0Y0_W1END[1] Tile_X0Y0_WW4END[1] _1037_/X _1038_/X _1941_/Q
+ _1939_/Q VPWR VGND sg13cmos5l_mux4_1
XFILLER_49_264 VPWR VGND sg13cmos5l_decap_4
XFILLER_323_41 VPWR VGND sg13cmos5l_fill_1
XFILLER_264_162 VPWR VGND sg13cmos5l_decap_8
XFILLER_323_85 VPWR VGND sg13cmos5l_decap_8
XANTENNA__2408__D Tile_X0Y2_FrameData[24] VPWR VGND sg13cmos5l_antennanp
XFILLER_64_267 VPWR VGND sg13cmos5l_decap_4
XFILLER_17_172 VPWR VGND sg13cmos5l_decap_8
XFILLER_64_278 VPWR VGND sg13cmos5l_fill_1
XANTENNA__3224__GATE Tile_X0Y5_FrameStrobe[5] VPWR VGND sg13cmos5l_antennanp
X_3812_ Tile_X0Y5_E1BEG[1] _3812_/A VPWR VGND sg13cmos5l_buf_1
XFILLER_32_153 VPWR VGND sg13cmos5l_decap_8
XANTENNA__2480__GATE Tile_X0Y5_FrameStrobe[7] VPWR VGND sg13cmos5l_antennanp
XFILLER_220_265 VPWR VGND sg13cmos5l_fill_2
XFILLER_32_197 VPWR VGND sg13cmos5l_decap_8
XANTENNA__2143__D Tile_X0Y1_FrameData[17] VPWR VGND sg13cmos5l_antennanp
XANTENNA__3239__D Tile_X0Y5_FrameData[9] VPWR VGND sg13cmos5l_antennanp
XANTENNA__3239__GATE Tile_X0Y5_FrameStrobe[5] VPWR VGND sg13cmos5l_antennanp
XANTENNA__3376__X Tile_X0Y2_E6BEG[6] VPWR VGND sg13cmos5l_antennanp
X_3743_ Tile_X0Y4_E2BEGb[1] _3743_/A VPWR VGND sg13cmos5l_buf_1
X_0955_ AXI_M_SOC_AWLEN2 _3337_/Q _0954_/X VPWR VGND sg13cmos5l_nor2b_1
X_3674_ Tile_X0Y3_E6BEG[5] _3674_/A VPWR VGND sg13cmos5l_buf_1
X_0886_ _0887_/B Tile_X0Y3_W1END[1] Tile_X0Y3_WW4END[13] Tile_X0Y3_WW4END[5] _0885_/X
+ _2589_/Q _2590_/Q VPWR VGND sg13cmos5l_mux4_1
XFILLER_334_100 VPWR VGND sg13cmos5l_fill_1
XANTENNA__1519__A0 Tile_X0Y3_W2END[1] VPWR VGND sg13cmos5l_antennanp
XANTENNA__1982__D Tile_X0Y1_FrameData[18] VPWR VGND sg13cmos5l_antennanp
X_2625_ _2625_/Q Tile_X0Y3_FrameData[15] Tile_X0Y5_FrameStrobe[3] VPWR VGND sg13cmos5l_dlhq_1
XFILLER_63_0 VPWR VGND sg13cmos5l_fill_2
XANTENNA__2495__GATE Tile_X0Y5_FrameStrobe[7] VPWR VGND sg13cmos5l_antennanp
XFILLER_133_228 VPWR VGND sg13cmos5l_decap_8
XFILLER_217_20 VPWR VGND sg13cmos5l_decap_8
XFILLER_217_64 VPWR VGND sg13cmos5l_fill_1
XFILLER_287_232 VPWR VGND sg13cmos5l_decap_8
X_2556_ _2556_/Q Tile_X0Y3_FrameData[20] Tile_X0Y5_FrameStrobe[1] VPWR VGND sg13cmos5l_dlhq_1
XANTENNA__0742__A1 Tile_X0Y5_N4END[3] VPWR VGND sg13cmos5l_antennanp
XANTENNA__3552__A Tile_X0Y5_FrameStrobe[3] VPWR VGND sg13cmos5l_antennanp
X_2487_ _2487_/Q Tile_X0Y2_FrameData[9] Tile_X0Y5_FrameStrobe[7] VPWR VGND sg13cmos5l_dlhq_1
X_1507_ _3657_/A Tile_X0Y3_W2MID[3] AXI_M_SOC_RDATA10 _1587_/B _1271_/X _2696_/Q _2695_/Q
+ VPWR VGND sg13cmos5l_mux4_1
XFILLER_101_125 VPWR VGND sg13cmos5l_decap_8
XFILLER_141_294 VPWR VGND sg13cmos5l_fill_1
X_1438_ _1439_/B Tile_X0Y2_W1END[1] Tile_X0Y2_W6END[5] Tile_X0Y2_WW4END[13] _1388_/X
+ _2448_/Q _2449_/Q VPWR VGND sg13cmos5l_mux4_1
XFILLER_233_41 VPWR VGND sg13cmos5l_decap_8
X_3108_ _3108_/Q Tile_X0Y5_FrameData[12] Tile_X0Y5_FrameStrobe[1] VPWR VGND sg13cmos5l_dlhq_1
X_1369_ _1369_/X _1018_/X _0623_/X Tile_X0Y5_N4END[13] Tile_X0Y0_S4END[9] _2277_/Q
+ _2278_/Q VPWR VGND sg13cmos5l_mux4_1
XFILLER_46_39 VPWR VGND sg13cmos5l_decap_8
XANTENNA__2433__GATE Tile_X0Y5_FrameStrobe[6] VPWR VGND sg13cmos5l_antennanp
XANTENNA__2318__D Tile_X0Y2_FrameData[18] VPWR VGND sg13cmos5l_antennanp
X_3039_ _3039_/Q Tile_X0Y4_FrameData[1] Tile_X0Y5_FrameStrobe[7] VPWR VGND sg13cmos5l_dlhq_1
XFILLER_70_226 VPWR VGND sg13cmos5l_decap_4
XFILLER_70_248 VPWR VGND sg13cmos5l_fill_1
XFILLER_141_7 VPWR VGND sg13cmos5l_decap_8
XFILLER_178_27 VPWR VGND sg13cmos5l_fill_1
XFILLER_62_49 VPWR VGND sg13cmos5l_decap_8
XANTENNA__2448__GATE Tile_X0Y5_FrameStrobe[6] VPWR VGND sg13cmos5l_antennanp
XFILLER_178_49 VPWR VGND sg13cmos5l_fill_1
XANTENNA__2053__D Tile_X0Y1_FrameData[11] VPWR VGND sg13cmos5l_antennanp
XANTENNA__3149__D Tile_X0Y5_FrameData[3] VPWR VGND sg13cmos5l_antennanp
XFILLER_109_214 VPWR VGND sg13cmos5l_decap_8
XANTENNA__1222__A2 Tile_X0Y0_S4END[0] VPWR VGND sg13cmos5l_antennanp
XANTENNA__3727__A Tile_X0Y3_FrameData[30] VPWR VGND sg13cmos5l_antennanp
XFILLER_194_15 VPWR VGND sg13cmos5l_fill_2
XANTENNA__1892__D Tile_X0Y0_FrameData[28] VPWR VGND sg13cmos5l_antennanp
XANTENNA__2988__D Tile_X0Y4_FrameData[20] VPWR VGND sg13cmos5l_antennanp
XFILLER_127_31 VPWR VGND sg13cmos5l_fill_1
XANTENNA__3462__A Tile_X0Y1_FrameData[30] VPWR VGND sg13cmos5l_antennanp
XFILLER_127_86 VPWR VGND sg13cmos5l_fill_2
XFILLER_87_35 VPWR VGND sg13cmos5l_decap_8
XFILLER_132_294 VPWR VGND sg13cmos5l_fill_1
XFILLER_100_180 VPWR VGND sg13cmos5l_fill_1
XFILLER_261_121 VPWR VGND sg13cmos5l_fill_1
XFILLER_46_234 VPWR VGND sg13cmos5l_decap_4
XANTENNA__2228__D Tile_X0Y1_FrameData[28] VPWR VGND sg13cmos5l_antennanp
XFILLER_61_248 VPWR VGND sg13cmos5l_decap_4
XFILLER_36_83 VPWR VGND sg13cmos5l_fill_1
XFILLER_14_153 VPWR VGND sg13cmos5l_fill_1
XANTENNA__3059__D Tile_X0Y5_FrameData[29] VPWR VGND sg13cmos5l_antennanp
XANTENNA__1213__A2 Tile_X0Y0_W6END[7] VPWR VGND sg13cmos5l_antennanp
X_0740_ _0740_/X Tile_X0Y5_N1END[3] Tile_X0Y5_N4END[3] _1133_/B _0739_/X _3082_/Q
+ _3081_/Q VPWR VGND sg13cmos5l_mux4_1
XANTENNA__2898__D Tile_X0Y4_FrameData[14] VPWR VGND sg13cmos5l_antennanp
XFILLER_316_155 VPWR VGND sg13cmos5l_decap_8
XANTENNA__0972__A1 Tile_X0Y5_W2MID[3] VPWR VGND sg13cmos5l_antennanp
XANTENNA__3924__X Tile_X0Y5_S4BEG[13] VPWR VGND sg13cmos5l_antennanp
XFILLER_182_183 VPWR VGND sg13cmos5l_decap_8
X_2410_ _2410_/Q Tile_X0Y2_FrameData[22] Tile_X0Y5_FrameStrobe[5] VPWR VGND sg13cmos5l_dlhq_1
X_0671_ _0671_/X _0666_/X _0667_/Y _0670_/Y VPWR VGND sg13cmos5l_a21o_1
XFILLER_254_18 VPWR VGND sg13cmos5l_fill_2
X_3390_ Tile_X0Y2_EE4BEG[8] _3390_/A VPWR VGND sg13cmos5l_buf_1
XFILLER_331_125 VPWR VGND sg13cmos5l_fill_2
XANTENNA__0724__A1 Tile_X0Y2_W6END[11] VPWR VGND sg13cmos5l_antennanp
X_2341_ _2341_/Q Tile_X0Y2_FrameData[27] Tile_X0Y5_FrameStrobe[3] VPWR VGND sg13cmos5l_dlhq_1
XFILLER_123_294 VPWR VGND sg13cmos5l_fill_1
X_2272_ _2272_/Q Tile_X0Y2_FrameData[0] Tile_X0Y5_FrameStrobe[0] VPWR VGND sg13cmos5l_dlhq_1
X_1223_ _3602_/A Tile_X0Y0_WW4END[14] AXI_M_SOC_RDATA31 _1006_/X _1010_/X _1854_/Q
+ _1853_/Q VPWR VGND sg13cmos5l_mux4_1
XFILLER_203_11 VPWR VGND sg13cmos5l_fill_2
XFILLER_284_279 VPWR VGND sg13cmos5l_fill_2
XFILLER_37_212 VPWR VGND sg13cmos5l_decap_8
X_1154_ _3547_/A Tile_X0Y0_W1END[2] Tile_X0Y0_W6END[6] _1006_/X _0665_/Y _1964_/Q
+ _1963_/Q VPWR VGND sg13cmos5l_mux4_1
XANTENNA__2138__D Tile_X0Y1_FrameData[22] VPWR VGND sg13cmos5l_antennanp
XANTENNA__3163__GATE Tile_X0Y5_FrameStrobe[3] VPWR VGND sg13cmos5l_antennanp
XFILLER_203_66 VPWR VGND sg13cmos5l_decap_8
X_1085_ _1085_/X Tile_X0Y3_W2MID[2] Tile_X0Y3_W2END[2] Tile_X0Y3_W6END[2] _1342_/X
+ _2766_/Q _2765_/Q VPWR VGND sg13cmos5l_mux4_1
XFILLER_52_204 VPWR VGND sg13cmos5l_fill_2
XFILLER_203_99 VPWR VGND sg13cmos5l_decap_8
XFILLER_252_165 VPWR VGND sg13cmos5l_fill_2
XFILLER_279_37 VPWR VGND sg13cmos5l_decap_4
XANTENNA__1977__D Tile_X0Y1_FrameData[23] VPWR VGND sg13cmos5l_antennanp
XFILLER_339_214 VPWR VGND sg13cmos5l_decap_4
XFILLER_339_203 VPWR VGND sg13cmos5l_fill_2
XFILLER_60_270 VPWR VGND sg13cmos5l_fill_2
XANTENNA__3178__GATE Tile_X0Y5_FrameStrobe[3] VPWR VGND sg13cmos5l_antennanp
XFILLER_148_19 VPWR VGND sg13cmos5l_decap_8
XFILLER_20_145 VPWR VGND sg13cmos5l_fill_2
X_1987_ _1987_/Q Tile_X0Y1_FrameData[13] Tile_X0Y5_FrameStrobe[0] VPWR VGND sg13cmos5l_dlhq_1
XFILLER_339_269 VPWR VGND sg13cmos5l_fill_1
XANTENNA__1204__A2 Tile_X0Y0_W6END[1] VPWR VGND sg13cmos5l_antennanp
XFILLER_20_189 VPWR VGND sg13cmos5l_decap_8
XFILLER_307_100 VPWR VGND sg13cmos5l_decap_8
X_3726_ Tile_X0Y3_FrameData_O[29] Tile_X0Y3_FrameData[29] VPWR VGND sg13cmos5l_buf_1
X_0938_ _0938_/Y _3297_/Q _0937_/Y _3296_/Q VPWR VGND sg13cmos5l_o21ai_1
XFILLER_173_150 VPWR VGND sg13cmos5l_decap_4
XFILLER_180_109 VPWR VGND sg13cmos5l_decap_8
XFILLER_228_52 VPWR VGND sg13cmos5l_fill_1
XANTENNA__0963__A1 Tile_X0Y1_WW4END[13] VPWR VGND sg13cmos5l_antennanp
XANTENNA__2601__D Tile_X0Y3_FrameData[7] VPWR VGND sg13cmos5l_antennanp
XANTENNA__3101__GATE Tile_X0Y5_FrameStrobe[1] VPWR VGND sg13cmos5l_antennanp
XANTENNA__3834__X Tile_X0Y5_E6BEG[3] VPWR VGND sg13cmos5l_antennanp
XFILLER_106_228 VPWR VGND sg13cmos5l_decap_8
XFILLER_173_172 VPWR VGND sg13cmos5l_fill_1
X_3657_ Tile_X0Y3_E2BEG[4] _3657_/A VPWR VGND sg13cmos5l_buf_1
X_0869_ _0869_/Y _3118_/Q Tile_X0Y5_W2MID[5] VPWR VGND sg13cmos5l_nand2b_1
XFILLER_173_194 VPWR VGND sg13cmos5l_fill_2
X_2608_ _2608_/Q Tile_X0Y3_FrameData[0] Tile_X0Y5_FrameStrobe[2] VPWR VGND sg13cmos5l_dlhq_1
X_3588_ Tile_X0Y0_FrameData_O[19] Tile_X0Y0_FrameData[19] VPWR VGND sg13cmos5l_buf_1
XFILLER_114_250 VPWR VGND sg13cmos5l_decap_4
X_2539_ _2539_/Q Tile_X0Y3_FrameData[5] Tile_X0Y5_FrameStrobe[0] VPWR VGND sg13cmos5l_dlhq_1
XFILLER_322_169 VPWR VGND sg13cmos5l_decap_8
XANTENNA__3116__GATE Tile_X0Y5_FrameStrobe[1] VPWR VGND sg13cmos5l_antennanp
XFILLER_114_294 VPWR VGND sg13cmos5l_fill_1
XFILLER_57_49 VPWR VGND sg13cmos5l_decap_8
XANTENNA__2372__GATE Tile_X0Y5_FrameStrobe[4] VPWR VGND sg13cmos5l_antennanp
XFILLER_275_279 VPWR VGND sg13cmos5l_fill_1
XFILLER_28_201 VPWR VGND sg13cmos5l_decap_8
XFILLER_113_44 VPWR VGND sg13cmos5l_decap_8
XFILLER_228_173 VPWR VGND sg13cmos5l_decap_8
XANTENNA__2048__D Tile_X0Y1_FrameData[16] VPWR VGND sg13cmos5l_antennanp
XFILLER_73_15 VPWR VGND sg13cmos5l_decap_8
XFILLER_43_237 VPWR VGND sg13cmos5l_decap_8
XANTENNA__1887__D Tile_X0Y0_FrameData[1] VPWR VGND sg13cmos5l_antennanp
XANTENNA__2387__GATE Tile_X0Y5_FrameStrobe[4] VPWR VGND sg13cmos5l_antennanp
XANTENNA__2310__GATE Tile_X0Y5_FrameStrobe[2] VPWR VGND sg13cmos5l_antennanp
XANTENNA__3457__A Tile_X0Y1_FrameData[25] VPWR VGND sg13cmos5l_antennanp
XFILLER_149_180 VPWR VGND sg13cmos5l_decap_4
XANTENNA__2940__GATE Tile_X0Y5_FrameStrobe[4] VPWR VGND sg13cmos5l_antennanp
XFILLER_164_150 VPWR VGND sg13cmos5l_decap_8
XANTENNA__0954__A1 Tile_X0Y1_WW4END[10] VPWR VGND sg13cmos5l_antennanp
XANTENNA__2511__D Tile_X0Y2_FrameData[17] VPWR VGND sg13cmos5l_antennanp
XANTENNA__3744__X Tile_X0Y4_E2BEGb[2] VPWR VGND sg13cmos5l_antennanp
XFILLER_164_161 VPWR VGND sg13cmos5l_fill_2
XANTENNA__2325__GATE Tile_X0Y5_FrameStrobe[2] VPWR VGND sg13cmos5l_antennanp
XFILLER_164_194 VPWR VGND sg13cmos5l_decap_8
XFILLER_313_125 VPWR VGND sg13cmos5l_fill_2
XANTENNA__2955__GATE Tile_X0Y5_FrameStrobe[5] VPWR VGND sg13cmos5l_antennanp
XFILLER_98_89 VPWR VGND sg13cmos5l_fill_1
XFILLER_98_78 VPWR VGND sg13cmos5l_decap_8
XFILLER_105_283 VPWR VGND sg13cmos5l_fill_1
XFILLER_266_213 VPWR VGND sg13cmos5l_decap_8
XFILLER_120_242 VPWR VGND sg13cmos5l_decap_8
XFILLER_266_224 VPWR VGND sg13cmos5l_fill_1
XFILLER_266_246 VPWR VGND sg13cmos5l_decap_4
XANTENNA__3342__D Tile_X0Y5_FrameData[8] VPWR VGND sg13cmos5l_antennanp
XFILLER_19_201 VPWR VGND sg13cmos5l_decap_8
XFILLER_93_137 VPWR VGND sg13cmos5l_decap_8
XFILLER_78_189 VPWR VGND sg13cmos5l_fill_1
XFILLER_304_87 VPWR VGND sg13cmos5l_decap_8
XFILLER_170_72 VPWR VGND sg13cmos5l_decap_8
XFILLER_234_132 VPWR VGND sg13cmos5l_fill_2
XANTENNA__1797__D Tile_X0Y0_FrameData[27] VPWR VGND sg13cmos5l_antennanp
XANTENNA__3919__X Tile_X0Y5_S4BEG[8] VPWR VGND sg13cmos5l_antennanp
XANTENNA__1434__A2 Tile_X0Y5_N4END[10] VPWR VGND sg13cmos5l_antennanp
X_2890_ _2890_/Q Tile_X0Y4_FrameData[22] Tile_X0Y5_FrameStrobe[3] VPWR VGND sg13cmos5l_dlhq_1
X_1910_ _1910_/Q Tile_X0Y0_FrameData[10] Tile_X0Y5_FrameStrobe[6] VPWR VGND sg13cmos5l_dlhq_1
XANTENNA__0642__A0 Tile_X0Y1_W6END[5] VPWR VGND sg13cmos5l_antennanp
XFILLER_187_275 VPWR VGND sg13cmos5l_fill_1
X_1841_ _1841_/Q Tile_X0Y0_FrameData[15] Tile_X0Y5_FrameStrobe[4] VPWR VGND sg13cmos5l_dlhq_1
XANTENNA__2908__GATE Tile_X0Y5_FrameStrobe[3] VPWR VGND sg13cmos5l_antennanp
XFILLER_329_51 VPWR VGND sg13cmos5l_fill_1
XANTENNA__1198__A1 Tile_X0Y0_WW4END[10] VPWR VGND sg13cmos5l_antennanp
X_1772_ _1772_/Q Tile_X0Y0_FrameData[20] Tile_X0Y5_FrameStrobe[2] VPWR VGND sg13cmos5l_dlhq_1
XFILLER_329_73 VPWR VGND sg13cmos5l_fill_1
XANTENNA__0945__A1 Tile_X0Y1_WW4END[15] VPWR VGND sg13cmos5l_antennanp
XANTENNA__2421__D Tile_X0Y2_FrameData[11] VPWR VGND sg13cmos5l_antennanp
XANTENNA__3654__X Tile_X0Y3_E2BEG[1] VPWR VGND sg13cmos5l_antennanp
X_3511_ Tile_X0Y1_E1BEG[3] _3511_/A VPWR VGND sg13cmos5l_buf_1
X_0723_ _0723_/X _0718_/X _0719_/Y _0722_/Y VPWR VGND sg13cmos5l_a21o_1
XFILLER_304_136 VPWR VGND sg13cmos5l_decap_8
X_3442_ Tile_X0Y1_FrameData_O[10] Tile_X0Y1_FrameData[10] VPWR VGND sg13cmos5l_buf_1
X_0654_ _3908_/A Tile_X0Y4_W1END[1] Tile_X0Y4_W2MID[2] Tile_X0Y4_W2END[2] _1318_/X
+ _3002_/Q _3001_/Q VPWR VGND sg13cmos5l_mux4_1
X_3373_ Tile_X0Y2_E6BEG[3] _3373_/A VPWR VGND sg13cmos5l_buf_1
XFILLER_170_197 VPWR VGND sg13cmos5l_fill_2
XFILLER_281_38 VPWR VGND sg13cmos5l_fill_1
X_2324_ _2324_/Q Tile_X0Y2_FrameData[12] Tile_X0Y5_FrameStrobe[2] VPWR VGND sg13cmos5l_dlhq_1
X_0585_ _0585_/X _0580_/X _0581_/Y _0584_/Y VPWR VGND sg13cmos5l_a21o_1
XFILLER_111_242 VPWR VGND sg13cmos5l_fill_2
XFILLER_26_0 VPWR VGND sg13cmos5l_fill_1
XFILLER_69_167 VPWR VGND sg13cmos5l_decap_8
XANTENNA__3252__D Tile_X0Y5_FrameData[28] VPWR VGND sg13cmos5l_antennanp
X_2255_ _2255_/Q Tile_X0Y2_FrameData[17] Tile_X0Y5_FrameStrobe[0] VPWR VGND sg13cmos5l_dlhq_1
X_2186_ _2186_/Q Tile_X0Y1_FrameData[6] Tile_X0Y5_FrameStrobe[6] VPWR VGND sg13cmos5l_dlhq_1
X_1206_ AXI_M_SOC_AWADDR29 Tile_X0Y0_W2MID[5] Tile_X0Y0_W2END[5] Tile_X0Y0_W6END[5]
+ _1045_/X _1758_/Q _1757_/Q VPWR VGND sg13cmos5l_mux4_1
XANTENNA__1122__A1 Tile_X0Y2_W6END[6] VPWR VGND sg13cmos5l_antennanp
X_1137_ _1137_/X _0986_/X _0984_/X Tile_X0Y0_S1END[3] Tile_X0Y0_S4END[3] _1730_/Q
+ _1729_/Q VPWR VGND sg13cmos5l_mux4_1
XANTENNA__1673__A2 AXI_M_SOC_RDATA0 VPWR VGND sg13cmos5l_antennanp
XANTENNA__3829__X Tile_X0Y5_E2BEGb[6] VPWR VGND sg13cmos5l_antennanp
XFILLER_280_293 VPWR VGND sg13cmos5l_fill_2
X_1068_ _1068_/X _1079_/X _1067_/X Tile_X0Y0_S1END[0] Tile_X0Y0_S4END[0] _1744_/Q
+ _1743_/Q VPWR VGND sg13cmos5l_mux4_1
XFILLER_43_18 VPWR VGND sg13cmos5l_fill_2
XANTENNA__1425__A2 Tile_X0Y2_WW4END[14] VPWR VGND sg13cmos5l_antennanp
XFILLER_138_128 VPWR VGND sg13cmos5l_decap_8
XFILLER_327_228 VPWR VGND sg13cmos5l_fill_1
XFILLER_327_217 VPWR VGND sg13cmos5l_decap_8
XANTENNA__1189__A1 Tile_X0Y4_W2END[3] VPWR VGND sg13cmos5l_antennanp
XANTENNA__3040__GATE Tile_X0Y5_FrameStrobe[7] VPWR VGND sg13cmos5l_antennanp
XANTENNA__3564__X Tile_X0Y0_FrameStrobe_O[15] VPWR VGND sg13cmos5l_antennanp
XFILLER_111_8 VPWR VGND sg13cmos5l_fill_2
XFILLER_146_150 VPWR VGND sg13cmos5l_fill_2
XFILLER_175_28 VPWR VGND sg13cmos5l_fill_1
XFILLER_209_8 VPWR VGND sg13cmos5l_fill_2
X_3709_ Tile_X0Y3_FrameData_O[12] Tile_X0Y3_FrameData[12] VPWR VGND sg13cmos5l_buf_1
XANTENNA__2331__D Tile_X0Y2_FrameData[5] VPWR VGND sg13cmos5l_antennanp
XFILLER_161_142 VPWR VGND sg13cmos5l_decap_8
XANTENNA__3055__GATE Tile_X0Y5_FrameStrobe[8] VPWR VGND sg13cmos5l_antennanp
XFILLER_108_55 VPWR VGND sg13cmos5l_fill_2
XFILLER_255_50 VPWR VGND sg13cmos5l_fill_1
XFILLER_68_15 VPWR VGND sg13cmos5l_decap_8
XFILLER_102_242 VPWR VGND sg13cmos5l_fill_1
XFILLER_124_21 VPWR VGND sg13cmos5l_decap_4
XANTENNA__3162__D Tile_X0Y5_FrameData[22] VPWR VGND sg13cmos5l_antennanp
XFILLER_102_264 VPWR VGND sg13cmos5l_fill_2
XFILLER_75_115 VPWR VGND sg13cmos5l_decap_4
XFILLER_187_4 VPWR VGND sg13cmos5l_fill_1
XFILLER_271_82 VPWR VGND sg13cmos5l_decap_4
XANTENNA__1113__A1 Tile_X0Y2_W2END[0] VPWR VGND sg13cmos5l_antennanp
XFILLER_16_237 VPWR VGND sg13cmos5l_decap_4
XFILLER_140_64 VPWR VGND sg13cmos5l_decap_8
XFILLER_271_293 VPWR VGND sg13cmos5l_fill_2
XANTENNA__1416__A2 Tile_X0Y2_W6END[0] VPWR VGND sg13cmos5l_antennanp
XANTENNA__2506__D Tile_X0Y2_FrameData[22] VPWR VGND sg13cmos5l_antennanp
XANTENNA__3739__X Tile_X0Y4_E2BEG[5] VPWR VGND sg13cmos5l_antennanp
XFILLER_169_231 VPWR VGND sg13cmos5l_decap_4
XANTENNA__3008__GATE Tile_X0Y5_FrameStrobe[6] VPWR VGND sg13cmos5l_antennanp
XFILLER_130_0 VPWR VGND sg13cmos5l_decap_4
XFILLER_149_40 VPWR VGND sg13cmos5l_fill_1
XFILLER_228_0 VPWR VGND sg13cmos5l_fill_2
XFILLER_33_84 VPWR VGND sg13cmos5l_fill_2
XFILLER_149_95 VPWR VGND sg13cmos5l_decap_8
XFILLER_296_90 VPWR VGND sg13cmos5l_fill_1
XANTENNA__3337__D Tile_X0Y5_FrameData[3] VPWR VGND sg13cmos5l_antennanp
XANTENNA__3474__X Tile_X0Y1_EE4BEG[10] VPWR VGND sg13cmos5l_antennanp
XANTENNA__2241__D Tile_X0Y1_FrameData[31] VPWR VGND sg13cmos5l_antennanp
XANTENNA__2264__GATE Tile_X0Y5_FrameStrobe[0] VPWR VGND sg13cmos5l_antennanp
XFILLER_152_120 VPWR VGND sg13cmos5l_decap_8
XFILLER_152_131 VPWR VGND sg13cmos5l_fill_2
XANTENNA__2894__GATE Tile_X0Y5_FrameStrobe[3] VPWR VGND sg13cmos5l_antennanp
XFILLER_165_61 VPWR VGND sg13cmos5l_decap_8
XFILLER_298_179 VPWR VGND sg13cmos5l_fill_1
XFILLER_315_42 VPWR VGND sg13cmos5l_decap_4
XANTENNA__2279__GATE Tile_X0Y5_FrameStrobe[1] VPWR VGND sg13cmos5l_antennanp
XFILLER_239_213 VPWR VGND sg13cmos5l_decap_4
XFILLER_315_64 VPWR VGND sg13cmos5l_fill_1
XANTENNA__3072__D Tile_X0Y5_FrameData[16] VPWR VGND sg13cmos5l_antennanp
XFILLER_66_104 VPWR VGND sg13cmos5l_decap_8
X_2040_ _2040_/Q Tile_X0Y1_FrameData[24] Tile_X0Y5_FrameStrobe[2] VPWR VGND sg13cmos5l_dlhq_1
XFILLER_66_159 VPWR VGND sg13cmos5l_decap_8
XFILLER_66_137 VPWR VGND sg13cmos5l_decap_4
XANTENNA__1104__A1 Tile_X0Y0_W2END[6] VPWR VGND sg13cmos5l_antennanp
XANTENNA__2202__GATE Tile_X0Y5_FrameStrobe[7] VPWR VGND sg13cmos5l_antennanp
XFILLER_331_41 VPWR VGND sg13cmos5l_decap_4
XANTENNA__1655__A2 Tile_X0Y4_W6END[5] VPWR VGND sg13cmos5l_antennanp
XANTENNA__2832__GATE Tile_X0Y5_FrameStrobe[1] VPWR VGND sg13cmos5l_antennanp
XFILLER_222_113 VPWR VGND sg13cmos5l_fill_1
XFILLER_222_124 VPWR VGND sg13cmos5l_decap_8
XFILLER_262_293 VPWR VGND sg13cmos5l_fill_2
XANTENNA__2416__D Tile_X0Y2_FrameData[16] VPWR VGND sg13cmos5l_antennanp
XANTENNA__3649__X Tile_X0Y3_E1BEG[0] VPWR VGND sg13cmos5l_antennanp
X_2942_ _2942_/Q Tile_X0Y4_FrameData[2] Tile_X0Y5_FrameStrobe[4] VPWR VGND sg13cmos5l_dlhq_1
XANTENNA__2217__GATE Tile_X0Y5_FrameStrobe[7] VPWR VGND sg13cmos5l_antennanp
XFILLER_200_67 VPWR VGND sg13cmos5l_decap_4
XANTENNA__2847__GATE Tile_X0Y5_FrameStrobe[1] VPWR VGND sg13cmos5l_antennanp
XFILLER_309_228 VPWR VGND sg13cmos5l_decap_8
X_2873_ _2873_/Q Tile_X0Y4_FrameData[7] Tile_X0Y5_FrameStrobe[2] VPWR VGND sg13cmos5l_dlhq_1
XFILLER_175_245 VPWR VGND sg13cmos5l_decap_8
X_1824_ _1824_/Q Tile_X0Y0_FrameData[0] Tile_X0Y5_FrameStrobe[3] VPWR VGND sg13cmos5l_dlhq_1
XANTENNA__3247__D Tile_X0Y5_FrameData[1] VPWR VGND sg13cmos5l_antennanp
XFILLER_128_150 VPWR VGND sg13cmos5l_decap_8
X_1755_ _1755_/Q Tile_X0Y0_FrameData[5] Tile_X0Y5_FrameStrobe[1] VPWR VGND sg13cmos5l_dlhq_1
XFILLER_317_261 VPWR VGND sg13cmos5l_fill_1
XANTENNA__2151__D Tile_X0Y1_FrameData[9] VPWR VGND sg13cmos5l_antennanp
XANTENNA__3384__X Tile_X0Y2_EE4BEG[2] VPWR VGND sg13cmos5l_antennanp
XFILLER_209_65 VPWR VGND sg13cmos5l_decap_4
X_0706_ _0706_/Y _3261_/Q _0705_/Y _3260_/Q VPWR VGND sg13cmos5l_o21ai_1
X_1686_ _1686_/X _1039_/X _1040_/X _1046_/X _1318_/X _2993_/Q _2992_/Q VPWR VGND sg13cmos5l_mux4_1
XFILLER_89_207 VPWR VGND sg13cmos5l_fill_2
XANTENNA__1990__D Tile_X0Y1_FrameData[10] VPWR VGND sg13cmos5l_antennanp
X_3425_ Tile_X0Y2_FrameData_O[27] Tile_X0Y2_FrameData[27] VPWR VGND sg13cmos5l_buf_1
X_0637_ _0639_/B Tile_X0Y4_W6END[1] _2790_/Q VPWR VGND sg13cmos5l_nor2b_1
X_3356_ Tile_X0Y2_E2BEG[2] _3356_/A VPWR VGND sg13cmos5l_buf_1
X_0568_ _0568_/X Tile_X0Y0_W1END[0] Tile_X0Y0_W6END[8] _1074_/X _0567_/Y _1932_/Q
+ _1931_/Q VPWR VGND sg13cmos5l_mux4_1
XFILLER_97_240 VPWR VGND sg13cmos5l_fill_2
XFILLER_38_18 VPWR VGND sg13cmos5l_decap_8
XFILLER_300_150 VPWR VGND sg13cmos5l_decap_4
X_3287_ _3287_/Q Tile_X0Y5_FrameData[25] Tile_X0Y5_FrameStrobe[7] VPWR VGND sg13cmos5l_dlhq_1
X_2307_ _2307_/Q Tile_X0Y2_FrameData[29] Tile_X0Y5_FrameStrobe[2] VPWR VGND sg13cmos5l_dlhq_1
XANTENNA__1632__X AXI_M_SOC_ARADDR0 VPWR VGND sg13cmos5l_antennanp
XANTENNA__3560__A Tile_X0Y5_FrameStrobe[11] VPWR VGND sg13cmos5l_antennanp
X_2238_ _2238_/Q Tile_X0Y1_FrameData[18] Tile_X0Y5_FrameStrobe[8] VPWR VGND sg13cmos5l_dlhq_1
XFILLER_241_30 VPWR VGND sg13cmos5l_fill_2
XANTENNA__1646__A2 Tile_X0Y4_W6END[4] VPWR VGND sg13cmos5l_antennanp
X_2169_ _2169_/Q Tile_X0Y1_FrameData[23] Tile_X0Y5_FrameStrobe[6] VPWR VGND sg13cmos5l_dlhq_1
XFILLER_54_39 VPWR VGND sg13cmos5l_decap_8
XFILLER_213_113 VPWR VGND sg13cmos5l_fill_1
XFILLER_213_135 VPWR VGND sg13cmos5l_fill_1
XANTENNA__2326__D Tile_X0Y2_FrameData[10] VPWR VGND sg13cmos5l_antennanp
XANTENNA__3559__X Tile_X0Y0_FrameStrobe_O[10] VPWR VGND sg13cmos5l_antennanp
XFILLER_110_34 VPWR VGND sg13cmos5l_decap_8
XANTENNA__0606__A0 Tile_X0Y3_W1END[0] VPWR VGND sg13cmos5l_antennanp
XFILLER_80_195 VPWR VGND sg13cmos5l_decap_8
XFILLER_110_89 VPWR VGND sg13cmos5l_decap_8
XFILLER_186_16 VPWR VGND sg13cmos5l_decap_8
XFILLER_70_49 VPWR VGND sg13cmos5l_fill_1
XFILLER_166_267 VPWR VGND sg13cmos5l_fill_1
XFILLER_186_49 VPWR VGND sg13cmos5l_decap_8
XANTENNA__3157__D Tile_X0Y5_FrameData[27] VPWR VGND sg13cmos5l_antennanp
XFILLER_119_54 VPWR VGND sg13cmos5l_fill_2
XANTENNA__2061__D Tile_X0Y1_FrameData[3] VPWR VGND sg13cmos5l_antennanp
XFILLER_79_14 VPWR VGND sg13cmos5l_decap_8
XANTENNA__1582__A1 Tile_X0Y3_W6END[11] VPWR VGND sg13cmos5l_antennanp
XANTENNA__2996__D Tile_X0Y4_FrameData[12] VPWR VGND sg13cmos5l_antennanp
XFILLER_295_105 VPWR VGND sg13cmos5l_fill_2
XANTENNA__1334__A1 AXI_M_SOC_RDATA29 VPWR VGND sg13cmos5l_antennanp
XFILLER_288_190 VPWR VGND sg13cmos5l_decap_4
XFILLER_95_35 VPWR VGND sg13cmos5l_decap_8
XFILLER_48_126 VPWR VGND sg13cmos5l_decap_8
XANTENNA__1098__A0 Tile_X0Y3_W2MID[5] VPWR VGND sg13cmos5l_antennanp
XFILLER_236_249 VPWR VGND sg13cmos5l_fill_2
XANTENNA__1637__A2 Tile_X0Y4_W6END[7] VPWR VGND sg13cmos5l_antennanp
XFILLER_301_11 VPWR VGND sg13cmos5l_fill_2
XFILLER_56_170 VPWR VGND sg13cmos5l_decap_8
XFILLER_244_293 VPWR VGND sg13cmos5l_fill_2
XANTENNA__2236__D Tile_X0Y1_FrameData[20] VPWR VGND sg13cmos5l_antennanp
XANTENNA__3469__X Tile_X0Y1_EE4BEG[5] VPWR VGND sg13cmos5l_antennanp
XFILLER_204_146 VPWR VGND sg13cmos5l_decap_8
XFILLER_301_66 VPWR VGND sg13cmos5l_fill_1
XFILLER_44_61 VPWR VGND sg13cmos5l_fill_1
XANTENNA__1270__A0 Tile_X0Y2_W1END[0] VPWR VGND sg13cmos5l_antennanp
XANTENNA__3067__D Tile_X0Y5_FrameData[21] VPWR VGND sg13cmos5l_antennanp
X_1540_ _3696_/A Tile_X0Y3_WW4END[0] _1539_/X AXI_M_SOC_RDATA6 _1267_/X _2641_/Q _2642_/Q
+ VPWR VGND sg13cmos5l_mux4_1
XFILLER_125_142 VPWR VGND sg13cmos5l_decap_4
XFILLER_314_242 VPWR VGND sg13cmos5l_fill_1
XFILLER_286_116 VPWR VGND sg13cmos5l_decap_8
X_1471_ _3390_/A Tile_X0Y2_WW4END[7] _1314_/X AXI_M_SOC_RDATA21 _1179_/X _2383_/Q
+ _2384_/Q VPWR VGND sg13cmos5l_mux4_1
XFILLER_326_63 VPWR VGND sg13cmos5l_fill_2
XFILLER_140_145 VPWR VGND sg13cmos5l_decap_8
X_3210_ _3210_/Q Tile_X0Y5_FrameData[6] Tile_X0Y5_FrameStrobe[4] VPWR VGND sg13cmos5l_dlhq_1
XFILLER_69_80 VPWR VGND sg13cmos5l_decap_8
X_3141_ _3141_/Q Tile_X0Y5_FrameData[11] Tile_X0Y5_FrameStrobe[2] VPWR VGND sg13cmos5l_dlhq_1
XANTENNA__2141__GATE Tile_X0Y5_FrameStrobe[5] VPWR VGND sg13cmos5l_antennanp
XFILLER_94_232 VPWR VGND sg13cmos5l_fill_1
XANTENNA__2771__GATE Tile_X0Y5_FrameStrobe[8] VPWR VGND sg13cmos5l_antennanp
X_3072_ _3072_/Q Tile_X0Y5_FrameData[16] Tile_X0Y5_FrameStrobe[0] VPWR VGND sg13cmos5l_dlhq_1
X_2023_ _2023_/Q Tile_X0Y1_FrameData[9] Tile_X0Y5_FrameStrobe[1] VPWR VGND sg13cmos5l_dlhq_1
XFILLER_54_129 VPWR VGND sg13cmos5l_decap_8
XANTENNA__0836__A0 Tile_X0Y5_WW4END[1] VPWR VGND sg13cmos5l_antennanp
XFILLER_211_22 VPWR VGND sg13cmos5l_decap_8
XFILLER_235_293 VPWR VGND sg13cmos5l_fill_2
XANTENNA__2146__D Tile_X0Y1_FrameData[14] VPWR VGND sg13cmos5l_antennanp
XANTENNA__2156__GATE Tile_X0Y5_FrameStrobe[5] VPWR VGND sg13cmos5l_antennanp
XANTENNA__3379__X Tile_X0Y2_E6BEG[9] VPWR VGND sg13cmos5l_antennanp
XFILLER_62_173 VPWR VGND sg13cmos5l_fill_2
XANTENNA__2786__GATE Tile_X0Y5_FrameStrobe[0] VPWR VGND sg13cmos5l_antennanp
XFILLER_93_0 VPWR VGND sg13cmos5l_fill_2
XANTENNA__1985__D Tile_X0Y1_FrameData[15] VPWR VGND sg13cmos5l_antennanp
XFILLER_210_149 VPWR VGND sg13cmos5l_fill_1
X_2925_ _2925_/Q Tile_X0Y4_FrameData[19] Tile_X0Y5_FrameStrobe[4] VPWR VGND sg13cmos5l_dlhq_1
XANTENNA__1261__A0 Tile_X0Y0_W2END[3] VPWR VGND sg13cmos5l_antennanp
X_2856_ _2856_/Q Tile_X0Y4_FrameData[24] Tile_X0Y5_FrameStrobe[2] VPWR VGND sg13cmos5l_dlhq_1
X_1807_ _1807_/Q Tile_X0Y0_FrameData[17] Tile_X0Y5_FrameStrobe[3] VPWR VGND sg13cmos5l_dlhq_1
XANTENNA__3555__A Tile_X0Y5_FrameStrobe[6] VPWR VGND sg13cmos5l_antennanp
X_2787_ _2787_/Q Tile_X0Y4_FrameData[29] Tile_X0Y5_FrameStrobe[0] VPWR VGND sg13cmos5l_dlhq_1
XANTENNA__1564__A1 Tile_X0Y3_W2END[5] VPWR VGND sg13cmos5l_antennanp
X_1738_ _1738_/Q Tile_X0Y0_FrameData[22] Tile_X0Y5_FrameStrobe[1] VPWR VGND sg13cmos5l_dlhq_1
XANTENNA__2724__GATE Tile_X0Y5_FrameStrobe[6] VPWR VGND sg13cmos5l_antennanp
XANTENNA__3842__X Tile_X0Y5_E6BEG[11] VPWR VGND sg13cmos5l_antennanp
X_1669_ _3734_/A Tile_X0Y4_W2MID[7] AXI_M_SOC_RRESP0 _1073_/X _1361_/X _2976_/Q _2975_/Q
+ VPWR VGND sg13cmos5l_mux4_1
XFILLER_131_145 VPWR VGND sg13cmos5l_fill_2
X_3408_ Tile_X0Y2_FrameData_O[10] Tile_X0Y2_FrameData[10] VPWR VGND sg13cmos5l_buf_1
XANTENNA__1316__A1 Tile_X0Y2_W2MID[2] VPWR VGND sg13cmos5l_antennanp
XANTENNA__1980__GATE Tile_X0Y5_FrameStrobe[0] VPWR VGND sg13cmos5l_antennanp
XANTENNA__2109__GATE Tile_X0Y5_FrameStrobe[4] VPWR VGND sg13cmos5l_antennanp
X_3339_ _3339_/Q Tile_X0Y5_FrameData[5] Tile_X0Y5_FrameStrobe[8] VPWR VGND sg13cmos5l_dlhq_1
XANTENNA__2739__GATE Tile_X0Y5_FrameStrobe[7] VPWR VGND sg13cmos5l_antennanp
XFILLER_252_95 VPWR VGND sg13cmos5l_fill_1
XFILLER_121_11 VPWR VGND sg13cmos5l_fill_2
XFILLER_38_181 VPWR VGND sg13cmos5l_decap_8
XANTENNA__0827__A0 Tile_X0Y5_N4END[3] VPWR VGND sg13cmos5l_antennanp
XANTENNA__1995__GATE Tile_X0Y5_FrameStrobe[0] VPWR VGND sg13cmos5l_antennanp
XANTENNA__2056__D Tile_X0Y1_FrameData[8] VPWR VGND sg13cmos5l_antennanp
XFILLER_81_15 VPWR VGND sg13cmos5l_decap_8
XFILLER_53_151 VPWR VGND sg13cmos5l_decap_8
XFILLER_197_26 VPWR VGND sg13cmos5l_decap_4
XFILLER_198_178 VPWR VGND sg13cmos5l_fill_2
XFILLER_201_116 VPWR VGND sg13cmos5l_fill_2
XFILLER_241_285 VPWR VGND sg13cmos5l_fill_2
XANTENNA__1895__D Tile_X0Y0_FrameData[25] VPWR VGND sg13cmos5l_antennanp
XANTENNA__1252__A0 Tile_X0Y0_W2MID[0] VPWR VGND sg13cmos5l_antennanp
XANTENNA__1555__A1 Tile_X0Y3_W2END[4] VPWR VGND sg13cmos5l_antennanp
XANTENNA__1933__GATE Tile_X0Y5_FrameStrobe[7] VPWR VGND sg13cmos5l_antennanp
XFILLER_146_30 VPWR VGND sg13cmos5l_decap_8
XFILLER_107_175 VPWR VGND sg13cmos5l_decap_8
XFILLER_30_85 VPWR VGND sg13cmos5l_decap_4
XANTENNA__3752__X Tile_X0Y4_E6BEG[2] VPWR VGND sg13cmos5l_antennanp
XFILLER_122_145 VPWR VGND sg13cmos5l_decap_8
XFILLER_268_116 VPWR VGND sg13cmos5l_fill_2
XANTENNA__1307__A1 Tile_X0Y1_W2END[3] VPWR VGND sg13cmos5l_antennanp
XANTENNA__1948__GATE Tile_X0Y5_FrameStrobe[7] VPWR VGND sg13cmos5l_antennanp
XFILLER_295_0 VPWR VGND sg13cmos5l_fill_2
XFILLER_162_73 VPWR VGND sg13cmos5l_fill_1
XFILLER_312_32 VPWR VGND sg13cmos5l_fill_2
XANTENNA__0818__A0 Tile_X0Y5_WW4END[5] VPWR VGND sg13cmos5l_antennanp
XFILLER_217_293 VPWR VGND sg13cmos5l_fill_2
XANTENNA__1086__A3 Tile_X0Y0_S2MID[5] VPWR VGND sg13cmos5l_antennanp
X_0971_ _0971_/X _1119_/X _0724_/X Tile_X0Y5_N4END[11] Tile_X0Y0_S4END[15] _2545_/Q
+ _2546_/Q VPWR VGND sg13cmos5l_mux4_1
XANTENNA__1243__A0 AXI_M_SOC_BVALID VPWR VGND sg13cmos5l_antennanp
XANTENNA__3927__X Tile_X0Y5_UserCLKo VPWR VGND sg13cmos5l_antennanp
X_2710_ _2710_/Q Tile_X0Y3_FrameData[26] Tile_X0Y5_FrameStrobe[6] VPWR VGND sg13cmos5l_dlhq_1
XFILLER_71_70 VPWR VGND sg13cmos5l_decap_8
X_3690_ Tile_X0Y3_EE4BEG[9] _3690_/A VPWR VGND sg13cmos5l_buf_1
XFILLER_145_248 VPWR VGND sg13cmos5l_fill_1
X_2641_ _2641_/Q Tile_X0Y3_FrameData[31] Tile_X0Y5_FrameStrobe[4] VPWR VGND sg13cmos5l_dlhq_1
XFILLER_65_4 VPWR VGND sg13cmos5l_fill_1
XFILLER_299_230 VPWR VGND sg13cmos5l_fill_1
X_2572_ _2572_/Q Tile_X0Y3_FrameData[4] Tile_X0Y5_FrameStrobe[1] VPWR VGND sg13cmos5l_dlhq_1
XANTENNA__1010__A3 Tile_X0Y0_S2END[6] VPWR VGND sg13cmos5l_antennanp
XFILLER_259_105 VPWR VGND sg13cmos5l_decap_8
X_1523_ _1523_/X _1017_/X _0629_/X Tile_X0Y5_N4END[9] Tile_X0Y0_S4END[13] _2549_/Q
+ _2550_/Q VPWR VGND sg13cmos5l_mux4_1
XANTENNA__3662__X Tile_X0Y3_E2BEGb[1] VPWR VGND sg13cmos5l_antennanp
X_1454_ _3355_/A Tile_X0Y2_W2MID[6] AXI_M_SOC_RDATA15 _1143_/X _1175_/X _2430_/Q _2429_/Q
+ VPWR VGND sg13cmos5l_mux4_1
XFILLER_113_167 VPWR VGND sg13cmos5l_fill_2
XFILLER_259_149 VPWR VGND sg13cmos5l_decap_8
XANTENNA__2080__GATE Tile_X0Y5_FrameStrobe[3] VPWR VGND sg13cmos5l_antennanp
X_1385_ _1385_/X _1313_/X _1379_/X _2482_/Q VPWR VGND sg13cmos5l_mux2_1
XFILLER_67_221 VPWR VGND sg13cmos5l_decap_8
X_3124_ _3124_/Q Tile_X0Y5_FrameData[28] Tile_X0Y5_FrameStrobe[2] VPWR VGND sg13cmos5l_dlhq_1
XANTENNA__3260__D Tile_X0Y5_FrameData[20] VPWR VGND sg13cmos5l_antennanp
X_3055_ _3055_/Q Tile_X0Y4_FrameData[17] Tile_X0Y5_FrameStrobe[8] VPWR VGND sg13cmos5l_dlhq_1
XANTENNA__0809__A0 Tile_X0Y5_WW4END[14] VPWR VGND sg13cmos5l_antennanp
XANTENNA__2095__GATE Tile_X0Y5_FrameStrobe[3] VPWR VGND sg13cmos5l_antennanp
XFILLER_222_65 VPWR VGND sg13cmos5l_decap_8
X_2006_ _2006_/Q Tile_X0Y1_FrameData[26] Tile_X0Y5_FrameStrobe[1] VPWR VGND sg13cmos5l_dlhq_1
XFILLER_208_293 VPWR VGND sg13cmos5l_fill_2
XFILLER_223_230 VPWR VGND sg13cmos5l_decap_4
XFILLER_35_162 VPWR VGND sg13cmos5l_fill_2
XFILLER_50_121 VPWR VGND sg13cmos5l_decap_8
XANTENNA__1234__A0 Tile_X0Y0_WW4END[3] VPWR VGND sg13cmos5l_antennanp
XANTENNA__2604__D Tile_X0Y3_FrameData[4] VPWR VGND sg13cmos5l_antennanp
XANTENNA__3837__X Tile_X0Y5_E6BEG[6] VPWR VGND sg13cmos5l_antennanp
X_2908_ _2908_/Q Tile_X0Y4_FrameData[4] Tile_X0Y5_FrameStrobe[3] VPWR VGND sg13cmos5l_dlhq_1
X_3888_ Tile_X0Y5_FrameData_O[29] Tile_X0Y5_FrameData[29] VPWR VGND sg13cmos5l_buf_1
XFILLER_136_226 VPWR VGND sg13cmos5l_decap_4
X_2839_ _2839_/Q Tile_X0Y4_FrameData[9] Tile_X0Y5_FrameStrobe[1] VPWR VGND sg13cmos5l_dlhq_1
XANTENNA__1537__A1 Tile_X0Y0_S4END[13] VPWR VGND sg13cmos5l_antennanp
XANTENNA__2033__GATE Tile_X0Y5_FrameStrobe[2] VPWR VGND sg13cmos5l_antennanp
XFILLER_136_259 VPWR VGND sg13cmos5l_fill_2
XFILLER_151_207 VPWR VGND sg13cmos5l_decap_8
XANTENNA__2663__GATE Tile_X0Y5_FrameStrobe[4] VPWR VGND sg13cmos5l_antennanp
XFILLER_183_28 VPWR VGND sg13cmos5l_decap_8
XFILLER_183_39 VPWR VGND sg13cmos5l_fill_2
XFILLER_2_217 VPWR VGND sg13cmos5l_fill_1
XANTENNA__3572__X Tile_X0Y0_FrameData_O[3] VPWR VGND sg13cmos5l_antennanp
XFILLER_116_11 VPWR VGND sg13cmos5l_fill_1
XANTENNA__2048__GATE Tile_X0Y5_FrameStrobe[2] VPWR VGND sg13cmos5l_antennanp
XANTENNA__2678__GATE Tile_X0Y5_FrameStrobe[5] VPWR VGND sg13cmos5l_antennanp
XFILLER_58_276 VPWR VGND sg13cmos5l_fill_1
XANTENNA__3170__D Tile_X0Y5_FrameData[14] VPWR VGND sg13cmos5l_antennanp
XANTENNA__2601__GATE Tile_X0Y5_FrameStrobe[2] VPWR VGND sg13cmos5l_antennanp
XFILLER_92_14 VPWR VGND sg13cmos5l_decap_8
XANTENNA__1068__A3 Tile_X0Y0_S4END[0] VPWR VGND sg13cmos5l_antennanp
XANTENNA__1473__A0 Tile_X0Y2_WW4END[5] VPWR VGND sg13cmos5l_antennanp
XANTENNA__1225__A0 Tile_X0Y0_WW4END[12] VPWR VGND sg13cmos5l_antennanp
XANTENNA__2514__D Tile_X0Y3_FrameData[30] VPWR VGND sg13cmos5l_antennanp
XANTENNA__2616__GATE Tile_X0Y5_FrameStrobe[3] VPWR VGND sg13cmos5l_antennanp
XANTENNA__3747__X Tile_X0Y4_E2BEGb[5] VPWR VGND sg13cmos5l_antennanp
XANTENNA__1872__GATE Tile_X0Y5_FrameStrobe[5] VPWR VGND sg13cmos5l_antennanp
XFILLER_127_226 VPWR VGND sg13cmos5l_decap_8
XFILLER_194_192 VPWR VGND sg13cmos5l_decap_8
XFILLER_210_0 VPWR VGND sg13cmos5l_fill_2
XFILLER_41_62 VPWR VGND sg13cmos5l_decap_8
XFILLER_308_0 VPWR VGND sg13cmos5l_fill_2
XANTENNA__1528__A1 AXI_M_SOC_RDATA10 VPWR VGND sg13cmos5l_antennanp
XANTENNA__3345__D Tile_X0Y5_FrameData[11] VPWR VGND sg13cmos5l_antennanp
XANTENNA__1887__GATE Tile_X0Y5_FrameStrobe[5] VPWR VGND sg13cmos5l_antennanp
XANTENNA__3482__X Tile_X0Y1_E6BEG[2] VPWR VGND sg13cmos5l_antennanp
XFILLER_173_72 VPWR VGND sg13cmos5l_decap_8
XFILLER_249_160 VPWR VGND sg13cmos5l_decap_4
XFILLER_323_31 VPWR VGND sg13cmos5l_fill_1
XANTENNA__1810__GATE Tile_X0Y5_FrameStrobe[3] VPWR VGND sg13cmos5l_antennanp
X_1170_ _1170_/X Tile_X0Y0_W6END[9] _1041_/X _1042_/X _1140_/X _1939_/Q _1941_/Q VPWR
+ VGND sg13cmos5l_mux4_1
XANTENNA__3080__D Tile_X0Y5_FrameData[8] VPWR VGND sg13cmos5l_antennanp
XFILLER_64_257 VPWR VGND sg13cmos5l_fill_2
XFILLER_205_230 VPWR VGND sg13cmos5l_decap_8
XANTENNA__1464__A0 Tile_X0Y2_W2MID[0] VPWR VGND sg13cmos5l_antennanp
XANTENNA__1825__GATE Tile_X0Y5_FrameStrobe[4] VPWR VGND sg13cmos5l_antennanp
XFILLER_32_132 VPWR VGND sg13cmos5l_decap_8
XFILLER_268_17 VPWR VGND sg13cmos5l_fill_1
X_3811_ Tile_X0Y5_E1BEG[0] _3811_/A VPWR VGND sg13cmos5l_buf_1
XANTENNA__2424__D Tile_X0Y2_FrameData[8] VPWR VGND sg13cmos5l_antennanp
XANTENNA__3657__X Tile_X0Y3_E2BEG[4] VPWR VGND sg13cmos5l_antennanp
X_3742_ Tile_X0Y4_E2BEGb[0] _3742_/A VPWR VGND sg13cmos5l_buf_1
X_0954_ _0954_/X Tile_X0Y1_WW4END[2] Tile_X0Y1_WW4END[10] Tile_X0Y1_W6END[10] _0953_/X
+ _2052_/Q _2051_/Q VPWR VGND sg13cmos5l_mux4_1
X_3673_ Tile_X0Y3_E6BEG[4] _3673_/A VPWR VGND sg13cmos5l_buf_1
X_0885_ _0885_/X _1017_/X _0629_/X Tile_X0Y5_N4END[9] Tile_X0Y0_S4END[13] _2541_/Q
+ _2542_/Q VPWR VGND sg13cmos5l_mux4_1
XFILLER_319_197 VPWR VGND sg13cmos5l_fill_2
XFILLER_319_186 VPWR VGND sg13cmos5l_decap_8
X_2624_ _2624_/Q Tile_X0Y3_FrameData[16] Tile_X0Y5_FrameStrobe[3] VPWR VGND sg13cmos5l_dlhq_1
XFILLER_334_134 VPWR VGND sg13cmos5l_fill_2
XANTENNA__1519__A1 AXI_M_SOC_RDATA7 VPWR VGND sg13cmos5l_antennanp
XFILLER_99_110 VPWR VGND sg13cmos5l_decap_8
XFILLER_56_0 VPWR VGND sg13cmos5l_decap_8
XFILLER_334_167 VPWR VGND sg13cmos5l_fill_2
XANTENNA__0850__B_N Tile_X0Y5_W6END[1] VPWR VGND sg13cmos5l_antennanp
XANTENNA__3255__D Tile_X0Y5_FrameData[25] VPWR VGND sg13cmos5l_antennanp
XANTENNA__3392__X Tile_X0Y2_EE4BEG[10] VPWR VGND sg13cmos5l_antennanp
X_2555_ _2555_/Q Tile_X0Y3_FrameData[21] Tile_X0Y5_FrameStrobe[1] VPWR VGND sg13cmos5l_dlhq_1
X_2486_ _2486_/Q Tile_X0Y2_FrameData[10] Tile_X0Y5_FrameStrobe[7] VPWR VGND sg13cmos5l_dlhq_1
X_1506_ _3658_/A Tile_X0Y3_W2MID[2] AXI_M_SOC_RDATA11 _1216_/X _1342_/X _2694_/Q _2693_/Q
+ VPWR VGND sg13cmos5l_mux4_1
XFILLER_233_20 VPWR VGND sg13cmos5l_decap_4
X_1437_ _1437_/X _1017_/X _0629_/X Tile_X0Y5_N4END[9] Tile_X0Y0_S4END[13] _2557_/Q
+ _2558_/Q VPWR VGND sg13cmos5l_mux4_1
X_1368_ _3911_/A _1365_/Y _1367_/Y _1363_/Y VPWR VGND sg13cmos5l_o21ai_1
X_3107_ _3107_/Q Tile_X0Y5_FrameData[13] Tile_X0Y5_FrameStrobe[1] VPWR VGND sg13cmos5l_dlhq_1
XFILLER_55_224 VPWR VGND sg13cmos5l_decap_8
XFILLER_46_18 VPWR VGND sg13cmos5l_decap_8
XANTENNA__1640__X AXI_M_SOC_ARADDR5 VPWR VGND sg13cmos5l_antennanp
X_1299_ AXI_M_SOC_AWADDR4 Tile_X0Y1_W2MID[4] Tile_X0Y1_W2END[4] Tile_X0Y1_W6END[4]
+ _1089_/X _2032_/Q _2031_/Q VPWR VGND sg13cmos5l_mux4_1
XANTENNA__3331__GATE Tile_X0Y5_FrameStrobe[9] VPWR VGND sg13cmos5l_antennanp
X_3038_ _3038_/Q Tile_X0Y4_FrameData[2] Tile_X0Y5_FrameStrobe[7] VPWR VGND sg13cmos5l_dlhq_1
XFILLER_55_268 VPWR VGND sg13cmos5l_fill_1
XANTENNA__1455__A0 Tile_X0Y2_W2MID[5] VPWR VGND sg13cmos5l_antennanp
XFILLER_102_68 VPWR VGND sg13cmos5l_decap_4
XFILLER_211_200 VPWR VGND sg13cmos5l_fill_2
XFILLER_62_28 VPWR VGND sg13cmos5l_decap_8
XANTENNA__1207__A0 Tile_X0Y0_W1END[3] VPWR VGND sg13cmos5l_antennanp
XANTENNA__2334__D Tile_X0Y2_FrameData[2] VPWR VGND sg13cmos5l_antennanp
XANTENNA__3567__X Tile_X0Y0_FrameStrobe_O[18] VPWR VGND sg13cmos5l_antennanp
XFILLER_211_255 VPWR VGND sg13cmos5l_fill_2
XANTENNA__3346__GATE Tile_X0Y5_FrameStrobe[8] VPWR VGND sg13cmos5l_antennanp
XFILLER_258_61 VPWR VGND sg13cmos5l_fill_2
XFILLER_325_123 VPWR VGND sg13cmos5l_fill_2
XFILLER_191_140 VPWR VGND sg13cmos5l_decap_8
XFILLER_194_27 VPWR VGND sg13cmos5l_fill_2
XANTENNA__0981__A2 Tile_X0Y5_N4END[7] VPWR VGND sg13cmos5l_antennanp
XFILLER_11_43 VPWR VGND sg13cmos5l_fill_1
XFILLER_11_54 VPWR VGND sg13cmos5l_fill_1
XFILLER_11_65 VPWR VGND sg13cmos5l_decap_4
XANTENNA__3165__D Tile_X0Y5_FrameData[19] VPWR VGND sg13cmos5l_antennanp
XFILLER_87_14 VPWR VGND sg13cmos5l_decap_8
XFILLER_127_98 VPWR VGND sg13cmos5l_decap_8
XFILLER_278_233 VPWR VGND sg13cmos5l_fill_1
XFILLER_278_244 VPWR VGND sg13cmos5l_fill_1
XFILLER_238_119 VPWR VGND sg13cmos5l_decap_8
XANTENNA__1694__A0 Tile_X0Y5_W1END[2] VPWR VGND sg13cmos5l_antennanp
XANTENNA__2509__D Tile_X0Y2_FrameData[19] VPWR VGND sg13cmos5l_antennanp
XANTENNA__2540__GATE Tile_X0Y5_FrameStrobe[0] VPWR VGND sg13cmos5l_antennanp
XFILLER_143_86 VPWR VGND sg13cmos5l_fill_2
XANTENNA__1550__X AXI_M_SOC_ARADDR26 VPWR VGND sg13cmos5l_antennanp
XFILLER_160_0 VPWR VGND sg13cmos5l_fill_2
XANTENNA__1446__A0 Tile_X0Y2_WW4END[11] VPWR VGND sg13cmos5l_antennanp
XFILLER_258_0 VPWR VGND sg13cmos5l_fill_2
XANTENNA__2555__GATE Tile_X0Y5_FrameStrobe[1] VPWR VGND sg13cmos5l_antennanp
XANTENNA__2244__D Tile_X0Y2_FrameData[28] VPWR VGND sg13cmos5l_antennanp
XANTENNA__3477__X Tile_X0Y1_EE4BEG[13] VPWR VGND sg13cmos5l_antennanp
XFILLER_14_176 VPWR VGND sg13cmos5l_fill_1
XFILLER_182_140 VPWR VGND sg13cmos5l_decap_4
X_0670_ _0670_/Y _1971_/Q _0670_/B _0670_/C VPWR VGND sg13cmos5l_nor3_1
XANTENNA__0972__A2 Tile_X0Y5_W2END[3] VPWR VGND sg13cmos5l_antennanp
XFILLER_115_229 VPWR VGND sg13cmos5l_decap_8
XANTENNA__3075__D Tile_X0Y5_FrameData[13] VPWR VGND sg13cmos5l_antennanp
XFILLER_108_281 VPWR VGND sg13cmos5l_fill_1
XFILLER_331_137 VPWR VGND sg13cmos5l_fill_1
XFILLER_123_262 VPWR VGND sg13cmos5l_decap_8
X_2340_ _2340_/Q Tile_X0Y2_FrameData[28] Tile_X0Y5_FrameStrobe[3] VPWR VGND sg13cmos5l_dlhq_1
X_2271_ _2271_/Q Tile_X0Y2_FrameData[1] Tile_X0Y5_FrameStrobe[0] VPWR VGND sg13cmos5l_dlhq_1
XFILLER_96_124 VPWR VGND sg13cmos5l_decap_8
X_1222_ _3617_/A _1067_/X _1137_/X Tile_X0Y0_S4END[0] _1124_/X _1823_/Q _1824_/Q VPWR
+ VGND sg13cmos5l_mux4_1
XANTENNA__2419__D Tile_X0Y2_FrameData[13] VPWR VGND sg13cmos5l_antennanp
XANTENNA__2508__GATE Tile_X0Y5_FrameStrobe[8] VPWR VGND sg13cmos5l_antennanp
XFILLER_203_45 VPWR VGND sg13cmos5l_decap_8
X_1153_ _3548_/A Tile_X0Y0_W1END[3] Tile_X0Y0_W6END[7] _1124_/X _0711_/Y _1962_/Q
+ _1961_/Q VPWR VGND sg13cmos5l_mux4_1
XANTENNA__1764__GATE Tile_X0Y5_FrameStrobe[2] VPWR VGND sg13cmos5l_antennanp
XFILLER_252_133 VPWR VGND sg13cmos5l_fill_1
X_1084_ _1084_/X Tile_X0Y0_W1END[1] Tile_X0Y0_W2MID[2] Tile_X0Y0_W2END[2] _1045_/X
+ _1914_/Q _1913_/Q VPWR VGND sg13cmos5l_mux4_1
XFILLER_37_279 VPWR VGND sg13cmos5l_fill_1
XANTENNA__2154__D Tile_X0Y1_FrameData[6] VPWR VGND sg13cmos5l_antennanp
XANTENNA__3387__X Tile_X0Y2_EE4BEG[5] VPWR VGND sg13cmos5l_antennanp
XFILLER_20_102 VPWR VGND sg13cmos5l_fill_1
XANTENNA__1779__GATE Tile_X0Y5_FrameStrobe[2] VPWR VGND sg13cmos5l_antennanp
XFILLER_165_107 VPWR VGND sg13cmos5l_fill_2
X_1986_ _1986_/Q Tile_X0Y1_FrameData[14] Tile_X0Y5_FrameStrobe[0] VPWR VGND sg13cmos5l_dlhq_1
XFILLER_60_293 VPWR VGND sg13cmos5l_fill_2
XANTENNA__1993__D Tile_X0Y1_FrameData[7] VPWR VGND sg13cmos5l_antennanp
X_3725_ Tile_X0Y3_FrameData_O[28] Tile_X0Y3_FrameData[28] VPWR VGND sg13cmos5l_buf_1
X_0937_ _0937_/Y _3298_/Q _0695_/X _0936_/Y VPWR VGND sg13cmos5l_o21ai_1
XANTENNA__0963__A2 Tile_X0Y1_WW4END[5] VPWR VGND sg13cmos5l_antennanp
XANTENNA__1702__GATE Tile_X0Y5_FrameStrobe[0] VPWR VGND sg13cmos5l_antennanp
X_3656_ Tile_X0Y3_E2BEG[3] _3656_/A VPWR VGND sg13cmos5l_buf_1
X_0868_ _0868_/Y _3118_/Q _0656_/X _0867_/Y VPWR VGND sg13cmos5l_a21oi_1
XFILLER_322_115 VPWR VGND sg13cmos5l_decap_4
XANTENNA__1635__X AXI_M_SOC_ARADDR9 VPWR VGND sg13cmos5l_antennanp
XANTENNA__3563__A Tile_X0Y5_FrameStrobe[14] VPWR VGND sg13cmos5l_antennanp
X_2607_ _2607_/Q Tile_X0Y3_FrameData[1] Tile_X0Y5_FrameStrobe[2] VPWR VGND sg13cmos5l_dlhq_1
X_3587_ Tile_X0Y0_FrameData_O[18] Tile_X0Y0_FrameData[18] VPWR VGND sg13cmos5l_buf_1
X_0799_ _3822_/A Tile_X0Y5_W2MID[0] AXI_M_SOC_RLAST _0782_/X _0563_/X _3234_/Q _3233_/Q
+ VPWR VGND sg13cmos5l_mux4_1
XFILLER_322_148 VPWR VGND sg13cmos5l_decap_4
X_2538_ _2538_/Q Tile_X0Y3_FrameData[6] Tile_X0Y5_FrameStrobe[0] VPWR VGND sg13cmos5l_dlhq_1
XANTENNA__1717__GATE Tile_X0Y5_FrameStrobe[0] VPWR VGND sg13cmos5l_antennanp
XFILLER_244_52 VPWR VGND sg13cmos5l_decap_8
XFILLER_275_203 VPWR VGND sg13cmos5l_decap_4
XFILLER_330_170 VPWR VGND sg13cmos5l_fill_1
XANTENNA__3850__X Tile_X0Y5_EE4BEG[7] VPWR VGND sg13cmos5l_antennanp
X_2469_ _2469_/Q Tile_X0Y2_FrameData[27] Tile_X0Y5_FrameStrobe[7] VPWR VGND sg13cmos5l_dlhq_1
XFILLER_87_146 VPWR VGND sg13cmos5l_decap_8
XFILLER_57_28 VPWR VGND sg13cmos5l_decap_8
XANTENNA__2329__D Tile_X0Y2_FrameData[7] VPWR VGND sg13cmos5l_antennanp
XFILLER_189_8 VPWR VGND sg13cmos5l_fill_1
XANTENNA__1676__A0 Tile_X0Y4_WW4END[14] VPWR VGND sg13cmos5l_antennanp
XANTENNA__3270__GATE Tile_X0Y5_FrameStrobe[6] VPWR VGND sg13cmos5l_antennanp
XFILLER_113_23 VPWR VGND sg13cmos5l_decap_8
XFILLER_28_224 VPWR VGND sg13cmos5l_fill_1
XANTENNA__1140__A2 Tile_X0Y0_S2MID[1] VPWR VGND sg13cmos5l_antennanp
XANTENNA__1428__A0 Tile_X0Y2_W2MID[6] VPWR VGND sg13cmos5l_antennanp
XFILLER_243_166 VPWR VGND sg13cmos5l_decap_4
XANTENNA__2064__D Tile_X0Y1_FrameData[0] VPWR VGND sg13cmos5l_antennanp
XANTENNA__3285__GATE Tile_X0Y5_FrameStrobe[7] VPWR VGND sg13cmos5l_antennanp
XFILLER_51_282 VPWR VGND sg13cmos5l_fill_2
XFILLER_156_107 VPWR VGND sg13cmos5l_decap_8
XFILLER_51_293 VPWR VGND sg13cmos5l_fill_2
XANTENNA__2999__D Tile_X0Y4_FrameData[9] VPWR VGND sg13cmos5l_antennanp
XFILLER_22_53 VPWR VGND sg13cmos5l_decap_8
XFILLER_22_64 VPWR VGND sg13cmos5l_fill_1
XANTENNA__0954__A2 Tile_X0Y1_W6END[10] VPWR VGND sg13cmos5l_antennanp
XFILLER_98_24 VPWR VGND sg13cmos5l_fill_2
XFILLER_313_148 VPWR VGND sg13cmos5l_decap_8
XFILLER_98_57 VPWR VGND sg13cmos5l_decap_8
XANTENNA__3223__GATE Tile_X0Y5_FrameStrobe[5] VPWR VGND sg13cmos5l_antennanp
XFILLER_105_240 VPWR VGND sg13cmos5l_fill_2
XFILLER_105_251 VPWR VGND sg13cmos5l_fill_2
XANTENNA__3760__X Tile_X0Y4_E6BEG[10] VPWR VGND sg13cmos5l_antennanp
XFILLER_78_168 VPWR VGND sg13cmos5l_fill_2
XFILLER_304_55 VPWR VGND sg13cmos5l_decap_8
XFILLER_93_116 VPWR VGND sg13cmos5l_decap_8
XANTENNA__2239__D Tile_X0Y1_FrameData[17] VPWR VGND sg13cmos5l_antennanp
XANTENNA__3238__GATE Tile_X0Y5_FrameStrobe[5] VPWR VGND sg13cmos5l_antennanp
XFILLER_47_72 VPWR VGND sg13cmos5l_fill_2
XFILLER_47_61 VPWR VGND sg13cmos5l_decap_8
XFILLER_34_216 VPWR VGND sg13cmos5l_decap_8
XANTENNA__1419__A0 Tile_X0Y2_WW4END[2] VPWR VGND sg13cmos5l_antennanp
XANTENNA__2494__GATE Tile_X0Y5_FrameStrobe[7] VPWR VGND sg13cmos5l_antennanp
XFILLER_234_166 VPWR VGND sg13cmos5l_decap_4
XFILLER_320_43 VPWR VGND sg13cmos5l_fill_1
XANTENNA__1434__A3 Tile_X0Y0_S4END[14] VPWR VGND sg13cmos5l_antennanp
XFILLER_63_82 VPWR VGND sg13cmos5l_decap_8
XFILLER_147_107 VPWR VGND sg13cmos5l_decap_8
X_1840_ _1840_/Q Tile_X0Y0_FrameData[16] Tile_X0Y5_FrameStrobe[4] VPWR VGND sg13cmos5l_dlhq_1
XFILLER_42_293 VPWR VGND sg13cmos5l_fill_2
XFILLER_8_55 VPWR VGND sg13cmos5l_fill_1
XFILLER_8_44 VPWR VGND sg13cmos5l_fill_1
XANTENNA__1198__A2 Tile_X0Y0_W6END[2] VPWR VGND sg13cmos5l_antennanp
XANTENNA__2702__D Tile_X0Y3_FrameData[2] VPWR VGND sg13cmos5l_antennanp
X_3510_ Tile_X0Y1_E1BEG[2] _3510_/A VPWR VGND sg13cmos5l_buf_1
X_1771_ _1771_/Q Tile_X0Y0_FrameData[21] Tile_X0Y5_FrameStrobe[2] VPWR VGND sg13cmos5l_dlhq_1
XANTENNA__0945__A2 Tile_X0Y1_W6END[7] VPWR VGND sg13cmos5l_antennanp
X_0722_ _0722_/Y _2513_/Q _0722_/B _0722_/C VPWR VGND sg13cmos5l_nor3_1
XANTENNA__2432__GATE Tile_X0Y5_FrameStrobe[5] VPWR VGND sg13cmos5l_antennanp
XFILLER_304_115 VPWR VGND sg13cmos5l_decap_8
X_3441_ Tile_X0Y1_FrameData_O[9] Tile_X0Y1_FrameData[9] VPWR VGND sg13cmos5l_buf_1
X_0653_ _0653_/Y _0533_/Y _0652_/X _3263_/Q VPWR VGND sg13cmos5l_a21oi_1
X_3372_ Tile_X0Y2_E6BEG[2] _3372_/A VPWR VGND sg13cmos5l_buf_1
X_0584_ _0584_/Y _2519_/Q _0584_/B _0584_/C VPWR VGND sg13cmos5l_nor3_1
X_2323_ _2323_/Q Tile_X0Y2_FrameData[13] Tile_X0Y5_FrameStrobe[2] VPWR VGND sg13cmos5l_dlhq_1
XFILLER_69_135 VPWR VGND sg13cmos5l_fill_1
XFILLER_69_124 VPWR VGND sg13cmos5l_decap_8
XANTENNA__1370__A2 Tile_X0Y5_N4END[15] VPWR VGND sg13cmos5l_antennanp
XANTENNA__2447__GATE Tile_X0Y5_FrameStrobe[6] VPWR VGND sg13cmos5l_antennanp
XANTENNA__3670__X Tile_X0Y3_E6BEG[1] VPWR VGND sg13cmos5l_antennanp
XFILLER_214_33 VPWR VGND sg13cmos5l_decap_8
X_2254_ _2254_/Q Tile_X0Y2_FrameData[18] Tile_X0Y5_FrameStrobe[0] VPWR VGND sg13cmos5l_dlhq_1
XANTENNA__1658__A0 Tile_X0Y4_W2MID[0] VPWR VGND sg13cmos5l_antennanp
XANTENNA__2149__D Tile_X0Y1_FrameData[11] VPWR VGND sg13cmos5l_antennanp
XFILLER_19_0 VPWR VGND sg13cmos5l_fill_2
X_2185_ _2185_/Q Tile_X0Y1_FrameData[7] Tile_X0Y5_FrameStrobe[6] VPWR VGND sg13cmos5l_dlhq_1
X_1205_ AXI_M_SOC_AWADDR24 Tile_X0Y0_W2MID[0] Tile_X0Y0_W2END[0] Tile_X0Y0_W6END[0]
+ _1145_/X _1768_/Q _1767_/Q VPWR VGND sg13cmos5l_mux4_1
X_1136_ _1136_/X _3536_/A _1113_/X Tile_X0Y0_S2MID[7] Tile_X0Y0_S2END[7] _1706_/Q
+ _1705_/Q VPWR VGND sg13cmos5l_mux4_1
XANTENNA__1988__D Tile_X0Y1_FrameData[12] VPWR VGND sg13cmos5l_antennanp
XFILLER_230_54 VPWR VGND sg13cmos5l_decap_8
X_1067_ _1067_/X _1066_/X _1064_/X _3030_/Q VPWR VGND sg13cmos5l_mux2_1
XANTENNA__3558__A Tile_X0Y5_FrameStrobe[9] VPWR VGND sg13cmos5l_antennanp
XFILLER_33_293 VPWR VGND sg13cmos5l_fill_2
XFILLER_33_282 VPWR VGND sg13cmos5l_fill_2
XANTENNA__1189__A2 Tile_X0Y4_W6END[3] VPWR VGND sg13cmos5l_antennanp
XANTENNA__2612__D Tile_X0Y3_FrameData[28] VPWR VGND sg13cmos5l_antennanp
XANTENNA__3845__X Tile_X0Y5_EE4BEG[2] VPWR VGND sg13cmos5l_antennanp
XFILLER_239_63 VPWR VGND sg13cmos5l_fill_1
XFILLER_239_85 VPWR VGND sg13cmos5l_decap_4
X_1969_ _1969_/Q Tile_X0Y0_FrameData[31] Tile_X0Y5_FrameStrobe[0] VPWR VGND sg13cmos5l_dlhq_1
X_3708_ Tile_X0Y3_FrameData_O[11] Tile_X0Y3_FrameData[11] VPWR VGND sg13cmos5l_buf_1
XFILLER_146_184 VPWR VGND sg13cmos5l_decap_8
XFILLER_161_121 VPWR VGND sg13cmos5l_decap_4
X_3639_ Tile_X0Y0_E2BEG[2] _3639_/A VPWR VGND sg13cmos5l_buf_1
XANTENNA__1361__A2 Tile_X0Y5_N2MID[7] VPWR VGND sg13cmos5l_antennanp
XANTENNA__3580__X Tile_X0Y0_FrameData_O[11] VPWR VGND sg13cmos5l_antennanp
XFILLER_248_225 VPWR VGND sg13cmos5l_decap_4
XANTENNA__1649__A0 Tile_X0Y4_W2MID[1] VPWR VGND sg13cmos5l_antennanp
XANTENNA__2059__D Tile_X0Y1_FrameData[5] VPWR VGND sg13cmos5l_antennanp
XFILLER_124_88 VPWR VGND sg13cmos5l_decap_8
XFILLER_84_15 VPWR VGND sg13cmos5l_decap_8
XANTENNA__1113__A2 Tile_X0Y2_W6END[0] VPWR VGND sg13cmos5l_antennanp
XFILLER_17_20 VPWR VGND sg13cmos5l_decap_4
XFILLER_84_48 VPWR VGND sg13cmos5l_decap_8
XANTENNA__1898__D Tile_X0Y0_FrameData[22] VPWR VGND sg13cmos5l_antennanp
XFILLER_271_261 VPWR VGND sg13cmos5l_decap_4
XFILLER_83_182 VPWR VGND sg13cmos5l_decap_8
XFILLER_31_219 VPWR VGND sg13cmos5l_decap_8
XFILLER_169_254 VPWR VGND sg13cmos5l_fill_2
XFILLER_33_52 VPWR VGND sg13cmos5l_decap_8
XFILLER_318_218 VPWR VGND sg13cmos5l_fill_2
XANTENNA__2522__D Tile_X0Y3_FrameData[22] VPWR VGND sg13cmos5l_antennanp
XANTENNA__3755__X Tile_X0Y4_E6BEG[5] VPWR VGND sg13cmos5l_antennanp
XFILLER_123_0 VPWR VGND sg13cmos5l_fill_2
XFILLER_149_74 VPWR VGND sg13cmos5l_decap_8
XFILLER_184_246 VPWR VGND sg13cmos5l_decap_8
XFILLER_184_257 VPWR VGND sg13cmos5l_fill_1
XANTENNA__3162__GATE Tile_X0Y5_FrameStrobe[3] VPWR VGND sg13cmos5l_antennanp
XFILLER_98_219 VPWR VGND sg13cmos5l_fill_2
XFILLER_152_198 VPWR VGND sg13cmos5l_decap_4
XANTENNA__3490__X Tile_X0Y1_E6BEG[10] VPWR VGND sg13cmos5l_antennanp
XANTENNA__0560__A0 Tile_X0Y5_W1END[2] VPWR VGND sg13cmos5l_antennanp
XANTENNA__3177__GATE Tile_X0Y5_FrameStrobe[3] VPWR VGND sg13cmos5l_antennanp
XFILLER_181_83 VPWR VGND sg13cmos5l_decap_4
XFILLER_181_94 VPWR VGND sg13cmos5l_fill_1
XANTENNA__1104__A2 Tile_X0Y0_W6END[9] VPWR VGND sg13cmos5l_antennanp
XFILLER_207_111 VPWR VGND sg13cmos5l_decap_4
XFILLER_331_31 VPWR VGND sg13cmos5l_decap_8
XANTENNA__3100__GATE Tile_X0Y5_FrameStrobe[1] VPWR VGND sg13cmos5l_antennanp
XFILLER_207_166 VPWR VGND sg13cmos5l_fill_1
XFILLER_74_160 VPWR VGND sg13cmos5l_decap_8
XFILLER_262_283 VPWR VGND sg13cmos5l_fill_1
X_2941_ _2941_/Q Tile_X0Y4_FrameData[3] Tile_X0Y5_FrameStrobe[4] VPWR VGND sg13cmos5l_dlhq_1
XFILLER_15_293 VPWR VGND sg13cmos5l_fill_2
XFILLER_200_46 VPWR VGND sg13cmos5l_decap_8
XFILLER_30_230 VPWR VGND sg13cmos5l_decap_8
XANTENNA__3115__GATE Tile_X0Y5_FrameStrobe[1] VPWR VGND sg13cmos5l_antennanp
XFILLER_175_224 VPWR VGND sg13cmos5l_decap_8
X_2872_ _2872_/Q Tile_X0Y4_FrameData[8] Tile_X0Y5_FrameStrobe[2] VPWR VGND sg13cmos5l_dlhq_1
XANTENNA__2432__D Tile_X0Y2_FrameData[0] VPWR VGND sg13cmos5l_antennanp
XANTENNA__3665__X Tile_X0Y3_E2BEGb[4] VPWR VGND sg13cmos5l_antennanp
X_1823_ _1823_/Q Tile_X0Y0_FrameData[1] Tile_X0Y5_FrameStrobe[3] VPWR VGND sg13cmos5l_dlhq_1
XANTENNA__2371__GATE Tile_X0Y5_FrameStrobe[4] VPWR VGND sg13cmos5l_antennanp
XFILLER_209_44 VPWR VGND sg13cmos5l_decap_4
X_1754_ _1754_/Q Tile_X0Y0_FrameData[6] Tile_X0Y5_FrameStrobe[1] VPWR VGND sg13cmos5l_dlhq_1
XFILLER_143_110 VPWR VGND sg13cmos5l_decap_8
X_0705_ _0705_/Y _3262_/Q _0695_/X _0704_/Y VPWR VGND sg13cmos5l_o21ai_1
XANTENNA__1591__A2 AXI_M_SOC_RDATA9 VPWR VGND sg13cmos5l_antennanp
X_3424_ Tile_X0Y2_FrameData_O[26] Tile_X0Y2_FrameData[26] VPWR VGND sg13cmos5l_buf_1
X_1685_ _3919_/A _1684_/X _1683_/X _2994_/Q VPWR VGND sg13cmos5l_mux2_1
XANTENNA__2386__GATE Tile_X0Y5_FrameStrobe[4] VPWR VGND sg13cmos5l_antennanp
X_0636_ _0636_/Y _2790_/Q _2789_/Q VPWR VGND sg13cmos5l_nor2b_1
XANTENNA__3263__D Tile_X0Y5_FrameData[17] VPWR VGND sg13cmos5l_antennanp
X_3355_ Tile_X0Y2_E2BEG[1] _3355_/A VPWR VGND sg13cmos5l_buf_1
X_0567_ _0567_/Y _0539_/Y _1703_/Q _1704_/Q _0565_/Y _0566_/Y VPWR VGND sg13cmos5l_a221oi_1
X_3286_ _3286_/Q Tile_X0Y5_FrameData[26] Tile_X0Y5_FrameStrobe[7] VPWR VGND sg13cmos5l_dlhq_1
X_2306_ _2306_/Q Tile_X0Y2_FrameData[30] Tile_X0Y5_FrameStrobe[2] VPWR VGND sg13cmos5l_dlhq_1
X_2237_ _2237_/Q Tile_X0Y1_FrameData[19] Tile_X0Y5_FrameStrobe[8] VPWR VGND sg13cmos5l_dlhq_1
XFILLER_57_127 VPWR VGND sg13cmos5l_fill_1
XFILLER_241_53 VPWR VGND sg13cmos5l_decap_8
XFILLER_253_250 VPWR VGND sg13cmos5l_decap_4
XFILLER_260_209 VPWR VGND sg13cmos5l_fill_2
X_2168_ _2168_/Q Tile_X0Y1_FrameData[24] Tile_X0Y5_FrameStrobe[6] VPWR VGND sg13cmos5l_dlhq_1
XFILLER_65_182 VPWR VGND sg13cmos5l_decap_8
XFILLER_54_18 VPWR VGND sg13cmos5l_decap_8
XANTENNA__2607__D Tile_X0Y3_FrameData[1] VPWR VGND sg13cmos5l_antennanp
X_2099_ _2099_/Q Tile_X0Y1_FrameData[29] Tile_X0Y5_FrameStrobe[4] VPWR VGND sg13cmos5l_dlhq_1
X_1119_ _1119_/X Tile_X0Y4_W1END[3] Tile_X0Y4_W6END[7] _1127_/X _0735_/X _3050_/Q
+ _3049_/Q VPWR VGND sg13cmos5l_mux4_1
XANTENNA__2324__GATE Tile_X0Y5_FrameStrobe[2] VPWR VGND sg13cmos5l_antennanp
XFILLER_80_163 VPWR VGND sg13cmos5l_fill_1
XANTENNA__0606__A1 Tile_X0Y3_W2MID[3] VPWR VGND sg13cmos5l_antennanp
XANTENNA__2954__GATE Tile_X0Y5_FrameStrobe[5] VPWR VGND sg13cmos5l_antennanp
XFILLER_70_39 VPWR VGND sg13cmos5l_decap_4
XANTENNA__2342__D Tile_X0Y2_FrameData[26] VPWR VGND sg13cmos5l_antennanp
XANTENNA__3575__X Tile_X0Y0_FrameData_O[6] VPWR VGND sg13cmos5l_antennanp
XANTENNA__2339__GATE Tile_X0Y5_FrameStrobe[3] VPWR VGND sg13cmos5l_antennanp
XANTENNA__2969__GATE Tile_X0Y5_FrameStrobe[5] VPWR VGND sg13cmos5l_antennanp
XFILLER_119_140 VPWR VGND sg13cmos5l_fill_1
XFILLER_181_238 VPWR VGND sg13cmos5l_decap_8
XANTENNA__1582__A2 Tile_X0Y3_WW4END[3] VPWR VGND sg13cmos5l_antennanp
XANTENNA__0790__A0 Tile_X0Y5_N2MID[2] VPWR VGND sg13cmos5l_antennanp
XANTENNA__3173__D Tile_X0Y5_FrameData[11] VPWR VGND sg13cmos5l_antennanp
XFILLER_295_128 VPWR VGND sg13cmos5l_decap_8
XFILLER_295_139 VPWR VGND sg13cmos5l_fill_2
XFILLER_95_14 VPWR VGND sg13cmos5l_decap_8
XFILLER_88_285 VPWR VGND sg13cmos5l_fill_1
XFILLER_48_105 VPWR VGND sg13cmos5l_decap_8
XANTENNA__1098__A1 Tile_X0Y3_W2END[5] VPWR VGND sg13cmos5l_antennanp
XANTENNA__2907__GATE Tile_X0Y5_FrameStrobe[3] VPWR VGND sg13cmos5l_antennanp
XFILLER_151_42 VPWR VGND sg13cmos5l_decap_8
XFILLER_229_280 VPWR VGND sg13cmos5l_fill_1
XFILLER_28_85 VPWR VGND sg13cmos5l_decap_8
XANTENNA__2517__D Tile_X0Y3_FrameData[27] VPWR VGND sg13cmos5l_antennanp
XFILLER_71_130 VPWR VGND sg13cmos5l_decap_8
XFILLER_240_0 VPWR VGND sg13cmos5l_fill_2
XFILLER_44_95 VPWR VGND sg13cmos5l_decap_8
XFILLER_338_0 VPWR VGND sg13cmos5l_fill_2
XANTENNA__1270__A1 Tile_X0Y2_W2MID[3] VPWR VGND sg13cmos5l_antennanp
XANTENNA__3348__D Tile_X0Y5_FrameData[14] VPWR VGND sg13cmos5l_antennanp
XANTENNA__3485__X Tile_X0Y1_E6BEG[5] VPWR VGND sg13cmos5l_antennanp
XANTENNA__2252__D Tile_X0Y2_FrameData[20] VPWR VGND sg13cmos5l_antennanp
XFILLER_172_216 VPWR VGND sg13cmos5l_decap_8
XFILLER_8_267 VPWR VGND sg13cmos5l_decap_4
XFILLER_176_72 VPWR VGND sg13cmos5l_decap_8
XFILLER_67_8 VPWR VGND sg13cmos5l_decap_8
XFILLER_60_94 VPWR VGND sg13cmos5l_decap_8
XFILLER_5_12 VPWR VGND sg13cmos5l_decap_8
XFILLER_326_20 VPWR VGND sg13cmos5l_fill_2
XANTENNA__0781__A0 Tile_X0Y4_W2MID[7] VPWR VGND sg13cmos5l_antennanp
XFILLER_140_102 VPWR VGND sg13cmos5l_decap_8
XFILLER_180_282 VPWR VGND sg13cmos5l_fill_2
XFILLER_180_293 VPWR VGND sg13cmos5l_fill_2
X_1470_ _3395_/A Tile_X0Y2_WW4END[2] AXI_M_SOC_RDATA16 _1380_/X _1151_/X _2374_/Q
+ _2373_/Q VPWR VGND sg13cmos5l_mux4_1
XANTENNA__3083__D Tile_X0Y5_FrameData[5] VPWR VGND sg13cmos5l_antennanp
XFILLER_262_19 VPWR VGND sg13cmos5l_fill_1
XFILLER_192_71 VPWR VGND sg13cmos5l_fill_2
X_3140_ _3140_/Q Tile_X0Y5_FrameData[12] Tile_X0Y5_FrameStrobe[2] VPWR VGND sg13cmos5l_dlhq_1
XFILLER_94_200 VPWR VGND sg13cmos5l_decap_8
XFILLER_227_206 VPWR VGND sg13cmos5l_decap_4
XFILLER_39_138 VPWR VGND sg13cmos5l_decap_8
X_3071_ _3071_/Q Tile_X0Y5_FrameData[17] Tile_X0Y5_FrameStrobe[0] VPWR VGND sg13cmos5l_dlhq_1
XFILLER_235_250 VPWR VGND sg13cmos5l_fill_2
X_2022_ _2022_/Q Tile_X0Y1_FrameData[10] Tile_X0Y5_FrameStrobe[1] VPWR VGND sg13cmos5l_dlhq_1
XFILLER_47_182 VPWR VGND sg13cmos5l_decap_8
XANTENNA__0836__A1 Tile_X0Y5_W6END[9] VPWR VGND sg13cmos5l_antennanp
XANTENNA__2427__D Tile_X0Y2_FrameData[5] VPWR VGND sg13cmos5l_antennanp
XFILLER_62_141 VPWR VGND sg13cmos5l_fill_1
XFILLER_62_130 VPWR VGND sg13cmos5l_decap_8
XANTENNA__3054__GATE Tile_X0Y5_FrameStrobe[8] VPWR VGND sg13cmos5l_antennanp
XFILLER_203_180 VPWR VGND sg13cmos5l_decap_4
X_2924_ _2924_/Q Tile_X0Y4_FrameData[20] Tile_X0Y5_FrameStrobe[4] VPWR VGND sg13cmos5l_dlhq_1
XFILLER_86_0 VPWR VGND sg13cmos5l_fill_2
XANTENNA__3258__D Tile_X0Y5_FrameData[22] VPWR VGND sg13cmos5l_antennanp
XANTENNA__3395__X Tile_X0Y2_EE4BEG[13] VPWR VGND sg13cmos5l_antennanp
X_2855_ _2855_/Q Tile_X0Y4_FrameData[25] Tile_X0Y5_FrameStrobe[2] VPWR VGND sg13cmos5l_dlhq_1
XANTENNA__2162__D Tile_X0Y1_FrameData[30] VPWR VGND sg13cmos5l_antennanp
XANTENNA__3069__GATE Tile_X0Y5_FrameStrobe[0] VPWR VGND sg13cmos5l_antennanp
XFILLER_148_279 VPWR VGND sg13cmos5l_fill_2
X_1806_ _1806_/Q Tile_X0Y0_FrameData[18] Tile_X0Y5_FrameStrobe[3] VPWR VGND sg13cmos5l_dlhq_1
XFILLER_163_238 VPWR VGND sg13cmos5l_decap_8
X_2786_ _2786_/Q Tile_X0Y4_FrameData[30] Tile_X0Y5_FrameStrobe[0] VPWR VGND sg13cmos5l_dlhq_1
XANTENNA__1564__A2 Tile_X0Y3_W6END[5] VPWR VGND sg13cmos5l_antennanp
XFILLER_236_42 VPWR VGND sg13cmos5l_decap_8
X_1737_ _1737_/Q Tile_X0Y0_FrameData[23] Tile_X0Y5_FrameStrobe[1] VPWR VGND sg13cmos5l_dlhq_1
XANTENNA__0772__A0 Tile_X0Y1_WW4END[2] VPWR VGND sg13cmos5l_antennanp
XFILLER_116_165 VPWR VGND sg13cmos5l_decap_8
XFILLER_131_102 VPWR VGND sg13cmos5l_decap_8
XFILLER_236_53 VPWR VGND sg13cmos5l_fill_1
XFILLER_236_75 VPWR VGND sg13cmos5l_decap_8
X_1668_ _3733_/A _1135_/X _0730_/X AXI_M_SOC_RRESP0 AXI_M_SOC_RDATA2 _2978_/Q _2977_/Q
+ VPWR VGND sg13cmos5l_mux4_1
XFILLER_171_293 VPWR VGND sg13cmos5l_fill_2
XFILLER_172_19 VPWR VGND sg13cmos5l_decap_8
XFILLER_277_117 VPWR VGND sg13cmos5l_fill_2
X_3407_ Tile_X0Y2_FrameData_O[9] Tile_X0Y2_FrameData[9] VPWR VGND sg13cmos5l_buf_1
X_0619_ _0621_/B Tile_X0Y1_W6END[1] _1974_/Q VPWR VGND sg13cmos5l_nor2b_1
XANTENNA__1316__A2 Tile_X0Y2_W2END[2] VPWR VGND sg13cmos5l_antennanp
XANTENNA__1643__X AXI_M_SOC_ARADDR11 VPWR VGND sg13cmos5l_antennanp
XANTENNA__3571__A Tile_X0Y0_FrameData[2] VPWR VGND sg13cmos5l_antennanp
X_3338_ _3338_/Q Tile_X0Y5_FrameData[4] Tile_X0Y5_FrameStrobe[8] VPWR VGND sg13cmos5l_dlhq_1
X_1599_ _1599_/X _1434_/X _1512_/X _2718_/Q VPWR VGND sg13cmos5l_mux2_1
XFILLER_105_46 VPWR VGND sg13cmos5l_decap_8
XFILLER_252_41 VPWR VGND sg13cmos5l_decap_4
XFILLER_292_109 VPWR VGND sg13cmos5l_fill_1
XFILLER_85_211 VPWR VGND sg13cmos5l_fill_2
XANTENNA__3007__GATE Tile_X0Y5_FrameStrobe[6] VPWR VGND sg13cmos5l_antennanp
XFILLER_285_183 VPWR VGND sg13cmos5l_decap_4
XFILLER_285_194 VPWR VGND sg13cmos5l_fill_1
X_3269_ _3269_/Q Tile_X0Y5_FrameData[11] Tile_X0Y5_FrameStrobe[6] VPWR VGND sg13cmos5l_dlhq_1
XFILLER_45_119 VPWR VGND sg13cmos5l_decap_8
XFILLER_38_160 VPWR VGND sg13cmos5l_decap_8
XANTENNA__2263__GATE Tile_X0Y5_FrameStrobe[0] VPWR VGND sg13cmos5l_antennanp
XANTENNA__2337__D Tile_X0Y2_FrameData[31] VPWR VGND sg13cmos5l_antennanp
XFILLER_269_8 VPWR VGND sg13cmos5l_fill_1
XFILLER_53_130 VPWR VGND sg13cmos5l_decap_8
XANTENNA__2893__GATE Tile_X0Y5_FrameStrobe[3] VPWR VGND sg13cmos5l_antennanp
XFILLER_121_56 VPWR VGND sg13cmos5l_decap_8
XFILLER_226_294 VPWR VGND sg13cmos5l_fill_1
XFILLER_139_202 VPWR VGND sg13cmos5l_decap_8
XANTENNA__2278__GATE Tile_X0Y5_FrameStrobe[1] VPWR VGND sg13cmos5l_antennanp
XANTENNA__3168__D Tile_X0Y5_FrameData[16] VPWR VGND sg13cmos5l_antennanp
XANTENNA__2072__D Tile_X0Y1_FrameData[24] VPWR VGND sg13cmos5l_antennanp
XANTENNA__1555__A2 Tile_X0Y3_W6END[4] VPWR VGND sg13cmos5l_antennanp
XANTENNA__2201__GATE Tile_X0Y5_FrameStrobe[7] VPWR VGND sg13cmos5l_antennanp
XANTENNA__2800__D Tile_X0Y4_FrameData[16] VPWR VGND sg13cmos5l_antennanp
XFILLER_107_154 VPWR VGND sg13cmos5l_decap_8
XANTENNA__0763__A0 Tile_X0Y5_WW4END[5] VPWR VGND sg13cmos5l_antennanp
XANTENNA__2831__GATE Tile_X0Y5_FrameStrobe[1] VPWR VGND sg13cmos5l_antennanp
XFILLER_162_293 VPWR VGND sg13cmos5l_fill_2
XANTENNA__1307__A2 Tile_X0Y1_W6END[3] VPWR VGND sg13cmos5l_antennanp
XANTENNA__1553__X AXI_M_SOC_ARADDR29 VPWR VGND sg13cmos5l_antennanp
XANTENNA__2216__GATE Tile_X0Y5_FrameStrobe[7] VPWR VGND sg13cmos5l_antennanp
XFILLER_39_51 VPWR VGND sg13cmos5l_decap_8
XANTENNA__2846__GATE Tile_X0Y5_FrameStrobe[1] VPWR VGND sg13cmos5l_antennanp
XFILLER_162_41 VPWR VGND sg13cmos5l_decap_8
XFILLER_190_0 VPWR VGND sg13cmos5l_fill_2
XFILLER_209_206 VPWR VGND sg13cmos5l_fill_2
XFILLER_39_62 VPWR VGND sg13cmos5l_decap_8
XFILLER_288_0 VPWR VGND sg13cmos5l_decap_8
XFILLER_39_95 VPWR VGND sg13cmos5l_decap_8
XFILLER_91_225 VPWR VGND sg13cmos5l_decap_4
XANTENNA__2247__D Tile_X0Y2_FrameData[25] VPWR VGND sg13cmos5l_antennanp
X_0970_ AXI_M_SOC_AWLEN7 _3337_/Q _0969_/X VPWR VGND sg13cmos5l_nor2b_1
XANTENNA__3078__D Tile_X0Y5_FrameData[10] VPWR VGND sg13cmos5l_antennanp
XFILLER_197_190 VPWR VGND sg13cmos5l_decap_8
X_2640_ _2640_/Q Tile_X0Y3_FrameData[0] Tile_X0Y5_FrameStrobe[3] VPWR VGND sg13cmos5l_dlhq_1
XFILLER_337_52 VPWR VGND sg13cmos5l_fill_1
XANTENNA__2710__D Tile_X0Y3_FrameData[26] VPWR VGND sg13cmos5l_antennanp
X_2571_ _2571_/Q Tile_X0Y3_FrameData[5] Tile_X0Y5_FrameStrobe[1] VPWR VGND sg13cmos5l_dlhq_1
X_1522_ _3687_/A Tile_X0Y3_WW4END[9] _1523_/X AXI_M_SOC_RDATA12 _1219_/X _2659_/Q
+ _2660_/Q VPWR VGND sg13cmos5l_mux4_1
XFILLER_113_146 VPWR VGND sg13cmos5l_decap_8
XFILLER_153_293 VPWR VGND sg13cmos5l_fill_2
XFILLER_206_34 VPWR VGND sg13cmos5l_decap_8
XFILLER_299_286 VPWR VGND sg13cmos5l_fill_1
X_1453_ _3354_/A Tile_X0Y2_W2MID[7] AXI_M_SOC_RDATA14 _1157_/X _1179_/X _2432_/Q _2431_/Q
+ VPWR VGND sg13cmos5l_mux4_1
X_1384_ _1384_/Y _2482_/Q _1151_/X _1383_/Y VPWR VGND sg13cmos5l_a21oi_1
X_3123_ _3123_/Q Tile_X0Y5_FrameData[29] Tile_X0Y5_FrameStrobe[2] VPWR VGND sg13cmos5l_dlhq_1
X_3054_ _3054_/Q Tile_X0Y4_FrameData[18] Tile_X0Y5_FrameStrobe[8] VPWR VGND sg13cmos5l_dlhq_1
XFILLER_82_214 VPWR VGND sg13cmos5l_fill_2
XANTENNA__2157__D Tile_X0Y1_FrameData[3] VPWR VGND sg13cmos5l_antennanp
X_2005_ _2005_/Q Tile_X0Y1_FrameData[27] Tile_X0Y5_FrameStrobe[1] VPWR VGND sg13cmos5l_dlhq_1
XFILLER_35_141 VPWR VGND sg13cmos5l_decap_8
XANTENNA__1996__D Tile_X0Y1_FrameData[4] VPWR VGND sg13cmos5l_antennanp
XFILLER_223_286 VPWR VGND sg13cmos5l_fill_1
XANTENNA__1234__A1 AXI_M_SOC_BVALID VPWR VGND sg13cmos5l_antennanp
XFILLER_167_19 VPWR VGND sg13cmos5l_fill_1
X_2907_ _2907_/Q Tile_X0Y4_FrameData[5] Tile_X0Y5_FrameStrobe[3] VPWR VGND sg13cmos5l_dlhq_1
XFILLER_50_188 VPWR VGND sg13cmos5l_decap_8
XANTENNA__1638__X AXI_M_SOC_ARADDR12 VPWR VGND sg13cmos5l_antennanp
XANTENNA__3566__A Tile_X0Y5_FrameStrobe[17] VPWR VGND sg13cmos5l_antennanp
X_3887_ Tile_X0Y5_FrameData_O[28] Tile_X0Y5_FrameData[28] VPWR VGND sg13cmos5l_buf_1
XFILLER_337_143 VPWR VGND sg13cmos5l_fill_1
XANTENNA__0993__A0 Tile_X0Y0_W6END[6] VPWR VGND sg13cmos5l_antennanp
X_2838_ _2838_/Q Tile_X0Y4_FrameData[10] Tile_X0Y5_FrameStrobe[1] VPWR VGND sg13cmos5l_dlhq_1
XFILLER_337_176 VPWR VGND sg13cmos5l_fill_2
XANTENNA__3853__X Tile_X0Y5_EE4BEG[10] VPWR VGND sg13cmos5l_antennanp
X_2769_ _2769_/Q Tile_X0Y3_FrameData[31] Tile_X0Y5_FrameStrobe[8] VPWR VGND sg13cmos5l_dlhq_1
XANTENNA__2620__D Tile_X0Y3_FrameData[20] VPWR VGND sg13cmos5l_antennanp
XFILLER_144_271 VPWR VGND sg13cmos5l_fill_1
XFILLER_183_18 VPWR VGND sg13cmos5l_decap_8
XANTENNA__0760__A3 AXI_M_SOC_RLAST VPWR VGND sg13cmos5l_antennanp
XANTENNA__1170__A0 Tile_X0Y0_W6END[9] VPWR VGND sg13cmos5l_antennanp
XFILLER_258_172 VPWR VGND sg13cmos5l_fill_2
XANTENNA__2067__D Tile_X0Y1_FrameData[29] VPWR VGND sg13cmos5l_antennanp
XFILLER_73_247 VPWR VGND sg13cmos5l_decap_4
XFILLER_214_242 VPWR VGND sg13cmos5l_decap_4
XFILLER_25_20 VPWR VGND sg13cmos5l_fill_1
XANTENNA__1225__A1 AXI_M_SOC_BVALID VPWR VGND sg13cmos5l_antennanp
XFILLER_186_149 VPWR VGND sg13cmos5l_fill_2
XANTENNA__1548__X AXI_M_SOC_ARADDR31 VPWR VGND sg13cmos5l_antennanp
XFILLER_41_41 VPWR VGND sg13cmos5l_decap_8
XANTENNA__2140__GATE Tile_X0Y5_FrameStrobe[5] VPWR VGND sg13cmos5l_antennanp
XFILLER_194_171 VPWR VGND sg13cmos5l_decap_8
XANTENNA__2770__GATE Tile_X0Y5_FrameStrobe[8] VPWR VGND sg13cmos5l_antennanp
XANTENNA__3763__X Tile_X0Y4_EE4BEG[1] VPWR VGND sg13cmos5l_antennanp
XFILLER_157_52 VPWR VGND sg13cmos5l_decap_8
XFILLER_203_0 VPWR VGND sg13cmos5l_fill_2
XFILLER_41_85 VPWR VGND sg13cmos5l_fill_1
XANTENNA__0736__A0 Tile_X0Y4_W1END[3] VPWR VGND sg13cmos5l_antennanp
XANTENNA__2530__D Tile_X0Y3_FrameData[14] VPWR VGND sg13cmos5l_antennanp
XANTENNA__2155__GATE Tile_X0Y5_FrameStrobe[5] VPWR VGND sg13cmos5l_antennanp
XFILLER_307_77 VPWR VGND sg13cmos5l_fill_2
XANTENNA__2785__GATE Tile_X0Y5_FrameStrobe[0] VPWR VGND sg13cmos5l_antennanp
XFILLER_173_51 VPWR VGND sg13cmos5l_decap_8
XFILLER_110_138 VPWR VGND sg13cmos5l_decap_8
XFILLER_2_13 VPWR VGND sg13cmos5l_fill_2
XFILLER_49_222 VPWR VGND sg13cmos5l_fill_1
XFILLER_49_211 VPWR VGND sg13cmos5l_decap_8
XANTENNA__1161__A0 Tile_X0Y0_W1END[3] VPWR VGND sg13cmos5l_antennanp
XFILLER_103_190 VPWR VGND sg13cmos5l_decap_8
XFILLER_110_149 VPWR VGND sg13cmos5l_fill_1
XFILLER_249_183 VPWR VGND sg13cmos5l_decap_4
XFILLER_17_141 VPWR VGND sg13cmos5l_decap_8
XANTENNA__1464__A1 AXI_M_SOC_RDATA21 VPWR VGND sg13cmos5l_antennanp
XFILLER_72_280 VPWR VGND sg13cmos5l_fill_1
XANTENNA__2705__D Tile_X0Y3_FrameData[31] VPWR VGND sg13cmos5l_antennanp
XANTENNA__2723__GATE Tile_X0Y5_FrameStrobe[6] VPWR VGND sg13cmos5l_antennanp
XFILLER_177_116 VPWR VGND sg13cmos5l_decap_4
X_3810_ Tile_X0Y4_UserCLKo Tile_X0Y4_UserCLK VPWR VGND sg13cmos5l_buf_1
XFILLER_82_92 VPWR VGND sg13cmos5l_decap_8
XFILLER_177_138 VPWR VGND sg13cmos5l_decap_8
X_3741_ Tile_X0Y4_E2BEG[7] _3741_/A VPWR VGND sg13cmos5l_buf_1
X_0953_ _0953_/X _1122_/X _0666_/X _0940_/Y Tile_X0Y0_S4END[6] _2003_/Q _2004_/Q VPWR
+ VGND sg13cmos5l_mux4_1
XFILLER_319_154 VPWR VGND sg13cmos5l_decap_8
XANTENNA__0975__A0 Tile_X0Y5_W1END[1] VPWR VGND sg13cmos5l_antennanp
XANTENNA__2108__GATE Tile_X0Y5_FrameStrobe[4] VPWR VGND sg13cmos5l_antennanp
XANTENNA__2738__GATE Tile_X0Y5_FrameStrobe[7] VPWR VGND sg13cmos5l_antennanp
X_3672_ Tile_X0Y3_E6BEG[3] _3672_/A VPWR VGND sg13cmos5l_buf_1
X_0884_ AXI_M_SOC_WSTRB0 _3334_/Q _0884_/B VPWR VGND sg13cmos5l_or2_1
X_2623_ _2623_/Q Tile_X0Y3_FrameData[17] Tile_X0Y5_FrameStrobe[3] VPWR VGND sg13cmos5l_dlhq_1
XANTENNA__2440__D Tile_X0Y2_FrameData[24] VPWR VGND sg13cmos5l_antennanp
XANTENNA__3673__X Tile_X0Y3_E6BEG[4] VPWR VGND sg13cmos5l_antennanp
X_2554_ _2554_/Q Tile_X0Y3_FrameData[22] Tile_X0Y5_FrameStrobe[1] VPWR VGND sg13cmos5l_dlhq_1
XANTENNA__1994__GATE Tile_X0Y5_FrameStrobe[0] VPWR VGND sg13cmos5l_antennanp
XFILLER_126_282 VPWR VGND sg13cmos5l_fill_1
XFILLER_126_293 VPWR VGND sg13cmos5l_fill_2
X_1505_ _3659_/A Tile_X0Y3_W2MID[1] AXI_M_SOC_RDATA12 _1219_/X _1348_/X _2692_/Q _2691_/Q
+ VPWR VGND sg13cmos5l_mux4_1
XFILLER_49_0 VPWR VGND sg13cmos5l_decap_4
XANTENNA__1193__X AXI_M_SOC_AWADDR15 VPWR VGND sg13cmos5l_antennanp
XFILLER_141_241 VPWR VGND sg13cmos5l_decap_8
XFILLER_141_252 VPWR VGND sg13cmos5l_fill_2
X_2485_ _2485_/Q Tile_X0Y2_FrameData[11] Tile_X0Y5_FrameStrobe[7] VPWR VGND sg13cmos5l_dlhq_1
X_1436_ _1436_/X _1050_/X _0580_/X Tile_X0Y5_N4END[8] Tile_X0Y0_S4END[12] _2559_/Q
+ _2560_/Q VPWR VGND sg13cmos5l_mux4_1
XANTENNA__1152__A0 Tile_X0Y0_W2MID[5] VPWR VGND sg13cmos5l_antennanp
XANTENNA__3271__D Tile_X0Y5_FrameData[9] VPWR VGND sg13cmos5l_antennanp
XFILLER_255_120 VPWR VGND sg13cmos5l_fill_2
X_1367_ _1367_/Y _2451_/Q _1366_/X _2450_/Q VPWR VGND sg13cmos5l_o21ai_1
X_3106_ _3106_/Q Tile_X0Y5_FrameData[14] Tile_X0Y5_FrameStrobe[1] VPWR VGND sg13cmos5l_dlhq_1
XFILLER_55_203 VPWR VGND sg13cmos5l_decap_8
X_1298_ _3484_/A AXI_M_SOC_RDATA22 _0956_/X _0944_/X _1110_/X _2087_/Q _2088_/Q VPWR
+ VGND sg13cmos5l_mux4_1
XANTENNA__1932__GATE Tile_X0Y5_FrameStrobe[7] VPWR VGND sg13cmos5l_antennanp
XFILLER_102_25 VPWR VGND sg13cmos5l_decap_4
XFILLER_270_134 VPWR VGND sg13cmos5l_fill_1
X_3037_ _3037_/Q Tile_X0Y4_FrameData[3] Tile_X0Y5_FrameStrobe[7] VPWR VGND sg13cmos5l_dlhq_1
XANTENNA__1455__A1 AXI_M_SOC_RDATA16 VPWR VGND sg13cmos5l_antennanp
XFILLER_102_47 VPWR VGND sg13cmos5l_decap_8
XANTENNA__2615__D Tile_X0Y3_FrameData[25] VPWR VGND sg13cmos5l_antennanp
XANTENNA__3848__X Tile_X0Y5_EE4BEG[5] VPWR VGND sg13cmos5l_antennanp
XFILLER_211_223 VPWR VGND sg13cmos5l_fill_1
XANTENNA__1207__A1 Tile_X0Y0_WW4END[15] VPWR VGND sg13cmos5l_antennanp
XANTENNA__1947__GATE Tile_X0Y5_FrameStrobe[7] VPWR VGND sg13cmos5l_antennanp
XANTENNA__0966__A0 Tile_X0Y1_W1END[2] VPWR VGND sg13cmos5l_antennanp
XANTENNA__0718__A0 Tile_X0Y1_W1END[3] VPWR VGND sg13cmos5l_antennanp
XANTENNA__2350__D Tile_X0Y2_FrameData[18] VPWR VGND sg13cmos5l_antennanp
XANTENNA__3583__X Tile_X0Y0_FrameData_O[14] VPWR VGND sg13cmos5l_antennanp
XFILLER_117_293 VPWR VGND sg13cmos5l_fill_2
XFILLER_278_201 VPWR VGND sg13cmos5l_decap_4
XFILLER_274_94 VPWR VGND sg13cmos5l_fill_2
XANTENNA__3181__D Tile_X0Y5_FrameData[3] VPWR VGND sg13cmos5l_antennanp
XFILLER_246_153 VPWR VGND sg13cmos5l_decap_8
XANTENNA__1694__A1 Tile_X0Y5_W6END[10] VPWR VGND sg13cmos5l_antennanp
XFILLER_100_171 VPWR VGND sg13cmos5l_decap_8
XFILLER_246_164 VPWR VGND sg13cmos5l_fill_2
XFILLER_261_101 VPWR VGND sg13cmos5l_fill_1
XFILLER_36_74 VPWR VGND sg13cmos5l_decap_8
XANTENNA__2525__D Tile_X0Y3_FrameData[19] VPWR VGND sg13cmos5l_antennanp
XANTENNA__3758__X Tile_X0Y4_E6BEG[8] VPWR VGND sg13cmos5l_antennanp
XFILLER_153_0 VPWR VGND sg13cmos5l_fill_2
XFILLER_159_138 VPWR VGND sg13cmos5l_decap_8
XFILLER_202_245 VPWR VGND sg13cmos5l_decap_4
XFILLER_202_278 VPWR VGND sg13cmos5l_fill_1
XFILLER_320_0 VPWR VGND sg13cmos5l_fill_2
XANTENNA__0957__A0 Tile_X0Y1_WW4END[3] VPWR VGND sg13cmos5l_antennanp
XFILLER_318_43 VPWR VGND sg13cmos5l_fill_1
XFILLER_318_21 VPWR VGND sg13cmos5l_fill_2
XANTENNA__2260__D Tile_X0Y2_FrameData[12] VPWR VGND sg13cmos5l_antennanp
XANTENNA__3493__X Tile_X0Y1_E2BEGb[1] VPWR VGND sg13cmos5l_antennanp
XFILLER_182_163 VPWR VGND sg13cmos5l_fill_2
XFILLER_318_65 VPWR VGND sg13cmos5l_fill_2
XANTENNA__2094__GATE Tile_X0Y5_FrameStrobe[3] VPWR VGND sg13cmos5l_antennanp
XFILLER_269_212 VPWR VGND sg13cmos5l_decap_4
XFILLER_331_149 VPWR VGND sg13cmos5l_fill_2
XFILLER_331_127 VPWR VGND sg13cmos5l_fill_1
X_2270_ _2270_/Q Tile_X0Y2_FrameData[2] Tile_X0Y5_FrameStrobe[0] VPWR VGND sg13cmos5l_dlhq_1
XFILLER_334_64 VPWR VGND sg13cmos5l_fill_1
XANTENNA__3091__D Tile_X0Y5_FrameData[29] VPWR VGND sg13cmos5l_antennanp
X_1221_ _3619_/A _1003_/X _1038_/X Tile_X0Y0_S4END[2] _1041_/X _1819_/Q _1820_/Q VPWR
+ VGND sg13cmos5l_mux4_1
XFILLER_96_158 VPWR VGND sg13cmos5l_decap_8
XFILLER_203_13 VPWR VGND sg13cmos5l_fill_1
XFILLER_237_153 VPWR VGND sg13cmos5l_fill_1
XFILLER_284_259 VPWR VGND sg13cmos5l_fill_1
XFILLER_203_24 VPWR VGND sg13cmos5l_decap_8
XFILLER_237_175 VPWR VGND sg13cmos5l_fill_2
X_1152_ _3539_/A Tile_X0Y0_W2MID[5] Tile_X0Y0_W2END[5] Tile_X0Y0_W6END[5] _1147_/X
+ _1956_/Q _1955_/Q VPWR VGND sg13cmos5l_mux4_1
XANTENNA__2032__GATE Tile_X0Y5_FrameStrobe[1] VPWR VGND sg13cmos5l_antennanp
X_1083_ _1083_/X _1008_/X _1081_/X _1082_/X Tile_X0Y0_S2MID[6] _1979_/Q _1980_/Q VPWR
+ VGND sg13cmos5l_mux4_1
XFILLER_37_258 VPWR VGND sg13cmos5l_fill_2
XANTENNA__2662__GATE Tile_X0Y5_FrameStrobe[4] VPWR VGND sg13cmos5l_antennanp
XFILLER_252_167 VPWR VGND sg13cmos5l_fill_1
XFILLER_279_17 VPWR VGND sg13cmos5l_fill_1
XANTENNA__2435__D Tile_X0Y2_FrameData[29] VPWR VGND sg13cmos5l_antennanp
XANTENNA__3668__X Tile_X0Y3_E2BEGb[7] VPWR VGND sg13cmos5l_antennanp
XANTENNA__2047__GATE Tile_X0Y5_FrameStrobe[2] VPWR VGND sg13cmos5l_antennanp
X_1985_ _1985_/Q Tile_X0Y1_FrameData[15] Tile_X0Y5_FrameStrobe[0] VPWR VGND sg13cmos5l_dlhq_1
XANTENNA__0948__A0 Tile_X0Y1_WW4END[0] VPWR VGND sg13cmos5l_antennanp
XANTENNA__2677__GATE Tile_X0Y5_FrameStrobe[5] VPWR VGND sg13cmos5l_antennanp
X_3724_ Tile_X0Y3_FrameData_O[27] Tile_X0Y3_FrameData[27] VPWR VGND sg13cmos5l_buf_1
X_0936_ _0936_/Y _0696_/X _3298_/Q VPWR VGND sg13cmos5l_nand2b_1
XANTENNA__3266__D Tile_X0Y5_FrameData[14] VPWR VGND sg13cmos5l_antennanp
XFILLER_228_43 VPWR VGND sg13cmos5l_decap_8
X_3655_ Tile_X0Y3_E2BEG[2] _3655_/A VPWR VGND sg13cmos5l_buf_1
XANTENNA__2170__D Tile_X0Y1_FrameData[22] VPWR VGND sg13cmos5l_antennanp
X_2606_ _2606_/Q Tile_X0Y3_FrameData[2] Tile_X0Y5_FrameStrobe[2] VPWR VGND sg13cmos5l_dlhq_1
X_0867_ _0867_/Y _3118_/Q Tile_X0Y5_W6END[5] VPWR VGND sg13cmos5l_nor2b_1
XANTENNA__2600__GATE Tile_X0Y5_FrameStrobe[2] VPWR VGND sg13cmos5l_antennanp
X_3586_ Tile_X0Y0_FrameData_O[17] Tile_X0Y0_FrameData[17] VPWR VGND sg13cmos5l_buf_1
X_0798_ _3821_/A Tile_X0Y5_W2MID[1] _0786_/X AXI_M_SOC_RVALID _0559_/X _3235_/Q _3236_/Q
+ VPWR VGND sg13cmos5l_mux4_1
X_2537_ _2537_/Q Tile_X0Y3_FrameData[7] Tile_X0Y5_FrameStrobe[0] VPWR VGND sg13cmos5l_dlhq_1
XFILLER_315_190 VPWR VGND sg13cmos5l_decap_4
X_2468_ _2468_/Q Tile_X0Y2_FrameData[28] Tile_X0Y5_FrameStrobe[7] VPWR VGND sg13cmos5l_dlhq_1
XFILLER_87_125 VPWR VGND sg13cmos5l_decap_8
XANTENNA__2615__GATE Tile_X0Y5_FrameStrobe[3] VPWR VGND sg13cmos5l_antennanp
X_1419_ AXI_M_SOC_WDATA18 Tile_X0Y2_WW4END[2] Tile_X0Y2_WW4END[10] Tile_X0Y2_W6END[10]
+ _1379_/X _2324_/Q _2323_/Q VPWR VGND sg13cmos5l_mux4_1
XANTENNA__1651__X AXI_M_SOC_ARADDR15 VPWR VGND sg13cmos5l_antennanp
X_2399_ _2399_/Q Tile_X0Y2_FrameData[1] Tile_X0Y5_FrameStrobe[4] VPWR VGND sg13cmos5l_dlhq_1
XANTENNA__1871__GATE Tile_X0Y5_FrameStrobe[5] VPWR VGND sg13cmos5l_antennanp
XANTENNA__1140__A3 Tile_X0Y0_S2END[1] VPWR VGND sg13cmos5l_antennanp
XFILLER_243_134 VPWR VGND sg13cmos5l_decap_8
XFILLER_260_52 VPWR VGND sg13cmos5l_fill_1
XANTENNA__1428__A1 Tile_X0Y2_W2END[6] VPWR VGND sg13cmos5l_antennanp
XANTENNA__2345__D Tile_X0Y2_FrameData[23] VPWR VGND sg13cmos5l_antennanp
XANTENNA__3578__X Tile_X0Y0_FrameData_O[9] VPWR VGND sg13cmos5l_antennanp
XANTENNA__1886__GATE Tile_X0Y5_FrameStrobe[5] VPWR VGND sg13cmos5l_antennanp
XFILLER_196_211 VPWR VGND sg13cmos5l_decap_8
XFILLER_196_266 VPWR VGND sg13cmos5l_decap_8
XFILLER_269_72 VPWR VGND sg13cmos5l_fill_1
XFILLER_269_83 VPWR VGND sg13cmos5l_decap_8
XFILLER_11_158 VPWR VGND sg13cmos5l_decap_8
XFILLER_125_4 VPWR VGND sg13cmos5l_fill_1
XFILLER_138_21 VPWR VGND sg13cmos5l_decap_8
XFILLER_338_293 VPWR VGND sg13cmos5l_fill_2
XANTENNA__2080__D Tile_X0Y1_FrameData[16] VPWR VGND sg13cmos5l_antennanp
XANTENNA__3176__D Tile_X0Y5_FrameData[8] VPWR VGND sg13cmos5l_antennanp
XFILLER_98_14 VPWR VGND sg13cmos5l_fill_1
XFILLER_98_36 VPWR VGND sg13cmos5l_decap_8
XANTENNA__1824__GATE Tile_X0Y5_FrameStrobe[3] VPWR VGND sg13cmos5l_antennanp
XFILLER_154_20 VPWR VGND sg13cmos5l_decap_8
XFILLER_105_274 VPWR VGND sg13cmos5l_fill_1
XFILLER_154_31 VPWR VGND sg13cmos5l_fill_2
XFILLER_321_160 VPWR VGND sg13cmos5l_fill_2
XANTENNA__1116__A0 Tile_X0Y0_W1END[1] VPWR VGND sg13cmos5l_antennanp
XANTENNA__1561__X AXI_M_SOC_WVALID VPWR VGND sg13cmos5l_antennanp
XANTENNA__1839__GATE Tile_X0Y5_FrameStrobe[4] VPWR VGND sg13cmos5l_antennanp
XFILLER_219_175 VPWR VGND sg13cmos5l_decap_8
XFILLER_270_0 VPWR VGND sg13cmos5l_fill_2
XFILLER_86_180 VPWR VGND sg13cmos5l_decap_8
XFILLER_170_52 VPWR VGND sg13cmos5l_decap_8
XFILLER_234_134 VPWR VGND sg13cmos5l_fill_1
XFILLER_47_95 VPWR VGND sg13cmos5l_decap_8
XANTENNA__1419__A1 Tile_X0Y2_WW4END[10] VPWR VGND sg13cmos5l_antennanp
XANTENNA__2255__D Tile_X0Y2_FrameData[17] VPWR VGND sg13cmos5l_antennanp
XANTENNA__3488__X Tile_X0Y1_E6BEG[8] VPWR VGND sg13cmos5l_antennanp
XFILLER_234_189 VPWR VGND sg13cmos5l_decap_8
XFILLER_63_61 VPWR VGND sg13cmos5l_decap_8
XFILLER_320_77 VPWR VGND sg13cmos5l_decap_4
XFILLER_320_99 VPWR VGND sg13cmos5l_decap_4
XFILLER_179_72 VPWR VGND sg13cmos5l_decap_8
X_1770_ _1770_/Q Tile_X0Y0_FrameData[22] Tile_X0Y5_FrameStrobe[2] VPWR VGND sg13cmos5l_dlhq_1
XFILLER_336_219 VPWR VGND sg13cmos5l_fill_2
XFILLER_329_271 VPWR VGND sg13cmos5l_decap_4
X_0721_ _0722_/C _2242_/Q _1120_/X VPWR VGND sg13cmos5l_nor2_1
XFILLER_329_86 VPWR VGND sg13cmos5l_fill_1
XANTENNA__3086__D Tile_X0Y5_FrameData[2] VPWR VGND sg13cmos5l_antennanp
XFILLER_155_174 VPWR VGND sg13cmos5l_decap_8
XFILLER_195_71 VPWR VGND sg13cmos5l_fill_2
XFILLER_155_185 VPWR VGND sg13cmos5l_fill_2
X_3440_ Tile_X0Y1_FrameData_O[8] Tile_X0Y1_FrameData[8] VPWR VGND sg13cmos5l_buf_1
X_0652_ _0652_/X Tile_X0Y5_W1END[1] Tile_X0Y5_WW4END[13] _3265_/Q VPWR VGND sg13cmos5l_mux2_1
XANTENNA__3330__GATE Tile_X0Y5_FrameStrobe[9] VPWR VGND sg13cmos5l_antennanp
X_3371_ Tile_X0Y2_E6BEG[1] _3371_/A VPWR VGND sg13cmos5l_buf_1
X_0583_ _0584_/C _2520_/Q _1050_/X VPWR VGND sg13cmos5l_nor2_1
XFILLER_40_4 VPWR VGND sg13cmos5l_fill_1
XFILLER_111_200 VPWR VGND sg13cmos5l_decap_4
X_2322_ _2322_/Q Tile_X0Y2_FrameData[14] Tile_X0Y5_FrameStrobe[2] VPWR VGND sg13cmos5l_dlhq_1
XFILLER_69_114 VPWR VGND sg13cmos5l_decap_8
XANTENNA__1370__A3 Tile_X0Y0_S4END[11] VPWR VGND sg13cmos5l_antennanp
XFILLER_111_244 VPWR VGND sg13cmos5l_fill_1
XFILLER_257_215 VPWR VGND sg13cmos5l_fill_1
XFILLER_257_237 VPWR VGND sg13cmos5l_fill_2
XANTENNA__1107__A0 Tile_X0Y3_W2MID[7] VPWR VGND sg13cmos5l_antennanp
XANTENNA__3345__GATE Tile_X0Y5_FrameStrobe[8] VPWR VGND sg13cmos5l_antennanp
X_2253_ _2253_/Q Tile_X0Y2_FrameData[19] Tile_X0Y5_FrameStrobe[0] VPWR VGND sg13cmos5l_dlhq_1
XFILLER_84_128 VPWR VGND sg13cmos5l_fill_1
XANTENNA__1658__A1 AXI_M_SOC_RDATA5 VPWR VGND sg13cmos5l_antennanp
X_2184_ _2184_/Q Tile_X0Y1_FrameData[8] Tile_X0Y5_FrameStrobe[6] VPWR VGND sg13cmos5l_dlhq_1
X_1204_ AXI_M_SOC_AWADDR25 Tile_X0Y0_W2MID[1] Tile_X0Y0_W2END[1] Tile_X0Y0_W6END[1]
+ _1140_/X _1766_/Q _1765_/Q VPWR VGND sg13cmos5l_mux4_1
X_1135_ _1135_/X Tile_X0Y5_W1END[3] Tile_X0Y5_W6END[7] _0740_/X _1134_/Y _3322_/Q
+ _3321_/Q VPWR VGND sg13cmos5l_mux4_1
XFILLER_92_150 VPWR VGND sg13cmos5l_fill_2
XFILLER_25_239 VPWR VGND sg13cmos5l_decap_8
XANTENNA__2165__D Tile_X0Y1_FrameData[27] VPWR VGND sg13cmos5l_antennanp
XANTENNA__3398__X Tile_X0Y2_FrameData_O[0] VPWR VGND sg13cmos5l_antennanp
XFILLER_225_178 VPWR VGND sg13cmos5l_decap_8
XFILLER_240_126 VPWR VGND sg13cmos5l_fill_2
X_1066_ _1066_/X Tile_X0Y4_W1END[0] Tile_X0Y4_WW4END[0] Tile_X0Y4_W6END[8] _1065_/X
+ _3032_/Q _3031_/Q VPWR VGND sg13cmos5l_mux4_1
XFILLER_178_255 VPWR VGND sg13cmos5l_decap_8
XFILLER_193_269 VPWR VGND sg13cmos5l_decap_8
X_1968_ _1968_/Q Tile_X0Y0_FrameData[16] Tile_X0Y5_FrameStrobe[8] VPWR VGND sg13cmos5l_dlhq_1
XANTENNA__1646__X AXI_M_SOC_ARADDR20 VPWR VGND sg13cmos5l_antennanp
XANTENNA__3574__A Tile_X0Y0_FrameData[5] VPWR VGND sg13cmos5l_antennanp
XFILLER_146_152 VPWR VGND sg13cmos5l_fill_1
X_3707_ Tile_X0Y3_FrameData_O[10] Tile_X0Y3_FrameData[10] VPWR VGND sg13cmos5l_buf_1
X_1899_ _1899_/Q Tile_X0Y0_FrameData[21] Tile_X0Y5_FrameStrobe[6] VPWR VGND sg13cmos5l_dlhq_1
X_0919_ _0919_/X _1138_/X _0568_/X _0918_/Y Tile_X0Y0_S4END[4] _2015_/Q _2016_/Q VPWR
+ VGND sg13cmos5l_mux4_1
XFILLER_108_24 VPWR VGND sg13cmos5l_decap_4
X_3638_ Tile_X0Y0_E2BEG[1] _3638_/A VPWR VGND sg13cmos5l_buf_1
XANTENNA__1346__A0 Tile_X0Y5_W2MID[1] VPWR VGND sg13cmos5l_antennanp
X_3569_ Tile_X0Y0_FrameData_O[0] Tile_X0Y0_FrameData[0] VPWR VGND sg13cmos5l_buf_1
XANTENNA__2554__GATE Tile_X0Y5_FrameStrobe[1] VPWR VGND sg13cmos5l_antennanp
XANTENNA__3861__X Tile_X0Y5_FrameData_O[2] VPWR VGND sg13cmos5l_antennanp
XFILLER_161_199 VPWR VGND sg13cmos5l_decap_8
XFILLER_102_233 VPWR VGND sg13cmos5l_decap_8
XFILLER_303_182 VPWR VGND sg13cmos5l_decap_8
XANTENNA__1649__A1 Tile_X0Y4_W2END[1] VPWR VGND sg13cmos5l_antennanp
XFILLER_124_67 VPWR VGND sg13cmos5l_decap_8
XANTENNA__2569__GATE Tile_X0Y5_FrameStrobe[1] VPWR VGND sg13cmos5l_antennanp
XFILLER_83_161 VPWR VGND sg13cmos5l_decap_8
XANTENNA__2075__D Tile_X0Y1_FrameData[21] VPWR VGND sg13cmos5l_antennanp
XFILLER_169_200 VPWR VGND sg13cmos5l_decap_8
XFILLER_24_294 VPWR VGND sg13cmos5l_fill_1
XFILLER_33_31 VPWR VGND sg13cmos5l_decap_8
XANTENNA__2803__D Tile_X0Y4_FrameData[13] VPWR VGND sg13cmos5l_antennanp
XFILLER_149_53 VPWR VGND sg13cmos5l_decap_8
XFILLER_184_214 VPWR VGND sg13cmos5l_fill_1
XFILLER_149_64 VPWR VGND sg13cmos5l_fill_1
XANTENNA__1556__X AXI_M_SOC_WDATA3 VPWR VGND sg13cmos5l_antennanp
XANTENNA__2507__GATE Tile_X0Y5_FrameStrobe[8] VPWR VGND sg13cmos5l_antennanp
XFILLER_116_0 VPWR VGND sg13cmos5l_fill_2
XANTENNA__0927__A3 Tile_X0Y0_S4END[5] VPWR VGND sg13cmos5l_antennanp
XANTENNA__1337__A0 Tile_X0Y1_W2MID[4] VPWR VGND sg13cmos5l_antennanp
XANTENNA__1763__GATE Tile_X0Y5_FrameStrobe[2] VPWR VGND sg13cmos5l_antennanp
XANTENNA__3771__X Tile_X0Y4_EE4BEG[9] VPWR VGND sg13cmos5l_antennanp
XFILLER_315_55 VPWR VGND sg13cmos5l_decap_8
XANTENNA__0560__A1 Tile_X0Y5_W2MID[1] VPWR VGND sg13cmos5l_antennanp
XANTENNA__1778__GATE Tile_X0Y5_FrameStrobe[2] VPWR VGND sg13cmos5l_antennanp
XFILLER_181_51 VPWR VGND sg13cmos5l_fill_1
XFILLER_58_83 VPWR VGND sg13cmos5l_decap_8
XFILLER_59_180 VPWR VGND sg13cmos5l_fill_1
XANTENNA__1701__GATE Tile_X0Y5_FrameStrobe[0] VPWR VGND sg13cmos5l_antennanp
XFILLER_262_262 VPWR VGND sg13cmos5l_decap_8
XFILLER_262_273 VPWR VGND sg13cmos5l_fill_1
XFILLER_74_71 VPWR VGND sg13cmos5l_decap_4
XFILLER_331_98 VPWR VGND sg13cmos5l_fill_2
XFILLER_200_14 VPWR VGND sg13cmos5l_fill_1
X_2940_ _2940_/Q Tile_X0Y4_FrameData[4] Tile_X0Y5_FrameStrobe[4] VPWR VGND sg13cmos5l_dlhq_1
X_2871_ _2871_/Q Tile_X0Y4_FrameData[9] Tile_X0Y5_FrameStrobe[2] VPWR VGND sg13cmos5l_dlhq_1
XANTENNA__1716__GATE Tile_X0Y5_FrameStrobe[0] VPWR VGND sg13cmos5l_antennanp
XANTENNA__2713__D Tile_X0Y3_FrameData[23] VPWR VGND sg13cmos5l_antennanp
XFILLER_175_203 VPWR VGND sg13cmos5l_decap_8
X_1822_ _1822_/Q Tile_X0Y0_FrameData[2] Tile_X0Y5_FrameStrobe[3] VPWR VGND sg13cmos5l_dlhq_1
XFILLER_90_81 VPWR VGND sg13cmos5l_decap_8
X_1753_ _1753_/Q Tile_X0Y0_FrameData[7] Tile_X0Y5_FrameStrobe[1] VPWR VGND sg13cmos5l_dlhq_1
XANTENNA__1040__A2 Tile_X0Y5_N4END[5] VPWR VGND sg13cmos5l_antennanp
X_1684_ _1684_/X Tile_X0Y4_W1END[0] Tile_X0Y4_W6END[4] Tile_X0Y4_WW4END[12] _1065_/X
+ _2995_/Q _2996_/Q VPWR VGND sg13cmos5l_mux4_1
X_0704_ _0704_/Y _0696_/X _3262_/Q VPWR VGND sg13cmos5l_nand2b_1
XANTENNA__1591__A3 AXI_M_SOC_RDATA13 VPWR VGND sg13cmos5l_antennanp
X_3423_ Tile_X0Y2_FrameData_O[25] Tile_X0Y2_FrameData[25] VPWR VGND sg13cmos5l_buf_1
X_0635_ _0635_/X Tile_X0Y3_W1END[1] Tile_X0Y3_W6END[9] _0885_/X _0634_/X _2746_/Q
+ _2745_/Q VPWR VGND sg13cmos5l_mux4_1
XFILLER_332_255 VPWR VGND sg13cmos5l_fill_1
XFILLER_332_233 VPWR VGND sg13cmos5l_fill_2
XANTENNA__1328__A0 Tile_X0Y1_W6END[11] VPWR VGND sg13cmos5l_antennanp
XANTENNA__3681__X Tile_X0Y3_EE4BEG[0] VPWR VGND sg13cmos5l_antennanp
XFILLER_143_177 VPWR VGND sg13cmos5l_decap_8
XANTENNA__3284__GATE Tile_X0Y5_FrameStrobe[7] VPWR VGND sg13cmos5l_antennanp
X_3354_ Tile_X0Y2_E2BEG[0] _3354_/A VPWR VGND sg13cmos5l_buf_1
X_0566_ _0566_/Y _1703_/Q _1704_/Q _1079_/X VPWR VGND sg13cmos5l_nor3_1
XFILLER_97_242 VPWR VGND sg13cmos5l_fill_1
XFILLER_31_0 VPWR VGND sg13cmos5l_fill_2
X_3285_ _3285_/Q Tile_X0Y5_FrameData[27] Tile_X0Y5_FrameStrobe[7] VPWR VGND sg13cmos5l_dlhq_1
X_2305_ _2305_/Q Tile_X0Y2_FrameData[31] Tile_X0Y5_FrameStrobe[2] VPWR VGND sg13cmos5l_dlhq_1
XFILLER_97_264 VPWR VGND sg13cmos5l_decap_8
XANTENNA__1999__D Tile_X0Y1_FrameData[1] VPWR VGND sg13cmos5l_antennanp
X_2236_ _2236_/Q Tile_X0Y1_FrameData[20] Tile_X0Y5_FrameStrobe[8] VPWR VGND sg13cmos5l_dlhq_1
XANTENNA__1500__A0 Tile_X0Y3_W2END[5] VPWR VGND sg13cmos5l_antennanp
XANTENNA__3299__GATE Tile_X0Y5_FrameStrobe[7] VPWR VGND sg13cmos5l_antennanp
X_2167_ _2167_/Q Tile_X0Y1_FrameData[25] Tile_X0Y5_FrameStrobe[6] VPWR VGND sg13cmos5l_dlhq_1
XFILLER_241_98 VPWR VGND sg13cmos5l_decap_8
X_2098_ _2098_/Q Tile_X0Y1_FrameData[30] Tile_X0Y5_FrameStrobe[4] VPWR VGND sg13cmos5l_dlhq_1
X_1118_ AXI_M_SOC_WLAST _3333_/Q _1118_/B VPWR VGND sg13cmos5l_or2_1
XFILLER_65_194 VPWR VGND sg13cmos5l_decap_8
XANTENNA__3569__A Tile_X0Y0_FrameData[0] VPWR VGND sg13cmos5l_antennanp
X_1049_ _1049_/X _1048_/X _0784_/X Tile_X0Y5_N2MID[1] _1047_/X _2805_/Q _2806_/Q VPWR
+ VGND sg13cmos5l_mux4_1
XANTENNA__0606__A2 Tile_X0Y3_W2END[3] VPWR VGND sg13cmos5l_antennanp
XANTENNA__3222__GATE Tile_X0Y5_FrameStrobe[5] VPWR VGND sg13cmos5l_antennanp
XANTENNA__2623__D Tile_X0Y3_FrameData[17] VPWR VGND sg13cmos5l_antennanp
XANTENNA__3856__X Tile_X0Y5_EE4BEG[13] VPWR VGND sg13cmos5l_antennanp
XFILLER_110_69 VPWR VGND sg13cmos5l_fill_2
XFILLER_166_203 VPWR VGND sg13cmos5l_decap_4
XFILLER_70_29 VPWR VGND sg13cmos5l_fill_1
XFILLER_166_236 VPWR VGND sg13cmos5l_fill_2
XANTENNA__3237__GATE Tile_X0Y5_FrameStrobe[5] VPWR VGND sg13cmos5l_antennanp
XFILLER_323_222 VPWR VGND sg13cmos5l_fill_2
XFILLER_323_200 VPWR VGND sg13cmos5l_fill_1
XFILLER_79_49 VPWR VGND sg13cmos5l_decap_8
XANTENNA__0790__A1 Tile_X0Y5_N2END[2] VPWR VGND sg13cmos5l_antennanp
XANTENNA__2493__GATE Tile_X0Y5_FrameStrobe[7] VPWR VGND sg13cmos5l_antennanp
XANTENNA__3591__X Tile_X0Y0_FrameData_O[22] VPWR VGND sg13cmos5l_antennanp
XFILLER_0_146 VPWR VGND sg13cmos5l_fill_1
XFILLER_135_66 VPWR VGND sg13cmos5l_decap_8
XFILLER_236_218 VPWR VGND sg13cmos5l_decap_4
XFILLER_151_21 VPWR VGND sg13cmos5l_decap_8
XFILLER_28_42 VPWR VGND sg13cmos5l_fill_2
XFILLER_28_64 VPWR VGND sg13cmos5l_decap_8
XANTENNA__1098__A2 Tile_X0Y3_W6END[5] VPWR VGND sg13cmos5l_antennanp
XANTENNA__1702__D Tile_X0Y0_FrameData[26] VPWR VGND sg13cmos5l_antennanp
XANTENNA__2431__GATE Tile_X0Y5_FrameStrobe[5] VPWR VGND sg13cmos5l_antennanp
XFILLER_44_52 VPWR VGND sg13cmos5l_decap_8
XFILLER_71_197 VPWR VGND sg13cmos5l_fill_1
XFILLER_44_74 VPWR VGND sg13cmos5l_decap_8
XANTENNA__2533__D Tile_X0Y3_FrameData[11] VPWR VGND sg13cmos5l_antennanp
XANTENNA__3766__X Tile_X0Y4_EE4BEG[4] VPWR VGND sg13cmos5l_antennanp
XFILLER_157_225 VPWR VGND sg13cmos5l_decap_8
XFILLER_233_0 VPWR VGND sg13cmos5l_fill_2
XANTENNA__1270__A2 Tile_X0Y2_W2END[3] VPWR VGND sg13cmos5l_antennanp
XANTENNA__2446__GATE Tile_X0Y5_FrameStrobe[6] VPWR VGND sg13cmos5l_antennanp
XANTENNA__1558__A0 Tile_X0Y3_W2MID[7] VPWR VGND sg13cmos5l_antennanp
XANTENNA__0631__A Tile_X0Y3_W6END[1] VPWR VGND sg13cmos5l_antennanp
XFILLER_176_51 VPWR VGND sg13cmos5l_decap_8
XFILLER_314_233 VPWR VGND sg13cmos5l_decap_8
XANTENNA__0781__A1 Tile_X0Y4_W2END[7] VPWR VGND sg13cmos5l_antennanp
XFILLER_125_188 VPWR VGND sg13cmos5l_decap_8
XFILLER_286_107 VPWR VGND sg13cmos5l_fill_2
XFILLER_5_68 VPWR VGND sg13cmos5l_decap_8
XFILLER_5_57 VPWR VGND sg13cmos5l_fill_1
XFILLER_279_170 VPWR VGND sg13cmos5l_fill_2
XFILLER_69_60 VPWR VGND sg13cmos5l_decap_4
X_3070_ _3070_/Q Tile_X0Y5_FrameData[18] Tile_X0Y5_FrameStrobe[0] VPWR VGND sg13cmos5l_dlhq_1
XANTENNA__2708__D Tile_X0Y3_FrameData[28] VPWR VGND sg13cmos5l_antennanp
X_2021_ _2021_/Q Tile_X0Y1_FrameData[11] Tile_X0Y5_FrameStrobe[1] VPWR VGND sg13cmos5l_dlhq_1
XFILLER_85_81 VPWR VGND sg13cmos5l_decap_8
XANTENNA__0836__A2 Tile_X0Y5_WW4END[9] VPWR VGND sg13cmos5l_antennanp
XANTENNA__2443__D Tile_X0Y2_FrameData[21] VPWR VGND sg13cmos5l_antennanp
XANTENNA__3676__X Tile_X0Y3_E6BEG[7] VPWR VGND sg13cmos5l_antennanp
XFILLER_148_203 VPWR VGND sg13cmos5l_decap_8
XFILLER_287_28 VPWR VGND sg13cmos5l_fill_1
X_2923_ _2923_/Q Tile_X0Y4_FrameData[21] Tile_X0Y5_FrameStrobe[4] VPWR VGND sg13cmos5l_dlhq_1
XANTENNA__1261__A2 AXI_M_SOC_BVALID VPWR VGND sg13cmos5l_antennanp
X_2854_ _2854_/Q Tile_X0Y4_FrameData[26] Tile_X0Y5_FrameStrobe[2] VPWR VGND sg13cmos5l_dlhq_1
XANTENNA__1549__A0 Tile_X0Y3_WW4END[3] VPWR VGND sg13cmos5l_antennanp
X_2785_ _2785_/Q Tile_X0Y3_FrameData[31] Tile_X0Y5_FrameStrobe[0] VPWR VGND sg13cmos5l_dlhq_1
X_1805_ _1805_/Q Tile_X0Y0_FrameData[19] Tile_X0Y5_FrameStrobe[3] VPWR VGND sg13cmos5l_dlhq_1
XFILLER_79_0 VPWR VGND sg13cmos5l_fill_2
XANTENNA__0541__A Tile_X0Y0_W6END[1] VPWR VGND sg13cmos5l_antennanp
XANTENNA__1013__A2 Tile_X0Y5_N4END[6] VPWR VGND sg13cmos5l_antennanp
XANTENNA__1196__X AXI_M_SOC_AWADDR12 VPWR VGND sg13cmos5l_antennanp
XFILLER_116_100 VPWR VGND sg13cmos5l_decap_8
XFILLER_305_200 VPWR VGND sg13cmos5l_fill_1
X_1736_ _1736_/Q Tile_X0Y0_FrameData[24] Tile_X0Y5_FrameStrobe[1] VPWR VGND sg13cmos5l_dlhq_1
XFILLER_116_144 VPWR VGND sg13cmos5l_decap_8
XFILLER_171_250 VPWR VGND sg13cmos5l_decap_8
XFILLER_305_222 VPWR VGND sg13cmos5l_decap_4
XANTENNA__0772__A1 Tile_X0Y1_WW4END[10] VPWR VGND sg13cmos5l_antennanp
XANTENNA__3274__D Tile_X0Y5_FrameData[6] VPWR VGND sg13cmos5l_antennanp
XFILLER_116_177 VPWR VGND sg13cmos5l_decap_8
XFILLER_116_188 VPWR VGND sg13cmos5l_fill_1
X_1667_ _3730_/A _1056_/X _0586_/X AXI_M_SOC_RDATA1 AXI_M_SOC_RDATA5 _2984_/Q _2983_/Q
+ VPWR VGND sg13cmos5l_mux4_1
XFILLER_49_19 VPWR VGND sg13cmos5l_decap_8
XFILLER_131_147 VPWR VGND sg13cmos5l_fill_1
X_3406_ Tile_X0Y2_FrameData_O[8] Tile_X0Y2_FrameData[8] VPWR VGND sg13cmos5l_buf_1
X_1598_ _1598_/Y _2718_/Q _1348_/X _1597_/Y VPWR VGND sg13cmos5l_a21oi_1
X_0618_ _0618_/Y _1974_/Q _1973_/Q VPWR VGND sg13cmos5l_nor2b_1
X_3337_ _3337_/Q Tile_X0Y5_FrameData[3] Tile_X0Y5_FrameStrobe[8] VPWR VGND sg13cmos5l_dlhq_1
X_0549_ _0549_/Y _1058_/X VPWR VGND sg13cmos5l_inv_1
XFILLER_105_25 VPWR VGND sg13cmos5l_decap_8
XFILLER_285_151 VPWR VGND sg13cmos5l_decap_8
XANTENNA__2618__D Tile_X0Y3_FrameData[22] VPWR VGND sg13cmos5l_antennanp
X_3268_ _3268_/Q Tile_X0Y5_FrameData[12] Tile_X0Y5_FrameStrobe[6] VPWR VGND sg13cmos5l_dlhq_1
X_3199_ _3199_/Q Tile_X0Y5_FrameData[17] Tile_X0Y5_FrameStrobe[4] VPWR VGND sg13cmos5l_dlhq_1
X_2219_ _2219_/Q Tile_X0Y1_FrameData[5] Tile_X0Y5_FrameStrobe[7] VPWR VGND sg13cmos5l_dlhq_1
XFILLER_226_262 VPWR VGND sg13cmos5l_decap_8
XFILLER_226_273 VPWR VGND sg13cmos5l_fill_1
XANTENNA__3161__GATE Tile_X0Y5_FrameStrobe[3] VPWR VGND sg13cmos5l_antennanp
XFILLER_201_118 VPWR VGND sg13cmos5l_fill_1
XFILLER_53_186 VPWR VGND sg13cmos5l_decap_8
XANTENNA__2353__D Tile_X0Y2_FrameData[15] VPWR VGND sg13cmos5l_antennanp
XANTENNA__3586__X Tile_X0Y0_FrameData_O[17] VPWR VGND sg13cmos5l_antennanp
XFILLER_201_90 VPWR VGND sg13cmos5l_fill_2
XANTENNA__1252__A2 AXI_M_SOC_AWREADY VPWR VGND sg13cmos5l_antennanp
XFILLER_139_247 VPWR VGND sg13cmos5l_decap_8
XANTENNA__3176__GATE Tile_X0Y5_FrameStrobe[3] VPWR VGND sg13cmos5l_antennanp
XFILLER_14_88 VPWR VGND sg13cmos5l_decap_8
XANTENNA__1004__A2 Tile_X0Y0_S1END[2] VPWR VGND sg13cmos5l_antennanp
XFILLER_107_133 VPWR VGND sg13cmos5l_decap_4
XFILLER_146_10 VPWR VGND sg13cmos5l_fill_1
XANTENNA__0763__A1 Tile_X0Y5_WW4END[13] VPWR VGND sg13cmos5l_antennanp
XANTENNA__3184__D Tile_X0Y5_FrameData[0] VPWR VGND sg13cmos5l_antennanp
XFILLER_268_118 VPWR VGND sg13cmos5l_fill_1
XANTENNA__3114__GATE Tile_X0Y5_FrameStrobe[1] VPWR VGND sg13cmos5l_antennanp
XFILLER_276_151 VPWR VGND sg13cmos5l_decap_4
XFILLER_76_212 VPWR VGND sg13cmos5l_fill_1
XFILLER_39_74 VPWR VGND sg13cmos5l_decap_8
XFILLER_276_195 VPWR VGND sg13cmos5l_decap_8
XANTENNA__2370__GATE Tile_X0Y5_FrameStrobe[4] VPWR VGND sg13cmos5l_antennanp
XANTENNA__2528__D Tile_X0Y3_FrameData[16] VPWR VGND sg13cmos5l_antennanp
XFILLER_29_150 VPWR VGND sg13cmos5l_fill_2
XFILLER_36_109 VPWR VGND sg13cmos5l_decap_8
XFILLER_29_183 VPWR VGND sg13cmos5l_fill_2
XFILLER_312_67 VPWR VGND sg13cmos5l_fill_1
XANTENNA__3129__GATE Tile_X0Y5_FrameStrobe[2] VPWR VGND sg13cmos5l_antennanp
XFILLER_55_84 VPWR VGND sg13cmos5l_decap_8
XFILLER_44_142 VPWR VGND sg13cmos5l_decap_8
XANTENNA__1491__A2 AXI_M_SOC_RDATA15 VPWR VGND sg13cmos5l_antennanp
XFILLER_232_276 VPWR VGND sg13cmos5l_fill_1
XANTENNA__2263__D Tile_X0Y2_FrameData[9] VPWR VGND sg13cmos5l_antennanp
XANTENNA__2385__GATE Tile_X0Y5_FrameStrobe[4] VPWR VGND sg13cmos5l_antennanp
XANTENNA__3496__X Tile_X0Y1_E2BEGb[4] VPWR VGND sg13cmos5l_antennanp
XFILLER_111_90 VPWR VGND sg13cmos5l_decap_8
XFILLER_200_151 VPWR VGND sg13cmos5l_fill_1
XFILLER_200_173 VPWR VGND sg13cmos5l_decap_8
XFILLER_138_280 VPWR VGND sg13cmos5l_fill_1
XFILLER_299_221 VPWR VGND sg13cmos5l_decap_8
X_2570_ _2570_/Q Tile_X0Y3_FrameData[6] Tile_X0Y5_FrameStrobe[1] VPWR VGND sg13cmos5l_dlhq_1
XANTENNA__3094__D Tile_X0Y5_FrameData[26] VPWR VGND sg13cmos5l_antennanp
X_1521_ _1521_/X _1050_/X _0580_/X Tile_X0Y5_N4END[8] Tile_X0Y0_S4END[12] _2551_/Q
+ _2552_/Q VPWR VGND sg13cmos5l_mux4_1
XANTENNA__2323__GATE Tile_X0Y5_FrameStrobe[2] VPWR VGND sg13cmos5l_antennanp
XFILLER_113_125 VPWR VGND sg13cmos5l_decap_4
X_1452_ _3385_/A Tile_X0Y2_WW4END[12] AXI_M_SOC_RDATA17 _1058_/X _1191_/X _2394_/Q
+ _2393_/Q VPWR VGND sg13cmos5l_mux4_1
XANTENNA__2953__GATE Tile_X0Y5_FrameStrobe[5] VPWR VGND sg13cmos5l_antennanp
X_3122_ _3122_/Q Tile_X0Y5_FrameData[30] Tile_X0Y5_FrameStrobe[2] VPWR VGND sg13cmos5l_dlhq_1
X_1383_ _1383_/Y _2482_/Q _0551_/Y _2481_/Q VPWR VGND sg13cmos5l_o21ai_1
XFILLER_67_201 VPWR VGND sg13cmos5l_fill_1
XFILLER_121_191 VPWR VGND sg13cmos5l_fill_1
XFILLER_310_280 VPWR VGND sg13cmos5l_fill_1
XFILLER_67_256 VPWR VGND sg13cmos5l_fill_1
XANTENNA__2338__GATE Tile_X0Y5_FrameStrobe[3] VPWR VGND sg13cmos5l_antennanp
XANTENNA__2438__D Tile_X0Y2_FrameData[26] VPWR VGND sg13cmos5l_antennanp
X_3053_ _3053_/Q Tile_X0Y4_FrameData[19] Tile_X0Y5_FrameStrobe[8] VPWR VGND sg13cmos5l_dlhq_1
XANTENNA__2968__GATE Tile_X0Y5_FrameStrobe[5] VPWR VGND sg13cmos5l_antennanp
XFILLER_282_176 VPWR VGND sg13cmos5l_fill_1
XFILLER_282_187 VPWR VGND sg13cmos5l_decap_4
X_2004_ _2004_/Q Tile_X0Y1_FrameData[28] Tile_X0Y5_FrameStrobe[1] VPWR VGND sg13cmos5l_dlhq_1
XFILLER_35_120 VPWR VGND sg13cmos5l_decap_8
XANTENNA__0690__A0 Tile_X0Y4_W1END[2] VPWR VGND sg13cmos5l_antennanp
XFILLER_223_276 VPWR VGND sg13cmos5l_fill_2
XFILLER_298_38 VPWR VGND sg13cmos5l_decap_8
XFILLER_35_197 VPWR VGND sg13cmos5l_fill_1
XANTENNA__3269__D Tile_X0Y5_FrameData[11] VPWR VGND sg13cmos5l_antennanp
XFILLER_50_156 VPWR VGND sg13cmos5l_decap_8
XANTENNA__2173__D Tile_X0Y1_FrameData[19] VPWR VGND sg13cmos5l_antennanp
X_2906_ _2906_/Q Tile_X0Y4_FrameData[6] Tile_X0Y5_FrameStrobe[3] VPWR VGND sg13cmos5l_dlhq_1
X_3886_ Tile_X0Y5_FrameData_O[27] Tile_X0Y5_FrameData[27] VPWR VGND sg13cmos5l_buf_1
XANTENNA__2901__D Tile_X0Y4_FrameData[11] VPWR VGND sg13cmos5l_antennanp
X_2837_ _2837_/Q Tile_X0Y4_FrameData[11] Tile_X0Y5_FrameStrobe[1] VPWR VGND sg13cmos5l_dlhq_1
XFILLER_337_199 VPWR VGND sg13cmos5l_decap_4
XANTENNA__2906__GATE Tile_X0Y5_FrameStrobe[3] VPWR VGND sg13cmos5l_antennanp
XFILLER_247_53 VPWR VGND sg13cmos5l_fill_1
XFILLER_247_75 VPWR VGND sg13cmos5l_decap_8
X_2768_ _2768_/Q Tile_X0Y3_FrameData[0] Tile_X0Y5_FrameStrobe[7] VPWR VGND sg13cmos5l_dlhq_1
XANTENNA__1654__X AXI_M_SOC_ARADDR22 VPWR VGND sg13cmos5l_antennanp
XFILLER_144_250 VPWR VGND sg13cmos5l_fill_2
X_2699_ _2699_/Q Tile_X0Y3_FrameData[5] Tile_X0Y5_FrameStrobe[5] VPWR VGND sg13cmos5l_dlhq_1
X_1719_ _1719_/Q Tile_X0Y0_FrameData[9] Tile_X0Y5_FrameStrobe[0] VPWR VGND sg13cmos5l_dlhq_1
XANTENNA__3582__A Tile_X0Y0_FrameData[13] VPWR VGND sg13cmos5l_antennanp
XFILLER_104_147 VPWR VGND sg13cmos5l_decap_8
XFILLER_263_30 VPWR VGND sg13cmos5l_fill_2
XFILLER_263_74 VPWR VGND sg13cmos5l_decap_8
XFILLER_76_39 VPWR VGND sg13cmos5l_decap_8
XFILLER_112_180 VPWR VGND sg13cmos5l_decap_8
XFILLER_58_256 VPWR VGND sg13cmos5l_decap_8
XANTENNA__2348__D Tile_X0Y2_FrameData[20] VPWR VGND sg13cmos5l_antennanp
XFILLER_132_23 VPWR VGND sg13cmos5l_decap_4
XFILLER_132_67 VPWR VGND sg13cmos5l_decap_4
XFILLER_92_49 VPWR VGND sg13cmos5l_decap_8
XANTENNA__1473__A2 AXI_M_SOC_RDATA19 VPWR VGND sg13cmos5l_antennanp
XFILLER_214_276 VPWR VGND sg13cmos5l_fill_1
XANTENNA__3179__D Tile_X0Y5_FrameData[5] VPWR VGND sg13cmos5l_antennanp
XFILLER_41_156 VPWR VGND sg13cmos5l_decap_8
XANTENNA__2083__D Tile_X0Y1_FrameData[13] VPWR VGND sg13cmos5l_antennanp
XFILLER_41_20 VPWR VGND sg13cmos5l_decap_8
XANTENNA__2811__D Tile_X0Y4_FrameData[5] VPWR VGND sg13cmos5l_antennanp
XFILLER_157_31 VPWR VGND sg13cmos5l_decap_8
XFILLER_328_188 VPWR VGND sg13cmos5l_decap_8
XFILLER_157_97 VPWR VGND sg13cmos5l_decap_8
XANTENNA__1564__X AXI_M_SOC_WDATA5 VPWR VGND sg13cmos5l_antennanp
XANTENNA__3053__GATE Tile_X0Y5_FrameStrobe[8] VPWR VGND sg13cmos5l_antennanp
XFILLER_1_230 VPWR VGND sg13cmos5l_fill_2
XFILLER_110_117 VPWR VGND sg13cmos5l_decap_8
XFILLER_323_22 VPWR VGND sg13cmos5l_fill_2
XANTENNA__1161__A1 Tile_X0Y0_WW4END[3] VPWR VGND sg13cmos5l_antennanp
XANTENNA__2258__D Tile_X0Y2_FrameData[14] VPWR VGND sg13cmos5l_antennanp
XFILLER_264_143 VPWR VGND sg13cmos5l_fill_2
XFILLER_64_215 VPWR VGND sg13cmos5l_decap_8
XFILLER_323_77 VPWR VGND sg13cmos5l_decap_4
XFILLER_323_66 VPWR VGND sg13cmos5l_fill_1
XANTENNA__3068__GATE Tile_X0Y5_FrameStrobe[0] VPWR VGND sg13cmos5l_antennanp
XFILLER_66_83 VPWR VGND sg13cmos5l_decap_8
XFILLER_323_99 VPWR VGND sg13cmos5l_decap_4
XANTENNA__0672__A0 Tile_X0Y1_W1END[2] VPWR VGND sg13cmos5l_antennanp
XANTENNA__3089__D Tile_X0Y5_FrameData[31] VPWR VGND sg13cmos5l_antennanp
XFILLER_82_71 VPWR VGND sg13cmos5l_decap_8
XFILLER_198_71 VPWR VGND sg13cmos5l_decap_8
X_3740_ Tile_X0Y4_E2BEG[6] _3740_/A VPWR VGND sg13cmos5l_buf_1
X_0952_ AXI_M_SOC_AWLEN1 _3337_/Q _0951_/X VPWR VGND sg13cmos5l_nor2b_1
XFILLER_32_167 VPWR VGND sg13cmos5l_decap_4
XANTENNA__0975__A1 Tile_X0Y5_W2MID[2] VPWR VGND sg13cmos5l_antennanp
XANTENNA__2721__D Tile_X0Y3_FrameData[15] VPWR VGND sg13cmos5l_antennanp
X_3671_ Tile_X0Y3_E6BEG[2] _3671_/A VPWR VGND sg13cmos5l_buf_1
X_0883_ _0884_/B Tile_X0Y3_W1END[0] Tile_X0Y3_WW4END[12] Tile_X0Y3_WW4END[4] _0882_/X
+ _2591_/Q _2592_/Q VPWR VGND sg13cmos5l_mux4_1
XANTENNA__3006__GATE Tile_X0Y5_FrameStrobe[6] VPWR VGND sg13cmos5l_antennanp
X_2622_ _2622_/Q Tile_X0Y3_FrameData[18] Tile_X0Y5_FrameStrobe[3] VPWR VGND sg13cmos5l_dlhq_1
XFILLER_126_250 VPWR VGND sg13cmos5l_fill_2
XFILLER_217_34 VPWR VGND sg13cmos5l_decap_8
X_2553_ _2553_/Q Tile_X0Y3_FrameData[23] Tile_X0Y5_FrameStrobe[1] VPWR VGND sg13cmos5l_dlhq_1
XANTENNA__2262__GATE Tile_X0Y5_FrameStrobe[0] VPWR VGND sg13cmos5l_antennanp
X_1504_ _3660_/A Tile_X0Y3_W2MID[0] AXI_M_SOC_RDATA13 _1267_/X _1351_/X _2690_/Q _2689_/Q
+ VPWR VGND sg13cmos5l_mux4_1
XANTENNA__2892__GATE Tile_X0Y5_FrameStrobe[3] VPWR VGND sg13cmos5l_antennanp
X_2484_ _2484_/Q Tile_X0Y2_FrameData[12] Tile_X0Y5_FrameStrobe[7] VPWR VGND sg13cmos5l_dlhq_1
X_1435_ _1435_/X _1119_/X _0724_/X Tile_X0Y5_N4END[11] Tile_X0Y0_S4END[15] _2553_/Q
+ _2554_/Q VPWR VGND sg13cmos5l_mux4_1
XFILLER_99_189 VPWR VGND sg13cmos5l_decap_8
XANTENNA__1152__A1 Tile_X0Y0_W2END[5] VPWR VGND sg13cmos5l_antennanp
XANTENNA__2277__GATE Tile_X0Y5_FrameStrobe[1] VPWR VGND sg13cmos5l_antennanp
XFILLER_101_139 VPWR VGND sg13cmos5l_decap_8
X_1366_ _1366_/X _1312_/X _1355_/X _2452_/Q VPWR VGND sg13cmos5l_mux2_1
XANTENNA__2168__D Tile_X0Y1_FrameData[24] VPWR VGND sg13cmos5l_antennanp
X_3105_ _3105_/Q Tile_X0Y5_FrameData[15] Tile_X0Y5_FrameStrobe[1] VPWR VGND sg13cmos5l_dlhq_1
X_3036_ _3036_/Q Tile_X0Y4_FrameData[4] Tile_X0Y5_FrameStrobe[7] VPWR VGND sg13cmos5l_dlhq_1
X_1297_ _3485_/A AXI_M_SOC_RDATA23 _0953_/X _0941_/X _1105_/X _2085_/Q _2086_/Q VPWR
+ VGND sg13cmos5l_mux4_1
XFILLER_55_248 VPWR VGND sg13cmos5l_decap_4
XANTENNA__2200__GATE Tile_X0Y5_FrameStrobe[7] VPWR VGND sg13cmos5l_antennanp
XANTENNA__1800__D Tile_X0Y0_FrameData[24] VPWR VGND sg13cmos5l_antennanp
XANTENNA__2830__GATE Tile_X0Y5_FrameStrobe[1] VPWR VGND sg13cmos5l_antennanp
XANTENNA__1207__A2 Tile_X0Y0_WW4END[7] VPWR VGND sg13cmos5l_antennanp
XANTENNA__1649__X AXI_M_SOC_ARADDR17 VPWR VGND sg13cmos5l_antennanp
XANTENNA__3577__A Tile_X0Y0_FrameData[8] VPWR VGND sg13cmos5l_antennanp
XFILLER_211_246 VPWR VGND sg13cmos5l_decap_4
XANTENNA__2215__GATE Tile_X0Y5_FrameStrobe[7] VPWR VGND sg13cmos5l_antennanp
XANTENNA__0966__A1 Tile_X0Y1_WW4END[6] VPWR VGND sg13cmos5l_antennanp
XANTENNA__2631__D Tile_X0Y3_FrameData[9] VPWR VGND sg13cmos5l_antennanp
XANTENNA__2845__GATE Tile_X0Y5_FrameStrobe[1] VPWR VGND sg13cmos5l_antennanp
XANTENNA__3864__X Tile_X0Y5_FrameData_O[5] VPWR VGND sg13cmos5l_antennanp
XFILLER_109_228 VPWR VGND sg13cmos5l_fill_2
XFILLER_258_63 VPWR VGND sg13cmos5l_fill_1
X_3869_ Tile_X0Y5_FrameData_O[10] Tile_X0Y5_FrameData[10] VPWR VGND sg13cmos5l_buf_1
XFILLER_194_29 VPWR VGND sg13cmos5l_fill_1
XFILLER_325_147 VPWR VGND sg13cmos5l_fill_1
XFILLER_325_125 VPWR VGND sg13cmos5l_fill_1
XFILLER_11_34 VPWR VGND sg13cmos5l_decap_8
XFILLER_127_45 VPWR VGND sg13cmos5l_decap_4
XFILLER_191_197 VPWR VGND sg13cmos5l_fill_2
XFILLER_274_84 VPWR VGND sg13cmos5l_fill_1
XFILLER_87_49 VPWR VGND sg13cmos5l_decap_8
XFILLER_293_238 VPWR VGND sg13cmos5l_decap_4
XANTENNA__2078__D Tile_X0Y1_FrameData[18] VPWR VGND sg13cmos5l_antennanp
XFILLER_100_150 VPWR VGND sg13cmos5l_decap_8
XFILLER_143_88 VPWR VGND sg13cmos5l_fill_1
XFILLER_246_187 VPWR VGND sg13cmos5l_fill_2
XFILLER_61_207 VPWR VGND sg13cmos5l_fill_2
XFILLER_46_259 VPWR VGND sg13cmos5l_fill_1
XFILLER_36_53 VPWR VGND sg13cmos5l_fill_2
XFILLER_36_42 VPWR VGND sg13cmos5l_fill_2
XFILLER_36_31 VPWR VGND sg13cmos5l_decap_8
XANTENNA__1446__A2 AXI_M_SOC_RDATA18 VPWR VGND sg13cmos5l_antennanp
XANTENNA__1710__D Tile_X0Y0_FrameData[18] VPWR VGND sg13cmos5l_antennanp
XANTENNA__2806__D Tile_X0Y4_FrameData[10] VPWR VGND sg13cmos5l_antennanp
XFILLER_54_281 VPWR VGND sg13cmos5l_fill_1
XFILLER_54_270 VPWR VGND sg13cmos5l_fill_2
XANTENNA__0654__A0 Tile_X0Y4_W1END[1] VPWR VGND sg13cmos5l_antennanp
XFILLER_14_123 VPWR VGND sg13cmos5l_decap_8
XFILLER_199_286 VPWR VGND sg13cmos5l_fill_1
XANTENNA__1559__X AXI_M_SOC_WDATA1 VPWR VGND sg13cmos5l_antennanp
XFILLER_146_0 VPWR VGND sg13cmos5l_decap_4
XANTENNA__0957__A1 Tile_X0Y1_W6END[11] VPWR VGND sg13cmos5l_antennanp
XANTENNA__3774__X Tile_X0Y4_EE4BEG[12] VPWR VGND sg13cmos5l_antennanp
XFILLER_168_85 VPWR VGND sg13cmos5l_decap_4
XANTENNA__2541__D Tile_X0Y3_FrameData[3] VPWR VGND sg13cmos5l_antennanp
XFILLER_115_209 VPWR VGND sg13cmos5l_fill_2
XFILLER_108_294 VPWR VGND sg13cmos5l_fill_1
XFILLER_184_73 VPWR VGND sg13cmos5l_decap_4
XFILLER_269_235 VPWR VGND sg13cmos5l_decap_4
XFILLER_42_8 VPWR VGND sg13cmos5l_decap_8
X_1220_ _3618_/A _1036_/X _1005_/X Tile_X0Y0_S4END[1] _1006_/X _1821_/Q _1822_/Q VPWR
+ VGND sg13cmos5l_mux4_1
XFILLER_334_87 VPWR VGND sg13cmos5l_fill_1
X_1151_ _1151_/X _1098_/X _1149_/X _1150_/X _1099_/X _2259_/Q _2260_/Q VPWR VGND sg13cmos5l_mux4_1
XFILLER_37_226 VPWR VGND sg13cmos5l_decap_8
XFILLER_252_113 VPWR VGND sg13cmos5l_fill_2
XFILLER_292_293 VPWR VGND sg13cmos5l_fill_2
X_1082_ _1082_/X Tile_X0Y3_W2MID[1] Tile_X0Y3_W2END[1] Tile_X0Y3_W6END[1] _1348_/X
+ _2764_/Q _2763_/Q VPWR VGND sg13cmos5l_mux4_1
XANTENNA__1437__A2 Tile_X0Y5_N4END[9] VPWR VGND sg13cmos5l_antennanp
XANTENNA__2716__D Tile_X0Y3_FrameData[20] VPWR VGND sg13cmos5l_antennanp
XANTENNA__0645__A0 Tile_X0Y5_N1END[1] VPWR VGND sg13cmos5l_antennanp
XFILLER_165_109 VPWR VGND sg13cmos5l_fill_1
X_1984_ _1984_/Q Tile_X0Y1_FrameData[16] Tile_X0Y5_FrameStrobe[0] VPWR VGND sg13cmos5l_dlhq_1
XANTENNA__0948__A1 Tile_X0Y1_WW4END[8] VPWR VGND sg13cmos5l_antennanp
XANTENNA__3684__X Tile_X0Y3_EE4BEG[3] VPWR VGND sg13cmos5l_antennanp
X_3723_ Tile_X0Y3_FrameData_O[26] Tile_X0Y3_FrameData[26] VPWR VGND sg13cmos5l_buf_1
X_0935_ _0935_/X _0694_/X _0790_/X _3298_/Q VPWR VGND sg13cmos5l_mux2_1
XANTENNA__2451__D Tile_X0Y2_FrameData[13] VPWR VGND sg13cmos5l_antennanp
XFILLER_228_11 VPWR VGND sg13cmos5l_fill_2
XFILLER_307_114 VPWR VGND sg13cmos5l_fill_2
X_3654_ Tile_X0Y3_E2BEG[1] _3654_/A VPWR VGND sg13cmos5l_buf_1
X_0866_ AXI_M_SOC_ARLEN4 _3119_/Q _0863_/Y _0864_/Y _0865_/Y _3332_/Q VPWR VGND sg13cmos5l_a221oi_1
X_2605_ _2605_/Q Tile_X0Y3_FrameData[3] Tile_X0Y5_FrameStrobe[2] VPWR VGND sg13cmos5l_dlhq_1
XFILLER_61_0 VPWR VGND sg13cmos5l_decap_4
X_3585_ Tile_X0Y0_FrameData_O[16] Tile_X0Y0_FrameData[16] VPWR VGND sg13cmos5l_buf_1
X_0797_ _3820_/A Tile_X0Y5_W2MID[2] _0773_/X _0790_/X _0656_/X _3238_/Q _3237_/Q VPWR
+ VGND sg13cmos5l_mux4_1
X_2536_ _2536_/Q Tile_X0Y3_FrameData[8] Tile_X0Y5_FrameStrobe[0] VPWR VGND sg13cmos5l_dlhq_1
XANTENNA__3282__D Tile_X0Y5_FrameData[30] VPWR VGND sg13cmos5l_antennanp
XFILLER_114_275 VPWR VGND sg13cmos5l_fill_1
X_2467_ _2467_/Q Tile_X0Y2_FrameData[29] Tile_X0Y5_FrameStrobe[7] VPWR VGND sg13cmos5l_dlhq_1
XFILLER_87_104 VPWR VGND sg13cmos5l_decap_8
XFILLER_330_161 VPWR VGND sg13cmos5l_decap_8
XANTENNA__3860__A Tile_X0Y5_FrameData[1] VPWR VGND sg13cmos5l_antennanp
X_1418_ AXI_M_SOC_WDATA19 Tile_X0Y2_WW4END[3] Tile_X0Y2_WW4END[11] Tile_X0Y2_W6END[11]
+ _1370_/X _2322_/Q _2321_/Q VPWR VGND sg13cmos5l_mux4_1
XFILLER_228_121 VPWR VGND sg13cmos5l_fill_2
X_2398_ _2398_/Q Tile_X0Y2_FrameData[2] Tile_X0Y5_FrameStrobe[4] VPWR VGND sg13cmos5l_dlhq_1
XANTENNA__1676__A2 AXI_M_SOC_RRESP1 VPWR VGND sg13cmos5l_antennanp
XFILLER_28_215 VPWR VGND sg13cmos5l_decap_8
XFILLER_290_219 VPWR VGND sg13cmos5l_fill_1
X_1349_ _1349_/X Tile_X0Y5_W2MID[0] Tile_X0Y5_W2END[0] Tile_X0Y5_W6END[0] _0563_/X
+ _3306_/Q _3305_/Q VPWR VGND sg13cmos5l_mux4_1
XFILLER_113_58 VPWR VGND sg13cmos5l_fill_1
XFILLER_228_187 VPWR VGND sg13cmos5l_fill_2
XFILLER_260_64 VPWR VGND sg13cmos5l_fill_2
XFILLER_283_293 VPWR VGND sg13cmos5l_fill_2
XANTENNA__1428__A2 Tile_X0Y2_W6END[6] VPWR VGND sg13cmos5l_antennanp
XANTENNA__2626__D Tile_X0Y3_FrameData[14] VPWR VGND sg13cmos5l_antennanp
XANTENNA__3859__X Tile_X0Y5_FrameData_O[0] VPWR VGND sg13cmos5l_antennanp
X_3019_ _3019_/Q Tile_X0Y4_FrameData[21] Tile_X0Y5_FrameStrobe[7] VPWR VGND sg13cmos5l_dlhq_1
XFILLER_73_29 VPWR VGND sg13cmos5l_decap_8
XANTENNA__2154__GATE Tile_X0Y5_FrameStrobe[5] VPWR VGND sg13cmos5l_antennanp
XANTENNA__2784__GATE Tile_X0Y5_FrameStrobe[8] VPWR VGND sg13cmos5l_antennanp
XFILLER_149_161 VPWR VGND sg13cmos5l_fill_2
XANTENNA__2361__D Tile_X0Y2_FrameData[7] VPWR VGND sg13cmos5l_antennanp
XANTENNA__3594__X Tile_X0Y0_FrameData_O[25] VPWR VGND sg13cmos5l_antennanp
XANTENNA__2169__GATE Tile_X0Y5_FrameStrobe[6] VPWR VGND sg13cmos5l_antennanp
XANTENNA__2799__GATE Tile_X0Y5_FrameStrobe[0] VPWR VGND sg13cmos5l_antennanp
XANTENNA__1705__D Tile_X0Y0_FrameData[23] VPWR VGND sg13cmos5l_antennanp
XANTENNA__2722__GATE Tile_X0Y5_FrameStrobe[6] VPWR VGND sg13cmos5l_antennanp
XANTENNA__3192__D Tile_X0Y5_FrameData[24] VPWR VGND sg13cmos5l_antennanp
XFILLER_154_54 VPWR VGND sg13cmos5l_fill_1
XANTENNA__1116__A1 Tile_X0Y0_W6END[5] VPWR VGND sg13cmos5l_antennanp
XFILLER_120_256 VPWR VGND sg13cmos5l_decap_8
XFILLER_219_121 VPWR VGND sg13cmos5l_decap_8
XANTENNA__1667__A2 AXI_M_SOC_RDATA1 VPWR VGND sg13cmos5l_antennanp
XANTENNA__2107__GATE Tile_X0Y5_FrameStrobe[4] VPWR VGND sg13cmos5l_antennanp
XFILLER_19_215 VPWR VGND sg13cmos5l_fill_1
XANTENNA__2737__GATE Tile_X0Y5_FrameStrobe[7] VPWR VGND sg13cmos5l_antennanp
XFILLER_19_259 VPWR VGND sg13cmos5l_fill_2
XANTENNA__1419__A2 Tile_X0Y2_W6END[10] VPWR VGND sg13cmos5l_antennanp
XANTENNA__2536__D Tile_X0Y3_FrameData[8] VPWR VGND sg13cmos5l_antennanp
XANTENNA__3769__X Tile_X0Y4_EE4BEG[7] VPWR VGND sg13cmos5l_antennanp
XFILLER_170_86 VPWR VGND sg13cmos5l_fill_2
XFILLER_27_270 VPWR VGND sg13cmos5l_decap_8
XFILLER_320_34 VPWR VGND sg13cmos5l_decap_4
XANTENNA__1993__GATE Tile_X0Y5_FrameStrobe[0] VPWR VGND sg13cmos5l_antennanp
XFILLER_63_51 VPWR VGND sg13cmos5l_decap_8
XFILLER_179_51 VPWR VGND sg13cmos5l_decap_8
XFILLER_42_273 VPWR VGND sg13cmos5l_fill_1
XFILLER_187_245 VPWR VGND sg13cmos5l_decap_8
XANTENNA__2271__D Tile_X0Y2_FrameData[1] VPWR VGND sg13cmos5l_antennanp
X_0720_ _0722_/B Tile_X0Y2_W6END[3] _2242_/Q VPWR VGND sg13cmos5l_nor2b_1
XFILLER_8_79 VPWR VGND sg13cmos5l_fill_2
XFILLER_329_294 VPWR VGND sg13cmos5l_fill_1
XFILLER_195_50 VPWR VGND sg13cmos5l_decap_4
XFILLER_170_134 VPWR VGND sg13cmos5l_decap_8
X_0651_ _0651_/Y _0532_/Y _0648_/X _0650_/Y VPWR VGND sg13cmos5l_o21ai_1
XANTENNA__1931__GATE Tile_X0Y5_FrameStrobe[7] VPWR VGND sg13cmos5l_antennanp
X_3370_ Tile_X0Y2_E6BEG[0] _3370_/A VPWR VGND sg13cmos5l_buf_1
X_0582_ _0584_/B Tile_X0Y3_W6END[0] _2520_/Q VPWR VGND sg13cmos5l_nor2b_1
X_2321_ _2321_/Q Tile_X0Y2_FrameData[15] Tile_X0Y5_FrameStrobe[2] VPWR VGND sg13cmos5l_dlhq_1
X_2252_ _2252_/Q Tile_X0Y2_FrameData[20] Tile_X0Y5_FrameStrobe[0] VPWR VGND sg13cmos5l_dlhq_1
XANTENNA__1107__A1 Tile_X0Y3_W2END[7] VPWR VGND sg13cmos5l_antennanp
XANTENNA__1946__GATE Tile_X0Y5_FrameStrobe[7] VPWR VGND sg13cmos5l_antennanp
X_1203_ AXI_M_SOC_AWADDR26 Tile_X0Y0_W2MID[2] Tile_X0Y0_W2END[2] Tile_X0Y0_W6END[2]
+ _1147_/X _1764_/Q _1763_/Q VPWR VGND sg13cmos5l_mux4_1
X_2183_ _2183_/Q Tile_X0Y1_FrameData[9] Tile_X0Y5_FrameStrobe[6] VPWR VGND sg13cmos5l_dlhq_1
XFILLER_265_293 VPWR VGND sg13cmos5l_fill_2
X_1134_ _1134_/Y _3329_/Q _1132_/Y _1133_/Y VPWR VGND sg13cmos5l_o21ai_1
XANTENNA__2446__D Tile_X0Y2_FrameData[18] VPWR VGND sg13cmos5l_antennanp
XANTENNA__3679__X Tile_X0Y3_E6BEG[10] VPWR VGND sg13cmos5l_antennanp
XFILLER_25_207 VPWR VGND sg13cmos5l_decap_8
X_1065_ _1065_/X _1056_/X _0586_/X Tile_X0Y5_N4END[4] _1061_/X _2839_/Q _2840_/Q VPWR
+ VGND sg13cmos5l_mux4_1
XANTENNA__1199__X AXI_M_SOC_AWADDR18 VPWR VGND sg13cmos5l_antennanp
XFILLER_178_234 VPWR VGND sg13cmos5l_decap_8
XANTENNA__1291__A0 Tile_X0Y1_WW4END[8] VPWR VGND sg13cmos5l_antennanp
XANTENNA__3277__D Tile_X0Y5_FrameData[3] VPWR VGND sg13cmos5l_antennanp
XANTENNA__1043__A0 Tile_X0Y2_W2MID[2] VPWR VGND sg13cmos5l_antennanp
XANTENNA__2181__D Tile_X0Y1_FrameData[11] VPWR VGND sg13cmos5l_antennanp
XFILLER_239_54 VPWR VGND sg13cmos5l_decap_8
X_3706_ Tile_X0Y3_FrameData_O[9] Tile_X0Y3_FrameData[9] VPWR VGND sg13cmos5l_buf_1
X_1967_ _1967_/Q Tile_X0Y0_FrameData[17] Tile_X0Y5_FrameStrobe[8] VPWR VGND sg13cmos5l_dlhq_1
X_1898_ _1898_/Q Tile_X0Y0_FrameData[22] Tile_X0Y5_FrameStrobe[6] VPWR VGND sg13cmos5l_dlhq_1
X_0918_ _0918_/Y _0910_/Y _0912_/Y _0917_/Y VPWR VGND sg13cmos5l_a21oi_1
XFILLER_335_264 VPWR VGND sg13cmos5l_fill_2
XFILLER_255_31 VPWR VGND sg13cmos5l_fill_2
X_3637_ Tile_X0Y0_E2BEG[0] _3637_/A VPWR VGND sg13cmos5l_buf_1
X_0849_ AXI_M_SOC_ARLEN0 _3332_/Q _0848_/X VPWR VGND sg13cmos5l_nor2b_1
XFILLER_161_156 VPWR VGND sg13cmos5l_decap_8
X_3568_ Tile_X0Y0_FrameStrobe_O[19] Tile_X0Y5_FrameStrobe[19] VPWR VGND sg13cmos5l_buf_1
XANTENNA__1346__A1 Tile_X0Y5_W2END[1] VPWR VGND sg13cmos5l_antennanp
XFILLER_102_212 VPWR VGND sg13cmos5l_decap_8
X_2519_ _2519_/Q Tile_X0Y3_FrameData[25] Tile_X0Y5_FrameStrobe[0] VPWR VGND sg13cmos5l_dlhq_1
XFILLER_68_29 VPWR VGND sg13cmos5l_fill_1
XANTENNA__3590__A Tile_X0Y0_FrameData[21] VPWR VGND sg13cmos5l_antennanp
X_3499_ Tile_X0Y1_E2BEGb[7] _3499_/A VPWR VGND sg13cmos5l_buf_1
XFILLER_102_278 VPWR VGND sg13cmos5l_fill_2
XFILLER_124_35 VPWR VGND sg13cmos5l_fill_2
XFILLER_124_46 VPWR VGND sg13cmos5l_decap_8
XFILLER_271_41 VPWR VGND sg13cmos5l_fill_1
XANTENNA__1649__A2 Tile_X0Y4_W6END[1] VPWR VGND sg13cmos5l_antennanp
XFILLER_68_181 VPWR VGND sg13cmos5l_fill_2
XFILLER_256_293 VPWR VGND sg13cmos5l_fill_2
XANTENNA__2356__D Tile_X0Y2_FrameData[12] VPWR VGND sg13cmos5l_antennanp
XANTENNA__3589__X Tile_X0Y0_FrameData_O[20] VPWR VGND sg13cmos5l_antennanp
XFILLER_140_23 VPWR VGND sg13cmos5l_fill_2
XFILLER_216_146 VPWR VGND sg13cmos5l_decap_8
XANTENNA__2093__GATE Tile_X0Y5_FrameStrobe[3] VPWR VGND sg13cmos5l_antennanp
XANTENNA__1282__A0 Tile_X0Y1_WW4END[11] VPWR VGND sg13cmos5l_antennanp
XANTENNA__3187__D Tile_X0Y5_FrameData[29] VPWR VGND sg13cmos5l_antennanp
XANTENNA__2091__D Tile_X0Y1_FrameData[5] VPWR VGND sg13cmos5l_antennanp
XFILLER_137_142 VPWR VGND sg13cmos5l_decap_8
XFILLER_152_101 VPWR VGND sg13cmos5l_fill_2
XFILLER_326_264 VPWR VGND sg13cmos5l_fill_2
XANTENNA__2031__GATE Tile_X0Y5_FrameStrobe[1] VPWR VGND sg13cmos5l_antennanp
XFILLER_109_0 VPWR VGND sg13cmos5l_fill_2
XFILLER_165_42 VPWR VGND sg13cmos5l_fill_2
XFILLER_3_122 VPWR VGND sg13cmos5l_decap_8
XANTENNA__1337__A1 AXI_M_SOC_RDATA25 VPWR VGND sg13cmos5l_antennanp
XANTENNA__2661__GATE Tile_X0Y5_FrameStrobe[4] VPWR VGND sg13cmos5l_antennanp
XFILLER_165_75 VPWR VGND sg13cmos5l_fill_1
XANTENNA__0560__A2 Tile_X0Y5_W2END[1] VPWR VGND sg13cmos5l_antennanp
XANTENNA__2046__GATE Tile_X0Y5_FrameStrobe[2] VPWR VGND sg13cmos5l_antennanp
XFILLER_58_62 VPWR VGND sg13cmos5l_decap_8
XANTENNA__2676__GATE Tile_X0Y5_FrameStrobe[5] VPWR VGND sg13cmos5l_antennanp
XFILLER_331_11 VPWR VGND sg13cmos5l_fill_2
XANTENNA__0848__A0 Tile_X0Y5_W2MID[0] VPWR VGND sg13cmos5l_antennanp
XFILLER_247_293 VPWR VGND sg13cmos5l_fill_2
XANTENNA__2266__D Tile_X0Y2_FrameData[6] VPWR VGND sg13cmos5l_antennanp
XANTENNA__3499__X Tile_X0Y1_E2BEGb[7] VPWR VGND sg13cmos5l_antennanp
XFILLER_74_50 VPWR VGND sg13cmos5l_decap_8
XFILLER_331_55 VPWR VGND sg13cmos5l_fill_1
XFILLER_222_138 VPWR VGND sg13cmos5l_decap_4
XANTENNA__1273__A0 Tile_X0Y1_WW4END[12] VPWR VGND sg13cmos5l_antennanp
X_2870_ _2870_/Q Tile_X0Y4_FrameData[10] Tile_X0Y5_FrameStrobe[2] VPWR VGND sg13cmos5l_dlhq_1
X_1821_ _1821_/Q Tile_X0Y0_FrameData[3] Tile_X0Y5_FrameStrobe[3] VPWR VGND sg13cmos5l_dlhq_1
XFILLER_90_60 VPWR VGND sg13cmos5l_decap_8
XANTENNA__2614__GATE Tile_X0Y5_FrameStrobe[3] VPWR VGND sg13cmos5l_antennanp
XANTENNA__3097__D Tile_X0Y5_FrameData[23] VPWR VGND sg13cmos5l_antennanp
XFILLER_175_259 VPWR VGND sg13cmos5l_decap_8
XFILLER_128_164 VPWR VGND sg13cmos5l_fill_1
X_1752_ _1752_/Q Tile_X0Y0_FrameData[8] Tile_X0Y5_FrameStrobe[1] VPWR VGND sg13cmos5l_dlhq_1
XANTENNA__1870__GATE Tile_X0Y5_FrameStrobe[5] VPWR VGND sg13cmos5l_antennanp
XFILLER_128_186 VPWR VGND sg13cmos5l_decap_8
X_1683_ _1683_/X _1062_/X _1063_/X _1070_/X _1319_/X _2996_/Q _2995_/Q VPWR VGND sg13cmos5l_mux4_1
X_0703_ _0703_/X _0694_/X _0559_/X _3262_/Q VPWR VGND sg13cmos5l_mux2_1
XANTENNA__2629__GATE Tile_X0Y5_FrameStrobe[3] VPWR VGND sg13cmos5l_antennanp
XFILLER_292_18 VPWR VGND sg13cmos5l_fill_1
X_3422_ Tile_X0Y2_FrameData_O[24] Tile_X0Y2_FrameData[24] VPWR VGND sg13cmos5l_buf_1
X_0634_ _0634_/X _0629_/X _0630_/Y _0633_/Y VPWR VGND sg13cmos5l_a21o_1
X_3353_ Tile_X0Y2_E1BEG[3] _3353_/A VPWR VGND sg13cmos5l_buf_1
X_0565_ _0565_/Y _1703_/Q Tile_X0Y0_W6END[0] VPWR VGND sg13cmos5l_nand2b_1
XANTENNA__1885__GATE Tile_X0Y5_FrameStrobe[5] VPWR VGND sg13cmos5l_antennanp
XFILLER_24_0 VPWR VGND sg13cmos5l_fill_2
X_3284_ _3284_/Q Tile_X0Y5_FrameData[28] Tile_X0Y5_FrameStrobe[7] VPWR VGND sg13cmos5l_dlhq_1
X_2304_ _2304_/Q Tile_X0Y2_FrameData[0] Tile_X0Y5_FrameStrobe[1] VPWR VGND sg13cmos5l_dlhq_1
XANTENNA__0539__A Tile_X0Y0_S1END[0] VPWR VGND sg13cmos5l_antennanp
X_2235_ _2235_/Q Tile_X0Y1_FrameData[21] Tile_X0Y5_FrameStrobe[8] VPWR VGND sg13cmos5l_dlhq_1
XFILLER_238_293 VPWR VGND sg13cmos5l_fill_2
XFILLER_241_11 VPWR VGND sg13cmos5l_fill_2
X_2166_ _2166_/Q Tile_X0Y1_FrameData[26] Tile_X0Y5_FrameStrobe[6] VPWR VGND sg13cmos5l_dlhq_1
XANTENNA__1500__A1 AXI_M_SOC_RDATA11 VPWR VGND sg13cmos5l_antennanp
XANTENNA__2176__D Tile_X0Y1_FrameData[16] VPWR VGND sg13cmos5l_antennanp
X_1117_ _1118_/B Tile_X0Y3_WW4END[3] Tile_X0Y3_WW4END[11] Tile_X0Y3_W6END[11] _0971_/X
+ _2594_/Q _2593_/Q VPWR VGND sg13cmos5l_mux4_1
X_2097_ _2097_/Q Tile_X0Y1_FrameData[31] Tile_X0Y5_FrameStrobe[4] VPWR VGND sg13cmos5l_dlhq_1
XFILLER_110_15 VPWR VGND sg13cmos5l_decap_8
XFILLER_110_26 VPWR VGND sg13cmos5l_fill_2
XFILLER_206_190 VPWR VGND sg13cmos5l_decap_8
X_1048_ _1048_/X Tile_X0Y5_W2MID[6] Tile_X0Y5_W2END[6] Tile_X0Y5_W6END[6] _0786_/X
+ _3318_/Q _3317_/Q VPWR VGND sg13cmos5l_mux4_1
XANTENNA__1264__A0 Tile_X0Y0_W2END[1] VPWR VGND sg13cmos5l_antennanp
XANTENNA__1823__GATE Tile_X0Y5_FrameStrobe[3] VPWR VGND sg13cmos5l_antennanp
XANTENNA__2904__D Tile_X0Y4_FrameData[8] VPWR VGND sg13cmos5l_antennanp
XFILLER_110_48 VPWR VGND sg13cmos5l_decap_8
XFILLER_21_254 VPWR VGND sg13cmos5l_decap_4
XANTENNA__3585__A Tile_X0Y0_FrameData[16] VPWR VGND sg13cmos5l_antennanp
X_2999_ _2999_/Q Tile_X0Y4_FrameData[9] Tile_X0Y5_FrameStrobe[6] VPWR VGND sg13cmos5l_dlhq_1
XFILLER_119_35 VPWR VGND sg13cmos5l_fill_2
XANTENNA__1838__GATE Tile_X0Y5_FrameStrobe[4] VPWR VGND sg13cmos5l_antennanp
XFILLER_134_112 VPWR VGND sg13cmos5l_decap_8
XANTENNA__3872__X Tile_X0Y5_FrameData_O[13] VPWR VGND sg13cmos5l_antennanp
XFILLER_79_28 VPWR VGND sg13cmos5l_decap_8
XFILLER_323_267 VPWR VGND sg13cmos5l_fill_2
XFILLER_288_160 VPWR VGND sg13cmos5l_fill_2
XFILLER_95_49 VPWR VGND sg13cmos5l_decap_8
XFILLER_185_4 VPWR VGND sg13cmos5l_fill_2
XANTENNA__2086__D Tile_X0Y1_FrameData[10] VPWR VGND sg13cmos5l_antennanp
XFILLER_229_293 VPWR VGND sg13cmos5l_fill_2
XFILLER_244_230 VPWR VGND sg13cmos5l_decap_4
XFILLER_56_184 VPWR VGND sg13cmos5l_decap_8
XANTENNA__1255__A0 Tile_X0Y0_W2END[5] VPWR VGND sg13cmos5l_antennanp
XANTENNA__2814__D Tile_X0Y4_FrameData[2] VPWR VGND sg13cmos5l_antennanp
XFILLER_100_81 VPWR VGND sg13cmos5l_decap_8
XFILLER_212_193 VPWR VGND sg13cmos5l_decap_8
XFILLER_226_0 VPWR VGND sg13cmos5l_fill_2
XANTENNA__1558__A1 Tile_X0Y3_W2END[7] VPWR VGND sg13cmos5l_antennanp
XANTENNA__3344__GATE Tile_X0Y5_FrameStrobe[8] VPWR VGND sg13cmos5l_antennanp
XFILLER_60_74 VPWR VGND sg13cmos5l_fill_1
XFILLER_60_63 VPWR VGND sg13cmos5l_decap_8
XANTENNA__3782__X Tile_X0Y4_FrameData_O[4] VPWR VGND sg13cmos5l_antennanp
XANTENNA__0781__A2 Tile_X0Y4_W6END[8] VPWR VGND sg13cmos5l_antennanp
XFILLER_314_267 VPWR VGND sg13cmos5l_decap_8
XFILLER_5_47 VPWR VGND sg13cmos5l_decap_8
XFILLER_140_159 VPWR VGND sg13cmos5l_decap_8
XFILLER_192_73 VPWR VGND sg13cmos5l_fill_1
XFILLER_294_174 VPWR VGND sg13cmos5l_decap_8
XFILLER_294_185 VPWR VGND sg13cmos5l_fill_1
X_2020_ _2020_/Q Tile_X0Y1_FrameData[12] Tile_X0Y5_FrameStrobe[1] VPWR VGND sg13cmos5l_dlhq_1
XFILLER_94_257 VPWR VGND sg13cmos5l_fill_1
XFILLER_85_60 VPWR VGND sg13cmos5l_decap_8
XANTENNA__1089__A3 Tile_X0Y0_S2MID[4] VPWR VGND sg13cmos5l_antennanp
XFILLER_211_36 VPWR VGND sg13cmos5l_fill_1
XFILLER_211_58 VPWR VGND sg13cmos5l_decap_4
XANTENNA__1246__A0 AXI_M_SOC_RDATA31 VPWR VGND sg13cmos5l_antennanp
XANTENNA__2724__D Tile_X0Y3_FrameData[12] VPWR VGND sg13cmos5l_antennanp
XFILLER_250_255 VPWR VGND sg13cmos5l_decap_4
X_2922_ _2922_/Q Tile_X0Y4_FrameData[22] Tile_X0Y5_FrameStrobe[4] VPWR VGND sg13cmos5l_dlhq_1
XANTENNA__2553__GATE Tile_X0Y5_FrameStrobe[1] VPWR VGND sg13cmos5l_antennanp
X_2853_ _2853_/Q Tile_X0Y4_FrameData[27] Tile_X0Y5_FrameStrobe[2] VPWR VGND sg13cmos5l_dlhq_1
XANTENNA__1549__A1 Tile_X0Y3_WW4END[11] VPWR VGND sg13cmos5l_antennanp
X_2784_ _2784_/Q Tile_X0Y3_FrameData[16] Tile_X0Y5_FrameStrobe[8] VPWR VGND sg13cmos5l_dlhq_1
X_1804_ _1804_/Q Tile_X0Y0_FrameData[20] Tile_X0Y5_FrameStrobe[3] VPWR VGND sg13cmos5l_dlhq_1
X_1735_ _1735_/Q Tile_X0Y0_FrameData[25] Tile_X0Y5_FrameStrobe[1] VPWR VGND sg13cmos5l_dlhq_1
XANTENNA__2568__GATE Tile_X0Y5_FrameStrobe[1] VPWR VGND sg13cmos5l_antennanp
XANTENNA__3692__X Tile_X0Y3_EE4BEG[11] VPWR VGND sg13cmos5l_antennanp
XANTENNA__0772__A2 Tile_X0Y1_W6END[2] VPWR VGND sg13cmos5l_antennanp
X_1666_ _3922_/A _1665_/X _1664_/X _2985_/Q VPWR VGND sg13cmos5l_mux2_1
X_3405_ Tile_X0Y2_FrameData_O[7] Tile_X0Y2_FrameData[7] VPWR VGND sg13cmos5l_buf_1
X_1597_ _1597_/Y _2718_/Q _0555_/Y _2717_/Q VPWR VGND sg13cmos5l_o21ai_1
X_0617_ _0617_/X Tile_X0Y0_W1END[1] Tile_X0Y0_W6END[9] _1041_/X _0616_/Y _1930_/Q
+ _1929_/Q VPWR VGND sg13cmos5l_mux4_1
XFILLER_285_130 VPWR VGND sg13cmos5l_fill_2
X_3336_ _3336_/Q Tile_X0Y5_FrameData[2] Tile_X0Y5_FrameStrobe[8] VPWR VGND sg13cmos5l_dlhq_1
X_0548_ _0548_/Y _3304_/Q VPWR VGND sg13cmos5l_inv_1
XANTENNA__3290__D Tile_X0Y5_FrameData[22] VPWR VGND sg13cmos5l_antennanp
XANTENNA__1803__D Tile_X0Y0_FrameData[21] VPWR VGND sg13cmos5l_antennanp
X_3267_ _3267_/Q Tile_X0Y5_FrameData[13] Tile_X0Y5_FrameStrobe[6] VPWR VGND sg13cmos5l_dlhq_1
XFILLER_85_268 VPWR VGND sg13cmos5l_fill_1
XFILLER_65_19 VPWR VGND sg13cmos5l_fill_1
XANTENNA__2506__GATE Tile_X0Y5_FrameStrobe[8] VPWR VGND sg13cmos5l_antennanp
XFILLER_226_230 VPWR VGND sg13cmos5l_fill_2
X_3198_ _3198_/Q Tile_X0Y5_FrameData[18] Tile_X0Y5_FrameStrobe[4] VPWR VGND sg13cmos5l_dlhq_1
X_2218_ _2218_/Q Tile_X0Y1_FrameData[6] Tile_X0Y5_FrameStrobe[7] VPWR VGND sg13cmos5l_dlhq_1
X_2149_ _2149_/Q Tile_X0Y1_FrameData[11] Tile_X0Y5_FrameStrobe[5] VPWR VGND sg13cmos5l_dlhq_1
XFILLER_38_195 VPWR VGND sg13cmos5l_decap_8
XANTENNA__1762__GATE Tile_X0Y5_FrameStrobe[2] VPWR VGND sg13cmos5l_antennanp
XFILLER_53_165 VPWR VGND sg13cmos5l_decap_8
XANTENNA__1237__A0 Tile_X0Y0_WW4END[5] VPWR VGND sg13cmos5l_antennanp
XANTENNA__2634__D Tile_X0Y3_FrameData[6] VPWR VGND sg13cmos5l_antennanp
XANTENNA__3867__X Tile_X0Y5_FrameData_O[8] VPWR VGND sg13cmos5l_antennanp
XFILLER_241_255 VPWR VGND sg13cmos5l_fill_2
XFILLER_277_40 VPWR VGND sg13cmos5l_fill_1
XANTENNA__0732__A Tile_X0Y4_W6END[3] VPWR VGND sg13cmos5l_antennanp
XANTENNA__1777__GATE Tile_X0Y5_FrameStrobe[2] VPWR VGND sg13cmos5l_antennanp
XFILLER_147_281 VPWR VGND sg13cmos5l_fill_2
XANTENNA__1004__A3 Tile_X0Y0_S4END[2] VPWR VGND sg13cmos5l_antennanp
XANTENNA__0763__A2 Tile_X0Y5_W6END[5] VPWR VGND sg13cmos5l_antennanp
XANTENNA__1700__GATE Tile_X0Y5_FrameStrobe[0] VPWR VGND sg13cmos5l_antennanp
XFILLER_146_44 VPWR VGND sg13cmos5l_decap_8
XFILLER_107_189 VPWR VGND sg13cmos5l_decap_8
XFILLER_146_88 VPWR VGND sg13cmos5l_decap_8
XFILLER_293_83 VPWR VGND sg13cmos5l_decap_8
XFILLER_122_159 VPWR VGND sg13cmos5l_decap_8
XANTENNA__1715__GATE Tile_X0Y5_FrameStrobe[0] VPWR VGND sg13cmos5l_antennanp
XANTENNA__2809__D Tile_X0Y4_FrameData[7] VPWR VGND sg13cmos5l_antennanp
XFILLER_209_208 VPWR VGND sg13cmos5l_fill_1
XANTENNA__1713__D Tile_X0Y0_FrameData[15] VPWR VGND sg13cmos5l_antennanp
XFILLER_162_98 VPWR VGND sg13cmos5l_decap_8
XFILLER_291_144 VPWR VGND sg13cmos5l_decap_8
XFILLER_189_115 VPWR VGND sg13cmos5l_decap_4
XFILLER_55_63 VPWR VGND sg13cmos5l_decap_8
XANTENNA__1228__A0 Tile_X0Y0_WW4END[9] VPWR VGND sg13cmos5l_antennanp
XANTENNA__1491__A3 AXI_M_SOC_RDATA19 VPWR VGND sg13cmos5l_antennanp
XANTENNA__2544__D Tile_X0Y3_FrameData[0] VPWR VGND sg13cmos5l_antennanp
XANTENNA__3777__X Tile_X0Y4_EE4BEG[15] VPWR VGND sg13cmos5l_antennanp
XFILLER_232_255 VPWR VGND sg13cmos5l_decap_4
XFILLER_44_187 VPWR VGND sg13cmos5l_decap_8
XANTENNA__3283__GATE Tile_X0Y5_FrameStrobe[7] VPWR VGND sg13cmos5l_antennanp
XFILLER_187_84 VPWR VGND sg13cmos5l_decap_8
XFILLER_71_84 VPWR VGND sg13cmos5l_decap_8
XANTENNA__1400__A0 Tile_X0Y5_N4END[12] VPWR VGND sg13cmos5l_antennanp
XFILLER_337_76 VPWR VGND sg13cmos5l_fill_2
XFILLER_337_65 VPWR VGND sg13cmos5l_fill_2
XANTENNA__3298__GATE Tile_X0Y5_FrameStrobe[7] VPWR VGND sg13cmos5l_antennanp
XFILLER_299_255 VPWR VGND sg13cmos5l_fill_2
X_1520_ _3688_/A Tile_X0Y3_WW4END[8] _1521_/X AXI_M_SOC_RDATA13 _1267_/X _2657_/Q
+ _2658_/Q VPWR VGND sg13cmos5l_mux4_1
X_1451_ _3384_/A Tile_X0Y2_WW4END[13] AXI_M_SOC_RDATA16 _1025_/X _1183_/X _2396_/Q
+ _2395_/Q VPWR VGND sg13cmos5l_mux4_1
XANTENNA__3221__GATE Tile_X0Y5_FrameStrobe[5] VPWR VGND sg13cmos5l_antennanp
X_1382_ _1382_/Y _2480_/Q _1382_/B VPWR VGND sg13cmos5l_nand2b_1
XANTENNA__2719__D Tile_X0Y3_FrameData[17] VPWR VGND sg13cmos5l_antennanp
X_3121_ _3121_/Q Tile_X0Y5_FrameData[31] Tile_X0Y5_FrameStrobe[2] VPWR VGND sg13cmos5l_dlhq_1
XFILLER_96_81 VPWR VGND sg13cmos5l_decap_8
XFILLER_67_235 VPWR VGND sg13cmos5l_decap_4
X_3052_ _3052_/Q Tile_X0Y4_FrameData[20] Tile_X0Y5_FrameStrobe[8] VPWR VGND sg13cmos5l_dlhq_1
XANTENNA__1467__A0 Tile_X0Y2_W2END[7] VPWR VGND sg13cmos5l_antennanp
XANTENNA__3236__GATE Tile_X0Y5_FrameStrobe[5] VPWR VGND sg13cmos5l_antennanp
XFILLER_222_79 VPWR VGND sg13cmos5l_fill_2
X_2003_ _2003_/Q Tile_X0Y1_FrameData[29] Tile_X0Y5_FrameStrobe[1] VPWR VGND sg13cmos5l_dlhq_1
XANTENNA__2454__D Tile_X0Y2_FrameData[10] VPWR VGND sg13cmos5l_antennanp
XANTENNA__2492__GATE Tile_X0Y5_FrameStrobe[7] VPWR VGND sg13cmos5l_antennanp
XANTENNA__3687__X Tile_X0Y3_EE4BEG[6] VPWR VGND sg13cmos5l_antennanp
XFILLER_90_293 VPWR VGND sg13cmos5l_fill_2
XFILLER_35_176 VPWR VGND sg13cmos5l_decap_8
XFILLER_91_0 VPWR VGND sg13cmos5l_decap_4
XFILLER_50_135 VPWR VGND sg13cmos5l_decap_8
XFILLER_195_129 VPWR VGND sg13cmos5l_decap_8
X_2905_ _2905_/Q Tile_X0Y4_FrameData[7] Tile_X0Y5_FrameStrobe[3] VPWR VGND sg13cmos5l_dlhq_1
X_3885_ Tile_X0Y5_FrameData_O[26] Tile_X0Y5_FrameData[26] VPWR VGND sg13cmos5l_buf_1
X_2836_ _2836_/Q Tile_X0Y4_FrameData[12] Tile_X0Y5_FrameStrobe[1] VPWR VGND sg13cmos5l_dlhq_1
XFILLER_337_156 VPWR VGND sg13cmos5l_fill_2
XFILLER_337_134 VPWR VGND sg13cmos5l_fill_2
XANTENNA__3285__D Tile_X0Y5_FrameData[27] VPWR VGND sg13cmos5l_antennanp
XANTENNA__3863__A Tile_X0Y5_FrameData[4] VPWR VGND sg13cmos5l_antennanp
X_2767_ _2767_/Q Tile_X0Y3_FrameData[1] Tile_X0Y5_FrameStrobe[7] VPWR VGND sg13cmos5l_dlhq_1
X_2698_ _2698_/Q Tile_X0Y3_FrameData[6] Tile_X0Y5_FrameStrobe[5] VPWR VGND sg13cmos5l_dlhq_1
X_1718_ _1718_/Q Tile_X0Y0_FrameData[10] Tile_X0Y5_FrameStrobe[0] VPWR VGND sg13cmos5l_dlhq_1
XANTENNA__2430__GATE Tile_X0Y5_FrameStrobe[5] VPWR VGND sg13cmos5l_antennanp
XFILLER_104_126 VPWR VGND sg13cmos5l_decap_8
X_1649_ AXI_M_SOC_ARADDR17 Tile_X0Y4_W2MID[1] Tile_X0Y4_W2END[1] Tile_X0Y4_W6END[1]
+ _1049_/X _2854_/Q _2853_/Q VPWR VGND sg13cmos5l_mux4_1
XANTENNA__2629__D Tile_X0Y3_FrameData[11] VPWR VGND sg13cmos5l_antennanp
XFILLER_76_18 VPWR VGND sg13cmos5l_decap_8
XANTENNA__2445__GATE Tile_X0Y5_FrameStrobe[6] VPWR VGND sg13cmos5l_antennanp
XFILLER_258_174 VPWR VGND sg13cmos5l_fill_1
X_3319_ _3319_/Q Tile_X0Y5_FrameData[25] Tile_X0Y5_FrameStrobe[8] VPWR VGND sg13cmos5l_dlhq_1
XFILLER_258_196 VPWR VGND sg13cmos5l_fill_1
XFILLER_273_155 VPWR VGND sg13cmos5l_decap_8
XANTENNA__1458__A0 Tile_X0Y2_W2MID[2] VPWR VGND sg13cmos5l_antennanp
XFILLER_273_166 VPWR VGND sg13cmos5l_fill_2
XFILLER_25_11 VPWR VGND sg13cmos5l_fill_1
XFILLER_92_28 VPWR VGND sg13cmos5l_decap_8
XANTENNA__2364__D Tile_X0Y2_FrameData[4] VPWR VGND sg13cmos5l_antennanp
XANTENNA__3597__X Tile_X0Y0_FrameData_O[28] VPWR VGND sg13cmos5l_antennanp
XFILLER_186_107 VPWR VGND sg13cmos5l_decap_8
XFILLER_186_118 VPWR VGND sg13cmos5l_decap_8
XFILLER_81_293 VPWR VGND sg13cmos5l_fill_2
XFILLER_41_135 VPWR VGND sg13cmos5l_decap_8
XFILLER_288_94 VPWR VGND sg13cmos5l_fill_1
XANTENNA__1630__A0 AXI_M_SOC_RDATA3 VPWR VGND sg13cmos5l_antennanp
XANTENNA__1708__D Tile_X0Y0_FrameData[20] VPWR VGND sg13cmos5l_antennanp
XANTENNA__3195__D Tile_X0Y5_FrameData[21] VPWR VGND sg13cmos5l_antennanp
XFILLER_41_76 VPWR VGND sg13cmos5l_decap_8
XFILLER_135_240 VPWR VGND sg13cmos5l_fill_2
XFILLER_157_76 VPWR VGND sg13cmos5l_decap_8
XANTENNA__0736__A2 Tile_X0Y4_W6END[11] VPWR VGND sg13cmos5l_antennanp
XFILLER_307_68 VPWR VGND sg13cmos5l_fill_1
XFILLER_150_243 VPWR VGND sg13cmos5l_fill_1
XFILLER_150_265 VPWR VGND sg13cmos5l_fill_2
XANTENNA__2539__D Tile_X0Y3_FrameData[5] VPWR VGND sg13cmos5l_antennanp
XFILLER_173_86 VPWR VGND sg13cmos5l_decap_8
XFILLER_293_0 VPWR VGND sg13cmos5l_fill_1
XANTENNA__1697__A0 Tile_X0Y5_W1END[0] VPWR VGND sg13cmos5l_antennanp
XFILLER_264_100 VPWR VGND sg13cmos5l_decap_8
XFILLER_264_111 VPWR VGND sg13cmos5l_fill_1
XFILLER_2_48 VPWR VGND sg13cmos5l_decap_4
XFILLER_66_62 VPWR VGND sg13cmos5l_decap_8
XFILLER_49_268 VPWR VGND sg13cmos5l_fill_1
XANTENNA__0637__A Tile_X0Y4_W6END[1] VPWR VGND sg13cmos5l_antennanp
XANTENNA__1449__A0 Tile_X0Y2_WW4END[8] VPWR VGND sg13cmos5l_antennanp
XANTENNA__2274__D Tile_X0Y2_FrameData[30] VPWR VGND sg13cmos5l_antennanp
XFILLER_82_50 VPWR VGND sg13cmos5l_decap_8
XFILLER_198_50 VPWR VGND sg13cmos5l_decap_8
XFILLER_205_277 VPWR VGND sg13cmos5l_fill_2
XFILLER_220_214 VPWR VGND sg13cmos5l_decap_4
XFILLER_72_293 VPWR VGND sg13cmos5l_fill_2
XFILLER_32_146 VPWR VGND sg13cmos5l_decap_8
X_0951_ _0951_/X Tile_X0Y1_WW4END[1] Tile_X0Y1_WW4END[9] Tile_X0Y1_W6END[9] _0950_/X
+ _2054_/Q _2053_/Q VPWR VGND sg13cmos5l_mux4_1
XANTENNA__1621__A0 Tile_X0Y4_WW4END[2] VPWR VGND sg13cmos5l_antennanp
XANTENNA__0975__A2 Tile_X0Y5_W2END[2] VPWR VGND sg13cmos5l_antennanp
X_3670_ Tile_X0Y3_E6BEG[1] _3670_/A VPWR VGND sg13cmos5l_buf_1
X_0882_ _0882_/X _1050_/X _0580_/X Tile_X0Y5_N4END[8] Tile_X0Y0_S4END[12] _2543_/Q
+ _2544_/Q VPWR VGND sg13cmos5l_mux4_1
X_2621_ _2621_/Q Tile_X0Y3_FrameData[19] Tile_X0Y5_FrameStrobe[3] VPWR VGND sg13cmos5l_dlhq_1
XFILLER_126_240 VPWR VGND sg13cmos5l_decap_8
X_2552_ _2552_/Q Tile_X0Y3_FrameData[24] Tile_X0Y5_FrameStrobe[1] VPWR VGND sg13cmos5l_dlhq_1
XFILLER_126_273 VPWR VGND sg13cmos5l_decap_4
X_1503_ _3666_/A Tile_X0Y3_W2END[2] AXI_M_SOC_RDATA8 _1216_/X _1342_/X _2678_/Q _2677_/Q
+ VPWR VGND sg13cmos5l_mux4_1
XANTENNA__3160__GATE Tile_X0Y5_FrameStrobe[3] VPWR VGND sg13cmos5l_antennanp
X_2483_ _2483_/Q Tile_X0Y2_FrameData[13] Tile_X0Y5_FrameStrobe[7] VPWR VGND sg13cmos5l_dlhq_1
XFILLER_101_118 VPWR VGND sg13cmos5l_decap_8
X_1434_ _1434_/X _0987_/X _0678_/X Tile_X0Y5_N4END[10] Tile_X0Y0_S4END[14] _2555_/Q
+ _2556_/Q VPWR VGND sg13cmos5l_mux4_1
XANTENNA__2449__D Tile_X0Y2_FrameData[15] VPWR VGND sg13cmos5l_antennanp
XFILLER_233_34 VPWR VGND sg13cmos5l_decap_8
X_1365_ _1365_/Y _2452_/Q _1191_/X _1364_/Y VPWR VGND sg13cmos5l_a21oi_1
XANTENNA__1152__A2 Tile_X0Y0_W6END[5] VPWR VGND sg13cmos5l_antennanp
XANTENNA__3175__GATE Tile_X0Y5_FrameStrobe[3] VPWR VGND sg13cmos5l_antennanp
X_3104_ _3104_/Q Tile_X0Y5_FrameData[16] Tile_X0Y5_FrameStrobe[1] VPWR VGND sg13cmos5l_dlhq_1
X_3035_ _3035_/Q Tile_X0Y4_FrameData[5] Tile_X0Y5_FrameStrobe[7] VPWR VGND sg13cmos5l_dlhq_1
X_1296_ _3481_/A _0926_/X _0953_/X Tile_X0Y0_S4END[5] _0965_/X _2093_/Q _2094_/Q VPWR
+ VGND sg13cmos5l_mux4_1
XFILLER_70_208 VPWR VGND sg13cmos5l_fill_1
XANTENNA__2184__D Tile_X0Y1_FrameData[8] VPWR VGND sg13cmos5l_antennanp
XFILLER_63_260 VPWR VGND sg13cmos5l_decap_4
XFILLER_168_107 VPWR VGND sg13cmos5l_fill_2
XFILLER_63_293 VPWR VGND sg13cmos5l_fill_2
XFILLER_23_179 VPWR VGND sg13cmos5l_decap_4
XANTENNA__1612__A0 Tile_X0Y4_WW4END[8] VPWR VGND sg13cmos5l_antennanp
XANTENNA__2912__D Tile_X0Y4_FrameData[0] VPWR VGND sg13cmos5l_antennanp
XFILLER_258_31 VPWR VGND sg13cmos5l_fill_2
XANTENNA__0966__A2 Tile_X0Y1_WW4END[14] VPWR VGND sg13cmos5l_antennanp
XANTENNA__3113__GATE Tile_X0Y5_FrameStrobe[1] VPWR VGND sg13cmos5l_antennanp
XFILLER_109_207 VPWR VGND sg13cmos5l_decap_8
X_3868_ Tile_X0Y5_FrameData_O[9] Tile_X0Y5_FrameData[9] VPWR VGND sg13cmos5l_buf_1
XANTENNA__3593__A Tile_X0Y0_FrameData[24] VPWR VGND sg13cmos5l_antennanp
X_2819_ _2819_/Q Tile_X0Y4_FrameData[29] Tile_X0Y5_FrameStrobe[1] VPWR VGND sg13cmos5l_dlhq_1
X_3799_ Tile_X0Y4_FrameData_O[21] Tile_X0Y4_FrameData[21] VPWR VGND sg13cmos5l_buf_1
XFILLER_117_251 VPWR VGND sg13cmos5l_decap_4
XFILLER_117_262 VPWR VGND sg13cmos5l_fill_2
XFILLER_274_30 VPWR VGND sg13cmos5l_fill_2
XANTENNA__0718__A2 Tile_X0Y1_W6END[11] VPWR VGND sg13cmos5l_antennanp
XANTENNA__3128__GATE Tile_X0Y5_FrameStrobe[2] VPWR VGND sg13cmos5l_antennanp
XFILLER_127_35 VPWR VGND sg13cmos5l_decap_4
XANTENNA__3880__X Tile_X0Y5_FrameData_O[21] VPWR VGND sg13cmos5l_antennanp
XFILLER_127_68 VPWR VGND sg13cmos5l_fill_1
XFILLER_127_79 VPWR VGND sg13cmos5l_decap_8
XFILLER_278_214 VPWR VGND sg13cmos5l_fill_1
XFILLER_278_225 VPWR VGND sg13cmos5l_fill_1
XFILLER_87_28 VPWR VGND sg13cmos5l_decap_8
XANTENNA__1679__A0 Tile_X0Y4_W2END[0] VPWR VGND sg13cmos5l_antennanp
XANTENNA__2359__D Tile_X0Y2_FrameData[9] VPWR VGND sg13cmos5l_antennanp
XANTENNA__2384__GATE Tile_X0Y5_FrameStrobe[4] VPWR VGND sg13cmos5l_antennanp
XFILLER_143_56 VPWR VGND sg13cmos5l_fill_2
XFILLER_46_205 VPWR VGND sg13cmos5l_fill_1
XFILLER_46_227 VPWR VGND sg13cmos5l_decap_8
XANTENNA__2399__GATE Tile_X0Y5_FrameStrobe[4] VPWR VGND sg13cmos5l_antennanp
XFILLER_14_102 VPWR VGND sg13cmos5l_decap_8
XANTENNA__0654__A1 Tile_X0Y4_W2MID[2] VPWR VGND sg13cmos5l_antennanp
XANTENNA__2094__D Tile_X0Y1_FrameData[2] VPWR VGND sg13cmos5l_antennanp
XFILLER_299_71 VPWR VGND sg13cmos5l_fill_1
XFILLER_299_93 VPWR VGND sg13cmos5l_decap_8
XFILLER_54_293 VPWR VGND sg13cmos5l_fill_2
XANTENNA__2322__GATE Tile_X0Y5_FrameStrobe[2] VPWR VGND sg13cmos5l_antennanp
XFILLER_52_42 VPWR VGND sg13cmos5l_decap_8
XANTENNA__1603__A0 Tile_X0Y3_W1END[0] VPWR VGND sg13cmos5l_antennanp
XANTENNA__2822__D Tile_X0Y4_FrameData[26] VPWR VGND sg13cmos5l_antennanp
XANTENNA__2952__GATE Tile_X0Y5_FrameStrobe[5] VPWR VGND sg13cmos5l_antennanp
XFILLER_139_0 VPWR VGND sg13cmos5l_decap_4
XFILLER_167_140 VPWR VGND sg13cmos5l_decap_8
XFILLER_168_42 VPWR VGND sg13cmos5l_decap_8
XANTENNA__0957__A2 Tile_X0Y1_WW4END[11] VPWR VGND sg13cmos5l_antennanp
XFILLER_316_104 VPWR VGND sg13cmos5l_decap_4
XFILLER_182_110 VPWR VGND sg13cmos5l_decap_4
XANTENNA__2337__GATE Tile_X0Y5_FrameStrobe[3] VPWR VGND sg13cmos5l_antennanp
XFILLER_182_165 VPWR VGND sg13cmos5l_fill_1
XFILLER_306_0 VPWR VGND sg13cmos5l_fill_2
XFILLER_316_148 VPWR VGND sg13cmos5l_decap_8
XANTENNA__2967__GATE Tile_X0Y5_FrameStrobe[5] VPWR VGND sg13cmos5l_antennanp
XANTENNA__3790__X Tile_X0Y4_FrameData_O[12] VPWR VGND sg13cmos5l_antennanp
XANTENNA__2269__D Tile_X0Y2_FrameData[3] VPWR VGND sg13cmos5l_antennanp
X_1150_ _1150_/X Tile_X0Y4_W2MID[5] Tile_X0Y4_W2END[5] Tile_X0Y4_W6END[5] _1016_/X
+ _3044_/Q _3043_/Q VPWR VGND sg13cmos5l_mux4_1
XFILLER_37_205 VPWR VGND sg13cmos5l_decap_8
XANTENNA__1901__D Tile_X0Y0_FrameData[19] VPWR VGND sg13cmos5l_antennanp
XANTENNA__2905__GATE Tile_X0Y5_FrameStrobe[3] VPWR VGND sg13cmos5l_antennanp
XFILLER_203_59 VPWR VGND sg13cmos5l_decap_8
X_1081_ _1081_/X Tile_X0Y0_W1END[2] Tile_X0Y0_W2MID[1] Tile_X0Y0_W2END[1] _1010_/X
+ _1912_/Q _1911_/Q VPWR VGND sg13cmos5l_mux4_1
XFILLER_93_60 VPWR VGND sg13cmos5l_decap_8
XANTENNA__1437__A3 Tile_X0Y0_S4END[13] VPWR VGND sg13cmos5l_antennanp
XFILLER_252_158 VPWR VGND sg13cmos5l_decap_8
XANTENNA__0645__A1 Tile_X0Y5_N4END[1] VPWR VGND sg13cmos5l_antennanp
XFILLER_60_263 VPWR VGND sg13cmos5l_decap_8
XFILLER_60_241 VPWR VGND sg13cmos5l_decap_8
XANTENNA__2732__D Tile_X0Y3_FrameData[4] VPWR VGND sg13cmos5l_antennanp
XFILLER_20_127 VPWR VGND sg13cmos5l_fill_1
XFILLER_20_138 VPWR VGND sg13cmos5l_decap_8
X_1983_ _1983_/Q Tile_X0Y1_FrameData[17] Tile_X0Y5_FrameStrobe[0] VPWR VGND sg13cmos5l_dlhq_1
X_3722_ Tile_X0Y3_FrameData_O[25] Tile_X0Y3_FrameData[25] VPWR VGND sg13cmos5l_buf_1
X_0934_ _0934_/Y _0545_/Y _0933_/X _3296_/Q VPWR VGND sg13cmos5l_a21oi_1
XANTENNA__0948__A2 Tile_X0Y1_W6END[8] VPWR VGND sg13cmos5l_antennanp
XFILLER_173_132 VPWR VGND sg13cmos5l_fill_1
XFILLER_307_137 VPWR VGND sg13cmos5l_decap_4
X_3653_ Tile_X0Y3_E2BEG[0] _3653_/A VPWR VGND sg13cmos5l_buf_1
X_0865_ _0865_/Y Tile_X0Y5_W2END[4] _3120_/Q _3119_/Q VPWR VGND sg13cmos5l_a21oi_1
XFILLER_173_154 VPWR VGND sg13cmos5l_fill_1
X_2604_ _2604_/Q Tile_X0Y3_FrameData[4] Tile_X0Y5_FrameStrobe[2] VPWR VGND sg13cmos5l_dlhq_1
XFILLER_114_210 VPWR VGND sg13cmos5l_decap_8
X_3584_ Tile_X0Y0_FrameData_O[15] Tile_X0Y0_FrameData[15] VPWR VGND sg13cmos5l_buf_1
X_0796_ _3819_/A Tile_X0Y5_W2MID[3] _0778_/X _0794_/X _0607_/X _3240_/Q _3239_/Q VPWR
+ VGND sg13cmos5l_mux4_1
XFILLER_54_0 VPWR VGND sg13cmos5l_decap_8
XFILLER_114_243 VPWR VGND sg13cmos5l_decap_8
X_2535_ _2535_/Q Tile_X0Y3_FrameData[9] Tile_X0Y5_FrameStrobe[0] VPWR VGND sg13cmos5l_dlhq_1
X_2466_ _2466_/Q Tile_X0Y2_FrameData[30] Tile_X0Y5_FrameStrobe[7] VPWR VGND sg13cmos5l_dlhq_1
XANTENNA__2179__D Tile_X0Y1_FrameData[13] VPWR VGND sg13cmos5l_antennanp
X_1417_ AXI_M_SOC_WDATA20 Tile_X0Y2_W1END[0] Tile_X0Y2_WW4END[12] Tile_X0Y2_WW4END[4]
+ _1058_/X _2319_/Q _2320_/Q VPWR VGND sg13cmos5l_mux4_1
XANTENNA__1125__A2 Tile_X0Y5_N4END[7] VPWR VGND sg13cmos5l_antennanp
X_2397_ _2397_/Q Tile_X0Y2_FrameData[3] Tile_X0Y5_FrameStrobe[4] VPWR VGND sg13cmos5l_dlhq_1
XANTENNA__2907__D Tile_X0Y4_FrameData[5] VPWR VGND sg13cmos5l_antennanp
XFILLER_113_37 VPWR VGND sg13cmos5l_decap_8
XFILLER_228_166 VPWR VGND sg13cmos5l_decap_8
X_1348_ _1348_/X _1174_/X _1346_/X _1347_/X _1173_/X _2524_/Q _2523_/Q VPWR VGND sg13cmos5l_mux4_1
XFILLER_95_182 VPWR VGND sg13cmos5l_decap_8
XANTENNA__1811__D Tile_X0Y0_FrameData[13] VPWR VGND sg13cmos5l_antennanp
XFILLER_28_249 VPWR VGND sg13cmos5l_decap_4
X_1279_ _3498_/A Tile_X0Y1_W2END[1] AXI_M_SOC_RDATA23 _1105_/X _1083_/X _2132_/Q _2131_/Q
+ VPWR VGND sg13cmos5l_mux4_1
X_3018_ _3018_/Q Tile_X0Y4_FrameData[22] Tile_X0Y5_FrameStrobe[7] VPWR VGND sg13cmos5l_dlhq_1
XANTENNA__3588__A Tile_X0Y0_FrameData[19] VPWR VGND sg13cmos5l_antennanp
XFILLER_36_293 VPWR VGND sg13cmos5l_fill_2
XFILLER_251_191 VPWR VGND sg13cmos5l_decap_8
XFILLER_269_30 VPWR VGND sg13cmos5l_fill_1
XANTENNA__2642__D Tile_X0Y3_FrameData[30] VPWR VGND sg13cmos5l_antennanp
XANTENNA__3052__GATE Tile_X0Y5_FrameStrobe[8] VPWR VGND sg13cmos5l_antennanp
XANTENNA__3875__X Tile_X0Y5_FrameData_O[16] VPWR VGND sg13cmos5l_antennanp
XFILLER_22_23 VPWR VGND sg13cmos5l_fill_1
XFILLER_338_273 VPWR VGND sg13cmos5l_fill_1
XFILLER_138_67 VPWR VGND sg13cmos5l_decap_4
XFILLER_164_143 VPWR VGND sg13cmos5l_decap_8
XFILLER_285_51 VPWR VGND sg13cmos5l_fill_2
XANTENNA__3067__GATE Tile_X0Y5_FrameStrobe[0] VPWR VGND sg13cmos5l_antennanp
XFILLER_164_187 VPWR VGND sg13cmos5l_decap_8
XFILLER_321_162 VPWR VGND sg13cmos5l_fill_1
XFILLER_321_140 VPWR VGND sg13cmos5l_fill_2
XANTENNA__2089__D Tile_X0Y1_FrameData[7] VPWR VGND sg13cmos5l_antennanp
XFILLER_120_235 VPWR VGND sg13cmos5l_decap_8
XFILLER_120_279 VPWR VGND sg13cmos5l_fill_1
XANTENNA__1667__A3 AXI_M_SOC_RDATA5 VPWR VGND sg13cmos5l_antennanp
XANTENNA__0875__A1 Tile_X0Y5_W2END[6] VPWR VGND sg13cmos5l_antennanp
XANTENNA__1721__D Tile_X0Y0_FrameData[7] VPWR VGND sg13cmos5l_antennanp
XANTENNA__2817__D Tile_X0Y4_FrameData[31] VPWR VGND sg13cmos5l_antennanp
XANTENNA__3005__GATE Tile_X0Y5_FrameStrobe[6] VPWR VGND sg13cmos5l_antennanp
XFILLER_170_43 VPWR VGND sg13cmos5l_decap_4
XFILLER_170_65 VPWR VGND sg13cmos5l_decap_8
XFILLER_219_199 VPWR VGND sg13cmos5l_decap_8
XFILLER_274_272 VPWR VGND sg13cmos5l_decap_4
XANTENNA__2261__GATE Tile_X0Y5_FrameStrobe[0] VPWR VGND sg13cmos5l_antennanp
XFILLER_256_0 VPWR VGND sg13cmos5l_fill_2
XFILLER_27_293 VPWR VGND sg13cmos5l_fill_2
XANTENNA__2891__GATE Tile_X0Y5_FrameStrobe[3] VPWR VGND sg13cmos5l_antennanp
XFILLER_187_213 VPWR VGND sg13cmos5l_decap_4
XFILLER_242_191 VPWR VGND sg13cmos5l_decap_8
XANTENNA__2552__D Tile_X0Y3_FrameData[24] VPWR VGND sg13cmos5l_antennanp
XANTENNA__3785__X Tile_X0Y4_FrameData_O[7] VPWR VGND sg13cmos5l_antennanp
XFILLER_63_96 VPWR VGND sg13cmos5l_fill_2
XFILLER_42_285 VPWR VGND sg13cmos5l_fill_2
XFILLER_329_11 VPWR VGND sg13cmos5l_fill_2
XFILLER_187_279 VPWR VGND sg13cmos5l_decap_4
XFILLER_8_36 VPWR VGND sg13cmos5l_fill_2
XFILLER_329_251 VPWR VGND sg13cmos5l_fill_2
XANTENNA__0921__Y AXI_M_SOC_AWBURST1 VPWR VGND sg13cmos5l_antennanp
XANTENNA__2276__GATE Tile_X0Y5_FrameStrobe[1] VPWR VGND sg13cmos5l_antennanp
XFILLER_195_73 VPWR VGND sg13cmos5l_fill_1
XFILLER_6_131 VPWR VGND sg13cmos5l_decap_8
XFILLER_170_113 VPWR VGND sg13cmos5l_decap_4
XFILLER_304_129 VPWR VGND sg13cmos5l_decap_8
X_0650_ _0650_/Y _0650_/A VPWR VGND sg13cmos5l_inv_1
X_0581_ _0581_/Y _2520_/Q _2519_/Q VPWR VGND sg13cmos5l_nor2b_1
XANTENNA__0563__A0 Tile_X0Y5_N2MID[7] VPWR VGND sg13cmos5l_antennanp
XANTENNA__1355__A2 Tile_X0Y5_N4END[12] VPWR VGND sg13cmos5l_antennanp
X_2320_ _2320_/Q Tile_X0Y2_FrameData[16] Tile_X0Y5_FrameStrobe[2] VPWR VGND sg13cmos5l_dlhq_1
X_2251_ _2251_/Q Tile_X0Y2_FrameData[21] Tile_X0Y5_FrameStrobe[0] VPWR VGND sg13cmos5l_dlhq_1
XANTENNA__1107__A2 Tile_X0Y3_W6END[7] VPWR VGND sg13cmos5l_antennanp
XANTENNA__2214__GATE Tile_X0Y5_FrameStrobe[7] VPWR VGND sg13cmos5l_antennanp
X_1202_ AXI_M_SOC_AWADDR16 Tile_X0Y0_WW4END[0] Tile_X0Y0_WW4END[8] Tile_X0Y0_W6END[8]
+ _1069_/X _1784_/Q _1783_/Q VPWR VGND sg13cmos5l_mux4_1
XANTENNA__2844__GATE Tile_X0Y5_FrameStrobe[1] VPWR VGND sg13cmos5l_antennanp
X_2182_ _2182_/Q Tile_X0Y1_FrameData[10] Tile_X0Y5_FrameStrobe[6] VPWR VGND sg13cmos5l_dlhq_1
XANTENNA__2727__D Tile_X0Y3_FrameData[9] VPWR VGND sg13cmos5l_antennanp
XFILLER_225_103 VPWR VGND sg13cmos5l_decap_4
X_1133_ _1133_/Y _3058_/Q _1133_/B _3329_/Q VPWR VGND sg13cmos5l_nand3b_1
X_1064_ _1064_/X _1062_/X _1063_/X _1070_/X _1073_/X _3032_/Q _3031_/Q VPWR VGND sg13cmos5l_mux4_1
XANTENNA__2229__GATE Tile_X0Y5_FrameStrobe[8] VPWR VGND sg13cmos5l_antennanp
XFILLER_18_293 VPWR VGND sg13cmos5l_fill_2
XFILLER_280_286 VPWR VGND sg13cmos5l_fill_1
XANTENNA__2859__GATE Tile_X0Y5_FrameStrobe[2] VPWR VGND sg13cmos5l_antennanp
XFILLER_178_202 VPWR VGND sg13cmos5l_decap_4
XFILLER_240_139 VPWR VGND sg13cmos5l_decap_4
XANTENNA__1291__A1 AXI_M_SOC_RDATA29 VPWR VGND sg13cmos5l_antennanp
XANTENNA__3695__X Tile_X0Y3_EE4BEG[14] VPWR VGND sg13cmos5l_antennanp
XFILLER_239_11 VPWR VGND sg13cmos5l_decap_4
XFILLER_33_274 VPWR VGND sg13cmos5l_decap_4
XANTENNA__2462__D Tile_X0Y2_FrameData[2] VPWR VGND sg13cmos5l_antennanp
X_1966_ _1966_/Q Tile_X0Y0_FrameData[18] Tile_X0Y5_FrameStrobe[8] VPWR VGND sg13cmos5l_dlhq_1
XANTENNA__1043__A1 Tile_X0Y2_W2END[2] VPWR VGND sg13cmos5l_antennanp
X_3705_ Tile_X0Y3_FrameData_O[8] Tile_X0Y3_FrameData[8] VPWR VGND sg13cmos5l_buf_1
X_0917_ _0917_/Y _3303_/Q _0913_/X _0916_/Y VPWR VGND sg13cmos5l_a21oi_1
XFILLER_146_143 VPWR VGND sg13cmos5l_decap_8
X_1897_ _1897_/Q Tile_X0Y0_FrameData[23] Tile_X0Y5_FrameStrobe[6] VPWR VGND sg13cmos5l_dlhq_1
XFILLER_335_232 VPWR VGND sg13cmos5l_fill_2
XFILLER_146_198 VPWR VGND sg13cmos5l_decap_8
X_3636_ Tile_X0Y0_E2BEGb[7] _3636_/A VPWR VGND sg13cmos5l_buf_1
X_0848_ _0848_/X Tile_X0Y5_W2MID[0] Tile_X0Y5_W2END[0] Tile_X0Y5_W6END[0] _0782_/X
+ _3128_/Q _3127_/Q VPWR VGND sg13cmos5l_mux4_1
XANTENNA__1806__D Tile_X0Y0_FrameData[18] VPWR VGND sg13cmos5l_antennanp
XANTENNA__3293__D Tile_X0Y5_FrameData[19] VPWR VGND sg13cmos5l_antennanp
XFILLER_108_48 VPWR VGND sg13cmos5l_decap_8
XFILLER_255_43 VPWR VGND sg13cmos5l_decap_8
X_3567_ Tile_X0Y0_FrameStrobe_O[18] Tile_X0Y5_FrameStrobe[18] VPWR VGND sg13cmos5l_buf_1
X_0779_ _3814_/A Tile_X0Y5_N1END[3] _0775_/X _1133_/B _0778_/X _3249_/Q _3250_/Q VPWR
+ VGND sg13cmos5l_mux4_1
XANTENNA__1346__A2 Tile_X0Y5_W6END[1] VPWR VGND sg13cmos5l_antennanp
XANTENNA__3871__A Tile_X0Y5_FrameData[12] VPWR VGND sg13cmos5l_antennanp
X_2518_ _2518_/Q Tile_X0Y3_FrameData[26] Tile_X0Y5_FrameStrobe[0] VPWR VGND sg13cmos5l_dlhq_1
X_3498_ Tile_X0Y1_E2BEGb[6] _3498_/A VPWR VGND sg13cmos5l_buf_1
XFILLER_102_246 VPWR VGND sg13cmos5l_fill_1
XFILLER_124_25 VPWR VGND sg13cmos5l_fill_1
X_2449_ _2449_/Q Tile_X0Y2_FrameData[15] Tile_X0Y5_FrameStrobe[6] VPWR VGND sg13cmos5l_dlhq_1
XFILLER_187_8 VPWR VGND sg13cmos5l_fill_2
XFILLER_271_75 VPWR VGND sg13cmos5l_fill_1
XFILLER_271_86 VPWR VGND sg13cmos5l_fill_1
XANTENNA__2637__D Tile_X0Y3_FrameData[3] VPWR VGND sg13cmos5l_antennanp
XFILLER_216_103 VPWR VGND sg13cmos5l_decap_4
XFILLER_83_130 VPWR VGND sg13cmos5l_decap_8
XFILLER_271_275 VPWR VGND sg13cmos5l_fill_2
XFILLER_83_196 VPWR VGND sg13cmos5l_decap_8
XANTENNA__1282__A1 AXI_M_SOC_RDATA26 VPWR VGND sg13cmos5l_antennanp
XFILLER_169_235 VPWR VGND sg13cmos5l_fill_2
XANTENNA__2372__D Tile_X0Y2_FrameData[28] VPWR VGND sg13cmos5l_antennanp
XFILLER_130_4 VPWR VGND sg13cmos5l_fill_1
XFILLER_149_22 VPWR VGND sg13cmos5l_decap_8
XFILLER_296_50 VPWR VGND sg13cmos5l_decap_8
XFILLER_149_88 VPWR VGND sg13cmos5l_decap_8
XFILLER_326_254 VPWR VGND sg13cmos5l_fill_1
XANTENNA__0793__A0 Tile_X0Y3_W2MID[4] VPWR VGND sg13cmos5l_antennanp
XANTENNA__1716__D Tile_X0Y0_FrameData[12] VPWR VGND sg13cmos5l_antennanp
XANTENNA__3781__A Tile_X0Y4_FrameData[3] VPWR VGND sg13cmos5l_antennanp
XFILLER_239_206 VPWR VGND sg13cmos5l_decap_8
XFILLER_58_41 VPWR VGND sg13cmos5l_decap_8
XANTENNA__0848__A1 Tile_X0Y5_W2END[0] VPWR VGND sg13cmos5l_antennanp
XANTENNA__2547__D Tile_X0Y3_FrameData[29] VPWR VGND sg13cmos5l_antennanp
XFILLER_247_261 VPWR VGND sg13cmos5l_fill_1
XFILLER_247_272 VPWR VGND sg13cmos5l_decap_8
XFILLER_74_141 VPWR VGND sg13cmos5l_fill_2
XFILLER_262_242 VPWR VGND sg13cmos5l_fill_2
XFILLER_331_45 VPWR VGND sg13cmos5l_fill_1
XANTENNA__1273__A1 AXI_M_SOC_RDATA25 VPWR VGND sg13cmos5l_antennanp
XFILLER_30_200 VPWR VGND sg13cmos5l_decap_8
XFILLER_30_211 VPWR VGND sg13cmos5l_fill_2
XANTENNA__2282__D Tile_X0Y2_FrameData[22] VPWR VGND sg13cmos5l_antennanp
XFILLER_230_172 VPWR VGND sg13cmos5l_decap_4
X_1820_ _1820_/Q Tile_X0Y0_FrameData[4] Tile_X0Y5_FrameStrobe[3] VPWR VGND sg13cmos5l_dlhq_1
XFILLER_175_238 VPWR VGND sg13cmos5l_decap_8
XFILLER_30_277 VPWR VGND sg13cmos5l_decap_4
XFILLER_128_143 VPWR VGND sg13cmos5l_decap_8
X_1751_ _1751_/Q Tile_X0Y0_FrameData[9] Tile_X0Y5_FrameStrobe[1] VPWR VGND sg13cmos5l_dlhq_1
XANTENNA__0784__A0 Tile_X0Y3_W2MID[6] VPWR VGND sg13cmos5l_antennanp
X_1682_ _3747_/A Tile_X0Y4_W2END[2] AXI_M_SOC_RDATA0 _1016_/X _1318_/X _2950_/Q _2949_/Q
+ VPWR VGND sg13cmos5l_mux4_1
X_0702_ _0702_/Y _0534_/Y _0701_/X _3260_/Q VPWR VGND sg13cmos5l_a21oi_1
XFILLER_332_213 VPWR VGND sg13cmos5l_fill_2
XFILLER_183_293 VPWR VGND sg13cmos5l_fill_2
XFILLER_289_117 VPWR VGND sg13cmos5l_fill_2
X_3421_ Tile_X0Y2_FrameData_O[23] Tile_X0Y2_FrameData[23] VPWR VGND sg13cmos5l_buf_1
X_0633_ _0633_/Y _2517_/Q _0633_/B _0633_/C VPWR VGND sg13cmos5l_nor3_1
X_3352_ Tile_X0Y2_E1BEG[2] _3352_/A VPWR VGND sg13cmos5l_buf_1
XFILLER_225_35 VPWR VGND sg13cmos5l_fill_2
X_2303_ _2303_/Q Tile_X0Y2_FrameData[1] Tile_X0Y5_FrameStrobe[1] VPWR VGND sg13cmos5l_dlhq_1
X_0564_ _3902_/A Tile_X0Y5_W1END[3] Tile_X0Y5_W2MID[0] Tile_X0Y5_W2END[0] _0563_/X
+ _3270_/Q _3269_/Q VPWR VGND sg13cmos5l_mux4_1
XFILLER_97_233 VPWR VGND sg13cmos5l_decap_8
XANTENNA__2153__GATE Tile_X0Y5_FrameStrobe[5] VPWR VGND sg13cmos5l_antennanp
XFILLER_300_143 VPWR VGND sg13cmos5l_decap_8
X_3283_ _3283_/Q Tile_X0Y5_FrameData[29] Tile_X0Y5_FrameStrobe[7] VPWR VGND sg13cmos5l_dlhq_1
XANTENNA__2783__GATE Tile_X0Y5_FrameStrobe[8] VPWR VGND sg13cmos5l_antennanp
XFILLER_300_154 VPWR VGND sg13cmos5l_fill_2
X_2234_ _2234_/Q Tile_X0Y1_FrameData[22] Tile_X0Y5_FrameStrobe[8] VPWR VGND sg13cmos5l_dlhq_1
XANTENNA__2457__D Tile_X0Y2_FrameData[7] VPWR VGND sg13cmos5l_antennanp
XFILLER_17_0 VPWR VGND sg13cmos5l_fill_2
XFILLER_241_23 VPWR VGND sg13cmos5l_decap_8
X_2165_ _2165_/Q Tile_X0Y1_FrameData[27] Tile_X0Y5_FrameStrobe[6] VPWR VGND sg13cmos5l_dlhq_1
XANTENNA__2168__GATE Tile_X0Y5_FrameStrobe[6] VPWR VGND sg13cmos5l_antennanp
X_1116_ _3546_/A Tile_X0Y0_W1END[1] Tile_X0Y0_W6END[5] _1041_/X _0616_/Y _1966_/Q
+ _1965_/Q VPWR VGND sg13cmos5l_mux4_1
XANTENNA__2798__GATE Tile_X0Y5_FrameStrobe[0] VPWR VGND sg13cmos5l_antennanp
X_2096_ _2096_/Q Tile_X0Y1_FrameData[0] Tile_X0Y5_FrameStrobe[3] VPWR VGND sg13cmos5l_dlhq_1
X_1047_ _1047_/X Tile_X0Y2_W2MID[6] Tile_X0Y2_W2END[6] Tile_X0Y2_W6END[9] _1143_/X
+ _2466_/Q _2465_/Q VPWR VGND sg13cmos5l_mux4_1
XANTENNA__1264__A1 AXI_M_SOC_RDATA31 VPWR VGND sg13cmos5l_antennanp
XANTENNA__3288__D Tile_X0Y5_FrameData[24] VPWR VGND sg13cmos5l_antennanp
XFILLER_80_188 VPWR VGND sg13cmos5l_decap_8
XANTENNA__2192__D Tile_X0Y1_FrameData[0] VPWR VGND sg13cmos5l_antennanp
XANTENNA__2721__GATE Tile_X0Y5_FrameStrobe[6] VPWR VGND sg13cmos5l_antennanp
XANTENNA__3866__A Tile_X0Y5_FrameData[7] VPWR VGND sg13cmos5l_antennanp
XFILLER_119_110 VPWR VGND sg13cmos5l_decap_8
XFILLER_166_238 VPWR VGND sg13cmos5l_fill_1
X_2998_ _2998_/Q Tile_X0Y4_FrameData[10] Tile_X0Y5_FrameStrobe[6] VPWR VGND sg13cmos5l_dlhq_1
XANTENNA__2920__D Tile_X0Y4_FrameData[24] VPWR VGND sg13cmos5l_antennanp
X_1949_ _1949_/Q Tile_X0Y0_FrameData[3] Tile_X0Y5_FrameStrobe[7] VPWR VGND sg13cmos5l_dlhq_1
XANTENNA__2106__GATE Tile_X0Y5_FrameStrobe[4] VPWR VGND sg13cmos5l_antennanp
XFILLER_119_47 VPWR VGND sg13cmos5l_decap_8
XFILLER_308_254 VPWR VGND sg13cmos5l_decap_4
XANTENNA__2736__GATE Tile_X0Y5_FrameStrobe[6] VPWR VGND sg13cmos5l_antennanp
XFILLER_174_293 VPWR VGND sg13cmos5l_fill_2
XFILLER_266_97 VPWR VGND sg13cmos5l_decap_4
X_3619_ Tile_X0Y0_E6BEG[2] _3619_/A VPWR VGND sg13cmos5l_buf_1
XFILLER_323_224 VPWR VGND sg13cmos5l_fill_1
XANTENNA__1319__A2 Tile_X0Y5_N2MID[4] VPWR VGND sg13cmos5l_antennanp
XANTENNA__1992__GATE Tile_X0Y5_FrameStrobe[0] VPWR VGND sg13cmos5l_antennanp
XFILLER_88_211 VPWR VGND sg13cmos5l_decap_8
XFILLER_288_183 VPWR VGND sg13cmos5l_decap_8
XFILLER_95_28 VPWR VGND sg13cmos5l_decap_8
XFILLER_48_119 VPWR VGND sg13cmos5l_decap_8
XANTENNA__2367__D Tile_X0Y2_FrameData[1] VPWR VGND sg13cmos5l_antennanp
XFILLER_28_99 VPWR VGND sg13cmos5l_decap_8
XFILLER_56_163 VPWR VGND sg13cmos5l_decap_8
XANTENNA__1930__GATE Tile_X0Y5_FrameStrobe[7] VPWR VGND sg13cmos5l_antennanp
XFILLER_204_139 VPWR VGND sg13cmos5l_decap_8
XFILLER_301_59 VPWR VGND sg13cmos5l_decap_8
XANTENNA__1255__A1 AXI_M_SOC_BRESP1 VPWR VGND sg13cmos5l_antennanp
XANTENNA__3198__D Tile_X0Y5_FrameData[18] VPWR VGND sg13cmos5l_antennanp
XFILLER_100_60 VPWR VGND sg13cmos5l_decap_8
XANTENNA__1945__GATE Tile_X0Y5_FrameStrobe[7] VPWR VGND sg13cmos5l_antennanp
XANTENNA__2830__D Tile_X0Y4_FrameData[18] VPWR VGND sg13cmos5l_antennanp
XFILLER_121_0 VPWR VGND sg13cmos5l_fill_2
XFILLER_176_20 VPWR VGND sg13cmos5l_decap_4
XANTENNA__0766__A0 Tile_X0Y5_N1END[1] VPWR VGND sg13cmos5l_antennanp
XANTENNA__1558__A2 Tile_X0Y3_W6END[7] VPWR VGND sg13cmos5l_antennanp
XFILLER_219_0 VPWR VGND sg13cmos5l_fill_2
XFILLER_125_135 VPWR VGND sg13cmos5l_decap_8
XFILLER_125_146 VPWR VGND sg13cmos5l_fill_1
XFILLER_165_293 VPWR VGND sg13cmos5l_fill_2
XFILLER_326_12 VPWR VGND sg13cmos5l_fill_2
XFILLER_140_138 VPWR VGND sg13cmos5l_decap_8
XFILLER_286_109 VPWR VGND sg13cmos5l_fill_1
XFILLER_279_172 VPWR VGND sg13cmos5l_fill_1
XFILLER_94_214 VPWR VGND sg13cmos5l_fill_1
XANTENNA__2277__D Tile_X0Y2_FrameData[27] VPWR VGND sg13cmos5l_antennanp
XFILLER_47_196 VPWR VGND sg13cmos5l_fill_2
XFILLER_62_166 VPWR VGND sg13cmos5l_decap_8
X_2921_ _2921_/Q Tile_X0Y4_FrameData[23] Tile_X0Y5_FrameStrobe[4] VPWR VGND sg13cmos5l_dlhq_1
X_2852_ _2852_/Q Tile_X0Y4_FrameData[28] Tile_X0Y5_FrameStrobe[2] VPWR VGND sg13cmos5l_dlhq_1
X_2783_ _2783_/Q Tile_X0Y3_FrameData[17] Tile_X0Y5_FrameStrobe[8] VPWR VGND sg13cmos5l_dlhq_1
X_1803_ _1803_/Q Tile_X0Y0_FrameData[21] Tile_X0Y5_FrameStrobe[3] VPWR VGND sg13cmos5l_dlhq_1
XANTENNA__0757__A0 Tile_X0Y5_WW4END[0] VPWR VGND sg13cmos5l_antennanp
XANTENNA__1549__A2 Tile_X0Y3_W6END[3] VPWR VGND sg13cmos5l_antennanp
XANTENNA__2740__D Tile_X0Y3_FrameData[28] VPWR VGND sg13cmos5l_antennanp
X_1734_ _1734_/Q Tile_X0Y0_FrameData[26] Tile_X0Y5_FrameStrobe[1] VPWR VGND sg13cmos5l_dlhq_1
XFILLER_156_293 VPWR VGND sg13cmos5l_fill_2
XFILLER_236_12 VPWR VGND sg13cmos5l_decap_8
X_3404_ Tile_X0Y2_FrameData_O[6] Tile_X0Y2_FrameData[6] VPWR VGND sg13cmos5l_buf_1
X_1665_ _1665_/X Tile_X0Y4_W1END[3] Tile_X0Y4_W6END[7] Tile_X0Y4_WW4END[15] _0981_/X
+ _2986_/Q _2987_/Q VPWR VGND sg13cmos5l_mux4_1
XANTENNA__2092__GATE Tile_X0Y5_FrameStrobe[3] VPWR VGND sg13cmos5l_antennanp
XFILLER_131_116 VPWR VGND sg13cmos5l_decap_4
XFILLER_131_138 VPWR VGND sg13cmos5l_decap_8
XFILLER_236_89 VPWR VGND sg13cmos5l_fill_1
X_1596_ _1596_/Y _2716_/Q _1596_/B VPWR VGND sg13cmos5l_nand2b_1
X_0616_ _0616_/Y _0541_/Y _1702_/Q _1701_/Q _0614_/Y _0615_/Y VPWR VGND sg13cmos5l_a221oi_1
XANTENNA__1182__A0 Tile_X0Y4_W2MID[2] VPWR VGND sg13cmos5l_antennanp
X_3335_ _3335_/Q Tile_X0Y5_FrameData[1] Tile_X0Y5_FrameStrobe[8] VPWR VGND sg13cmos5l_dlhq_1
X_0547_ _0547_/Y _3303_/Q VPWR VGND sg13cmos5l_inv_1
X_3266_ _3266_/Q Tile_X0Y5_FrameData[14] Tile_X0Y5_FrameStrobe[6] VPWR VGND sg13cmos5l_dlhq_1
XANTENNA__0837__X AXI_M_SOC_ARVALID VPWR VGND sg13cmos5l_antennanp
XANTENNA__2187__D Tile_X0Y1_FrameData[5] VPWR VGND sg13cmos5l_antennanp
X_2217_ _2217_/Q Tile_X0Y1_FrameData[7] Tile_X0Y5_FrameStrobe[7] VPWR VGND sg13cmos5l_dlhq_1
XFILLER_226_220 VPWR VGND sg13cmos5l_fill_1
XFILLER_226_242 VPWR VGND sg13cmos5l_decap_4
XFILLER_252_88 VPWR VGND sg13cmos5l_decap_8
X_3197_ _3197_/Q Tile_X0Y5_FrameData[19] Tile_X0Y5_FrameStrobe[4] VPWR VGND sg13cmos5l_dlhq_1
XFILLER_226_253 VPWR VGND sg13cmos5l_decap_4
X_2148_ _2148_/Q Tile_X0Y1_FrameData[12] Tile_X0Y5_FrameStrobe[5] VPWR VGND sg13cmos5l_dlhq_1
XFILLER_38_174 VPWR VGND sg13cmos5l_decap_8
XANTENNA__2030__GATE Tile_X0Y5_FrameStrobe[1] VPWR VGND sg13cmos5l_antennanp
XANTENNA__2915__D Tile_X0Y4_FrameData[29] VPWR VGND sg13cmos5l_antennanp
X_2079_ _2079_/Q Tile_X0Y1_FrameData[17] Tile_X0Y5_FrameStrobe[3] VPWR VGND sg13cmos5l_dlhq_1
XFILLER_53_144 VPWR VGND sg13cmos5l_decap_8
XANTENNA__1237__A1 AXI_M_SOC_BRESP1 VPWR VGND sg13cmos5l_antennanp
XANTENNA__2660__GATE Tile_X0Y5_FrameStrobe[4] VPWR VGND sg13cmos5l_antennanp
XFILLER_201_109 VPWR VGND sg13cmos5l_decap_8
XANTENNA__3596__A Tile_X0Y0_FrameData[27] VPWR VGND sg13cmos5l_antennanp
XFILLER_197_19 VPWR VGND sg13cmos5l_decap_8
XFILLER_201_92 VPWR VGND sg13cmos5l_fill_1
XANTENNA__2045__GATE Tile_X0Y5_FrameStrobe[2] VPWR VGND sg13cmos5l_antennanp
XANTENNA__3883__X Tile_X0Y5_FrameData_O[24] VPWR VGND sg13cmos5l_antennanp
XFILLER_317_8 VPWR VGND sg13cmos5l_fill_1
XANTENNA__2650__D Tile_X0Y3_FrameData[22] VPWR VGND sg13cmos5l_antennanp
XANTENNA__2675__GATE Tile_X0Y5_FrameStrobe[5] VPWR VGND sg13cmos5l_antennanp
XFILLER_146_23 VPWR VGND sg13cmos5l_decap_8
XFILLER_147_293 VPWR VGND sg13cmos5l_fill_2
XFILLER_107_168 VPWR VGND sg13cmos5l_decap_8
XFILLER_30_89 VPWR VGND sg13cmos5l_fill_2
XFILLER_122_116 VPWR VGND sg13cmos5l_fill_1
XFILLER_122_138 VPWR VGND sg13cmos5l_decap_8
XFILLER_311_216 VPWR VGND sg13cmos5l_fill_2
XANTENNA__1173__A0 Tile_X0Y1_W1END[2] VPWR VGND sg13cmos5l_antennanp
XFILLER_39_32 VPWR VGND sg13cmos5l_decap_8
XFILLER_276_131 VPWR VGND sg13cmos5l_fill_2
XANTENNA__0920__A0 Tile_X0Y1_WW4END[4] VPWR VGND sg13cmos5l_antennanp
XANTENNA__2097__D Tile_X0Y1_FrameData[31] VPWR VGND sg13cmos5l_antennanp
XANTENNA__2613__GATE Tile_X0Y5_FrameStrobe[3] VPWR VGND sg13cmos5l_antennanp
XFILLER_130_193 VPWR VGND sg13cmos5l_decap_8
XFILLER_162_66 VPWR VGND sg13cmos5l_decap_8
XFILLER_76_258 VPWR VGND sg13cmos5l_decap_4
XFILLER_217_220 VPWR VGND sg13cmos5l_decap_8
XFILLER_55_42 VPWR VGND sg13cmos5l_decap_8
XANTENNA__2825__D Tile_X0Y4_FrameData[23] VPWR VGND sg13cmos5l_antennanp
XFILLER_169_0 VPWR VGND sg13cmos5l_fill_2
XANTENNA__2628__GATE Tile_X0Y5_FrameStrobe[3] VPWR VGND sg13cmos5l_antennanp
XFILLER_336_0 VPWR VGND sg13cmos5l_fill_2
XANTENNA__0987__A0 Tile_X0Y4_W1END[2] VPWR VGND sg13cmos5l_antennanp
XANTENNA__1884__GATE Tile_X0Y5_FrameStrobe[5] VPWR VGND sg13cmos5l_antennanp
XFILLER_71_63 VPWR VGND sg13cmos5l_decap_8
XANTENNA__2560__D Tile_X0Y3_FrameData[16] VPWR VGND sg13cmos5l_antennanp
XANTENNA__3793__X Tile_X0Y4_FrameData_O[15] VPWR VGND sg13cmos5l_antennanp
XFILLER_145_219 VPWR VGND sg13cmos5l_decap_4
XFILLER_138_293 VPWR VGND sg13cmos5l_fill_2
XFILLER_65_8 VPWR VGND sg13cmos5l_decap_8
XANTENNA__1899__GATE Tile_X0Y5_FrameStrobe[6] VPWR VGND sg13cmos5l_antennanp
XFILLER_299_278 VPWR VGND sg13cmos5l_fill_1
X_1450_ _3383_/A Tile_X0Y2_WW4END[14] _0976_/X AXI_M_SOC_RDATA15 _1175_/X _2397_/Q
+ _2398_/Q VPWR VGND sg13cmos5l_mux4_1
XANTENNA__1164__A0 Tile_X0Y0_W1END[2] VPWR VGND sg13cmos5l_antennanp
XANTENNA__1904__D Tile_X0Y0_FrameData[16] VPWR VGND sg13cmos5l_antennanp
XFILLER_206_48 VPWR VGND sg13cmos5l_fill_2
X_1381_ _1382_/B Tile_X0Y2_W1END[2] Tile_X0Y2_W6END[10] Tile_X0Y2_WW4END[2] _1380_/X
+ _2481_/Q _2482_/Q VPWR VGND sg13cmos5l_mux4_1
XANTENNA__1822__GATE Tile_X0Y5_FrameStrobe[3] VPWR VGND sg13cmos5l_antennanp
X_3120_ _3120_/Q Tile_X0Y5_FrameData[0] Tile_X0Y5_FrameStrobe[1] VPWR VGND sg13cmos5l_dlhq_1
XFILLER_67_214 VPWR VGND sg13cmos5l_decap_8
XANTENNA__0911__A0 Tile_X0Y5_W1END[0] VPWR VGND sg13cmos5l_antennanp
XFILLER_310_293 VPWR VGND sg13cmos5l_fill_2
XFILLER_267_197 VPWR VGND sg13cmos5l_decap_4
XFILLER_282_134 VPWR VGND sg13cmos5l_fill_2
X_3051_ _3051_/Q Tile_X0Y4_FrameData[21] Tile_X0Y5_FrameStrobe[8] VPWR VGND sg13cmos5l_dlhq_1
XFILLER_67_269 VPWR VGND sg13cmos5l_fill_1
XANTENNA__1467__A1 AXI_M_SOC_RDATA21 VPWR VGND sg13cmos5l_antennanp
XANTENNA__1837__GATE Tile_X0Y5_FrameStrobe[4] VPWR VGND sg13cmos5l_antennanp
XFILLER_208_253 VPWR VGND sg13cmos5l_decap_4
X_2002_ _2002_/Q Tile_X0Y1_FrameData[30] Tile_X0Y5_FrameStrobe[1] VPWR VGND sg13cmos5l_dlhq_1
XANTENNA__2735__D Tile_X0Y3_FrameData[1] VPWR VGND sg13cmos5l_antennanp
XFILLER_223_234 VPWR VGND sg13cmos5l_fill_1
XFILLER_35_155 VPWR VGND sg13cmos5l_decap_4
XFILLER_50_114 VPWR VGND sg13cmos5l_decap_8
XANTENNA__0690__A2 Tile_X0Y4_W6END[10] VPWR VGND sg13cmos5l_antennanp
XANTENNA__0978__A0 Tile_X0Y0_W6END[7] VPWR VGND sg13cmos5l_antennanp
XFILLER_188_160 VPWR VGND sg13cmos5l_decap_8
X_2904_ _2904_/Q Tile_X0Y4_FrameData[8] Tile_X0Y5_FrameStrobe[3] VPWR VGND sg13cmos5l_dlhq_1
X_3884_ Tile_X0Y5_FrameData_O[25] Tile_X0Y5_FrameData[25] VPWR VGND sg13cmos5l_buf_1
X_2835_ _2835_/Q Tile_X0Y4_FrameData[13] Tile_X0Y5_FrameStrobe[1] VPWR VGND sg13cmos5l_dlhq_1
XFILLER_84_0 VPWR VGND sg13cmos5l_decap_4
XANTENNA__2470__D Tile_X0Y2_FrameData[26] VPWR VGND sg13cmos5l_antennanp
XFILLER_136_219 VPWR VGND sg13cmos5l_decap_8
X_2766_ _2766_/Q Tile_X0Y3_FrameData[2] Tile_X0Y5_FrameStrobe[7] VPWR VGND sg13cmos5l_dlhq_1
X_2697_ _2697_/Q Tile_X0Y3_FrameData[7] Tile_X0Y5_FrameStrobe[5] VPWR VGND sg13cmos5l_dlhq_1
X_1717_ _1717_/Q Tile_X0Y0_FrameData[11] Tile_X0Y5_FrameStrobe[0] VPWR VGND sg13cmos5l_dlhq_1
X_1648_ AXI_M_SOC_ARADDR18 Tile_X0Y4_W2MID[2] Tile_X0Y4_W2END[2] Tile_X0Y4_W6END[2]
+ _1016_/X _2852_/Q _2851_/Q VPWR VGND sg13cmos5l_mux4_1
XANTENNA__1155__A0 Tile_X0Y1_W2MID[7] VPWR VGND sg13cmos5l_antennanp
XANTENNA__1814__D Tile_X0Y0_FrameData[10] VPWR VGND sg13cmos5l_antennanp
XFILLER_258_142 VPWR VGND sg13cmos5l_fill_2
X_3318_ _3318_/Q Tile_X0Y5_FrameData[26] Tile_X0Y5_FrameStrobe[8] VPWR VGND sg13cmos5l_dlhq_1
X_1579_ _1579_/X _1434_/X _1512_/X _0888_/X _1216_/X _2754_/Q _2753_/Q VPWR VGND sg13cmos5l_mux4_1
XFILLER_301_293 VPWR VGND sg13cmos5l_fill_2
XFILLER_58_236 VPWR VGND sg13cmos5l_fill_2
XANTENNA__3343__GATE Tile_X0Y5_FrameStrobe[8] VPWR VGND sg13cmos5l_antennanp
X_3249_ _3249_/Q Tile_X0Y5_FrameData[31] Tile_X0Y5_FrameStrobe[6] VPWR VGND sg13cmos5l_dlhq_1
XANTENNA__1458__A1 AXI_M_SOC_RDATA19 VPWR VGND sg13cmos5l_antennanp
XANTENNA__2645__D Tile_X0Y3_FrameData[27] VPWR VGND sg13cmos5l_antennanp
XANTENNA__3878__X Tile_X0Y5_FrameData_O[19] VPWR VGND sg13cmos5l_antennanp
XFILLER_273_189 VPWR VGND sg13cmos5l_fill_2
XANTENNA__0969__A0 Tile_X0Y1_W1END[3] VPWR VGND sg13cmos5l_antennanp
XFILLER_328_113 VPWR VGND sg13cmos5l_fill_2
XANTENNA__2380__D Tile_X0Y2_FrameData[20] VPWR VGND sg13cmos5l_antennanp
XFILLER_194_185 VPWR VGND sg13cmos5l_decap_8
XFILLER_41_55 VPWR VGND sg13cmos5l_decap_8
XFILLER_328_157 VPWR VGND sg13cmos5l_decap_4
XFILLER_150_200 VPWR VGND sg13cmos5l_decap_8
XANTENNA__1146__A0 Tile_X0Y0_W2MID[4] VPWR VGND sg13cmos5l_antennanp
XANTENNA__1724__D Tile_X0Y0_FrameData[4] VPWR VGND sg13cmos5l_antennanp
XFILLER_173_65 VPWR VGND sg13cmos5l_decap_8
XANTENNA__1697__A1 Tile_X0Y5_W6END[8] VPWR VGND sg13cmos5l_antennanp
XANTENNA__2552__GATE Tile_X0Y5_FrameStrobe[1] VPWR VGND sg13cmos5l_antennanp
XFILLER_249_164 VPWR VGND sg13cmos5l_fill_2
XFILLER_286_0 VPWR VGND sg13cmos5l_decap_8
XFILLER_66_41 VPWR VGND sg13cmos5l_decap_8
XANTENNA__1449__A1 AXI_M_SOC_RDATA21 VPWR VGND sg13cmos5l_antennanp
XANTENNA__2555__D Tile_X0Y3_FrameData[21] VPWR VGND sg13cmos5l_antennanp
XANTENNA__2567__GATE Tile_X0Y5_FrameStrobe[1] VPWR VGND sg13cmos5l_antennanp
XANTENNA__3788__X Tile_X0Y4_FrameData_O[10] VPWR VGND sg13cmos5l_antennanp
XFILLER_17_133 VPWR VGND sg13cmos5l_decap_4
XFILLER_17_155 VPWR VGND sg13cmos5l_decap_8
XFILLER_122_91 VPWR VGND sg13cmos5l_fill_1
XFILLER_72_261 VPWR VGND sg13cmos5l_fill_2
XANTENNA__0672__A2 Tile_X0Y1_W6END[10] VPWR VGND sg13cmos5l_antennanp
XFILLER_32_125 VPWR VGND sg13cmos5l_decap_8
X_0950_ _0950_/X _1139_/X _0617_/X _0926_/X Tile_X0Y0_S4END[5] _2005_/Q _2006_/Q VPWR
+ VGND sg13cmos5l_mux4_1
XFILLER_319_102 VPWR VGND sg13cmos5l_fill_1
XANTENNA__1621__A1 AXI_M_SOC_RDATA0 VPWR VGND sg13cmos5l_antennanp
XFILLER_40_180 VPWR VGND sg13cmos5l_decap_8
XANTENNA__2290__D Tile_X0Y2_FrameData[14] VPWR VGND sg13cmos5l_antennanp
X_2620_ _2620_/Q Tile_X0Y3_FrameData[20] Tile_X0Y5_FrameStrobe[3] VPWR VGND sg13cmos5l_dlhq_1
X_0881_ AXI_M_SOC_ARLEN7 _3113_/Q _0878_/Y _0879_/Y _0880_/Y _3332_/Q VPWR VGND sg13cmos5l_a221oi_1
XANTENNA__2505__GATE Tile_X0Y5_FrameStrobe[8] VPWR VGND sg13cmos5l_antennanp
X_2551_ _2551_/Q Tile_X0Y3_FrameData[25] Tile_X0Y5_FrameStrobe[1] VPWR VGND sg13cmos5l_dlhq_1
X_2482_ _2482_/Q Tile_X0Y2_FrameData[14] Tile_X0Y5_FrameStrobe[7] VPWR VGND sg13cmos5l_dlhq_1
X_1502_ _3661_/A Tile_X0Y3_W2END[7] AXI_M_SOC_RDATA13 _1267_/X _1351_/X _2688_/Q _2687_/Q
+ VPWR VGND sg13cmos5l_mux4_1
XANTENNA__1761__GATE Tile_X0Y5_FrameStrobe[2] VPWR VGND sg13cmos5l_antennanp
X_1433_ AXI_M_SOC_WDATA25 Tile_X0Y2_W2MID[1] Tile_X0Y2_W2END[1] Tile_X0Y2_W6END[1]
+ _1143_/X _2310_/Q _2309_/Q VPWR VGND sg13cmos5l_mux4_1
XFILLER_233_24 VPWR VGND sg13cmos5l_fill_1
X_1364_ _1364_/Y _2452_/Q _0549_/Y _2451_/Q VPWR VGND sg13cmos5l_o21ai_1
XANTENNA__1776__GATE Tile_X0Y5_FrameStrobe[2] VPWR VGND sg13cmos5l_antennanp
X_3103_ _3103_/Q Tile_X0Y5_FrameData[17] Tile_X0Y5_FrameStrobe[1] VPWR VGND sg13cmos5l_dlhq_1
X_1295_ _3486_/A AXI_M_SOC_RDATA24 _0927_/X _0950_/X _1100_/X _2084_/Q _2083_/Q VPWR
+ VGND sg13cmos5l_mux4_1
XFILLER_255_167 VPWR VGND sg13cmos5l_decap_4
X_3034_ _3034_/Q Tile_X0Y4_FrameData[6] Tile_X0Y5_FrameStrobe[7] VPWR VGND sg13cmos5l_dlhq_1
XFILLER_55_217 VPWR VGND sg13cmos5l_decap_8
XANTENNA__2465__D Tile_X0Y2_FrameData[31] VPWR VGND sg13cmos5l_antennanp
XANTENNA__3698__X Tile_X0Y3_FrameData_O[1] VPWR VGND sg13cmos5l_antennanp
XFILLER_313_90 VPWR VGND sg13cmos5l_decap_8
XFILLER_23_147 VPWR VGND sg13cmos5l_decap_4
XFILLER_258_43 VPWR VGND sg13cmos5l_fill_2
XANTENNA__1714__GATE Tile_X0Y5_FrameStrobe[0] VPWR VGND sg13cmos5l_antennanp
XANTENNA__1809__D Tile_X0Y0_FrameData[15] VPWR VGND sg13cmos5l_antennanp
XANTENNA__3296__D Tile_X0Y5_FrameData[16] VPWR VGND sg13cmos5l_antennanp
XANTENNA__3874__A Tile_X0Y5_FrameData[15] VPWR VGND sg13cmos5l_antennanp
X_3867_ Tile_X0Y5_FrameData_O[8] Tile_X0Y5_FrameData[8] VPWR VGND sg13cmos5l_buf_1
X_2818_ _2818_/Q Tile_X0Y4_FrameData[30] Tile_X0Y5_FrameStrobe[1] VPWR VGND sg13cmos5l_dlhq_1
X_3798_ Tile_X0Y4_FrameData_O[20] Tile_X0Y4_FrameData[20] VPWR VGND sg13cmos5l_buf_1
XFILLER_325_116 VPWR VGND sg13cmos5l_decap_8
XFILLER_11_58 VPWR VGND sg13cmos5l_decap_8
XFILLER_191_166 VPWR VGND sg13cmos5l_decap_8
X_2749_ _2749_/Q Tile_X0Y3_FrameData[19] Tile_X0Y5_FrameStrobe[7] VPWR VGND sg13cmos5l_dlhq_1
XFILLER_11_69 VPWR VGND sg13cmos5l_fill_1
XFILLER_191_199 VPWR VGND sg13cmos5l_fill_1
XFILLER_333_171 VPWR VGND sg13cmos5l_fill_1
XANTENNA__1729__GATE Tile_X0Y5_FrameStrobe[1] VPWR VGND sg13cmos5l_antennanp
XFILLER_132_255 VPWR VGND sg13cmos5l_decap_8
XFILLER_278_237 VPWR VGND sg13cmos5l_decap_8
XANTENNA__1128__A0 Tile_X0Y2_W2MID[4] VPWR VGND sg13cmos5l_antennanp
XANTENNA__1679__A1 AXI_M_SOC_RRESP0 VPWR VGND sg13cmos5l_antennanp
XANTENNA__3282__GATE Tile_X0Y5_FrameStrobe[7] VPWR VGND sg13cmos5l_antennanp
XFILLER_143_79 VPWR VGND sg13cmos5l_decap_8
XANTENNA__2375__D Tile_X0Y2_FrameData[25] VPWR VGND sg13cmos5l_antennanp
XFILLER_246_189 VPWR VGND sg13cmos5l_fill_1
XANTENNA__1300__A0 Tile_X0Y1_W2MID[1] VPWR VGND sg13cmos5l_antennanp
XANTENNA__3297__GATE Tile_X0Y5_FrameStrobe[7] VPWR VGND sg13cmos5l_antennanp
XANTENNA__3401__X Tile_X0Y2_FrameData_O[3] VPWR VGND sg13cmos5l_antennanp
XFILLER_61_209 VPWR VGND sg13cmos5l_fill_1
XANTENNA__0654__A2 Tile_X0Y4_W2END[2] VPWR VGND sg13cmos5l_antennanp
XFILLER_52_21 VPWR VGND sg13cmos5l_decap_8
XANTENNA__1603__A1 Tile_X0Y3_W6END[8] VPWR VGND sg13cmos5l_antennanp
XANTENNA__3220__GATE Tile_X0Y5_FrameStrobe[5] VPWR VGND sg13cmos5l_antennanp
XANTENNA__1719__D Tile_X0Y0_FrameData[9] VPWR VGND sg13cmos5l_antennanp
XANTENNA__3784__A Tile_X0Y4_FrameData[6] VPWR VGND sg13cmos5l_antennanp
XFILLER_167_185 VPWR VGND sg13cmos5l_decap_4
XFILLER_182_133 VPWR VGND sg13cmos5l_decap_8
XFILLER_318_35 VPWR VGND sg13cmos5l_decap_4
XFILLER_108_230 VPWR VGND sg13cmos5l_decap_4
XFILLER_182_144 VPWR VGND sg13cmos5l_fill_2
XANTENNA__3235__GATE Tile_X0Y5_FrameStrobe[5] VPWR VGND sg13cmos5l_antennanp
XFILLER_201_0 VPWR VGND sg13cmos5l_fill_2
XFILLER_123_244 VPWR VGND sg13cmos5l_fill_1
XANTENNA__1119__A0 Tile_X0Y4_W1END[3] VPWR VGND sg13cmos5l_antennanp
XANTENNA__2491__GATE Tile_X0Y5_FrameStrobe[7] VPWR VGND sg13cmos5l_antennanp
XFILLER_96_117 VPWR VGND sg13cmos5l_decap_8
XFILLER_77_51 VPWR VGND sg13cmos5l_decap_8
XFILLER_203_38 VPWR VGND sg13cmos5l_decap_8
XANTENNA__2285__D Tile_X0Y2_FrameData[19] VPWR VGND sg13cmos5l_antennanp
XFILLER_252_115 VPWR VGND sg13cmos5l_fill_1
X_1080_ _1080_/X _0986_/X _0984_/X Tile_X0Y0_S1END[3] Tile_X0Y0_S4END[3] _1746_/Q
+ _1745_/Q VPWR VGND sg13cmos5l_mux4_1
X_1982_ _1982_/Q Tile_X0Y1_FrameData[18] Tile_X0Y5_FrameStrobe[0] VPWR VGND sg13cmos5l_dlhq_1
X_3721_ Tile_X0Y3_FrameData_O[24] Tile_X0Y3_FrameData[24] VPWR VGND sg13cmos5l_buf_1
X_0933_ _0933_/X Tile_X0Y5_W1END[2] Tile_X0Y5_WW4END[2] _3298_/Q VPWR VGND sg13cmos5l_mux2_1
XANTENNA__1070__A2 Tile_X0Y5_N4END[4] VPWR VGND sg13cmos5l_antennanp
XANTENNA__2444__GATE Tile_X0Y5_FrameStrobe[6] VPWR VGND sg13cmos5l_antennanp
XFILLER_173_100 VPWR VGND sg13cmos5l_decap_8
X_3652_ Tile_X0Y3_E1BEG[3] _3652_/A VPWR VGND sg13cmos5l_buf_1
X_0864_ _0864_/Y _3120_/Q Tile_X0Y5_W2MID[4] VPWR VGND sg13cmos5l_nand2b_1
XFILLER_9_173 VPWR VGND sg13cmos5l_decap_8
XANTENNA__1358__A0 Tile_X0Y2_W1END[0] VPWR VGND sg13cmos5l_antennanp
X_2603_ _2603_/Q Tile_X0Y3_FrameData[5] Tile_X0Y5_FrameStrobe[2] VPWR VGND sg13cmos5l_dlhq_1
X_3583_ Tile_X0Y0_FrameData_O[14] Tile_X0Y0_FrameData[14] VPWR VGND sg13cmos5l_buf_1
X_2534_ _2534_/Q Tile_X0Y3_FrameData[10] Tile_X0Y5_FrameStrobe[0] VPWR VGND sg13cmos5l_dlhq_1
X_0795_ _3818_/A Tile_X0Y5_W2MID[4] _0759_/X _0794_/X _0607_/X _3242_/Q _3241_/Q VPWR
+ VGND sg13cmos5l_mux4_1
XFILLER_322_119 VPWR VGND sg13cmos5l_fill_1
XANTENNA__2459__GATE Tile_X0Y5_FrameStrobe[6] VPWR VGND sg13cmos5l_antennanp
XFILLER_47_0 VPWR VGND sg13cmos5l_decap_8
X_2465_ _2465_/Q Tile_X0Y2_FrameData[31] Tile_X0Y5_FrameStrobe[7] VPWR VGND sg13cmos5l_dlhq_1
XFILLER_275_207 VPWR VGND sg13cmos5l_fill_2
X_2396_ _2396_/Q Tile_X0Y2_FrameData[4] Tile_X0Y5_FrameStrobe[4] VPWR VGND sg13cmos5l_dlhq_1
X_1416_ AXI_M_SOC_WDATA24 Tile_X0Y2_W2MID[0] Tile_X0Y2_W2END[0] Tile_X0Y2_W6END[0]
+ _1157_/X _2312_/Q _2311_/Q VPWR VGND sg13cmos5l_mux4_1
XFILLER_87_139 VPWR VGND sg13cmos5l_decap_8
XFILLER_228_123 VPWR VGND sg13cmos5l_fill_1
X_1347_ _1347_/X Tile_X0Y2_W1END[2] Tile_X0Y2_W2MID[1] Tile_X0Y2_W2END[1] _1175_/X
+ _2456_/Q _2455_/Q VPWR VGND sg13cmos5l_mux4_1
XFILLER_95_161 VPWR VGND sg13cmos5l_decap_8
XANTENNA__2195__D Tile_X0Y1_FrameData[29] VPWR VGND sg13cmos5l_antennanp
XANTENNA__3869__A Tile_X0Y5_FrameData[10] VPWR VGND sg13cmos5l_antennanp
XFILLER_228_189 VPWR VGND sg13cmos5l_fill_1
X_1278_ _3499_/A Tile_X0Y1_W2END[0] AXI_M_SOC_RDATA22 _1110_/X _1115_/X _2130_/Q _2129_/Q
+ VPWR VGND sg13cmos5l_mux4_1
XANTENNA__0845__X AXI_M_SOC_ARSIZE1 VPWR VGND sg13cmos5l_antennanp
X_3017_ _3017_/Q Tile_X0Y4_FrameData[23] Tile_X0Y5_FrameStrobe[7] VPWR VGND sg13cmos5l_dlhq_1
XANTENNA__2923__D Tile_X0Y4_FrameData[21] VPWR VGND sg13cmos5l_antennanp
XFILLER_196_225 VPWR VGND sg13cmos5l_decap_8
XFILLER_11_139 VPWR VGND sg13cmos5l_fill_2
XFILLER_132_8 VPWR VGND sg13cmos5l_decap_8
X_3919_ Tile_X0Y5_S4BEG[8] _3919_/A VPWR VGND sg13cmos5l_buf_1
XFILLER_338_241 VPWR VGND sg13cmos5l_fill_2
XFILLER_22_46 VPWR VGND sg13cmos5l_decap_8
XANTENNA__1349__A0 Tile_X0Y5_W2MID[0] VPWR VGND sg13cmos5l_antennanp
XFILLER_138_35 VPWR VGND sg13cmos5l_decap_4
XFILLER_285_41 VPWR VGND sg13cmos5l_fill_1
XANTENNA__3891__X Tile_X0Y5_S1BEG[0] VPWR VGND sg13cmos5l_antennanp
XFILLER_105_233 VPWR VGND sg13cmos5l_decap_4
XFILLER_304_26 VPWR VGND sg13cmos5l_fill_1
XFILLER_304_48 VPWR VGND sg13cmos5l_decap_8
XFILLER_93_109 VPWR VGND sg13cmos5l_decap_8
XFILLER_47_21 VPWR VGND sg13cmos5l_decap_8
XFILLER_219_134 VPWR VGND sg13cmos5l_fill_2
XFILLER_47_54 VPWR VGND sg13cmos5l_decap_8
XFILLER_274_284 VPWR VGND sg13cmos5l_fill_2
XFILLER_86_194 VPWR VGND sg13cmos5l_decap_4
XANTENNA__3779__A Tile_X0Y4_FrameData[1] VPWR VGND sg13cmos5l_antennanp
XFILLER_170_88 VPWR VGND sg13cmos5l_fill_1
XFILLER_234_159 VPWR VGND sg13cmos5l_decap_8
XFILLER_34_209 VPWR VGND sg13cmos5l_decap_8
XFILLER_103_71 VPWR VGND sg13cmos5l_fill_1
XANTENNA__2833__D Tile_X0Y4_FrameData[15] VPWR VGND sg13cmos5l_antennanp
XFILLER_151_0 VPWR VGND sg13cmos5l_fill_2
XFILLER_187_203 VPWR VGND sg13cmos5l_decap_4
XFILLER_249_0 VPWR VGND sg13cmos5l_fill_2
XFILLER_63_75 VPWR VGND sg13cmos5l_decap_8
XFILLER_8_59 VPWR VGND sg13cmos5l_decap_4
XANTENNA__3174__GATE Tile_X0Y5_FrameStrobe[3] VPWR VGND sg13cmos5l_antennanp
X_0580_ _0580_/X Tile_X0Y2_W1END[0] Tile_X0Y2_W6END[8] _1058_/X _0579_/X _2476_/Q
+ _2475_/Q VPWR VGND sg13cmos5l_mux4_1
XANTENNA__0563__A1 Tile_X0Y5_N2END[7] VPWR VGND sg13cmos5l_antennanp
XANTENNA__1355__A3 Tile_X0Y0_S4END[8] VPWR VGND sg13cmos5l_antennanp
XANTENNA__3189__GATE Tile_X0Y5_FrameStrobe[4] VPWR VGND sg13cmos5l_antennanp
XFILLER_88_72 VPWR VGND sg13cmos5l_decap_8
X_2250_ _2250_/Q Tile_X0Y2_FrameData[22] Tile_X0Y5_FrameStrobe[0] VPWR VGND sg13cmos5l_dlhq_1
XFILLER_214_26 VPWR VGND sg13cmos5l_decap_8
X_1201_ AXI_M_SOC_AWADDR17 Tile_X0Y0_WW4END[1] Tile_X0Y0_WW4END[9] Tile_X0Y0_W6END[9]
+ _1038_/X _1782_/Q _1781_/Q VPWR VGND sg13cmos5l_mux4_1
XANTENNA__1912__D Tile_X0Y0_FrameData[8] VPWR VGND sg13cmos5l_antennanp
XANTENNA__3112__GATE Tile_X0Y5_FrameStrobe[1] VPWR VGND sg13cmos5l_antennanp
XFILLER_265_240 VPWR VGND sg13cmos5l_fill_1
X_2181_ _2181_/Q Tile_X0Y1_FrameData[11] Tile_X0Y5_FrameStrobe[6] VPWR VGND sg13cmos5l_dlhq_1
XFILLER_77_150 VPWR VGND sg13cmos5l_decap_8
X_1132_ _1132_/Y Tile_X0Y5_W6END[3] _3058_/Q _1131_/Y VPWR VGND sg13cmos5l_a21oi_1
X_1063_ _1063_/X _1056_/X _0586_/X Tile_X0Y5_N4END[4] _1061_/X _2823_/Q _2824_/Q VPWR
+ VGND sg13cmos5l_mux4_1
XFILLER_230_47 VPWR VGND sg13cmos5l_decap_8
XFILLER_280_276 VPWR VGND sg13cmos5l_fill_2
XFILLER_92_197 VPWR VGND sg13cmos5l_decap_8
XANTENNA__2743__D Tile_X0Y3_FrameData[25] VPWR VGND sg13cmos5l_antennanp
XANTENNA__3127__GATE Tile_X0Y5_FrameStrobe[2] VPWR VGND sg13cmos5l_antennanp
XANTENNA__2383__GATE Tile_X0Y5_FrameStrobe[4] VPWR VGND sg13cmos5l_antennanp
XFILLER_178_269 VPWR VGND sg13cmos5l_fill_1
X_1965_ _1965_/Q Tile_X0Y0_FrameData[19] Tile_X0Y5_FrameStrobe[8] VPWR VGND sg13cmos5l_dlhq_1
XANTENNA__1043__A2 Tile_X0Y2_W6END[2] VPWR VGND sg13cmos5l_antennanp
X_3704_ Tile_X0Y3_FrameData_O[7] Tile_X0Y3_FrameData[7] VPWR VGND sg13cmos5l_buf_1
X_0916_ _0916_/Y _3303_/Q _0915_/Y _3302_/Q VPWR VGND sg13cmos5l_o21ai_1
XFILLER_239_89 VPWR VGND sg13cmos5l_fill_2
X_1896_ _1896_/Q Tile_X0Y0_FrameData[24] Tile_X0Y5_FrameStrobe[6] VPWR VGND sg13cmos5l_dlhq_1
XFILLER_146_177 VPWR VGND sg13cmos5l_decap_8
XFILLER_161_114 VPWR VGND sg13cmos5l_decap_8
X_3635_ Tile_X0Y0_E2BEGb[6] _3635_/A VPWR VGND sg13cmos5l_buf_1
X_0847_ AXI_M_SOC_ARSIZE2 _3331_/Q _0846_/X VPWR VGND sg13cmos5l_nor2b_1
XANTENNA__2398__GATE Tile_X0Y5_FrameStrobe[4] VPWR VGND sg13cmos5l_antennanp
XFILLER_255_33 VPWR VGND sg13cmos5l_fill_1
X_3566_ Tile_X0Y0_FrameStrobe_O[17] Tile_X0Y5_FrameStrobe[17] VPWR VGND sg13cmos5l_buf_1
X_0778_ _0778_/X _0777_/X _0776_/X _3346_/Q VPWR VGND sg13cmos5l_mux2_1
X_2517_ _2517_/Q Tile_X0Y3_FrameData[27] Tile_X0Y5_FrameStrobe[0] VPWR VGND sg13cmos5l_dlhq_1
X_3497_ Tile_X0Y1_E2BEGb[5] _3497_/A VPWR VGND sg13cmos5l_buf_1
XFILLER_303_163 VPWR VGND sg13cmos5l_fill_2
X_2448_ _2448_/Q Tile_X0Y2_FrameData[16] Tile_X0Y5_FrameStrobe[6] VPWR VGND sg13cmos5l_dlhq_1
XANTENNA__2321__GATE Tile_X0Y5_FrameStrobe[2] VPWR VGND sg13cmos5l_antennanp
XANTENNA__2918__D Tile_X0Y4_FrameData[26] VPWR VGND sg13cmos5l_antennanp
XFILLER_303_196 VPWR VGND sg13cmos5l_fill_2
XANTENNA__1503__A0 Tile_X0Y3_W2END[2] VPWR VGND sg13cmos5l_antennanp
XANTENNA__1822__D Tile_X0Y0_FrameData[2] VPWR VGND sg13cmos5l_antennanp
XANTENNA__2951__GATE Tile_X0Y5_FrameStrobe[5] VPWR VGND sg13cmos5l_antennanp
XFILLER_271_54 VPWR VGND sg13cmos5l_fill_1
X_2379_ _2379_/Q Tile_X0Y2_FrameData[21] Tile_X0Y5_FrameStrobe[4] VPWR VGND sg13cmos5l_dlhq_1
XFILLER_68_183 VPWR VGND sg13cmos5l_fill_1
XANTENNA__2336__GATE Tile_X0Y5_FrameStrobe[2] VPWR VGND sg13cmos5l_antennanp
XANTENNA__3599__A Tile_X0Y0_FrameData[30] VPWR VGND sg13cmos5l_antennanp
XFILLER_140_25 VPWR VGND sg13cmos5l_fill_1
XFILLER_83_175 VPWR VGND sg13cmos5l_decap_8
XANTENNA__2966__GATE Tile_X0Y5_FrameStrobe[5] VPWR VGND sg13cmos5l_antennanp
XFILLER_271_254 VPWR VGND sg13cmos5l_decap_8
XANTENNA__2653__D Tile_X0Y3_FrameData[19] VPWR VGND sg13cmos5l_antennanp
XANTENNA__3886__X Tile_X0Y5_FrameData_O[27] VPWR VGND sg13cmos5l_antennanp
XFILLER_33_45 VPWR VGND sg13cmos5l_decap_8
XANTENNA__0793__A1 Tile_X0Y3_W2END[4] VPWR VGND sg13cmos5l_antennanp
XFILLER_326_277 VPWR VGND sg13cmos5l_decap_4
XANTENNA__2904__GATE Tile_X0Y5_FrameStrobe[3] VPWR VGND sg13cmos5l_antennanp
XFILLER_192_294 VPWR VGND sg13cmos5l_fill_1
XFILLER_315_14 VPWR VGND sg13cmos5l_fill_2
XFILLER_58_20 VPWR VGND sg13cmos5l_decap_8
XANTENNA__2828__D Tile_X0Y4_FrameData[20] VPWR VGND sg13cmos5l_antennanp
XANTENNA__2919__GATE Tile_X0Y5_FrameStrobe[4] VPWR VGND sg13cmos5l_antennanp
XFILLER_181_32 VPWR VGND sg13cmos5l_decap_4
XANTENNA__1732__D Tile_X0Y0_FrameData[28] VPWR VGND sg13cmos5l_antennanp
XFILLER_181_76 VPWR VGND sg13cmos5l_decap_8
XFILLER_199_0 VPWR VGND sg13cmos5l_fill_2
XFILLER_58_97 VPWR VGND sg13cmos5l_decap_8
XANTENNA__0848__A2 Tile_X0Y5_W6END[0] VPWR VGND sg13cmos5l_antennanp
XFILLER_181_87 VPWR VGND sg13cmos5l_fill_2
XFILLER_207_115 VPWR VGND sg13cmos5l_fill_2
XFILLER_74_120 VPWR VGND sg13cmos5l_decap_8
XANTENNA__2563__D Tile_X0Y3_FrameData[13] VPWR VGND sg13cmos5l_antennanp
XANTENNA__3796__X Tile_X0Y4_FrameData_O[18] VPWR VGND sg13cmos5l_antennanp
XFILLER_15_253 VPWR VGND sg13cmos5l_fill_1
XFILLER_215_181 VPWR VGND sg13cmos5l_decap_4
XFILLER_200_39 VPWR VGND sg13cmos5l_decap_8
XFILLER_175_217 VPWR VGND sg13cmos5l_decap_8
XFILLER_230_151 VPWR VGND sg13cmos5l_decap_8
XFILLER_88_7 VPWR VGND sg13cmos5l_fill_2
XANTENNA__1025__A2 Tile_X0Y5_N4END[13] VPWR VGND sg13cmos5l_antennanp
XFILLER_230_195 VPWR VGND sg13cmos5l_decap_8
X_1750_ _1750_/Q Tile_X0Y0_FrameData[10] Tile_X0Y5_FrameStrobe[1] VPWR VGND sg13cmos5l_dlhq_1
XFILLER_90_95 VPWR VGND sg13cmos5l_decap_4
XFILLER_317_200 VPWR VGND sg13cmos5l_decap_8
XFILLER_190_209 VPWR VGND sg13cmos5l_decap_4
X_0701_ _0701_/X Tile_X0Y5_W1END[2] Tile_X0Y5_WW4END[14] _3262_/Q VPWR VGND sg13cmos5l_mux2_1
XANTENNA__0784__A1 Tile_X0Y3_W2END[6] VPWR VGND sg13cmos5l_antennanp
XANTENNA__1907__D Tile_X0Y0_FrameData[13] VPWR VGND sg13cmos5l_antennanp
XFILLER_183_261 VPWR VGND sg13cmos5l_decap_8
XFILLER_209_37 VPWR VGND sg13cmos5l_decap_8
X_1681_ _3746_/A Tile_X0Y4_W2END[3] AXI_M_SOC_RDATA1 _1130_/X _1319_/X _2952_/Q _2951_/Q
+ VPWR VGND sg13cmos5l_mux4_1
X_3420_ Tile_X0Y2_FrameData_O[22] Tile_X0Y2_FrameData[22] VPWR VGND sg13cmos5l_buf_1
X_0632_ _0633_/C _2518_/Q _1017_/X VPWR VGND sg13cmos5l_nor2_1
X_3351_ Tile_X0Y2_E1BEG[1] _3351_/A VPWR VGND sg13cmos5l_buf_1
X_0563_ _0563_/X Tile_X0Y5_N2MID[7] Tile_X0Y5_N2END[7] _3910_/A _0562_/X _3066_/Q
+ _3065_/Q VPWR VGND sg13cmos5l_mux4_1
XFILLER_300_111 VPWR VGND sg13cmos5l_decap_4
X_2302_ _2302_/Q Tile_X0Y2_FrameData[2] Tile_X0Y5_FrameStrobe[1] VPWR VGND sg13cmos5l_dlhq_1
XANTENNA__2738__D Tile_X0Y3_FrameData[30] VPWR VGND sg13cmos5l_antennanp
X_3282_ _3282_/Q Tile_X0Y5_FrameData[30] Tile_X0Y5_FrameStrobe[7] VPWR VGND sg13cmos5l_dlhq_1
XANTENNA__3051__GATE Tile_X0Y5_FrameStrobe[8] VPWR VGND sg13cmos5l_antennanp
X_2233_ _2233_/Q Tile_X0Y1_FrameData[23] Tile_X0Y5_FrameStrobe[8] VPWR VGND sg13cmos5l_dlhq_1
XFILLER_97_278 VPWR VGND sg13cmos5l_fill_1
XFILLER_238_251 VPWR VGND sg13cmos5l_decap_8
X_2164_ _2164_/Q Tile_X0Y1_FrameData[28] Tile_X0Y5_FrameStrobe[6] VPWR VGND sg13cmos5l_dlhq_1
XFILLER_253_243 VPWR VGND sg13cmos5l_decap_8
X_1115_ _1115_/X _1113_/X _1114_/X _1112_/X Tile_X0Y0_S2MID[7] _1977_/Q _1978_/Q VPWR
+ VGND sg13cmos5l_mux4_1
XANTENNA__3066__GATE Tile_X0Y5_FrameStrobe[0] VPWR VGND sg13cmos5l_antennanp
XFILLER_253_254 VPWR VGND sg13cmos5l_fill_2
X_2095_ _2095_/Q Tile_X0Y1_FrameData[1] Tile_X0Y5_FrameStrobe[3] VPWR VGND sg13cmos5l_dlhq_1
XFILLER_80_112 VPWR VGND sg13cmos5l_fill_2
XFILLER_65_175 VPWR VGND sg13cmos5l_decap_8
XANTENNA__2473__D Tile_X0Y2_FrameData[23] VPWR VGND sg13cmos5l_antennanp
X_1046_ _1046_/X _1023_/X _0635_/X Tile_X0Y5_N4END[5] _1028_/X _2813_/Q _2814_/Q VPWR
+ VGND sg13cmos5l_mux4_1
XFILLER_21_223 VPWR VGND sg13cmos5l_fill_2
XANTENNA__1016__A2 Tile_X0Y5_N2MID[2] VPWR VGND sg13cmos5l_antennanp
XFILLER_159_280 VPWR VGND sg13cmos5l_fill_1
X_2997_ _2997_/Q Tile_X0Y4_FrameData[11] Tile_X0Y5_FrameStrobe[6] VPWR VGND sg13cmos5l_dlhq_1
X_1948_ _1948_/Q Tile_X0Y0_FrameData[4] Tile_X0Y5_FrameStrobe[7] VPWR VGND sg13cmos5l_dlhq_1
XANTENNA__1817__D Tile_X0Y0_FrameData[7] VPWR VGND sg13cmos5l_antennanp
XANTENNA__3882__A Tile_X0Y5_FrameData[23] VPWR VGND sg13cmos5l_antennanp
X_1879_ _1879_/Q Tile_X0Y0_FrameData[9] Tile_X0Y5_FrameStrobe[5] VPWR VGND sg13cmos5l_dlhq_1
XANTENNA__3004__GATE Tile_X0Y5_FrameStrobe[6] VPWR VGND sg13cmos5l_antennanp
X_3618_ Tile_X0Y0_E6BEG[1] _3618_/A VPWR VGND sg13cmos5l_buf_1
XFILLER_134_169 VPWR VGND sg13cmos5l_decap_4
XFILLER_135_14 VPWR VGND sg13cmos5l_decap_8
XANTENNA__2260__GATE Tile_X0Y5_FrameStrobe[0] VPWR VGND sg13cmos5l_antennanp
X_3549_ Tile_X0Y0_FrameStrobe_O[0] Tile_X0Y5_FrameStrobe[0] VPWR VGND sg13cmos5l_buf_1
XANTENNA__2890__GATE Tile_X0Y5_FrameStrobe[3] VPWR VGND sg13cmos5l_antennanp
XANTENNA__3019__GATE Tile_X0Y5_FrameStrobe[7] VPWR VGND sg13cmos5l_antennanp
XANTENNA__2648__D Tile_X0Y3_FrameData[24] VPWR VGND sg13cmos5l_antennanp
XFILLER_28_12 VPWR VGND sg13cmos5l_fill_2
XANTENNA__2275__GATE Tile_X0Y5_FrameStrobe[1] VPWR VGND sg13cmos5l_antennanp
XFILLER_151_35 VPWR VGND sg13cmos5l_decap_8
XFILLER_28_78 VPWR VGND sg13cmos5l_decap_8
XFILLER_56_142 VPWR VGND sg13cmos5l_decap_8
XFILLER_244_276 VPWR VGND sg13cmos5l_decap_4
XFILLER_301_16 VPWR VGND sg13cmos5l_fill_1
XFILLER_71_112 VPWR VGND sg13cmos5l_decap_8
XANTENNA__2383__D Tile_X0Y2_FrameData[17] VPWR VGND sg13cmos5l_antennanp
XFILLER_44_22 VPWR VGND sg13cmos5l_decap_4
XFILLER_212_173 VPWR VGND sg13cmos5l_fill_2
XFILLER_44_88 VPWR VGND sg13cmos5l_decap_8
XFILLER_12_278 VPWR VGND sg13cmos5l_fill_2
XFILLER_60_21 VPWR VGND sg13cmos5l_fill_2
XANTENNA__1007__A2 Tile_X0Y0_S1END[2] VPWR VGND sg13cmos5l_antennanp
XANTENNA__2213__GATE Tile_X0Y5_FrameStrobe[7] VPWR VGND sg13cmos5l_antennanp
XFILLER_8_238 VPWR VGND sg13cmos5l_fill_1
XANTENNA__1727__D Tile_X0Y0_FrameData[1] VPWR VGND sg13cmos5l_antennanp
XANTENNA__2843__GATE Tile_X0Y5_FrameStrobe[1] VPWR VGND sg13cmos5l_antennanp
XFILLER_172_209 VPWR VGND sg13cmos5l_decap_8
XFILLER_176_32 VPWR VGND sg13cmos5l_fill_2
XFILLER_176_65 VPWR VGND sg13cmos5l_decap_8
XFILLER_60_87 VPWR VGND sg13cmos5l_decap_8
XANTENNA__3792__A Tile_X0Y4_FrameData[14] VPWR VGND sg13cmos5l_antennanp
XFILLER_114_0 VPWR VGND sg13cmos5l_fill_2
XFILLER_5_27 VPWR VGND sg13cmos5l_fill_1
XFILLER_5_38 VPWR VGND sg13cmos5l_fill_2
XANTENNA__2228__GATE Tile_X0Y5_FrameStrobe[8] VPWR VGND sg13cmos5l_antennanp
XANTENNA__2858__GATE Tile_X0Y5_FrameStrobe[2] VPWR VGND sg13cmos5l_antennanp
XFILLER_279_162 VPWR VGND sg13cmos5l_fill_2
XFILLER_69_74 VPWR VGND sg13cmos5l_fill_2
XFILLER_192_53 VPWR VGND sg13cmos5l_fill_1
XFILLER_79_245 VPWR VGND sg13cmos5l_decap_8
XANTENNA__2558__D Tile_X0Y3_FrameData[18] VPWR VGND sg13cmos5l_antennanp
XFILLER_39_109 VPWR VGND sg13cmos5l_decap_4
XFILLER_85_95 VPWR VGND sg13cmos5l_decap_8
XANTENNA__1494__A2 AXI_M_SOC_RDATA6 VPWR VGND sg13cmos5l_antennanp
XFILLER_62_123 VPWR VGND sg13cmos5l_decap_8
XANTENNA__0943__X AXI_M_SOC_AWSIZE1 VPWR VGND sg13cmos5l_antennanp
XANTENNA__2293__D Tile_X0Y2_FrameData[11] VPWR VGND sg13cmos5l_antennanp
X_2920_ _2920_/Q Tile_X0Y4_FrameData[24] Tile_X0Y5_FrameStrobe[4] VPWR VGND sg13cmos5l_dlhq_1
XFILLER_203_173 VPWR VGND sg13cmos5l_decap_8
XFILLER_148_217 VPWR VGND sg13cmos5l_fill_2
X_2851_ _2851_/Q Tile_X0Y4_FrameData[29] Tile_X0Y5_FrameStrobe[2] VPWR VGND sg13cmos5l_dlhq_1
X_2782_ _2782_/Q Tile_X0Y3_FrameData[18] Tile_X0Y5_FrameStrobe[8] VPWR VGND sg13cmos5l_dlhq_1
X_1802_ _1802_/Q Tile_X0Y0_FrameData[22] Tile_X0Y5_FrameStrobe[3] VPWR VGND sg13cmos5l_dlhq_1
XANTENNA__0757__A1 Tile_X0Y5_W6END[0] VPWR VGND sg13cmos5l_antennanp
XFILLER_156_261 VPWR VGND sg13cmos5l_fill_1
X_1733_ _1733_/Q Tile_X0Y0_FrameData[27] Tile_X0Y5_FrameStrobe[1] VPWR VGND sg13cmos5l_dlhq_1
XFILLER_116_125 VPWR VGND sg13cmos5l_fill_2
XFILLER_7_293 VPWR VGND sg13cmos5l_fill_2
XFILLER_116_158 VPWR VGND sg13cmos5l_decap_8
XFILLER_236_35 VPWR VGND sg13cmos5l_decap_8
X_3403_ Tile_X0Y2_FrameData_O[5] Tile_X0Y2_FrameData[5] VPWR VGND sg13cmos5l_buf_1
X_1664_ _1664_/X _1125_/X _1126_/X _1127_/X _1361_/X _2987_/Q _2986_/Q VPWR VGND sg13cmos5l_mux4_1
X_1595_ _1596_/B Tile_X0Y3_W1END[2] Tile_X0Y3_WW4END[14] Tile_X0Y3_W6END[6] _1524_/X
+ _2718_/Q _2717_/Q VPWR VGND sg13cmos5l_mux4_1
X_0615_ _0615_/Y _1702_/Q _1701_/Q _1057_/X VPWR VGND sg13cmos5l_nor3_1
XANTENNA__1182__A1 Tile_X0Y4_W2END[2] VPWR VGND sg13cmos5l_antennanp
XFILLER_313_280 VPWR VGND sg13cmos5l_fill_1
X_3334_ _3334_/Q Tile_X0Y5_FrameData[0] Tile_X0Y5_FrameStrobe[8] VPWR VGND sg13cmos5l_dlhq_1
X_0546_ _0546_/Y _3298_/Q VPWR VGND sg13cmos5l_inv_1
XANTENNA__2468__D Tile_X0Y2_FrameData[28] VPWR VGND sg13cmos5l_antennanp
XFILLER_105_39 VPWR VGND sg13cmos5l_decap_8
XFILLER_252_34 VPWR VGND sg13cmos5l_decap_8
X_3265_ _3265_/Q Tile_X0Y5_FrameData[15] Tile_X0Y5_FrameStrobe[6] VPWR VGND sg13cmos5l_dlhq_1
XFILLER_252_45 VPWR VGND sg13cmos5l_fill_2
XFILLER_285_187 VPWR VGND sg13cmos5l_fill_1
X_2216_ _2216_/Q Tile_X0Y1_FrameData[8] Tile_X0Y5_FrameStrobe[7] VPWR VGND sg13cmos5l_dlhq_1
XFILLER_38_120 VPWR VGND sg13cmos5l_decap_8
X_3196_ _3196_/Q Tile_X0Y5_FrameData[20] Tile_X0Y5_FrameStrobe[4] VPWR VGND sg13cmos5l_dlhq_1
XFILLER_38_153 VPWR VGND sg13cmos5l_decap_8
X_2147_ _2147_/Q Tile_X0Y1_FrameData[13] Tile_X0Y5_FrameStrobe[5] VPWR VGND sg13cmos5l_dlhq_1
XFILLER_53_123 VPWR VGND sg13cmos5l_decap_8
XANTENNA__3299__D Tile_X0Y5_FrameData[13] VPWR VGND sg13cmos5l_antennanp
XFILLER_121_49 VPWR VGND sg13cmos5l_decap_8
X_2078_ _2078_/Q Tile_X0Y1_FrameData[18] Tile_X0Y5_FrameStrobe[3] VPWR VGND sg13cmos5l_dlhq_1
XANTENNA__3877__A Tile_X0Y5_FrameData[18] VPWR VGND sg13cmos5l_antennanp
X_1029_ _1029_/X _1023_/X _0635_/X Tile_X0Y5_N4END[5] _1028_/X _2837_/Q _2838_/Q VPWR
+ VGND sg13cmos5l_mux4_1
XANTENNA__2931__D Tile_X0Y4_FrameData[13] VPWR VGND sg13cmos5l_antennanp
XFILLER_277_31 VPWR VGND sg13cmos5l_fill_2
XFILLER_147_261 VPWR VGND sg13cmos5l_fill_2
XANTENNA__1173__A1 Tile_X0Y1_W2MID[1] VPWR VGND sg13cmos5l_antennanp
XFILLER_115_180 VPWR VGND sg13cmos5l_decap_8
XFILLER_115_191 VPWR VGND sg13cmos5l_fill_1
XFILLER_39_11 VPWR VGND sg13cmos5l_decap_8
XANTENNA__2378__D Tile_X0Y2_FrameData[22] VPWR VGND sg13cmos5l_antennanp
XFILLER_162_12 VPWR VGND sg13cmos5l_fill_1
XFILLER_39_44 VPWR VGND sg13cmos5l_decap_8
XANTENNA__0920__A1 Tile_X0Y1_WW4END[12] VPWR VGND sg13cmos5l_antennanp
XANTENNA__3404__X Tile_X0Y2_FrameData_O[6] VPWR VGND sg13cmos5l_antennanp
XFILLER_130_172 VPWR VGND sg13cmos5l_decap_8
XFILLER_39_88 VPWR VGND sg13cmos5l_decap_8
XFILLER_312_37 VPWR VGND sg13cmos5l_fill_1
XFILLER_91_218 VPWR VGND sg13cmos5l_decap_8
XANTENNA__1476__A2 AXI_M_SOC_RDATA16 VPWR VGND sg13cmos5l_antennanp
XFILLER_55_21 VPWR VGND sg13cmos5l_decap_8
XANTENNA__0684__A0 Tile_X0Y3_W1END[2] VPWR VGND sg13cmos5l_antennanp
XFILLER_217_276 VPWR VGND sg13cmos5l_fill_2
XANTENNA__1228__A2 AXI_M_SOC_WREADY VPWR VGND sg13cmos5l_antennanp
XANTENNA__3002__D Tile_X0Y4_FrameData[6] VPWR VGND sg13cmos5l_antennanp
XANTENNA__3787__A Tile_X0Y4_FrameData[9] VPWR VGND sg13cmos5l_antennanp
XFILLER_55_98 VPWR VGND sg13cmos5l_decap_8
XANTENNA__0987__A1 Tile_X0Y4_W6END[6] VPWR VGND sg13cmos5l_antennanp
XANTENNA__2152__GATE Tile_X0Y5_FrameStrobe[5] VPWR VGND sg13cmos5l_antennanp
XANTENNA__2841__D Tile_X0Y4_FrameData[7] VPWR VGND sg13cmos5l_antennanp
XFILLER_197_183 VPWR VGND sg13cmos5l_decap_8
XFILLER_231_0 VPWR VGND sg13cmos5l_fill_2
XFILLER_71_42 VPWR VGND sg13cmos5l_decap_8
XANTENNA__2782__GATE Tile_X0Y5_FrameStrobe[8] VPWR VGND sg13cmos5l_antennanp
XFILLER_329_0 VPWR VGND sg13cmos5l_fill_2
XFILLER_200_187 VPWR VGND sg13cmos5l_decap_4
XANTENNA__1400__A2 Tile_X0Y0_S4END[8] VPWR VGND sg13cmos5l_antennanp
XANTENNA__2167__GATE Tile_X0Y5_FrameStrobe[6] VPWR VGND sg13cmos5l_antennanp
XANTENNA__2797__GATE Tile_X0Y5_FrameStrobe[0] VPWR VGND sg13cmos5l_antennanp
XFILLER_153_286 VPWR VGND sg13cmos5l_fill_1
XFILLER_302_217 VPWR VGND sg13cmos5l_fill_1
XFILLER_4_285 VPWR VGND sg13cmos5l_fill_1
XFILLER_4_274 VPWR VGND sg13cmos5l_decap_4
XANTENNA__1164__A1 Tile_X0Y0_WW4END[2] VPWR VGND sg13cmos5l_antennanp
XFILLER_106_191 VPWR VGND sg13cmos5l_decap_8
XFILLER_206_27 VPWR VGND sg13cmos5l_decap_8
X_1380_ _1380_/X _0977_/X _0672_/X Tile_X0Y5_N4END[14] Tile_X0Y0_S4END[10] _2291_/Q
+ _2292_/Q VPWR VGND sg13cmos5l_mux4_1
XANTENNA__2288__D Tile_X0Y2_FrameData[16] VPWR VGND sg13cmos5l_antennanp
XANTENNA__0911__A1 Tile_X0Y5_WW4END[0] VPWR VGND sg13cmos5l_antennanp
XANTENNA__2720__GATE Tile_X0Y5_FrameStrobe[6] VPWR VGND sg13cmos5l_antennanp
XFILLER_267_154 VPWR VGND sg13cmos5l_decap_4
XFILLER_267_176 VPWR VGND sg13cmos5l_fill_1
X_3050_ _3050_/Q Tile_X0Y4_FrameData[22] Tile_X0Y5_FrameStrobe[8] VPWR VGND sg13cmos5l_dlhq_1
XFILLER_282_124 VPWR VGND sg13cmos5l_fill_1
XFILLER_282_146 VPWR VGND sg13cmos5l_decap_4
X_2001_ _2001_/Q Tile_X0Y1_FrameData[31] Tile_X0Y5_FrameStrobe[1] VPWR VGND sg13cmos5l_dlhq_1
XANTENNA__1920__D Tile_X0Y0_FrameData[0] VPWR VGND sg13cmos5l_antennanp
XANTENNA__2105__GATE Tile_X0Y5_FrameStrobe[4] VPWR VGND sg13cmos5l_antennanp
XFILLER_282_157 VPWR VGND sg13cmos5l_decap_4
XFILLER_282_168 VPWR VGND sg13cmos5l_fill_1
XANTENNA__2735__GATE Tile_X0Y5_FrameStrobe[6] VPWR VGND sg13cmos5l_antennanp
XFILLER_208_276 VPWR VGND sg13cmos5l_fill_2
XFILLER_90_240 VPWR VGND sg13cmos5l_fill_2
XFILLER_35_134 VPWR VGND sg13cmos5l_decap_8
XANTENNA__3697__A Tile_X0Y3_FrameData[0] VPWR VGND sg13cmos5l_antennanp
XANTENNA__1991__GATE Tile_X0Y5_FrameStrobe[0] VPWR VGND sg13cmos5l_antennanp
XANTENNA__2751__D Tile_X0Y3_FrameData[17] VPWR VGND sg13cmos5l_antennanp
X_2903_ _2903_/Q Tile_X0Y4_FrameData[9] Tile_X0Y5_FrameStrobe[3] VPWR VGND sg13cmos5l_dlhq_1
X_3883_ Tile_X0Y5_FrameData_O[24] Tile_X0Y5_FrameData[24] VPWR VGND sg13cmos5l_buf_1
XFILLER_337_114 VPWR VGND sg13cmos5l_fill_2
X_2834_ _2834_/Q Tile_X0Y4_FrameData[14] Tile_X0Y5_FrameStrobe[1] VPWR VGND sg13cmos5l_dlhq_1
XFILLER_337_147 VPWR VGND sg13cmos5l_fill_2
XFILLER_77_0 VPWR VGND sg13cmos5l_fill_2
XFILLER_129_294 VPWR VGND sg13cmos5l_fill_1
XFILLER_144_220 VPWR VGND sg13cmos5l_decap_4
X_2765_ _2765_/Q Tile_X0Y3_FrameData[3] Tile_X0Y5_FrameStrobe[7] VPWR VGND sg13cmos5l_dlhq_1
X_2696_ _2696_/Q Tile_X0Y3_FrameData[8] Tile_X0Y5_FrameStrobe[5] VPWR VGND sg13cmos5l_dlhq_1
X_1716_ _1716_/Q Tile_X0Y0_FrameData[12] Tile_X0Y5_FrameStrobe[0] VPWR VGND sg13cmos5l_dlhq_1
X_1647_ AXI_M_SOC_ARADDR19 Tile_X0Y4_W2MID[3] Tile_X0Y4_W2END[3] Tile_X0Y4_W6END[3]
+ _1130_/X _2850_/Q _2849_/Q VPWR VGND sg13cmos5l_mux4_1
XANTENNA__1155__A1 Tile_X0Y1_W2END[7] VPWR VGND sg13cmos5l_antennanp
XANTENNA__2198__D Tile_X0Y1_FrameData[26] VPWR VGND sg13cmos5l_antennanp
X_3317_ _3317_/Q Tile_X0Y5_FrameData[27] Tile_X0Y5_FrameStrobe[8] VPWR VGND sg13cmos5l_dlhq_1
X_1578_ _3915_/A _1575_/Y _1577_/Y _1573_/Y VPWR VGND sg13cmos5l_o21ai_1
XFILLER_112_194 VPWR VGND sg13cmos5l_decap_8
XFILLER_258_165 VPWR VGND sg13cmos5l_decap_8
XFILLER_263_88 VPWR VGND sg13cmos5l_decap_4
XANTENNA__1944__GATE Tile_X0Y5_FrameStrobe[7] VPWR VGND sg13cmos5l_antennanp
XFILLER_132_15 VPWR VGND sg13cmos5l_decap_4
XFILLER_273_113 VPWR VGND sg13cmos5l_fill_1
X_3248_ _3248_/Q Tile_X0Y5_FrameData[0] Tile_X0Y5_FrameStrobe[5] VPWR VGND sg13cmos5l_dlhq_1
XANTENNA__1830__D Tile_X0Y0_FrameData[26] VPWR VGND sg13cmos5l_antennanp
XANTENNA__2926__D Tile_X0Y4_FrameData[18] VPWR VGND sg13cmos5l_antennanp
XFILLER_26_112 VPWR VGND sg13cmos5l_decap_8
X_3179_ _3179_/Q Tile_X0Y5_FrameData[5] Tile_X0Y5_FrameStrobe[3] VPWR VGND sg13cmos5l_dlhq_1
XANTENNA__0666__A0 Tile_X0Y0_W1END[2] VPWR VGND sg13cmos5l_antennanp
XFILLER_212_92 VPWR VGND sg13cmos5l_fill_1
XANTENNA__1959__GATE Tile_X0Y5_FrameStrobe[8] VPWR VGND sg13cmos5l_antennanp
XANTENNA__3400__A Tile_X0Y2_FrameData[2] VPWR VGND sg13cmos5l_antennanp
XANTENNA__0969__A1 Tile_X0Y1_WW4END[15] VPWR VGND sg13cmos5l_antennanp
XANTENNA__3894__X Tile_X0Y5_S1BEG[3] VPWR VGND sg13cmos5l_antennanp
XANTENNA__1091__A0 Tile_X0Y3_W2MID[4] VPWR VGND sg13cmos5l_antennanp
XANTENNA__2661__D Tile_X0Y3_FrameData[11] VPWR VGND sg13cmos5l_antennanp
XFILLER_194_142 VPWR VGND sg13cmos5l_decap_4
XFILLER_194_164 VPWR VGND sg13cmos5l_decap_8
XFILLER_41_34 VPWR VGND sg13cmos5l_decap_8
XFILLER_157_45 VPWR VGND sg13cmos5l_decap_8
XANTENNA__1146__A1 Tile_X0Y0_W2END[4] VPWR VGND sg13cmos5l_antennanp
XFILLER_1_266 VPWR VGND sg13cmos5l_fill_1
XFILLER_103_183 VPWR VGND sg13cmos5l_decap_8
XFILLER_106_60 VPWR VGND sg13cmos5l_fill_1
XFILLER_106_82 VPWR VGND sg13cmos5l_decap_8
XFILLER_181_0 VPWR VGND sg13cmos5l_fill_2
XFILLER_249_187 VPWR VGND sg13cmos5l_fill_2
XANTENNA__1740__D Tile_X0Y0_FrameData[20] VPWR VGND sg13cmos5l_antennanp
XANTENNA__2836__D Tile_X0Y4_FrameData[12] VPWR VGND sg13cmos5l_antennanp
XFILLER_279_0 VPWR VGND sg13cmos5l_fill_1
XFILLER_66_97 VPWR VGND sg13cmos5l_decap_8
XFILLER_17_167 VPWR VGND sg13cmos5l_fill_2
XANTENNA__2091__GATE Tile_X0Y5_FrameStrobe[3] VPWR VGND sg13cmos5l_antennanp
XFILLER_205_279 VPWR VGND sg13cmos5l_fill_1
XFILLER_82_85 VPWR VGND sg13cmos5l_decap_8
XANTENNA__1082__A0 Tile_X0Y3_W2MID[1] VPWR VGND sg13cmos5l_antennanp
XANTENNA__2571__D Tile_X0Y3_FrameData[5] VPWR VGND sg13cmos5l_antennanp
X_0880_ _0880_/Y Tile_X0Y5_W2END[7] _3114_/Q _3113_/Q VPWR VGND sg13cmos5l_a21oi_1
XFILLER_185_186 VPWR VGND sg13cmos5l_fill_2
X_2550_ _2550_/Q Tile_X0Y3_FrameData[26] Tile_X0Y5_FrameStrobe[1] VPWR VGND sg13cmos5l_dlhq_1
XANTENNA__1915__D Tile_X0Y0_FrameData[5] VPWR VGND sg13cmos5l_antennanp
XFILLER_126_286 VPWR VGND sg13cmos5l_fill_1
XFILLER_141_212 VPWR VGND sg13cmos5l_decap_8
X_2481_ _2481_/Q Tile_X0Y2_FrameData[15] Tile_X0Y5_FrameStrobe[7] VPWR VGND sg13cmos5l_dlhq_1
X_1501_ _3662_/A Tile_X0Y3_W2END[6] AXI_M_SOC_RDATA12 _1219_/X _1348_/X _2686_/Q _2685_/Q
+ VPWR VGND sg13cmos5l_mux4_1
XFILLER_141_223 VPWR VGND sg13cmos5l_fill_1
X_1432_ AXI_M_SOC_WDATA26 Tile_X0Y2_W2MID[2] Tile_X0Y2_W2END[2] Tile_X0Y2_W6END[2]
+ _1151_/X _2308_/Q _2307_/Q VPWR VGND sg13cmos5l_mux4_1
XFILLER_99_148 VPWR VGND sg13cmos5l_fill_2
XFILLER_49_4 VPWR VGND sg13cmos5l_fill_2
X_1363_ _1363_/Y _2450_/Q _1363_/B VPWR VGND sg13cmos5l_nand2b_1
XANTENNA__2044__GATE Tile_X0Y5_FrameStrobe[2] VPWR VGND sg13cmos5l_antennanp
XFILLER_255_113 VPWR VGND sg13cmos5l_decap_8
X_3102_ _3102_/Q Tile_X0Y5_FrameData[18] Tile_X0Y5_FrameStrobe[1] VPWR VGND sg13cmos5l_dlhq_1
X_1294_ _3482_/A _0940_/Y _0950_/X Tile_X0Y0_S4END[6] _0962_/X _2091_/Q _2092_/Q VPWR
+ VGND sg13cmos5l_mux4_1
XANTENNA__2674__GATE Tile_X0Y5_FrameStrobe[5] VPWR VGND sg13cmos5l_antennanp
XANTENNA__2746__D Tile_X0Y3_FrameData[22] VPWR VGND sg13cmos5l_antennanp
X_3033_ _3033_/Q Tile_X0Y4_FrameData[7] Tile_X0Y5_FrameStrobe[7] VPWR VGND sg13cmos5l_dlhq_1
XANTENNA__0648__A0 Tile_X0Y5_N1END[1] VPWR VGND sg13cmos5l_antennanp
XFILLER_270_127 VPWR VGND sg13cmos5l_decap_8
XFILLER_102_29 VPWR VGND sg13cmos5l_fill_1
XANTENNA__2059__GATE Tile_X0Y5_FrameStrobe[2] VPWR VGND sg13cmos5l_antennanp
XANTENNA__2689__GATE Tile_X0Y5_FrameStrobe[5] VPWR VGND sg13cmos5l_antennanp
XFILLER_168_109 VPWR VGND sg13cmos5l_fill_1
XANTENNA__2481__D Tile_X0Y2_FrameData[15] VPWR VGND sg13cmos5l_antennanp
XFILLER_258_11 VPWR VGND sg13cmos5l_fill_1
XANTENNA__0820__A0 Tile_X0Y5_WW4END[3] VPWR VGND sg13cmos5l_antennanp
XANTENNA__1612__A2 AXI_M_SOC_RDATA5 VPWR VGND sg13cmos5l_antennanp
X_3866_ Tile_X0Y5_FrameData_O[7] Tile_X0Y5_FrameData[7] VPWR VGND sg13cmos5l_buf_1
XANTENNA__2612__GATE Tile_X0Y5_FrameStrobe[3] VPWR VGND sg13cmos5l_antennanp
XFILLER_176_175 VPWR VGND sg13cmos5l_fill_2
X_2817_ _2817_/Q Tile_X0Y4_FrameData[31] Tile_X0Y5_FrameStrobe[1] VPWR VGND sg13cmos5l_dlhq_1
X_3797_ Tile_X0Y4_FrameData_O[19] Tile_X0Y4_FrameData[19] VPWR VGND sg13cmos5l_buf_1
X_2748_ _2748_/Q Tile_X0Y3_FrameData[20] Tile_X0Y5_FrameStrobe[7] VPWR VGND sg13cmos5l_dlhq_1
XFILLER_318_191 VPWR VGND sg13cmos5l_decap_4
XANTENNA__1825__D Tile_X0Y0_FrameData[31] VPWR VGND sg13cmos5l_antennanp
XANTENNA__3890__A Tile_X0Y5_FrameData[31] VPWR VGND sg13cmos5l_antennanp
XFILLER_278_205 VPWR VGND sg13cmos5l_fill_1
X_2679_ _2679_/Q Tile_X0Y3_FrameData[25] Tile_X0Y5_FrameStrobe[5] VPWR VGND sg13cmos5l_dlhq_1
XANTENNA__1128__A1 Tile_X0Y2_W2END[4] VPWR VGND sg13cmos5l_antennanp
XANTENNA__2627__GATE Tile_X0Y5_FrameStrobe[3] VPWR VGND sg13cmos5l_antennanp
XFILLER_278_249 VPWR VGND sg13cmos5l_fill_2
XANTENNA__1883__GATE Tile_X0Y5_FrameStrobe[5] VPWR VGND sg13cmos5l_antennanp
XFILLER_286_282 VPWR VGND sg13cmos5l_fill_2
XFILLER_286_293 VPWR VGND sg13cmos5l_fill_2
XANTENNA__2656__D Tile_X0Y3_FrameData[16] VPWR VGND sg13cmos5l_antennanp
XANTENNA__3889__X Tile_X0Y5_FrameData_O[30] VPWR VGND sg13cmos5l_antennanp
XFILLER_100_164 VPWR VGND sg13cmos5l_decap_8
XFILLER_246_146 VPWR VGND sg13cmos5l_decap_8
XANTENNA__1300__A1 Tile_X0Y1_W2END[1] VPWR VGND sg13cmos5l_antennanp
XANTENNA__1898__GATE Tile_X0Y5_FrameStrobe[6] VPWR VGND sg13cmos5l_antennanp
XFILLER_36_67 VPWR VGND sg13cmos5l_decap_8
XANTENNA__1202__X AXI_M_SOC_AWADDR16 VPWR VGND sg13cmos5l_antennanp
XFILLER_202_205 VPWR VGND sg13cmos5l_fill_2
XFILLER_14_159 VPWR VGND sg13cmos5l_decap_8
XFILLER_199_278 VPWR VGND sg13cmos5l_fill_1
XFILLER_202_249 VPWR VGND sg13cmos5l_fill_2
XANTENNA__1821__GATE Tile_X0Y5_FrameStrobe[3] VPWR VGND sg13cmos5l_antennanp
XANTENNA__2391__D Tile_X0Y2_FrameData[9] VPWR VGND sg13cmos5l_antennanp
XFILLER_168_33 VPWR VGND sg13cmos5l_fill_2
XFILLER_52_66 VPWR VGND sg13cmos5l_fill_2
XANTENNA__0811__A0 Tile_X0Y5_WW4END[12] VPWR VGND sg13cmos5l_antennanp
XANTENNA__1603__A2 Tile_X0Y3_WW4END[0] VPWR VGND sg13cmos5l_antennanp
XFILLER_167_164 VPWR VGND sg13cmos5l_decap_4
XFILLER_167_197 VPWR VGND sg13cmos5l_decap_4
XFILLER_210_293 VPWR VGND sg13cmos5l_fill_2
XFILLER_108_242 VPWR VGND sg13cmos5l_fill_1
XFILLER_318_47 VPWR VGND sg13cmos5l_fill_2
XANTENNA__1735__D Tile_X0Y0_FrameData[25] VPWR VGND sg13cmos5l_antennanp
XANTENNA__1836__GATE Tile_X0Y5_FrameStrobe[4] VPWR VGND sg13cmos5l_antennanp
XFILLER_123_212 VPWR VGND sg13cmos5l_decap_8
XFILLER_123_223 VPWR VGND sg13cmos5l_decap_4
XFILLER_269_216 VPWR VGND sg13cmos5l_fill_2
XFILLER_7_0 VPWR VGND sg13cmos5l_fill_2
XANTENNA__1119__A1 Tile_X0Y4_W6END[7] VPWR VGND sg13cmos5l_antennanp
XFILLER_77_30 VPWR VGND sg13cmos5l_decap_8
XFILLER_334_57 VPWR VGND sg13cmos5l_fill_1
XFILLER_277_293 VPWR VGND sg13cmos5l_fill_2
XANTENNA__2566__D Tile_X0Y3_FrameData[10] VPWR VGND sg13cmos5l_antennanp
XANTENNA__3799__X Tile_X0Y4_FrameData_O[21] VPWR VGND sg13cmos5l_antennanp
XFILLER_203_17 VPWR VGND sg13cmos5l_decap_8
XFILLER_237_146 VPWR VGND sg13cmos5l_decap_8
XFILLER_292_285 VPWR VGND sg13cmos5l_fill_2
XFILLER_245_190 VPWR VGND sg13cmos5l_decap_8
X_3720_ Tile_X0Y3_FrameData_O[23] Tile_X0Y3_FrameData[23] VPWR VGND sg13cmos5l_buf_1
X_1981_ _1981_/Q Tile_X0Y1_FrameData[19] Tile_X0Y5_FrameStrobe[0] VPWR VGND sg13cmos5l_dlhq_1
XFILLER_60_276 VPWR VGND sg13cmos5l_fill_2
XANTENNA__0802__A0 Tile_X0Y5_W2END[5] VPWR VGND sg13cmos5l_antennanp
XFILLER_13_181 VPWR VGND sg13cmos5l_decap_8
X_0932_ _0932_/Y _0546_/Y _0698_/A _0931_/Y VPWR VGND sg13cmos5l_o21ai_1
XFILLER_201_293 VPWR VGND sg13cmos5l_fill_2
X_3651_ Tile_X0Y3_E1BEG[2] _3651_/A VPWR VGND sg13cmos5l_buf_1
X_0863_ _0863_/Y _3120_/Q _0607_/X _0862_/Y VPWR VGND sg13cmos5l_a21oi_1
XANTENNA__3342__GATE Tile_X0Y5_FrameStrobe[8] VPWR VGND sg13cmos5l_antennanp
X_2602_ _2602_/Q Tile_X0Y3_FrameData[6] Tile_X0Y5_FrameStrobe[2] VPWR VGND sg13cmos5l_dlhq_1
X_3582_ Tile_X0Y0_FrameData_O[13] Tile_X0Y0_FrameData[13] VPWR VGND sg13cmos5l_buf_1
XANTENNA__1358__A1 Tile_X0Y2_W6END[8] VPWR VGND sg13cmos5l_antennanp
X_2533_ _2533_/Q Tile_X0Y3_FrameData[11] Tile_X0Y5_FrameStrobe[0] VPWR VGND sg13cmos5l_dlhq_1
X_0794_ _0794_/X Tile_X0Y5_N2MID[3] Tile_X0Y5_N2END[3] _3906_/A _0793_/X _3074_/Q
+ _3073_/Q VPWR VGND sg13cmos5l_mux4_1
XFILLER_315_194 VPWR VGND sg13cmos5l_fill_2
X_2464_ _2464_/Q Tile_X0Y2_FrameData[0] Tile_X0Y5_FrameStrobe[6] VPWR VGND sg13cmos5l_dlhq_1
XFILLER_87_118 VPWR VGND sg13cmos5l_decap_8
XFILLER_330_142 VPWR VGND sg13cmos5l_fill_2
X_2395_ _2395_/Q Tile_X0Y2_FrameData[5] Tile_X0Y5_FrameStrobe[4] VPWR VGND sg13cmos5l_dlhq_1
X_1415_ AXI_M_SOC_WDATA11 Tile_X0Y2_WW4END[3] Tile_X0Y2_WW4END[11] Tile_X0Y2_W6END[3]
+ _1371_/X _2338_/Q _2337_/Q VPWR VGND sg13cmos5l_mux4_1
XFILLER_268_293 VPWR VGND sg13cmos5l_fill_2
X_1346_ _1346_/X Tile_X0Y5_W2MID[1] Tile_X0Y5_W2END[1] Tile_X0Y5_W6END[1] _0559_/X
+ _3308_/Q _3307_/Q VPWR VGND sg13cmos5l_mux4_1
XANTENNA__2476__D Tile_X0Y2_FrameData[20] VPWR VGND sg13cmos5l_antennanp
XANTENNA__3502__X Tile_X0Y1_E2BEG[2] VPWR VGND sg13cmos5l_antennanp
XFILLER_243_127 VPWR VGND sg13cmos5l_decap_8
XFILLER_260_56 VPWR VGND sg13cmos5l_fill_1
XFILLER_283_285 VPWR VGND sg13cmos5l_fill_2
X_1277_ _3464_/A Tile_X0Y1_WW4END[15] AXI_M_SOC_RDATA22 _0968_/X _1115_/X _2128_/Q
+ _2127_/Q VPWR VGND sg13cmos5l_mux4_1
X_3016_ _3016_/Q Tile_X0Y4_FrameData[24] Tile_X0Y5_FrameStrobe[7] VPWR VGND sg13cmos5l_dlhq_1
XFILLER_196_204 VPWR VGND sg13cmos5l_decap_8
XANTENNA__3885__A Tile_X0Y5_FrameData[26] VPWR VGND sg13cmos5l_antennanp
XFILLER_269_76 VPWR VGND sg13cmos5l_decap_8
XANTENNA__2551__GATE Tile_X0Y5_FrameStrobe[1] VPWR VGND sg13cmos5l_antennanp
XANTENNA__3100__D Tile_X0Y5_FrameData[20] VPWR VGND sg13cmos5l_antennanp
XFILLER_149_131 VPWR VGND sg13cmos5l_decap_4
X_3918_ Tile_X0Y5_S4BEG[7] _3918_/A VPWR VGND sg13cmos5l_buf_1
XFILLER_125_8 VPWR VGND sg13cmos5l_fill_1
XFILLER_138_14 VPWR VGND sg13cmos5l_decap_8
X_3849_ Tile_X0Y5_EE4BEG[6] _3849_/A VPWR VGND sg13cmos5l_buf_1
XFILLER_338_286 VPWR VGND sg13cmos5l_fill_1
XFILLER_285_53 VPWR VGND sg13cmos5l_fill_1
XANTENNA__1349__A1 Tile_X0Y5_W2END[0] VPWR VGND sg13cmos5l_antennanp
XFILLER_306_161 VPWR VGND sg13cmos5l_decap_4
XFILLER_98_29 VPWR VGND sg13cmos5l_decap_8
XANTENNA__2566__GATE Tile_X0Y5_FrameStrobe[1] VPWR VGND sg13cmos5l_antennanp
XFILLER_105_212 VPWR VGND sg13cmos5l_decap_8
XFILLER_120_204 VPWR VGND sg13cmos5l_decap_8
XFILLER_321_142 VPWR VGND sg13cmos5l_fill_1
XFILLER_259_260 VPWR VGND sg13cmos5l_fill_1
XFILLER_78_129 VPWR VGND sg13cmos5l_fill_1
XFILLER_259_282 VPWR VGND sg13cmos5l_fill_2
XFILLER_259_293 VPWR VGND sg13cmos5l_fill_2
XANTENNA__2386__D Tile_X0Y2_FrameData[14] VPWR VGND sg13cmos5l_antennanp
XFILLER_86_173 VPWR VGND sg13cmos5l_decap_8
XANTENNA__3412__X Tile_X0Y2_FrameData_O[14] VPWR VGND sg13cmos5l_antennanp
XANTENNA__2504__GATE Tile_X0Y5_FrameStrobe[8] VPWR VGND sg13cmos5l_antennanp
XFILLER_103_50 VPWR VGND sg13cmos5l_decap_8
XANTENNA__1285__A0 Tile_X0Y1_WW4END[2] VPWR VGND sg13cmos5l_antennanp
XFILLER_63_32 VPWR VGND sg13cmos5l_fill_2
XFILLER_42_210 VPWR VGND sg13cmos5l_decap_8
XANTENNA__1760__GATE Tile_X0Y5_FrameStrobe[1] VPWR VGND sg13cmos5l_antennanp
XANTENNA__3795__A Tile_X0Y4_FrameData[17] VPWR VGND sg13cmos5l_antennanp
XFILLER_144_0 VPWR VGND sg13cmos5l_decap_4
XFILLER_179_65 VPWR VGND sg13cmos5l_decap_8
XFILLER_63_98 VPWR VGND sg13cmos5l_fill_1
XANTENNA__2519__GATE Tile_X0Y5_FrameStrobe[0] VPWR VGND sg13cmos5l_antennanp
XANTENNA__3010__D Tile_X0Y4_FrameData[30] VPWR VGND sg13cmos5l_antennanp
XFILLER_179_98 VPWR VGND sg13cmos5l_decap_4
XFILLER_311_0 VPWR VGND sg13cmos5l_fill_2
XFILLER_329_275 VPWR VGND sg13cmos5l_fill_2
XANTENNA__1775__GATE Tile_X0Y5_FrameStrobe[2] VPWR VGND sg13cmos5l_antennanp
XFILLER_10_162 VPWR VGND sg13cmos5l_decap_8
XFILLER_170_148 VPWR VGND sg13cmos5l_fill_1
XFILLER_88_40 VPWR VGND sg13cmos5l_fill_1
XFILLER_69_107 VPWR VGND sg13cmos5l_decap_8
XFILLER_40_8 VPWR VGND sg13cmos5l_decap_8
XFILLER_257_208 VPWR VGND sg13cmos5l_decap_8
X_2180_ _2180_/Q Tile_X0Y1_FrameData[12] Tile_X0Y5_FrameStrobe[6] VPWR VGND sg13cmos5l_dlhq_1
X_1200_ AXI_M_SOC_AWADDR9 Tile_X0Y0_WW4END[1] Tile_X0Y0_WW4END[9] Tile_X0Y0_W6END[1]
+ _1042_/X _1798_/Q _1797_/Q VPWR VGND sg13cmos5l_mux4_1
XANTENNA__2296__D Tile_X0Y2_FrameData[8] VPWR VGND sg13cmos5l_antennanp
XANTENNA__1713__GATE Tile_X0Y5_FrameStrobe[0] VPWR VGND sg13cmos5l_antennanp
XFILLER_265_285 VPWR VGND sg13cmos5l_fill_2
X_1131_ _1131_/Y _3058_/Q Tile_X0Y5_N1END[3] VPWR VGND sg13cmos5l_nor2b_1
X_1062_ _1062_/X _1056_/X _0586_/X Tile_X0Y5_N4END[4] _1061_/X _2831_/Q _2832_/Q VPWR
+ VGND sg13cmos5l_mux4_1
XANTENNA__1276__A0 Tile_X0Y1_WW4END[9] VPWR VGND sg13cmos5l_antennanp
XFILLER_18_262 VPWR VGND sg13cmos5l_fill_2
XANTENNA__1728__GATE Tile_X0Y5_FrameStrobe[0] VPWR VGND sg13cmos5l_antennanp
XFILLER_178_248 VPWR VGND sg13cmos5l_decap_8
X_1964_ _1964_/Q Tile_X0Y0_FrameData[20] Tile_X0Y5_FrameStrobe[8] VPWR VGND sg13cmos5l_dlhq_1
XANTENNA__3281__GATE Tile_X0Y5_FrameStrobe[7] VPWR VGND sg13cmos5l_antennanp
X_3703_ Tile_X0Y3_FrameData_O[6] Tile_X0Y3_FrameData[6] VPWR VGND sg13cmos5l_buf_1
X_0915_ _0915_/Y _3304_/Q _0597_/X _0914_/Y VPWR VGND sg13cmos5l_o21ai_1
X_3634_ Tile_X0Y0_E2BEGb[5] _3634_/A VPWR VGND sg13cmos5l_buf_1
X_1895_ _1895_/Q Tile_X0Y0_FrameData[25] Tile_X0Y5_FrameStrobe[6] VPWR VGND sg13cmos5l_dlhq_1
XFILLER_108_17 VPWR VGND sg13cmos5l_decap_8
X_0846_ _0846_/X Tile_X0Y5_W1END[3] Tile_X0Y5_WW4END[15] Tile_X0Y5_WW4END[7] _0740_/X
+ _3129_/Q _3130_/Q VPWR VGND sg13cmos5l_mux4_1
XANTENNA__1200__A0 Tile_X0Y0_WW4END[1] VPWR VGND sg13cmos5l_antennanp
XFILLER_108_28 VPWR VGND sg13cmos5l_fill_2
X_3565_ Tile_X0Y0_FrameStrobe_O[16] Tile_X0Y5_FrameStrobe[16] VPWR VGND sg13cmos5l_buf_1
X_0777_ _0777_/X _0768_/X _0767_/X _3347_/Q VPWR VGND sg13cmos5l_mux2_1
XANTENNA__3296__GATE Tile_X0Y5_FrameStrobe[7] VPWR VGND sg13cmos5l_antennanp
XFILLER_255_89 VPWR VGND sg13cmos5l_decap_8
X_2516_ _2516_/Q Tile_X0Y3_FrameData[28] Tile_X0Y5_FrameStrobe[0] VPWR VGND sg13cmos5l_dlhq_1
X_3496_ Tile_X0Y1_E2BEGb[4] _3496_/A VPWR VGND sg13cmos5l_buf_1
XFILLER_102_226 VPWR VGND sg13cmos5l_decap_8
X_2447_ _2447_/Q Tile_X0Y2_FrameData[17] Tile_X0Y5_FrameStrobe[6] VPWR VGND sg13cmos5l_dlhq_1
XFILLER_271_11 VPWR VGND sg13cmos5l_fill_1
XFILLER_271_33 VPWR VGND sg13cmos5l_fill_2
XFILLER_68_140 VPWR VGND sg13cmos5l_fill_2
XANTENNA__1503__A1 AXI_M_SOC_RDATA8 VPWR VGND sg13cmos5l_antennanp
XFILLER_256_230 VPWR VGND sg13cmos5l_fill_1
XFILLER_271_66 VPWR VGND sg13cmos5l_fill_2
X_2378_ _2378_/Q Tile_X0Y2_FrameData[22] Tile_X0Y5_FrameStrobe[4] VPWR VGND sg13cmos5l_dlhq_1
XFILLER_110_270 VPWR VGND sg13cmos5l_decap_8
X_1329_ _1329_/X Tile_X0Y1_W1END[3] _0944_/X Tile_X0Y1_WW4END[3] _0956_/X _2205_/Q
+ _2207_/Q VPWR VGND sg13cmos5l_mux4_1
XFILLER_204_71 VPWR VGND sg13cmos5l_decap_4
XFILLER_271_222 VPWR VGND sg13cmos5l_decap_8
XANTENNA__2934__D Tile_X0Y4_FrameData[10] VPWR VGND sg13cmos5l_antennanp
XANTENNA__3234__GATE Tile_X0Y5_FrameStrobe[5] VPWR VGND sg13cmos5l_antennanp
XFILLER_224_171 VPWR VGND sg13cmos5l_fill_2
XANTENNA__2490__GATE Tile_X0Y5_FrameStrobe[7] VPWR VGND sg13cmos5l_antennanp
XFILLER_33_24 VPWR VGND sg13cmos5l_decap_8
XFILLER_169_259 VPWR VGND sg13cmos5l_fill_2
XANTENNA__3249__GATE Tile_X0Y5_FrameStrobe[6] VPWR VGND sg13cmos5l_antennanp
XFILLER_137_101 VPWR VGND sg13cmos5l_decap_4
XFILLER_149_46 VPWR VGND sg13cmos5l_decap_8
XANTENNA__0793__A2 Tile_X0Y3_W6END[11] VPWR VGND sg13cmos5l_antennanp
XFILLER_137_156 VPWR VGND sg13cmos5l_fill_2
XANTENNA__3407__X Tile_X0Y2_FrameData_O[9] VPWR VGND sg13cmos5l_antennanp
XFILLER_165_23 VPWR VGND sg13cmos5l_fill_1
XFILLER_181_11 VPWR VGND sg13cmos5l_decap_8
XFILLER_59_173 VPWR VGND sg13cmos5l_decap_8
XFILLER_58_76 VPWR VGND sg13cmos5l_decap_8
XANTENNA__2443__GATE Tile_X0Y5_FrameStrobe[6] VPWR VGND sg13cmos5l_antennanp
XANTENNA__3005__D Tile_X0Y4_FrameData[3] VPWR VGND sg13cmos5l_antennanp
XFILLER_207_138 VPWR VGND sg13cmos5l_decap_4
XFILLER_262_211 VPWR VGND sg13cmos5l_decap_8
XFILLER_262_244 VPWR VGND sg13cmos5l_fill_1
XANTENNA__1258__A0 Tile_X0Y0_W2MID[4] VPWR VGND sg13cmos5l_antennanp
XANTENNA__2844__D Tile_X0Y4_FrameData[4] VPWR VGND sg13cmos5l_antennanp
XFILLER_74_75 VPWR VGND sg13cmos5l_fill_1
XFILLER_74_64 VPWR VGND sg13cmos5l_decap_8
XANTENNA__2458__GATE Tile_X0Y5_FrameStrobe[6] VPWR VGND sg13cmos5l_antennanp
XFILLER_90_74 VPWR VGND sg13cmos5l_decap_8
XANTENNA__1025__A3 Tile_X0Y0_S4END[9] VPWR VGND sg13cmos5l_antennanp
XANTENNA__1430__A0 Tile_X0Y2_W2MID[4] VPWR VGND sg13cmos5l_antennanp
X_0700_ _0700_/X _3262_/Q _0698_/Y _0699_/Y VPWR VGND sg13cmos5l_a21o_1
XANTENNA__0784__A2 Tile_X0Y3_W6END[9] VPWR VGND sg13cmos5l_antennanp
XFILLER_183_273 VPWR VGND sg13cmos5l_fill_2
X_1680_ _3745_/A Tile_X0Y4_W2END[4] AXI_M_SOC_RDATA2 _1130_/X _1319_/X _2954_/Q _2953_/Q
+ VPWR VGND sg13cmos5l_mux4_1
XFILLER_143_148 VPWR VGND sg13cmos5l_decap_4
X_0631_ _0633_/B Tile_X0Y3_W6END[1] _2518_/Q VPWR VGND sg13cmos5l_nor2b_1
XFILLER_332_215 VPWR VGND sg13cmos5l_fill_1
X_3350_ Tile_X0Y2_E1BEG[0] _3350_/A VPWR VGND sg13cmos5l_buf_1
X_0562_ _0562_/X Tile_X0Y3_W1END[3] Tile_X0Y3_W2MID[0] Tile_X0Y3_W2END[0] _1351_/X
+ _2726_/Q _2725_/Q VPWR VGND sg13cmos5l_mux4_1
XFILLER_225_37 VPWR VGND sg13cmos5l_fill_1
X_2301_ _2301_/Q Tile_X0Y2_FrameData[3] Tile_X0Y5_FrameStrobe[1] VPWR VGND sg13cmos5l_dlhq_1
XFILLER_97_202 VPWR VGND sg13cmos5l_decap_8
XANTENNA__1923__D Tile_X0Y0_FrameData[29] VPWR VGND sg13cmos5l_antennanp
X_3281_ _3281_/Q Tile_X0Y5_FrameData[31] Tile_X0Y5_FrameStrobe[7] VPWR VGND sg13cmos5l_dlhq_1
X_2232_ _2232_/Q Tile_X0Y1_FrameData[24] Tile_X0Y5_FrameStrobe[8] VPWR VGND sg13cmos5l_dlhq_1
XANTENNA__1497__A0 Tile_X0Y3_W2MID[5] VPWR VGND sg13cmos5l_antennanp
X_2163_ _2163_/Q Tile_X0Y1_FrameData[29] Tile_X0Y5_FrameStrobe[6] VPWR VGND sg13cmos5l_dlhq_1
XFILLER_65_132 VPWR VGND sg13cmos5l_fill_1
X_1114_ _1114_/X Tile_X0Y0_W1END[3] Tile_X0Y0_W2MID[0] Tile_X0Y0_W2END[0] _1136_/X
+ _1910_/Q _1909_/Q VPWR VGND sg13cmos5l_mux4_1
XANTENNA__2754__D Tile_X0Y3_FrameData[14] VPWR VGND sg13cmos5l_antennanp
XFILLER_253_277 VPWR VGND sg13cmos5l_decap_4
X_2094_ _2094_/Q Tile_X0Y1_FrameData[2] Tile_X0Y5_FrameStrobe[3] VPWR VGND sg13cmos5l_dlhq_1
XFILLER_0_72 VPWR VGND sg13cmos5l_fill_2
X_1045_ _1045_/X _3534_/A _1043_/X Tile_X0Y0_S2MID[5] Tile_X0Y0_S2END[5] _1710_/Q
+ _1709_/Q VPWR VGND sg13cmos5l_mux4_1
XANTENNA__1300__X AXI_M_SOC_AWADDR1 VPWR VGND sg13cmos5l_antennanp
XFILLER_166_207 VPWR VGND sg13cmos5l_fill_1
XFILLER_166_229 VPWR VGND sg13cmos5l_decap_8
X_2996_ _2996_/Q Tile_X0Y4_FrameData[12] Tile_X0Y5_FrameStrobe[6] VPWR VGND sg13cmos5l_dlhq_1
XANTENNA__1421__A0 Tile_X0Y2_WW4END[0] VPWR VGND sg13cmos5l_antennanp
X_1947_ _1947_/Q Tile_X0Y0_FrameData[5] Tile_X0Y5_FrameStrobe[7] VPWR VGND sg13cmos5l_dlhq_1
X_1878_ _1878_/Q Tile_X0Y0_FrameData[10] Tile_X0Y5_FrameStrobe[5] VPWR VGND sg13cmos5l_dlhq_1
XFILLER_119_189 VPWR VGND sg13cmos5l_fill_1
XFILLER_134_126 VPWR VGND sg13cmos5l_fill_2
X_3617_ Tile_X0Y0_E6BEG[0] _3617_/A VPWR VGND sg13cmos5l_buf_1
X_0829_ _3836_/A _0771_/X _0696_/X _0695_/X _0786_/X _3173_/Q _3174_/Q VPWR VGND sg13cmos5l_mux4_1
X_3548_ Tile_X0Y0_N1BEG[3] _3548_/A VPWR VGND sg13cmos5l_buf_1
XANTENNA__2929__D Tile_X0Y4_FrameData[15] VPWR VGND sg13cmos5l_antennanp
XFILLER_282_32 VPWR VGND sg13cmos5l_decap_8
XANTENNA__1833__D Tile_X0Y0_FrameData[23] VPWR VGND sg13cmos5l_antennanp
XFILLER_135_59 VPWR VGND sg13cmos5l_decap_8
XFILLER_282_54 VPWR VGND sg13cmos5l_fill_1
X_3479_ Tile_X0Y1_EE4BEG[15] _3479_/A VPWR VGND sg13cmos5l_buf_1
XFILLER_88_279 VPWR VGND sg13cmos5l_fill_2
XFILLER_151_14 VPWR VGND sg13cmos5l_decap_8
XFILLER_229_252 VPWR VGND sg13cmos5l_decap_8
XFILLER_28_24 VPWR VGND sg13cmos5l_fill_1
XFILLER_28_35 VPWR VGND sg13cmos5l_decap_4
XFILLER_28_57 VPWR VGND sg13cmos5l_decap_8
XFILLER_56_121 VPWR VGND sg13cmos5l_decap_8
XANTENNA__3173__GATE Tile_X0Y5_FrameStrobe[3] VPWR VGND sg13cmos5l_antennanp
XANTENNA__3403__A Tile_X0Y2_FrameData[5] VPWR VGND sg13cmos5l_antennanp
XANTENNA__2664__D Tile_X0Y3_FrameData[8] VPWR VGND sg13cmos5l_antennanp
XANTENNA__3897__X Tile_X0Y5_S2BEG[2] VPWR VGND sg13cmos5l_antennanp
XFILLER_44_67 VPWR VGND sg13cmos5l_decap_8
XFILLER_44_45 VPWR VGND sg13cmos5l_decap_8
XANTENNA__1660__A0 Tile_X0Y4_W2END[6] VPWR VGND sg13cmos5l_antennanp
XANTENNA__3188__GATE Tile_X0Y5_FrameStrobe[4] VPWR VGND sg13cmos5l_antennanp
XFILLER_212_152 VPWR VGND sg13cmos5l_decap_4
XANTENNA__1210__X AXI_M_SOC_AWADDR20 VPWR VGND sg13cmos5l_antennanp
XFILLER_157_218 VPWR VGND sg13cmos5l_decap_8
XANTENNA__1007__A3 Tile_X0Y0_S4END[2] VPWR VGND sg13cmos5l_antennanp
XANTENNA__1412__A0 Tile_X0Y2_WW4END[1] VPWR VGND sg13cmos5l_antennanp
XFILLER_100_95 VPWR VGND sg13cmos5l_decap_8
XANTENNA__3111__GATE Tile_X0Y5_FrameStrobe[1] VPWR VGND sg13cmos5l_antennanp
XFILLER_176_44 VPWR VGND sg13cmos5l_decap_8
XFILLER_125_126 VPWR VGND sg13cmos5l_decap_4
XFILLER_107_0 VPWR VGND sg13cmos5l_fill_2
XANTENNA__2839__D Tile_X0Y4_FrameData[9] VPWR VGND sg13cmos5l_antennanp
XFILLER_69_53 VPWR VGND sg13cmos5l_decap_8
XANTENNA__1743__D Tile_X0Y0_FrameData[17] VPWR VGND sg13cmos5l_antennanp
XANTENNA__3126__GATE Tile_X0Y5_FrameStrobe[2] VPWR VGND sg13cmos5l_antennanp
XANTENNA__2382__GATE Tile_X0Y5_FrameStrobe[4] VPWR VGND sg13cmos5l_antennanp
XFILLER_85_74 VPWR VGND sg13cmos5l_decap_8
XANTENNA__1494__A3 AXI_M_SOC_RDATA10 VPWR VGND sg13cmos5l_antennanp
XANTENNA__2574__D Tile_X0Y3_FrameData[2] VPWR VGND sg13cmos5l_antennanp
XFILLER_211_17 VPWR VGND sg13cmos5l_fill_2
XFILLER_62_102 VPWR VGND sg13cmos5l_decap_8
XFILLER_47_198 VPWR VGND sg13cmos5l_fill_1
XANTENNA__2397__GATE Tile_X0Y5_FrameStrobe[4] VPWR VGND sg13cmos5l_antennanp
XANTENNA__3600__X Tile_X0Y0_FrameData_O[31] VPWR VGND sg13cmos5l_antennanp
XFILLER_141_91 VPWR VGND sg13cmos5l_decap_8
XFILLER_250_203 VPWR VGND sg13cmos5l_decap_8
XANTENNA__1651__A0 Tile_X0Y4_W1END[3] VPWR VGND sg13cmos5l_antennanp
X_2850_ _2850_/Q Tile_X0Y4_FrameData[30] Tile_X0Y5_FrameStrobe[2] VPWR VGND sg13cmos5l_dlhq_1
XANTENNA__2320__GATE Tile_X0Y5_FrameStrobe[2] VPWR VGND sg13cmos5l_antennanp
X_1801_ _1801_/Q Tile_X0Y0_FrameData[23] Tile_X0Y5_FrameStrobe[3] VPWR VGND sg13cmos5l_dlhq_1
XANTENNA__1403__A0 AXI_M_SOC_RDATA15 VPWR VGND sg13cmos5l_antennanp
XANTENNA__1918__D Tile_X0Y0_FrameData[2] VPWR VGND sg13cmos5l_antennanp
XANTENNA__2950__GATE Tile_X0Y5_FrameStrobe[5] VPWR VGND sg13cmos5l_antennanp
X_2781_ _2781_/Q Tile_X0Y3_FrameData[19] Tile_X0Y5_FrameStrobe[8] VPWR VGND sg13cmos5l_dlhq_1
X_1732_ _1732_/Q Tile_X0Y0_FrameData[28] Tile_X0Y5_FrameStrobe[1] VPWR VGND sg13cmos5l_dlhq_1
XANTENNA__0757__A2 Tile_X0Y5_WW4END[8] VPWR VGND sg13cmos5l_antennanp
XFILLER_116_137 VPWR VGND sg13cmos5l_decap_8
XFILLER_305_226 VPWR VGND sg13cmos5l_fill_2
X_1663_ _3739_/A Tile_X0Y4_W2MID[2] AXI_M_SOC_RDATA3 _1016_/X _1318_/X _2966_/Q _2965_/Q
+ VPWR VGND sg13cmos5l_mux4_1
XANTENNA__2335__GATE Tile_X0Y5_FrameStrobe[2] VPWR VGND sg13cmos5l_antennanp
XFILLER_171_243 VPWR VGND sg13cmos5l_decap_8
X_3402_ Tile_X0Y2_FrameData_O[4] Tile_X0Y2_FrameData[4] VPWR VGND sg13cmos5l_buf_1
X_0614_ _0614_/Y _1702_/Q Tile_X0Y0_S1END[1] VPWR VGND sg13cmos5l_nand2b_1
XANTENNA__2749__D Tile_X0Y3_FrameData[19] VPWR VGND sg13cmos5l_antennanp
XANTENNA__2965__GATE Tile_X0Y5_FrameStrobe[5] VPWR VGND sg13cmos5l_antennanp
X_1594_ _3918_/A _1593_/X _1592_/X _2713_/Q VPWR VGND sg13cmos5l_mux2_1
XANTENNA__1182__A2 Tile_X0Y4_W6END[2] VPWR VGND sg13cmos5l_antennanp
X_3333_ _3333_/Q Tile_X0Y5_FrameData[31] Tile_X0Y5_FrameStrobe[9] VPWR VGND sg13cmos5l_dlhq_1
X_0545_ _0545_/Y _3297_/Q VPWR VGND sg13cmos5l_inv_1
XFILLER_105_18 VPWR VGND sg13cmos5l_decap_8
XFILLER_22_0 VPWR VGND sg13cmos5l_fill_2
XFILLER_285_144 VPWR VGND sg13cmos5l_decap_8
X_3264_ _3264_/Q Tile_X0Y5_FrameData[16] Tile_X0Y5_FrameStrobe[6] VPWR VGND sg13cmos5l_dlhq_1
X_2215_ _2215_/Q Tile_X0Y1_FrameData[9] Tile_X0Y5_FrameStrobe[7] VPWR VGND sg13cmos5l_dlhq_1
X_3195_ _3195_/Q Tile_X0Y5_FrameData[21] Tile_X0Y5_FrameStrobe[4] VPWR VGND sg13cmos5l_dlhq_1
XANTENNA__2484__D Tile_X0Y2_FrameData[12] VPWR VGND sg13cmos5l_antennanp
X_2146_ _2146_/Q Tile_X0Y1_FrameData[14] Tile_X0Y5_FrameStrobe[5] VPWR VGND sg13cmos5l_dlhq_1
XANTENNA__2903__GATE Tile_X0Y5_FrameStrobe[3] VPWR VGND sg13cmos5l_antennanp
XANTENNA__3510__X Tile_X0Y1_E1BEG[2] VPWR VGND sg13cmos5l_antennanp
XFILLER_226_277 VPWR VGND sg13cmos5l_fill_2
XFILLER_241_225 VPWR VGND sg13cmos5l_decap_4
X_2077_ _2077_/Q Tile_X0Y1_FrameData[19] Tile_X0Y5_FrameStrobe[3] VPWR VGND sg13cmos5l_dlhq_1
XFILLER_241_247 VPWR VGND sg13cmos5l_decap_4
X_1028_ _1028_/X _1027_/X _1026_/X _1904_/Q VPWR VGND sg13cmos5l_mux2_1
XFILLER_53_179 VPWR VGND sg13cmos5l_decap_8
XANTENNA__0582__A Tile_X0Y3_W6END[0] VPWR VGND sg13cmos5l_antennanp
XANTENNA__1642__A0 Tile_X0Y4_WW4END[3] VPWR VGND sg13cmos5l_antennanp
XANTENNA__0996__A2 Tile_X0Y5_N4END[6] VPWR VGND sg13cmos5l_antennanp
XANTENNA__1828__D Tile_X0Y0_FrameData[28] VPWR VGND sg13cmos5l_antennanp
XANTENNA__2918__GATE Tile_X0Y5_FrameStrobe[4] VPWR VGND sg13cmos5l_antennanp
XFILLER_277_54 VPWR VGND sg13cmos5l_fill_1
X_2979_ _2979_/Q Tile_X0Y4_FrameData[29] Tile_X0Y5_FrameStrobe[6] VPWR VGND sg13cmos5l_dlhq_1
XFILLER_147_240 VPWR VGND sg13cmos5l_decap_8
XFILLER_30_14 VPWR VGND sg13cmos5l_fill_1
XFILLER_162_210 VPWR VGND sg13cmos5l_decap_8
XFILLER_30_36 VPWR VGND sg13cmos5l_fill_2
XFILLER_30_47 VPWR VGND sg13cmos5l_decap_8
XFILLER_162_254 VPWR VGND sg13cmos5l_fill_2
XANTENNA__2659__D Tile_X0Y3_FrameData[13] VPWR VGND sg13cmos5l_antennanp
XFILLER_146_58 VPWR VGND sg13cmos5l_decap_4
XFILLER_162_276 VPWR VGND sg13cmos5l_fill_2
XFILLER_311_218 VPWR VGND sg13cmos5l_fill_1
XANTENNA__1173__A2 Tile_X0Y1_W2END[1] VPWR VGND sg13cmos5l_antennanp
XFILLER_130_151 VPWR VGND sg13cmos5l_decap_8
XFILLER_76_205 VPWR VGND sg13cmos5l_decap_8
XANTENNA__0920__A2 Tile_X0Y1_W6END[4] VPWR VGND sg13cmos5l_antennanp
XFILLER_276_155 VPWR VGND sg13cmos5l_fill_2
XANTENNA__1205__X AXI_M_SOC_AWADDR24 VPWR VGND sg13cmos5l_antennanp
XFILLER_29_132 VPWR VGND sg13cmos5l_fill_1
XANTENNA__1476__A3 AXI_M_SOC_RDATA20 VPWR VGND sg13cmos5l_antennanp
XANTENNA__2394__D Tile_X0Y2_FrameData[6] VPWR VGND sg13cmos5l_antennanp
XFILLER_29_176 VPWR VGND sg13cmos5l_decap_8
XFILLER_44_102 VPWR VGND sg13cmos5l_decap_8
XANTENNA__0684__A1 Tile_X0Y3_W6END[10] VPWR VGND sg13cmos5l_antennanp
XANTENNA__3420__X Tile_X0Y2_FrameData_O[22] VPWR VGND sg13cmos5l_antennanp
XFILLER_84_293 VPWR VGND sg13cmos5l_fill_2
XFILLER_55_77 VPWR VGND sg13cmos5l_decap_8
XFILLER_44_135 VPWR VGND sg13cmos5l_decap_8
XANTENNA__1633__A0 AXI_M_SOC_RDATA5 VPWR VGND sg13cmos5l_antennanp
XFILLER_111_50 VPWR VGND sg13cmos5l_fill_2
XFILLER_197_140 VPWR VGND sg13cmos5l_decap_4
XFILLER_71_21 VPWR VGND sg13cmos5l_decap_8
XFILLER_187_10 VPWR VGND sg13cmos5l_fill_1
XANTENNA__1738__D Tile_X0Y0_FrameData[22] VPWR VGND sg13cmos5l_antennanp
XANTENNA__3050__GATE Tile_X0Y5_FrameStrobe[8] VPWR VGND sg13cmos5l_antennanp
XFILLER_200_144 VPWR VGND sg13cmos5l_decap_8
XFILLER_224_0 VPWR VGND sg13cmos5l_fill_2
XFILLER_71_98 VPWR VGND sg13cmos5l_decap_8
XFILLER_138_262 VPWR VGND sg13cmos5l_decap_8
XFILLER_187_98 VPWR VGND sg13cmos5l_decap_4
XFILLER_337_57 VPWR VGND sg13cmos5l_fill_1
XFILLER_299_214 VPWR VGND sg13cmos5l_decap_8
XANTENNA__3065__GATE Tile_X0Y5_FrameStrobe[0] VPWR VGND sg13cmos5l_antennanp
XFILLER_113_118 VPWR VGND sg13cmos5l_decap_8
XANTENNA__2569__D Tile_X0Y3_FrameData[7] VPWR VGND sg13cmos5l_antennanp
XFILLER_96_95 VPWR VGND sg13cmos5l_decap_4
XFILLER_67_249 VPWR VGND sg13cmos5l_decap_4
XFILLER_282_136 VPWR VGND sg13cmos5l_fill_1
X_2000_ _2000_/Q Tile_X0Y1_FrameData[0] Tile_X0Y5_FrameStrobe[0] VPWR VGND sg13cmos5l_dlhq_1
XFILLER_35_102 VPWR VGND sg13cmos5l_fill_2
XANTENNA__3003__GATE Tile_X0Y5_FrameStrobe[6] VPWR VGND sg13cmos5l_antennanp
XFILLER_75_293 VPWR VGND sg13cmos5l_fill_2
XANTENNA__1624__A0 AXI_M_SOC_RDATA4 VPWR VGND sg13cmos5l_antennanp
X_2902_ _2902_/Q Tile_X0Y4_FrameData[10] Tile_X0Y5_FrameStrobe[3] VPWR VGND sg13cmos5l_dlhq_1
XFILLER_90_285 VPWR VGND sg13cmos5l_fill_2
X_3882_ Tile_X0Y5_FrameData_O[23] Tile_X0Y5_FrameData[23] VPWR VGND sg13cmos5l_buf_1
XFILLER_50_149 VPWR VGND sg13cmos5l_decap_8
XFILLER_43_190 VPWR VGND sg13cmos5l_fill_2
XFILLER_337_104 VPWR VGND sg13cmos5l_decap_4
XANTENNA__3018__GATE Tile_X0Y5_FrameStrobe[7] VPWR VGND sg13cmos5l_antennanp
X_2833_ _2833_/Q Tile_X0Y4_FrameData[15] Tile_X0Y5_FrameStrobe[1] VPWR VGND sg13cmos5l_dlhq_1
XFILLER_129_262 VPWR VGND sg13cmos5l_fill_1
X_2764_ _2764_/Q Tile_X0Y3_FrameData[4] Tile_X0Y5_FrameStrobe[7] VPWR VGND sg13cmos5l_dlhq_1
XANTENNA__2274__GATE Tile_X0Y5_FrameStrobe[1] VPWR VGND sg13cmos5l_antennanp
X_1715_ _1715_/Q Tile_X0Y0_FrameData[13] Tile_X0Y5_FrameStrobe[0] VPWR VGND sg13cmos5l_dlhq_1
XFILLER_144_243 VPWR VGND sg13cmos5l_decap_8
X_2695_ _2695_/Q Tile_X0Y3_FrameData[9] Tile_X0Y5_FrameStrobe[5] VPWR VGND sg13cmos5l_dlhq_1
X_1646_ AXI_M_SOC_ARADDR20 Tile_X0Y4_W2MID[4] Tile_X0Y4_W2END[4] Tile_X0Y4_W6END[4]
+ _1319_/X _2848_/Q _2847_/Q VPWR VGND sg13cmos5l_mux4_1
XANTENNA__2479__D Tile_X0Y2_FrameData[17] VPWR VGND sg13cmos5l_antennanp
X_1577_ _1577_/Y _2723_/Q _1576_/X _2722_/Q VPWR VGND sg13cmos5l_o21ai_1
XANTENNA__1155__A2 Tile_X0Y1_W6END[8] VPWR VGND sg13cmos5l_antennanp
XANTENNA__2289__GATE Tile_X0Y5_FrameStrobe[1] VPWR VGND sg13cmos5l_antennanp
XANTENNA__3505__X Tile_X0Y1_E2BEG[5] VPWR VGND sg13cmos5l_antennanp
XFILLER_112_140 VPWR VGND sg13cmos5l_fill_2
XFILLER_263_56 VPWR VGND sg13cmos5l_decap_4
XFILLER_263_67 VPWR VGND sg13cmos5l_decap_8
X_3316_ _3316_/Q Tile_X0Y5_FrameData[28] Tile_X0Y5_FrameStrobe[8] VPWR VGND sg13cmos5l_dlhq_1
XFILLER_112_173 VPWR VGND sg13cmos5l_decap_8
XFILLER_273_103 VPWR VGND sg13cmos5l_fill_1
XFILLER_58_249 VPWR VGND sg13cmos5l_decap_8
XFILLER_58_238 VPWR VGND sg13cmos5l_fill_1
XFILLER_132_27 VPWR VGND sg13cmos5l_fill_2
X_3247_ _3247_/Q Tile_X0Y5_FrameData[1] Tile_X0Y5_FrameStrobe[5] VPWR VGND sg13cmos5l_dlhq_1
XANTENNA__2212__GATE Tile_X0Y5_FrameStrobe[7] VPWR VGND sg13cmos5l_antennanp
XANTENNA__2842__GATE Tile_X0Y5_FrameStrobe[1] VPWR VGND sg13cmos5l_antennanp
X_3178_ _3178_/Q Tile_X0Y5_FrameData[6] Tile_X0Y5_FrameStrobe[3] VPWR VGND sg13cmos5l_dlhq_1
XANTENNA__0666__A1 Tile_X0Y0_W6END[10] VPWR VGND sg13cmos5l_antennanp
XANTENNA__3103__D Tile_X0Y5_FrameData[17] VPWR VGND sg13cmos5l_antennanp
XANTENNA__3888__A Tile_X0Y5_FrameData[29] VPWR VGND sg13cmos5l_antennanp
XFILLER_214_203 VPWR VGND sg13cmos5l_fill_1
X_2129_ _2129_/Q Tile_X0Y1_FrameData[31] Tile_X0Y5_FrameStrobe[5] VPWR VGND sg13cmos5l_dlhq_1
XFILLER_66_293 VPWR VGND sg13cmos5l_fill_2
XANTENNA__1615__A0 Tile_X0Y4_WW4END[11] VPWR VGND sg13cmos5l_antennanp
XANTENNA__2227__GATE Tile_X0Y5_FrameStrobe[8] VPWR VGND sg13cmos5l_antennanp
XANTENNA__2942__D Tile_X0Y4_FrameData[2] VPWR VGND sg13cmos5l_antennanp
XFILLER_155_8 VPWR VGND sg13cmos5l_fill_1
XFILLER_81_285 VPWR VGND sg13cmos5l_fill_2
XANTENNA__2857__GATE Tile_X0Y5_FrameStrobe[2] VPWR VGND sg13cmos5l_antennanp
XFILLER_179_162 VPWR VGND sg13cmos5l_fill_1
XFILLER_41_149 VPWR VGND sg13cmos5l_decap_8
XANTENNA__0969__A2 Tile_X0Y1_WW4END[7] VPWR VGND sg13cmos5l_antennanp
XANTENNA__1091__A1 Tile_X0Y3_W2END[4] VPWR VGND sg13cmos5l_antennanp
XFILLER_41_13 VPWR VGND sg13cmos5l_decap_8
XFILLER_336_181 VPWR VGND sg13cmos5l_fill_2
XANTENNA__2389__D Tile_X0Y2_FrameData[11] VPWR VGND sg13cmos5l_antennanp
XFILLER_1_223 VPWR VGND sg13cmos5l_decap_8
XANTENNA__1146__A2 Tile_X0Y0_W6END[4] VPWR VGND sg13cmos5l_antennanp
XANTENNA__3415__X Tile_X0Y2_FrameData_O[17] VPWR VGND sg13cmos5l_antennanp
XFILLER_103_162 VPWR VGND sg13cmos5l_decap_8
XFILLER_323_59 VPWR VGND sg13cmos5l_fill_1
XFILLER_323_48 VPWR VGND sg13cmos5l_fill_2
XFILLER_264_169 VPWR VGND sg13cmos5l_decap_4
XFILLER_66_76 VPWR VGND sg13cmos5l_decap_8
XANTENNA__3013__D Tile_X0Y4_FrameData[27] VPWR VGND sg13cmos5l_antennanp
XANTENNA__3798__A Tile_X0Y4_FrameData[20] VPWR VGND sg13cmos5l_antennanp
XFILLER_174_0 VPWR VGND sg13cmos5l_fill_2
XFILLER_57_293 VPWR VGND sg13cmos5l_fill_2
XFILLER_122_71 VPWR VGND sg13cmos5l_fill_2
XFILLER_17_179 VPWR VGND sg13cmos5l_decap_4
XFILLER_32_105 VPWR VGND sg13cmos5l_fill_2
XANTENNA__1606__A0 Tile_X0Y3_W1END[1] VPWR VGND sg13cmos5l_antennanp
XANTENNA__2852__D Tile_X0Y4_FrameData[28] VPWR VGND sg13cmos5l_antennanp
XFILLER_82_64 VPWR VGND sg13cmos5l_decap_8
XFILLER_198_64 VPWR VGND sg13cmos5l_decap_8
XANTENNA__1082__A1 Tile_X0Y3_W2END[1] VPWR VGND sg13cmos5l_antennanp
XANTENNA__0593__A0 Tile_X0Y1_W6END[4] VPWR VGND sg13cmos5l_antennanp
XFILLER_217_27 VPWR VGND sg13cmos5l_decap_8
X_2480_ _2480_/Q Tile_X0Y2_FrameData[16] Tile_X0Y5_FrameStrobe[7] VPWR VGND sg13cmos5l_dlhq_1
X_1500_ _3663_/A Tile_X0Y3_W2END[5] AXI_M_SOC_RDATA11 _1216_/X _1342_/X _2684_/Q _2683_/Q
+ VPWR VGND sg13cmos5l_mux4_1
XANTENNA__2299__D Tile_X0Y2_FrameData[5] VPWR VGND sg13cmos5l_antennanp
X_1431_ AXI_M_SOC_WDATA27 Tile_X0Y2_W2MID[3] Tile_X0Y2_W2END[3] Tile_X0Y2_W6END[3]
+ _1187_/X _2306_/Q _2305_/Q VPWR VGND sg13cmos5l_mux4_1
XANTENNA__1137__A2 Tile_X0Y0_S1END[3] VPWR VGND sg13cmos5l_antennanp
X_3101_ _3101_/Q Tile_X0Y5_FrameData[19] Tile_X0Y5_FrameStrobe[1] VPWR VGND sg13cmos5l_dlhq_1
X_1362_ _1363_/B Tile_X0Y2_W1END[0] Tile_X0Y2_W6END[4] Tile_X0Y2_WW4END[12] _1357_/X
+ _2451_/Q _2452_/Q VPWR VGND sg13cmos5l_mux4_1
XANTENNA__1931__D Tile_X0Y0_FrameData[21] VPWR VGND sg13cmos5l_antennanp
XFILLER_233_48 VPWR VGND sg13cmos5l_decap_8
XFILLER_295_294 VPWR VGND sg13cmos5l_fill_1
X_1293_ _3483_/A _0904_/Y _0947_/X Tile_X0Y0_S4END[7] _0959_/X _2089_/Q _2090_/Q VPWR
+ VGND sg13cmos5l_mux4_1
X_3032_ _3032_/Q Tile_X0Y4_FrameData[8] Tile_X0Y5_FrameStrobe[7] VPWR VGND sg13cmos5l_dlhq_1
XANTENNA__0648__A1 Tile_X0Y5_N4END[1] VPWR VGND sg13cmos5l_antennanp
XFILLER_48_293 VPWR VGND sg13cmos5l_fill_2
XANTENNA__2762__D Tile_X0Y3_FrameData[6] VPWR VGND sg13cmos5l_antennanp
XFILLER_63_285 VPWR VGND sg13cmos5l_fill_2
XFILLER_211_228 VPWR VGND sg13cmos5l_fill_1
X_3865_ Tile_X0Y5_FrameData_O[6] Tile_X0Y5_FrameData[6] VPWR VGND sg13cmos5l_buf_1
XFILLER_258_45 VPWR VGND sg13cmos5l_fill_1
X_2816_ _2816_/Q Tile_X0Y4_FrameData[0] Tile_X0Y5_FrameStrobe[0] VPWR VGND sg13cmos5l_dlhq_1
XFILLER_31_193 VPWR VGND sg13cmos5l_fill_2
X_3796_ Tile_X0Y4_FrameData_O[18] Tile_X0Y4_FrameData[18] VPWR VGND sg13cmos5l_buf_1
XFILLER_117_232 VPWR VGND sg13cmos5l_decap_8
XFILLER_274_11 VPWR VGND sg13cmos5l_fill_1
X_2747_ _2747_/Q Tile_X0Y3_FrameData[21] Tile_X0Y5_FrameStrobe[7] VPWR VGND sg13cmos5l_dlhq_1
XFILLER_117_276 VPWR VGND sg13cmos5l_fill_1
XFILLER_127_49 VPWR VGND sg13cmos5l_fill_2
X_2678_ _2678_/Q Tile_X0Y3_FrameData[26] Tile_X0Y5_FrameStrobe[5] VPWR VGND sg13cmos5l_dlhq_1
XFILLER_333_162 VPWR VGND sg13cmos5l_decap_8
XFILLER_333_140 VPWR VGND sg13cmos5l_fill_2
X_1629_ _3754_/A AXI_M_SOC_RRESP0 _1126_/X _1125_/X _1073_/X _2903_/Q _2904_/Q VPWR
+ VGND sg13cmos5l_mux4_1
XANTENNA__1128__A2 Tile_X0Y2_W6END[11] VPWR VGND sg13cmos5l_antennanp
XANTENNA__2002__D Tile_X0Y1_FrameData[30] VPWR VGND sg13cmos5l_antennanp
XFILLER_207_71 VPWR VGND sg13cmos5l_fill_2
XFILLER_98_171 VPWR VGND sg13cmos5l_fill_1
XANTENNA__1841__D Tile_X0Y0_FrameData[15] VPWR VGND sg13cmos5l_antennanp
XANTENNA__2151__GATE Tile_X0Y5_FrameStrobe[5] VPWR VGND sg13cmos5l_antennanp
XANTENNA__2937__D Tile_X0Y4_FrameData[7] VPWR VGND sg13cmos5l_antennanp
XFILLER_100_143 VPWR VGND sg13cmos5l_decap_8
XFILLER_290_43 VPWR VGND sg13cmos5l_fill_2
XANTENNA__2781__GATE Tile_X0Y5_FrameStrobe[8] VPWR VGND sg13cmos5l_antennanp
XFILLER_272_8 VPWR VGND sg13cmos5l_fill_1
XFILLER_100_198 VPWR VGND sg13cmos5l_decap_8
XFILLER_39_293 VPWR VGND sg13cmos5l_fill_2
XANTENNA__1300__A2 Tile_X0Y1_W6END[1] VPWR VGND sg13cmos5l_antennanp
XANTENNA__2166__GATE Tile_X0Y5_FrameStrobe[6] VPWR VGND sg13cmos5l_antennanp
XANTENNA__3411__A Tile_X0Y2_FrameData[13] VPWR VGND sg13cmos5l_antennanp
XFILLER_54_263 VPWR VGND sg13cmos5l_decap_8
XANTENNA__2672__D Tile_X0Y3_FrameData[0] VPWR VGND sg13cmos5l_antennanp
XANTENNA__2796__GATE Tile_X0Y5_FrameStrobe[0] VPWR VGND sg13cmos5l_antennanp
XFILLER_14_116 VPWR VGND sg13cmos5l_decap_8
XFILLER_199_257 VPWR VGND sg13cmos5l_fill_1
XFILLER_14_149 VPWR VGND sg13cmos5l_decap_4
XFILLER_146_4 VPWR VGND sg13cmos5l_fill_1
XFILLER_168_12 VPWR VGND sg13cmos5l_fill_1
XFILLER_168_67 VPWR VGND sg13cmos5l_fill_1
XFILLER_22_171 VPWR VGND sg13cmos5l_fill_1
XFILLER_168_78 VPWR VGND sg13cmos5l_decap_8
XFILLER_168_89 VPWR VGND sg13cmos5l_fill_1
XANTENNA__2104__GATE Tile_X0Y5_FrameStrobe[4] VPWR VGND sg13cmos5l_antennanp
XFILLER_184_33 VPWR VGND sg13cmos5l_fill_2
XANTENNA__2734__GATE Tile_X0Y5_FrameStrobe[6] VPWR VGND sg13cmos5l_antennanp
XANTENNA__3008__D Tile_X0Y4_FrameData[0] VPWR VGND sg13cmos5l_antennanp
XFILLER_269_239 VPWR VGND sg13cmos5l_fill_1
XANTENNA__1990__GATE Tile_X0Y5_FrameStrobe[0] VPWR VGND sg13cmos5l_antennanp
XANTENNA__2119__GATE Tile_X0Y5_FrameStrobe[4] VPWR VGND sg13cmos5l_antennanp
XFILLER_291_0 VPWR VGND sg13cmos5l_fill_2
XFILLER_89_182 VPWR VGND sg13cmos5l_decap_8
XFILLER_89_160 VPWR VGND sg13cmos5l_fill_1
XANTENNA__1751__D Tile_X0Y0_FrameData[9] VPWR VGND sg13cmos5l_antennanp
XANTENNA__2749__GATE Tile_X0Y5_FrameStrobe[7] VPWR VGND sg13cmos5l_antennanp
XANTENNA__2847__D Tile_X0Y4_FrameData[1] VPWR VGND sg13cmos5l_antennanp
XFILLER_292_220 VPWR VGND sg13cmos5l_decap_4
XFILLER_37_219 VPWR VGND sg13cmos5l_decap_8
XFILLER_93_74 VPWR VGND sg13cmos5l_fill_1
XANTENNA__2582__D Tile_X0Y3_FrameData[26] VPWR VGND sg13cmos5l_antennanp
X_1980_ _1980_/Q Tile_X0Y1_FrameData[20] Tile_X0Y5_FrameStrobe[0] VPWR VGND sg13cmos5l_dlhq_1
XFILLER_13_160 VPWR VGND sg13cmos5l_decap_8
X_0931_ _0931_/Y _0931_/A VPWR VGND sg13cmos5l_inv_1
XANTENNA__0680__A Tile_X0Y3_W6END[2] VPWR VGND sg13cmos5l_antennanp
XFILLER_307_107 VPWR VGND sg13cmos5l_decap_8
X_3650_ Tile_X0Y3_E1BEG[1] _3650_/A VPWR VGND sg13cmos5l_buf_1
X_0862_ _0862_/Y _3120_/Q Tile_X0Y5_W6END[4] VPWR VGND sg13cmos5l_nor2b_1
XANTENNA__1926__D Tile_X0Y0_FrameData[26] VPWR VGND sg13cmos5l_antennanp
XANTENNA__1943__GATE Tile_X0Y5_FrameStrobe[7] VPWR VGND sg13cmos5l_antennanp
X_2601_ _2601_/Q Tile_X0Y3_FrameData[7] Tile_X0Y5_FrameStrobe[2] VPWR VGND sg13cmos5l_dlhq_1
X_3581_ Tile_X0Y0_FrameData_O[12] Tile_X0Y0_FrameData[12] VPWR VGND sg13cmos5l_buf_1
X_0793_ _0793_/X Tile_X0Y3_W2MID[4] Tile_X0Y3_W2END[4] Tile_X0Y3_W6END[11] _1587_/B
+ _2734_/Q _2733_/Q VPWR VGND sg13cmos5l_mux4_1
XFILLER_61_4 VPWR VGND sg13cmos5l_fill_1
XANTENNA__1358__A2 Tile_X0Y2_WW4END[0] VPWR VGND sg13cmos5l_antennanp
X_2532_ _2532_/Q Tile_X0Y3_FrameData[12] Tile_X0Y5_FrameStrobe[0] VPWR VGND sg13cmos5l_dlhq_1
XFILLER_114_224 VPWR VGND sg13cmos5l_fill_2
X_2463_ _2463_/Q Tile_X0Y2_FrameData[1] Tile_X0Y5_FrameStrobe[6] VPWR VGND sg13cmos5l_dlhq_1
XANTENNA__1958__GATE Tile_X0Y5_FrameStrobe[8] VPWR VGND sg13cmos5l_antennanp
X_2394_ _2394_/Q Tile_X0Y2_FrameData[6] Tile_X0Y5_FrameStrobe[4] VPWR VGND sg13cmos5l_dlhq_1
X_1414_ AXI_M_SOC_WDATA12 Tile_X0Y2_WW4END[4] Tile_X0Y2_WW4END[12] Tile_X0Y2_W6END[4]
+ _1312_/X _2336_/Q _2335_/Q VPWR VGND sg13cmos5l_mux4_1
XANTENNA__2757__D Tile_X0Y3_FrameData[11] VPWR VGND sg13cmos5l_antennanp
X_1345_ _3521_/A _1344_/X _1343_/X _2215_/Q VPWR VGND sg13cmos5l_mux2_1
XANTENNA__1530__A2 Tile_X0Y5_N4END[9] VPWR VGND sg13cmos5l_antennanp
XFILLER_283_231 VPWR VGND sg13cmos5l_decap_8
XFILLER_283_242 VPWR VGND sg13cmos5l_fill_1
XFILLER_283_253 VPWR VGND sg13cmos5l_fill_1
XFILLER_28_208 VPWR VGND sg13cmos5l_decap_8
XFILLER_283_275 VPWR VGND sg13cmos5l_fill_1
X_3015_ _3015_/Q Tile_X0Y4_FrameData[25] Tile_X0Y5_FrameStrobe[7] VPWR VGND sg13cmos5l_dlhq_1
X_1276_ _3470_/A Tile_X0Y1_WW4END[9] AXI_M_SOC_RDATA28 _0950_/X _1105_/X _2116_/Q
+ _2115_/Q VPWR VGND sg13cmos5l_mux4_1
XFILLER_95_196 VPWR VGND sg13cmos5l_decap_8
XFILLER_51_211 VPWR VGND sg13cmos5l_decap_8
XANTENNA__2492__D Tile_X0Y2_FrameData[4] VPWR VGND sg13cmos5l_antennanp
XFILLER_51_244 VPWR VGND sg13cmos5l_decap_8
XFILLER_11_108 VPWR VGND sg13cmos5l_decap_8
XFILLER_338_221 VPWR VGND sg13cmos5l_fill_1
XANTENNA__0861__Y AXI_M_SOC_ARLEN3 VPWR VGND sg13cmos5l_antennanp
XFILLER_149_154 VPWR VGND sg13cmos5l_decap_8
X_3917_ Tile_X0Y5_S4BEG[6] _3917_/A VPWR VGND sg13cmos5l_buf_1
XFILLER_338_243 VPWR VGND sg13cmos5l_fill_1
XFILLER_285_10 VPWR VGND sg13cmos5l_fill_1
XFILLER_285_21 VPWR VGND sg13cmos5l_fill_2
X_3848_ Tile_X0Y5_EE4BEG[5] _3848_/A VPWR VGND sg13cmos5l_buf_1
XANTENNA__1836__D Tile_X0Y0_FrameData[20] VPWR VGND sg13cmos5l_antennanp
XFILLER_164_157 VPWR VGND sg13cmos5l_decap_4
X_3779_ Tile_X0Y4_FrameData_O[1] Tile_X0Y4_FrameData[1] VPWR VGND sg13cmos5l_buf_1
XANTENNA__0557__A0 Tile_X0Y4_W1END[2] VPWR VGND sg13cmos5l_antennanp
XANTENNA__1349__A2 Tile_X0Y5_W6END[0] VPWR VGND sg13cmos5l_antennanp
XFILLER_306_184 VPWR VGND sg13cmos5l_decap_4
XANTENNA__3406__A Tile_X0Y2_FrameData[8] VPWR VGND sg13cmos5l_antennanp
XFILLER_172_190 VPWR VGND sg13cmos5l_fill_2
XFILLER_218_92 VPWR VGND sg13cmos5l_fill_1
XANTENNA__2090__GATE Tile_X0Y5_FrameStrobe[3] VPWR VGND sg13cmos5l_antennanp
XANTENNA__2667__D Tile_X0Y3_FrameData[5] VPWR VGND sg13cmos5l_antennanp
XFILLER_120_249 VPWR VGND sg13cmos5l_decap_8
XFILLER_219_114 VPWR VGND sg13cmos5l_decap_8
XANTENNA__1521__A2 Tile_X0Y5_N4END[8] VPWR VGND sg13cmos5l_antennanp
XFILLER_19_208 VPWR VGND sg13cmos5l_decap_8
XFILLER_219_136 VPWR VGND sg13cmos5l_fill_1
XFILLER_86_152 VPWR VGND sg13cmos5l_decap_8
XANTENNA__1213__X AXI_M_SOC_AWADDR31 VPWR VGND sg13cmos5l_antennanp
XFILLER_170_79 VPWR VGND sg13cmos5l_decap_8
XANTENNA__1285__A1 AXI_M_SOC_RDATA24 VPWR VGND sg13cmos5l_antennanp
XFILLER_27_285 VPWR VGND sg13cmos5l_fill_2
XFILLER_179_11 VPWR VGND sg13cmos5l_fill_1
XFILLER_179_33 VPWR VGND sg13cmos5l_fill_1
XFILLER_63_44 VPWR VGND sg13cmos5l_decap_8
XFILLER_42_244 VPWR VGND sg13cmos5l_decap_4
XFILLER_187_238 VPWR VGND sg13cmos5l_decap_8
XFILLER_137_0 VPWR VGND sg13cmos5l_decap_8
XANTENNA__0796__A0 Tile_X0Y5_W2MID[3] VPWR VGND sg13cmos5l_antennanp
XFILLER_10_141 VPWR VGND sg13cmos5l_decap_8
XFILLER_155_113 VPWR VGND sg13cmos5l_decap_4
XFILLER_6_101 VPWR VGND sg13cmos5l_decap_4
XFILLER_329_47 VPWR VGND sg13cmos5l_fill_1
XANTENNA__1746__D Tile_X0Y0_FrameData[14] VPWR VGND sg13cmos5l_antennanp
XANTENNA__2043__GATE Tile_X0Y5_FrameStrobe[2] VPWR VGND sg13cmos5l_antennanp
XFILLER_195_293 VPWR VGND sg13cmos5l_fill_2
XFILLER_195_32 VPWR VGND sg13cmos5l_fill_1
XANTENNA__2673__GATE Tile_X0Y5_FrameStrobe[5] VPWR VGND sg13cmos5l_antennanp
XANTENNA__2058__GATE Tile_X0Y5_FrameStrobe[2] VPWR VGND sg13cmos5l_antennanp
XANTENNA__2577__D Tile_X0Y3_FrameData[31] VPWR VGND sg13cmos5l_antennanp
XANTENNA__2688__GATE Tile_X0Y5_FrameStrobe[5] VPWR VGND sg13cmos5l_antennanp
XANTENNA__1512__A2 Tile_X0Y5_N4END[10] VPWR VGND sg13cmos5l_antennanp
XANTENNA__3603__X Tile_X0Y0_EE4BEG[2] VPWR VGND sg13cmos5l_antennanp
X_1130_ _1130_/X _1129_/X _0793_/X Tile_X0Y5_N2MID[3] _1128_/X _2801_/Q _2802_/Q VPWR
+ VGND sg13cmos5l_mux4_1
XANTENNA__0946__Y AXI_M_SOC_AWSIZE2 VPWR VGND sg13cmos5l_antennanp
XANTENNA__2611__GATE Tile_X0Y5_FrameStrobe[3] VPWR VGND sg13cmos5l_antennanp
XFILLER_218_180 VPWR VGND sg13cmos5l_fill_1
XFILLER_280_234 VPWR VGND sg13cmos5l_decap_4
X_1061_ _1061_/X _1060_/X _1059_/X _1907_/Q VPWR VGND sg13cmos5l_mux2_1
XANTENNA__1276__A1 AXI_M_SOC_RDATA28 VPWR VGND sg13cmos5l_antennanp
XFILLER_233_172 VPWR VGND sg13cmos5l_decap_8
XFILLER_233_183 VPWR VGND sg13cmos5l_fill_1
XANTENNA__2626__GATE Tile_X0Y5_FrameStrobe[3] VPWR VGND sg13cmos5l_antennanp
XANTENNA__3201__D Tile_X0Y5_FrameData[15] VPWR VGND sg13cmos5l_antennanp
XFILLER_178_227 VPWR VGND sg13cmos5l_decap_8
X_1963_ _1963_/Q Tile_X0Y0_FrameData[21] Tile_X0Y5_FrameStrobe[8] VPWR VGND sg13cmos5l_dlhq_1
XANTENNA__0787__A0 Tile_X0Y5_W2MID[6] VPWR VGND sg13cmos5l_antennanp
XANTENNA__1882__GATE Tile_X0Y5_FrameStrobe[5] VPWR VGND sg13cmos5l_antennanp
XFILLER_146_102 VPWR VGND sg13cmos5l_decap_8
XFILLER_186_271 VPWR VGND sg13cmos5l_decap_4
X_3702_ Tile_X0Y3_FrameData_O[5] Tile_X0Y3_FrameData[5] VPWR VGND sg13cmos5l_buf_1
X_1894_ _1894_/Q Tile_X0Y0_FrameData[26] Tile_X0Y5_FrameStrobe[6] VPWR VGND sg13cmos5l_dlhq_1
X_0914_ _0914_/Y _0598_/X _3304_/Q VPWR VGND sg13cmos5l_nand2b_1
X_3633_ Tile_X0Y0_E2BEGb[4] _3633_/A VPWR VGND sg13cmos5l_buf_1
X_0845_ AXI_M_SOC_ARSIZE1 _3331_/Q _0845_/B VPWR VGND sg13cmos5l_or2_1
XFILLER_255_13 VPWR VGND sg13cmos5l_decap_4
XFILLER_161_149 VPWR VGND sg13cmos5l_decap_8
X_3564_ Tile_X0Y0_FrameStrobe_O[15] Tile_X0Y5_FrameStrobe[15] VPWR VGND sg13cmos5l_buf_1
X_0776_ _0776_/X _0769_/X _0770_/X _3347_/Q VPWR VGND sg13cmos5l_mux2_1
XFILLER_52_0 VPWR VGND sg13cmos5l_decap_8
XANTENNA__1200__A1 Tile_X0Y0_WW4END[9] VPWR VGND sg13cmos5l_antennanp
XANTENNA__1897__GATE Tile_X0Y5_FrameStrobe[6] VPWR VGND sg13cmos5l_antennanp
XFILLER_255_68 VPWR VGND sg13cmos5l_decap_4
X_2515_ _2515_/Q Tile_X0Y3_FrameData[29] Tile_X0Y5_FrameStrobe[0] VPWR VGND sg13cmos5l_dlhq_1
X_3495_ Tile_X0Y1_E2BEGb[3] _3495_/A VPWR VGND sg13cmos5l_buf_1
XFILLER_102_205 VPWR VGND sg13cmos5l_decap_8
X_2446_ _2446_/Q Tile_X0Y2_FrameData[18] Tile_X0Y5_FrameStrobe[6] VPWR VGND sg13cmos5l_dlhq_1
XANTENNA__2487__D Tile_X0Y2_FrameData[9] VPWR VGND sg13cmos5l_antennanp
XANTENNA__1820__GATE Tile_X0Y5_FrameStrobe[3] VPWR VGND sg13cmos5l_antennanp
XANTENNA__3513__X Tile_X0Y0_N4BEG[0] VPWR VGND sg13cmos5l_antennanp
XFILLER_271_45 VPWR VGND sg13cmos5l_fill_2
X_2377_ _2377_/Q Tile_X0Y2_FrameData[23] Tile_X0Y5_FrameStrobe[4] VPWR VGND sg13cmos5l_dlhq_1
XANTENNA__0856__Y AXI_M_SOC_ARLEN2 VPWR VGND sg13cmos5l_antennanp
XFILLER_110_293 VPWR VGND sg13cmos5l_fill_2
X_1328_ _1328_/X Tile_X0Y1_W6END[11] _0968_/X _0905_/X _1094_/X _2205_/Q _2207_/Q
+ VPWR VGND sg13cmos5l_mux4_1
XFILLER_140_16 VPWR VGND sg13cmos5l_decap_8
XFILLER_204_94 VPWR VGND sg13cmos5l_decap_8
X_1259_ _3642_/A Tile_X0Y0_W2MID[2] AXI_M_SOC_BRESP1 _1147_/X _1045_/X _1878_/Q _1877_/Q
+ VPWR VGND sg13cmos5l_mux4_1
XANTENNA__1835__GATE Tile_X0Y5_FrameStrobe[4] VPWR VGND sg13cmos5l_antennanp
XFILLER_24_200 VPWR VGND sg13cmos5l_fill_1
XANTENNA__3111__D Tile_X0Y5_FrameData[9] VPWR VGND sg13cmos5l_antennanp
XANTENNA__2950__D Tile_X0Y4_FrameData[26] VPWR VGND sg13cmos5l_antennanp
XFILLER_149_36 VPWR VGND sg13cmos5l_decap_4
XFILLER_177_271 VPWR VGND sg13cmos5l_decap_8
XFILLER_184_219 VPWR VGND sg13cmos5l_fill_2
XFILLER_137_135 VPWR VGND sg13cmos5l_decap_8
XFILLER_149_69 VPWR VGND sg13cmos5l_fill_2
XFILLER_177_293 VPWR VGND sg13cmos5l_fill_2
XFILLER_296_86 VPWR VGND sg13cmos5l_decap_4
XFILLER_326_224 VPWR VGND sg13cmos5l_fill_1
XFILLER_229_91 VPWR VGND sg13cmos5l_decap_8
XFILLER_326_246 VPWR VGND sg13cmos5l_decap_4
XFILLER_152_127 VPWR VGND sg13cmos5l_decap_4
XANTENNA__1208__X AXI_M_SOC_AWADDR22 VPWR VGND sg13cmos5l_antennanp
XFILLER_165_68 VPWR VGND sg13cmos5l_decap_8
XANTENNA__2397__D Tile_X0Y2_FrameData[3] VPWR VGND sg13cmos5l_antennanp
XFILLER_58_55 VPWR VGND sg13cmos5l_decap_8
XANTENNA__3423__X Tile_X0Y2_FrameData_O[25] VPWR VGND sg13cmos5l_antennanp
XFILLER_247_231 VPWR VGND sg13cmos5l_decap_8
XFILLER_59_152 VPWR VGND sg13cmos5l_decap_8
XANTENNA__3341__GATE Tile_X0Y5_FrameStrobe[8] VPWR VGND sg13cmos5l_antennanp
XFILLER_247_286 VPWR VGND sg13cmos5l_fill_1
XFILLER_74_43 VPWR VGND sg13cmos5l_decap_8
XANTENNA__1258__A1 AXI_M_SOC_BVALID VPWR VGND sg13cmos5l_antennanp
XANTENNA__3021__D Tile_X0Y4_FrameData[19] VPWR VGND sg13cmos5l_antennanp
XFILLER_90_53 VPWR VGND sg13cmos5l_decap_8
XANTENNA__0769__A0 Tile_X0Y5_WW4END[4] VPWR VGND sg13cmos5l_antennanp
XANTENNA__2860__D Tile_X0Y4_FrameData[20] VPWR VGND sg13cmos5l_antennanp
XANTENNA__1430__A1 Tile_X0Y2_W2END[4] VPWR VGND sg13cmos5l_antennanp
XFILLER_168_293 VPWR VGND sg13cmos5l_fill_2
XFILLER_128_157 VPWR VGND sg13cmos5l_decap_8
XFILLER_317_279 VPWR VGND sg13cmos5l_fill_2
X_0630_ _0630_/Y _2518_/Q _2517_/Q VPWR VGND sg13cmos5l_nor2b_1
XANTENNA__1194__A0 Tile_X0Y0_WW4END[6] VPWR VGND sg13cmos5l_antennanp
X_0561_ _3910_/A Tile_X0Y4_W1END[3] Tile_X0Y4_W2MID[0] Tile_X0Y4_W2END[0] _1361_/X
+ _2998_/Q _2997_/Q VPWR VGND sg13cmos5l_mux4_1
XANTENNA__1118__X AXI_M_SOC_WLAST VPWR VGND sg13cmos5l_antennanp
X_3280_ _3280_/Q Tile_X0Y5_FrameData[0] Tile_X0Y5_FrameStrobe[6] VPWR VGND sg13cmos5l_dlhq_1
X_2300_ _2300_/Q Tile_X0Y2_FrameData[4] Tile_X0Y5_FrameStrobe[1] VPWR VGND sg13cmos5l_dlhq_1
XFILLER_151_182 VPWR VGND sg13cmos5l_decap_8
XFILLER_2_192 VPWR VGND sg13cmos5l_fill_1
X_2231_ _2231_/Q Tile_X0Y1_FrameData[25] Tile_X0Y5_FrameStrobe[8] VPWR VGND sg13cmos5l_dlhq_1
XANTENNA__2100__D Tile_X0Y1_FrameData[28] VPWR VGND sg13cmos5l_antennanp
XANTENNA__1497__A1 AXI_M_SOC_RDATA8 VPWR VGND sg13cmos5l_antennanp
XANTENNA__2550__GATE Tile_X0Y5_FrameStrobe[1] VPWR VGND sg13cmos5l_antennanp
X_2162_ _2162_/Q Tile_X0Y1_FrameData[30] Tile_X0Y5_FrameStrobe[6] VPWR VGND sg13cmos5l_dlhq_1
XANTENNA__3309__GATE Tile_X0Y5_FrameStrobe[7] VPWR VGND sg13cmos5l_antennanp
XFILLER_238_286 VPWR VGND sg13cmos5l_fill_1
X_2093_ _2093_/Q Tile_X0Y1_FrameData[3] Tile_X0Y5_FrameStrobe[3] VPWR VGND sg13cmos5l_dlhq_1
X_1113_ _1113_/X Tile_X0Y2_W2MID[0] Tile_X0Y2_W2END[0] Tile_X0Y2_W6END[0] _1179_/X
+ _2490_/Q _2489_/Q VPWR VGND sg13cmos5l_mux4_1
XANTENNA__1249__A1 AXI_M_SOC_RDATA30 VPWR VGND sg13cmos5l_antennanp
X_1044_ _3534_/A Tile_X0Y1_W2MID[2] Tile_X0Y1_W2END[2] Tile_X0Y1_W6END[2] _1086_/X
+ _2222_/Q _2221_/Q VPWR VGND sg13cmos5l_mux4_1
XFILLER_80_114 VPWR VGND sg13cmos5l_fill_1
XANTENNA__2565__GATE Tile_X0Y5_FrameStrobe[1] VPWR VGND sg13cmos5l_antennanp
XFILLER_80_136 VPWR VGND sg13cmos5l_fill_2
XFILLER_206_183 VPWR VGND sg13cmos5l_decap_8
XFILLER_221_131 VPWR VGND sg13cmos5l_decap_4
XANTENNA__0852__B Tile_X0Y5_W2MID[1] VPWR VGND sg13cmos5l_antennanp
XFILLER_21_225 VPWR VGND sg13cmos5l_fill_1
XANTENNA__2770__D Tile_X0Y3_FrameData[30] VPWR VGND sg13cmos5l_antennanp
XFILLER_21_247 VPWR VGND sg13cmos5l_decap_8
XFILLER_21_258 VPWR VGND sg13cmos5l_fill_1
X_2995_ _2995_/Q Tile_X0Y4_FrameData[13] Tile_X0Y5_FrameStrobe[6] VPWR VGND sg13cmos5l_dlhq_1
XANTENNA__1421__A1 Tile_X0Y2_WW4END[8] VPWR VGND sg13cmos5l_antennanp
XFILLER_159_293 VPWR VGND sg13cmos5l_fill_2
X_1946_ _1946_/Q Tile_X0Y0_FrameData[6] Tile_X0Y5_FrameStrobe[7] VPWR VGND sg13cmos5l_dlhq_1
XANTENNA__3508__X Tile_X0Y1_E1BEG[0] VPWR VGND sg13cmos5l_antennanp
XFILLER_174_263 VPWR VGND sg13cmos5l_decap_8
XFILLER_266_45 VPWR VGND sg13cmos5l_fill_1
X_1877_ _1877_/Q Tile_X0Y0_FrameData[11] Tile_X0Y5_FrameStrobe[5] VPWR VGND sg13cmos5l_dlhq_1
XFILLER_174_285 VPWR VGND sg13cmos5l_fill_2
X_3616_ Tile_X0Y0_EE4BEG[15] _3616_/A VPWR VGND sg13cmos5l_buf_1
X_0828_ _3835_/A _0775_/X _0742_/X _0741_/X _0782_/X _3175_/Q _3176_/Q VPWR VGND sg13cmos5l_mux4_1
XANTENNA__1185__A0 Tile_X0Y1_W2MID[4] VPWR VGND sg13cmos5l_antennanp
XANTENNA__2503__GATE Tile_X0Y5_FrameStrobe[8] VPWR VGND sg13cmos5l_antennanp
X_3547_ Tile_X0Y0_N1BEG[2] _3547_/A VPWR VGND sg13cmos5l_buf_1
X_0759_ _0759_/X _0758_/X _0757_/X _0755_/X _0756_/X _3345_/Q _3344_/Q VPWR VGND sg13cmos5l_mux4_1
XFILLER_288_153 VPWR VGND sg13cmos5l_decap_8
XFILLER_88_225 VPWR VGND sg13cmos5l_fill_2
XFILLER_142_193 VPWR VGND sg13cmos5l_decap_8
X_3478_ Tile_X0Y1_EE4BEG[14] _3478_/A VPWR VGND sg13cmos5l_buf_1
XFILLER_331_293 VPWR VGND sg13cmos5l_fill_2
XANTENNA__2010__D Tile_X0Y1_FrameData[22] VPWR VGND sg13cmos5l_antennanp
XANTENNA__2518__GATE Tile_X0Y5_FrameStrobe[0] VPWR VGND sg13cmos5l_antennanp
XANTENNA__3106__D Tile_X0Y5_FrameData[14] VPWR VGND sg13cmos5l_antennanp
XFILLER_215_60 VPWR VGND sg13cmos5l_fill_2
XFILLER_215_71 VPWR VGND sg13cmos5l_decap_8
X_2429_ _2429_/Q Tile_X0Y2_FrameData[3] Tile_X0Y5_FrameStrobe[5] VPWR VGND sg13cmos5l_dlhq_1
XFILLER_56_100 VPWR VGND sg13cmos5l_decap_8
XANTENNA__2945__D Tile_X0Y4_FrameData[31] VPWR VGND sg13cmos5l_antennanp
XFILLER_244_212 VPWR VGND sg13cmos5l_fill_1
XANTENNA__1774__GATE Tile_X0Y5_FrameStrobe[2] VPWR VGND sg13cmos5l_antennanp
XFILLER_56_177 VPWR VGND sg13cmos5l_decap_8
XANTENNA__1660__A1 AXI_M_SOC_RDATA4 VPWR VGND sg13cmos5l_antennanp
XANTENNA__1789__GATE Tile_X0Y5_FrameStrobe[2] VPWR VGND sg13cmos5l_antennanp
XANTENNA__2680__D Tile_X0Y3_FrameData[24] VPWR VGND sg13cmos5l_antennanp
XFILLER_212_175 VPWR VGND sg13cmos5l_fill_1
XFILLER_100_74 VPWR VGND sg13cmos5l_decap_8
XFILLER_176_12 VPWR VGND sg13cmos5l_fill_2
XFILLER_60_34 VPWR VGND sg13cmos5l_decap_4
XFILLER_60_23 VPWR VGND sg13cmos5l_fill_1
XANTENNA__1412__A1 Tile_X0Y2_WW4END[9] VPWR VGND sg13cmos5l_antennanp
XANTENNA__1712__GATE Tile_X0Y5_FrameStrobe[0] VPWR VGND sg13cmos5l_antennanp
XANTENNA__3418__X Tile_X0Y2_FrameData_O[20] VPWR VGND sg13cmos5l_antennanp
XFILLER_60_56 VPWR VGND sg13cmos5l_decap_8
XANTENNA__0766__A3 AXI_M_SOC_RVALID VPWR VGND sg13cmos5l_antennanp
XFILLER_180_200 VPWR VGND sg13cmos5l_decap_8
XFILLER_180_211 VPWR VGND sg13cmos5l_fill_1
XANTENNA__1176__A0 Tile_X0Y0_W2MID[1] VPWR VGND sg13cmos5l_antennanp
XFILLER_109_72 VPWR VGND sg13cmos5l_decap_8
XFILLER_180_266 VPWR VGND sg13cmos5l_fill_1
XFILLER_69_32 VPWR VGND sg13cmos5l_decap_8
XFILLER_326_37 VPWR VGND sg13cmos5l_fill_2
XFILLER_133_160 VPWR VGND sg13cmos5l_fill_2
XFILLER_279_120 VPWR VGND sg13cmos5l_fill_1
XFILLER_279_142 VPWR VGND sg13cmos5l_fill_1
XANTENNA__0923__A0 Tile_X0Y5_W1END[1] VPWR VGND sg13cmos5l_antennanp
XANTENNA__1727__GATE Tile_X0Y5_FrameStrobe[0] VPWR VGND sg13cmos5l_antennanp
XFILLER_133_193 VPWR VGND sg13cmos5l_fill_2
XFILLER_294_112 VPWR VGND sg13cmos5l_fill_2
XFILLER_69_87 VPWR VGND sg13cmos5l_decap_8
XFILLER_69_76 VPWR VGND sg13cmos5l_fill_1
XFILLER_322_293 VPWR VGND sg13cmos5l_fill_2
XANTENNA__3016__D Tile_X0Y4_FrameData[24] VPWR VGND sg13cmos5l_antennanp
XFILLER_79_269 VPWR VGND sg13cmos5l_fill_1
XFILLER_85_53 VPWR VGND sg13cmos5l_decap_8
XANTENNA__2855__D Tile_X0Y4_FrameData[25] VPWR VGND sg13cmos5l_antennanp
XANTENNA__3280__GATE Tile_X0Y5_FrameStrobe[6] VPWR VGND sg13cmos5l_antennanp
XFILLER_47_133 VPWR VGND sg13cmos5l_decap_4
XFILLER_235_256 VPWR VGND sg13cmos5l_fill_2
XFILLER_141_70 VPWR VGND sg13cmos5l_decap_8
XFILLER_211_29 VPWR VGND sg13cmos5l_decap_8
XANTENNA__3295__GATE Tile_X0Y5_FrameStrobe[7] VPWR VGND sg13cmos5l_antennanp
XFILLER_250_248 VPWR VGND sg13cmos5l_decap_8
XANTENNA__1651__A1 Tile_X0Y4_WW4END[7] VPWR VGND sg13cmos5l_antennanp
XANTENNA__2590__D Tile_X0Y3_FrameData[18] VPWR VGND sg13cmos5l_antennanp
X_1800_ _1800_/Q Tile_X0Y0_FrameData[24] Tile_X0Y5_FrameStrobe[3] VPWR VGND sg13cmos5l_dlhq_1
XFILLER_34_90 VPWR VGND sg13cmos5l_decap_8
X_2780_ _2780_/Q Tile_X0Y3_FrameData[20] Tile_X0Y5_FrameStrobe[8] VPWR VGND sg13cmos5l_dlhq_1
X_1731_ _1731_/Q Tile_X0Y0_FrameData[29] Tile_X0Y5_FrameStrobe[1] VPWR VGND sg13cmos5l_dlhq_1
X_1662_ _3738_/A Tile_X0Y4_W2MID[3] AXI_M_SOC_RDATA2 _1130_/X _1319_/X _2968_/Q _2967_/Q
+ VPWR VGND sg13cmos5l_mux4_1
XANTENNA__1167__A0 Tile_X0Y0_W6END[8] VPWR VGND sg13cmos5l_antennanp
X_3401_ Tile_X0Y2_FrameData_O[3] Tile_X0Y2_FrameData[3] VPWR VGND sg13cmos5l_buf_1
X_0613_ _3923_/A _0602_/Y _0604_/Y _0612_/Y VPWR VGND sg13cmos5l_a21oi_1
XANTENNA__1934__D Tile_X0Y0_FrameData[18] VPWR VGND sg13cmos5l_antennanp
XANTENNA__3233__GATE Tile_X0Y5_FrameStrobe[5] VPWR VGND sg13cmos5l_antennanp
X_3332_ _3332_/Q Tile_X0Y5_FrameData[30] Tile_X0Y5_FrameStrobe[9] VPWR VGND sg13cmos5l_dlhq_1
X_1593_ _1593_/X Tile_X0Y3_W1END[3] Tile_X0Y3_WW4END[15] Tile_X0Y3_W6END[7] _1526_/X
+ _2715_/Q _2714_/Q VPWR VGND sg13cmos5l_mux4_1
XFILLER_124_182 VPWR VGND sg13cmos5l_decap_8
XFILLER_124_193 VPWR VGND sg13cmos5l_fill_1
XFILLER_313_293 VPWR VGND sg13cmos5l_fill_2
X_0544_ _0544_/Y _3295_/Q VPWR VGND sg13cmos5l_inv_1
XFILLER_252_14 VPWR VGND sg13cmos5l_fill_2
XFILLER_252_25 VPWR VGND sg13cmos5l_fill_2
X_3263_ _3263_/Q Tile_X0Y5_FrameData[17] Tile_X0Y5_FrameStrobe[6] VPWR VGND sg13cmos5l_dlhq_1
XANTENNA__3248__GATE Tile_X0Y5_FrameStrobe[5] VPWR VGND sg13cmos5l_antennanp
XFILLER_252_69 VPWR VGND sg13cmos5l_fill_2
X_3194_ _3194_/Q Tile_X0Y5_FrameData[22] Tile_X0Y5_FrameStrobe[4] VPWR VGND sg13cmos5l_dlhq_1
X_2214_ _2214_/Q Tile_X0Y1_FrameData[10] Tile_X0Y5_FrameStrobe[7] VPWR VGND sg13cmos5l_dlhq_1
XANTENNA__2765__D Tile_X0Y3_FrameData[3] VPWR VGND sg13cmos5l_antennanp
XFILLER_15_0 VPWR VGND sg13cmos5l_fill_2
X_2145_ _2145_/Q Tile_X0Y1_FrameData[15] Tile_X0Y5_FrameStrobe[5] VPWR VGND sg13cmos5l_dlhq_1
XFILLER_38_188 VPWR VGND sg13cmos5l_decap_8
X_2076_ _2076_/Q Tile_X0Y1_FrameData[20] Tile_X0Y5_FrameStrobe[3] VPWR VGND sg13cmos5l_dlhq_1
XANTENNA__1311__X AXI_M_SOC_AWADDR5 VPWR VGND sg13cmos5l_antennanp
X_1027_ _1027_/X Tile_X0Y0_W1END[1] Tile_X0Y0_WW4END[13] _1037_/X _1038_/X _1905_/Q
+ _1903_/Q VPWR VGND sg13cmos5l_mux4_1
XFILLER_53_158 VPWR VGND sg13cmos5l_decap_8
XANTENNA__1642__A1 Tile_X0Y4_W6END[3] VPWR VGND sg13cmos5l_antennanp
XFILLER_277_33 VPWR VGND sg13cmos5l_fill_1
X_2978_ _2978_/Q Tile_X0Y4_FrameData[30] Tile_X0Y5_FrameStrobe[6] VPWR VGND sg13cmos5l_dlhq_1
XFILLER_147_263 VPWR VGND sg13cmos5l_fill_1
X_1929_ _1929_/Q Tile_X0Y0_FrameData[23] Tile_X0Y5_FrameStrobe[7] VPWR VGND sg13cmos5l_dlhq_1
XANTENNA__2005__D Tile_X0Y1_FrameData[27] VPWR VGND sg13cmos5l_antennanp
XANTENNA__2442__GATE Tile_X0Y5_FrameStrobe[6] VPWR VGND sg13cmos5l_antennanp
XFILLER_146_37 VPWR VGND sg13cmos5l_decap_8
XANTENNA__1158__A0 Tile_X0Y0_W2MID[7] VPWR VGND sg13cmos5l_antennanp
XANTENNA__1844__D Tile_X0Y0_FrameData[12] VPWR VGND sg13cmos5l_antennanp
XFILLER_162_266 VPWR VGND sg13cmos5l_fill_1
XFILLER_293_76 VPWR VGND sg13cmos5l_decap_8
XFILLER_304_293 VPWR VGND sg13cmos5l_fill_2
XANTENNA__2457__GATE Tile_X0Y5_FrameStrobe[6] VPWR VGND sg13cmos5l_antennanp
XFILLER_130_141 VPWR VGND sg13cmos5l_fill_1
XFILLER_226_92 VPWR VGND sg13cmos5l_fill_1
XANTENNA__3414__A Tile_X0Y2_FrameData[16] VPWR VGND sg13cmos5l_antennanp
XFILLER_162_36 VPWR VGND sg13cmos5l_fill_2
XANTENNA__2675__D Tile_X0Y3_FrameData[29] VPWR VGND sg13cmos5l_antennanp
XANTENNA__3701__X Tile_X0Y3_FrameData_O[4] VPWR VGND sg13cmos5l_antennanp
XFILLER_189_108 VPWR VGND sg13cmos5l_decap_8
XFILLER_55_56 VPWR VGND sg13cmos5l_decap_8
XFILLER_189_119 VPWR VGND sg13cmos5l_fill_1
XFILLER_232_248 VPWR VGND sg13cmos5l_decap_8
XFILLER_71_77 VPWR VGND sg13cmos5l_decap_8
XANTENNA__1397__A0 Tile_X0Y5_N4END[14] VPWR VGND sg13cmos5l_antennanp
XFILLER_187_77 VPWR VGND sg13cmos5l_decap_8
XFILLER_337_14 VPWR VGND sg13cmos5l_fill_2
XFILLER_217_0 VPWR VGND sg13cmos5l_fill_2
XFILLER_153_222 VPWR VGND sg13cmos5l_decap_4
XANTENNA__1149__A0 Tile_X0Y1_W2MID[5] VPWR VGND sg13cmos5l_antennanp
XANTENNA__1754__D Tile_X0Y0_FrameData[6] VPWR VGND sg13cmos5l_antennanp
XFILLER_299_248 VPWR VGND sg13cmos5l_decap_8
XFILLER_310_285 VPWR VGND sg13cmos5l_fill_2
XFILLER_67_228 VPWR VGND sg13cmos5l_decap_8
XANTENNA__2585__D Tile_X0Y3_FrameData[23] VPWR VGND sg13cmos5l_antennanp
XANTENNA__1321__A0 Tile_X0Y1_W2MID[7] VPWR VGND sg13cmos5l_antennanp
XANTENNA__3611__X Tile_X0Y0_EE4BEG[10] VPWR VGND sg13cmos5l_antennanp
XFILLER_222_28 VPWR VGND sg13cmos5l_fill_1
XFILLER_29_90 VPWR VGND sg13cmos5l_fill_1
XFILLER_90_242 VPWR VGND sg13cmos5l_fill_1
XFILLER_35_169 VPWR VGND sg13cmos5l_decap_8
X_2901_ _2901_/Q Tile_X0Y4_FrameData[11] Tile_X0Y5_FrameStrobe[3] VPWR VGND sg13cmos5l_dlhq_1
XFILLER_50_128 VPWR VGND sg13cmos5l_decap_8
XANTENNA__1929__D Tile_X0Y0_FrameData[23] VPWR VGND sg13cmos5l_antennanp
X_3881_ Tile_X0Y5_FrameData_O[22] Tile_X0Y5_FrameData[22] VPWR VGND sg13cmos5l_buf_1
XFILLER_91_4 VPWR VGND sg13cmos5l_fill_1
X_2832_ _2832_/Q Tile_X0Y4_FrameData[16] Tile_X0Y5_FrameStrobe[1] VPWR VGND sg13cmos5l_dlhq_1
X_2763_ _2763_/Q Tile_X0Y3_FrameData[5] Tile_X0Y5_FrameStrobe[7] VPWR VGND sg13cmos5l_dlhq_1
XFILLER_77_2 VPWR VGND sg13cmos5l_fill_1
XFILLER_337_149 VPWR VGND sg13cmos5l_fill_1
X_1714_ _1714_/Q Tile_X0Y0_FrameData[14] Tile_X0Y5_FrameStrobe[0] VPWR VGND sg13cmos5l_dlhq_1
XANTENNA__3172__GATE Tile_X0Y5_FrameStrobe[3] VPWR VGND sg13cmos5l_antennanp
X_2694_ _2694_/Q Tile_X0Y3_FrameData[10] Tile_X0Y5_FrameStrobe[5] VPWR VGND sg13cmos5l_dlhq_1
XFILLER_104_119 VPWR VGND sg13cmos5l_decap_8
X_1645_ AXI_M_SOC_ARADDR23 Tile_X0Y4_W2MID[7] Tile_X0Y4_W2END[7] Tile_X0Y4_W6END[7]
+ _1361_/X _2842_/Q _2841_/Q VPWR VGND sg13cmos5l_mux4_1
XFILLER_6_94 VPWR VGND sg13cmos5l_decap_8
XFILLER_263_35 VPWR VGND sg13cmos5l_fill_2
X_1576_ _1576_/X _1436_/X _1521_/X _2724_/Q VPWR VGND sg13cmos5l_mux2_1
X_3315_ _3315_/Q Tile_X0Y5_FrameData[29] Tile_X0Y5_FrameStrobe[8] VPWR VGND sg13cmos5l_dlhq_1
XANTENNA__1560__A0 Tile_X0Y3_W2MID[0] VPWR VGND sg13cmos5l_antennanp
XANTENNA__3187__GATE Tile_X0Y5_FrameStrobe[4] VPWR VGND sg13cmos5l_antennanp
XFILLER_301_252 VPWR VGND sg13cmos5l_decap_4
X_3246_ _3246_/Q Tile_X0Y5_FrameData[2] Tile_X0Y5_FrameStrobe[5] VPWR VGND sg13cmos5l_dlhq_1
XANTENNA__2495__D Tile_X0Y2_FrameData[1] VPWR VGND sg13cmos5l_antennanp
XANTENNA__3521__X Tile_X0Y0_N4BEG[8] VPWR VGND sg13cmos5l_antennanp
X_3177_ _3177_/Q Tile_X0Y5_FrameData[7] Tile_X0Y5_FrameStrobe[3] VPWR VGND sg13cmos5l_dlhq_1
XANTENNA__3110__GATE Tile_X0Y5_FrameStrobe[1] VPWR VGND sg13cmos5l_antennanp
X_2128_ _2128_/Q Tile_X0Y1_FrameData[0] Tile_X0Y5_FrameStrobe[4] VPWR VGND sg13cmos5l_dlhq_1
X_2059_ _2059_/Q Tile_X0Y1_FrameData[5] Tile_X0Y5_FrameStrobe[2] VPWR VGND sg13cmos5l_dlhq_1
XFILLER_41_128 VPWR VGND sg13cmos5l_decap_8
XANTENNA__1839__D Tile_X0Y0_FrameData[17] VPWR VGND sg13cmos5l_antennanp
XANTENNA__3125__GATE Tile_X0Y5_FrameStrobe[2] VPWR VGND sg13cmos5l_antennanp
XFILLER_179_141 VPWR VGND sg13cmos5l_decap_8
XANTENNA__1091__A2 Tile_X0Y3_W6END[4] VPWR VGND sg13cmos5l_antennanp
XFILLER_328_138 VPWR VGND sg13cmos5l_fill_2
XANTENNA__2381__GATE Tile_X0Y5_FrameStrobe[4] VPWR VGND sg13cmos5l_antennanp
XFILLER_157_14 VPWR VGND sg13cmos5l_fill_2
XANTENNA__3409__A Tile_X0Y2_FrameData[11] VPWR VGND sg13cmos5l_antennanp
XFILLER_194_199 VPWR VGND sg13cmos5l_decap_8
XFILLER_41_69 VPWR VGND sg13cmos5l_decap_8
XFILLER_157_69 VPWR VGND sg13cmos5l_decap_8
XANTENNA__2396__GATE Tile_X0Y5_FrameStrobe[4] VPWR VGND sg13cmos5l_antennanp
XFILLER_150_214 VPWR VGND sg13cmos5l_fill_1
XFILLER_150_236 VPWR VGND sg13cmos5l_decap_8
XANTENNA__1551__A0 Tile_X0Y3_WW4END[1] VPWR VGND sg13cmos5l_antennanp
XFILLER_173_79 VPWR VGND sg13cmos5l_decap_8
XFILLER_1_279 VPWR VGND sg13cmos5l_fill_1
XFILLER_2_19 VPWR VGND sg13cmos5l_fill_1
XFILLER_323_27 VPWR VGND sg13cmos5l_decap_4
XFILLER_66_22 VPWR VGND sg13cmos5l_decap_8
XANTENNA__1303__A0 AXI_M_SOC_RDATA28 VPWR VGND sg13cmos5l_antennanp
XANTENNA__3431__X Tile_X0Y1_UserCLKo VPWR VGND sg13cmos5l_antennanp
XFILLER_66_55 VPWR VGND sg13cmos5l_decap_8
XANTENNA__2334__GATE Tile_X0Y5_FrameStrobe[2] VPWR VGND sg13cmos5l_antennanp
XFILLER_167_0 VPWR VGND sg13cmos5l_fill_1
XFILLER_205_237 VPWR VGND sg13cmos5l_fill_2
XANTENNA__2964__GATE Tile_X0Y5_FrameStrobe[5] VPWR VGND sg13cmos5l_antennanp
XFILLER_220_207 VPWR VGND sg13cmos5l_decap_8
XFILLER_82_43 VPWR VGND sg13cmos5l_decap_8
XANTENNA__1606__A1 Tile_X0Y3_W6END[9] VPWR VGND sg13cmos5l_antennanp
XANTENNA__1749__D Tile_X0Y0_FrameData[11] VPWR VGND sg13cmos5l_antennanp
XFILLER_198_43 VPWR VGND sg13cmos5l_decap_8
XFILLER_220_218 VPWR VGND sg13cmos5l_fill_1
XFILLER_334_0 VPWR VGND sg13cmos5l_fill_2
XFILLER_32_139 VPWR VGND sg13cmos5l_decap_8
XANTENNA__1082__A2 Tile_X0Y3_W6END[1] VPWR VGND sg13cmos5l_antennanp
XANTENNA__2349__GATE Tile_X0Y5_FrameStrobe[3] VPWR VGND sg13cmos5l_antennanp
XFILLER_40_194 VPWR VGND sg13cmos5l_decap_4
XANTENNA__2979__GATE Tile_X0Y5_FrameStrobe[6] VPWR VGND sg13cmos5l_antennanp
XFILLER_185_188 VPWR VGND sg13cmos5l_fill_1
XFILLER_126_233 VPWR VGND sg13cmos5l_decap_8
XFILLER_63_8 VPWR VGND sg13cmos5l_decap_4
XANTENNA__3606__X Tile_X0Y0_EE4BEG[5] VPWR VGND sg13cmos5l_antennanp
XFILLER_126_277 VPWR VGND sg13cmos5l_fill_1
XFILLER_147_80 VPWR VGND sg13cmos5l_fill_2
XFILLER_99_117 VPWR VGND sg13cmos5l_fill_2
XFILLER_56_7 VPWR VGND sg13cmos5l_decap_8
XANTENNA__0949__Y AXI_M_SOC_AWLEN0 VPWR VGND sg13cmos5l_antennanp
XANTENNA__2902__GATE Tile_X0Y5_FrameStrobe[3] VPWR VGND sg13cmos5l_antennanp
X_1430_ AXI_M_SOC_WDATA28 Tile_X0Y2_W2MID[4] Tile_X0Y2_W2END[4] Tile_X0Y2_W6END[4]
+ _1191_/X _2304_/Q _2303_/Q VPWR VGND sg13cmos5l_mux4_1
XANTENNA__1137__A3 Tile_X0Y0_S4END[3] VPWR VGND sg13cmos5l_antennanp
X_1361_ _1361_/X _1349_/X _0562_/X Tile_X0Y5_N2MID[7] _1350_/X _2793_/Q _2794_/Q VPWR
+ VGND sg13cmos5l_mux4_1
XANTENNA__1542__A0 AXI_M_SOC_RDATA8 VPWR VGND sg13cmos5l_antennanp
X_3100_ _3100_/Q Tile_X0Y5_FrameData[20] Tile_X0Y5_FrameStrobe[1] VPWR VGND sg13cmos5l_dlhq_1
XANTENNA__2917__GATE Tile_X0Y5_FrameStrobe[4] VPWR VGND sg13cmos5l_antennanp
X_1292_ _3479_/A Tile_X0Y1_WW4END[0] AXI_M_SOC_RDATA22 _1268_/X _1110_/X _2098_/Q
+ _2097_/Q VPWR VGND sg13cmos5l_mux4_1
XANTENNA__3204__D Tile_X0Y5_FrameData[12] VPWR VGND sg13cmos5l_antennanp
X_3031_ _3031_/Q Tile_X0Y4_FrameData[9] Tile_X0Y5_FrameStrobe[7] VPWR VGND sg13cmos5l_dlhq_1
XFILLER_63_264 VPWR VGND sg13cmos5l_fill_2
XANTENNA__1073__A2 Tile_X0Y5_N2MID[0] VPWR VGND sg13cmos5l_antennanp
XFILLER_258_24 VPWR VGND sg13cmos5l_decap_4
X_3864_ Tile_X0Y5_FrameData_O[5] Tile_X0Y5_FrameData[5] VPWR VGND sg13cmos5l_buf_1
XFILLER_31_150 VPWR VGND sg13cmos5l_fill_1
XFILLER_176_155 VPWR VGND sg13cmos5l_fill_2
X_2815_ _2815_/Q Tile_X0Y4_FrameData[1] Tile_X0Y5_FrameStrobe[0] VPWR VGND sg13cmos5l_dlhq_1
XFILLER_82_0 VPWR VGND sg13cmos5l_decap_4
X_3795_ Tile_X0Y4_FrameData_O[17] Tile_X0Y4_FrameData[17] VPWR VGND sg13cmos5l_buf_1
XFILLER_117_211 VPWR VGND sg13cmos5l_decap_8
XFILLER_191_147 VPWR VGND sg13cmos5l_fill_2
X_2746_ _2746_/Q Tile_X0Y3_FrameData[22] Tile_X0Y5_FrameStrobe[7] VPWR VGND sg13cmos5l_dlhq_1
XFILLER_127_17 VPWR VGND sg13cmos5l_fill_2
X_2677_ _2677_/Q Tile_X0Y3_FrameData[27] Tile_X0Y5_FrameStrobe[5] VPWR VGND sg13cmos5l_dlhq_1
XFILLER_333_152 VPWR VGND sg13cmos5l_decap_8
XANTENNA__3516__X Tile_X0Y0_N4BEG[3] VPWR VGND sg13cmos5l_antennanp
XFILLER_132_214 VPWR VGND sg13cmos5l_fill_2
XFILLER_278_218 VPWR VGND sg13cmos5l_decap_4
XFILLER_278_229 VPWR VGND sg13cmos5l_decap_4
X_1628_ _3755_/A AXI_M_SOC_RRESP1 _1012_/X _1011_/X _1049_/X _2901_/Q _2902_/Q VPWR
+ VGND sg13cmos5l_mux4_1
XANTENNA__0588__A Tile_X0Y4_W6END[0] VPWR VGND sg13cmos5l_antennanp
XFILLER_207_50 VPWR VGND sg13cmos5l_decap_8
XANTENNA__1533__A0 AXI_M_SOC_RDATA7 VPWR VGND sg13cmos5l_antennanp
XFILLER_290_11 VPWR VGND sg13cmos5l_fill_1
X_1559_ AXI_M_SOC_WDATA1 Tile_X0Y3_W2MID[1] Tile_X0Y3_W2END[1] Tile_X0Y3_W6END[1]
+ _1219_/X _2582_/Q _2581_/Q VPWR VGND sg13cmos5l_mux4_1
XFILLER_143_49 VPWR VGND sg13cmos5l_decap_8
XFILLER_246_115 VPWR VGND sg13cmos5l_decap_8
XANTENNA__3114__D Tile_X0Y5_FrameData[6] VPWR VGND sg13cmos5l_antennanp
X_3229_ _3229_/Q Tile_X0Y5_FrameData[19] Tile_X0Y5_FrameStrobe[5] VPWR VGND sg13cmos5l_dlhq_1
XFILLER_39_272 VPWR VGND sg13cmos5l_decap_4
XFILLER_36_14 VPWR VGND sg13cmos5l_decap_4
XANTENNA__2953__D Tile_X0Y4_FrameData[23] VPWR VGND sg13cmos5l_antennanp
XFILLER_54_242 VPWR VGND sg13cmos5l_decap_8
XANTENNA__3064__GATE Tile_X0Y5_FrameStrobe[0] VPWR VGND sg13cmos5l_antennanp
XFILLER_54_286 VPWR VGND sg13cmos5l_fill_1
XFILLER_52_35 VPWR VGND sg13cmos5l_decap_8
XFILLER_139_4 VPWR VGND sg13cmos5l_fill_1
XFILLER_167_133 VPWR VGND sg13cmos5l_decap_8
XFILLER_168_35 VPWR VGND sg13cmos5l_fill_1
XFILLER_210_262 VPWR VGND sg13cmos5l_decap_4
XFILLER_52_68 VPWR VGND sg13cmos5l_fill_1
XANTENNA__3079__GATE Tile_X0Y5_FrameStrobe[0] VPWR VGND sg13cmos5l_antennanp
XFILLER_182_103 VPWR VGND sg13cmos5l_decap_8
XFILLER_182_114 VPWR VGND sg13cmos5l_fill_2
XFILLER_316_108 VPWR VGND sg13cmos5l_fill_2
XFILLER_318_49 VPWR VGND sg13cmos5l_fill_1
XFILLER_184_12 VPWR VGND sg13cmos5l_decap_8
XFILLER_324_141 VPWR VGND sg13cmos5l_decap_8
XANTENNA__3002__GATE Tile_X0Y5_FrameStrobe[6] VPWR VGND sg13cmos5l_antennanp
XANTENNA__3426__X Tile_X0Y2_FrameData_O[28] VPWR VGND sg13cmos5l_antennanp
XFILLER_117_50 VPWR VGND sg13cmos5l_decap_8
XFILLER_117_61 VPWR VGND sg13cmos5l_fill_2
XFILLER_123_269 VPWR VGND sg13cmos5l_fill_1
XFILLER_7_2 VPWR VGND sg13cmos5l_fill_1
XANTENNA__3017__GATE Tile_X0Y5_FrameStrobe[7] VPWR VGND sg13cmos5l_antennanp
XFILLER_277_262 VPWR VGND sg13cmos5l_decap_4
XFILLER_77_65 VPWR VGND sg13cmos5l_decap_8
XANTENNA__3024__D Tile_X0Y4_FrameData[16] VPWR VGND sg13cmos5l_antennanp
XFILLER_284_0 VPWR VGND sg13cmos5l_decap_8
XFILLER_292_254 VPWR VGND sg13cmos5l_fill_2
XANTENNA__2273__GATE Tile_X0Y5_FrameStrobe[1] VPWR VGND sg13cmos5l_antennanp
XANTENNA__2863__D Tile_X0Y4_FrameData[17] VPWR VGND sg13cmos5l_antennanp
XFILLER_93_53 VPWR VGND sg13cmos5l_decap_8
XFILLER_60_201 VPWR VGND sg13cmos5l_fill_2
XFILLER_260_173 VPWR VGND sg13cmos5l_fill_1
XANTENNA__2288__GATE Tile_X0Y5_FrameStrobe[1] VPWR VGND sg13cmos5l_antennanp
XFILLER_158_122 VPWR VGND sg13cmos5l_decap_8
XFILLER_198_280 VPWR VGND sg13cmos5l_fill_1
XFILLER_260_195 VPWR VGND sg13cmos5l_decap_8
X_0930_ _0931_/A Tile_X0Y5_W6END[10] _3298_/Q _3297_/Q VPWR VGND sg13cmos5l_o21ai_1
XFILLER_158_133 VPWR VGND sg13cmos5l_fill_1
XFILLER_9_143 VPWR VGND sg13cmos5l_decap_4
XFILLER_201_273 VPWR VGND sg13cmos5l_decap_8
X_0861_ AXI_M_SOC_ARLEN3 _3121_/Q _0858_/Y _0859_/Y _0860_/Y _3332_/Q VPWR VGND sg13cmos5l_a221oi_1
XANTENNA__2211__GATE Tile_X0Y5_FrameStrobe[7] VPWR VGND sg13cmos5l_antennanp
X_2600_ _2600_/Q Tile_X0Y3_FrameData[8] Tile_X0Y5_FrameStrobe[2] VPWR VGND sg13cmos5l_dlhq_1
X_3580_ Tile_X0Y0_FrameData_O[11] Tile_X0Y0_FrameData[11] VPWR VGND sg13cmos5l_buf_1
X_0792_ _3906_/A Tile_X0Y4_W2MID[4] Tile_X0Y4_W2END[4] Tile_X0Y4_W6END[11] _1130_/X
+ _3006_/Q _3005_/Q VPWR VGND sg13cmos5l_mux4_1
XANTENNA__2841__GATE Tile_X0Y5_FrameStrobe[1] VPWR VGND sg13cmos5l_antennanp
X_2531_ _2531_/Q Tile_X0Y3_FrameData[13] Tile_X0Y5_FrameStrobe[0] VPWR VGND sg13cmos5l_dlhq_1
XANTENNA__2103__D Tile_X0Y1_FrameData[25] VPWR VGND sg13cmos5l_antennanp
XFILLER_114_203 VPWR VGND sg13cmos5l_decap_8
XFILLER_315_174 VPWR VGND sg13cmos5l_decap_4
XFILLER_308_93 VPWR VGND sg13cmos5l_decap_8
X_2462_ _2462_/Q Tile_X0Y2_FrameData[2] Tile_X0Y5_FrameStrobe[6] VPWR VGND sg13cmos5l_dlhq_1
XANTENNA__1515__A0 Tile_X0Y3_WW4END[13] VPWR VGND sg13cmos5l_antennanp
XANTENNA__1942__D Tile_X0Y0_FrameData[10] VPWR VGND sg13cmos5l_antennanp
XANTENNA__2226__GATE Tile_X0Y5_FrameStrobe[8] VPWR VGND sg13cmos5l_antennanp
X_2393_ _2393_/Q Tile_X0Y2_FrameData[7] Tile_X0Y5_FrameStrobe[4] VPWR VGND sg13cmos5l_dlhq_1
X_1413_ AXI_M_SOC_WDATA8 Tile_X0Y2_WW4END[0] Tile_X0Y2_WW4END[8] Tile_X0Y2_W6END[0]
+ _1357_/X _2344_/Q _2343_/Q VPWR VGND sg13cmos5l_mux4_1
XANTENNA__2856__GATE Tile_X0Y5_FrameStrobe[2] VPWR VGND sg13cmos5l_antennanp
X_1344_ _1344_/X Tile_X0Y1_W1END[0] _0919_/X Tile_X0Y1_WW4END[0] _0947_/X _2214_/Q
+ _2216_/Q VPWR VGND sg13cmos5l_mux4_1
XFILLER_3_62 VPWR VGND sg13cmos5l_fill_1
XANTENNA__1530__A3 Tile_X0Y0_S4END[13] VPWR VGND sg13cmos5l_antennanp
X_1275_ _3465_/A Tile_X0Y1_WW4END[14] AXI_M_SOC_RDATA23 _0965_/X _1083_/X _2126_/Q
+ _2125_/Q VPWR VGND sg13cmos5l_mux4_1
XFILLER_95_175 VPWR VGND sg13cmos5l_decap_8
XANTENNA__3512__A Tile_X0Y0_UserCLK VPWR VGND sg13cmos5l_antennanp
XFILLER_260_25 VPWR VGND sg13cmos5l_decap_4
XFILLER_260_36 VPWR VGND sg13cmos5l_decap_8
X_3014_ _3014_/Q Tile_X0Y4_FrameData[26] Tile_X0Y5_FrameStrobe[7] VPWR VGND sg13cmos5l_dlhq_1
XANTENNA__2773__D Tile_X0Y3_FrameData[27] VPWR VGND sg13cmos5l_antennanp
XANTENNA__1294__A2 Tile_X0Y0_S4END[6] VPWR VGND sg13cmos5l_antennanp
XFILLER_251_184 VPWR VGND sg13cmos5l_decap_8
XANTENNA__1046__A2 Tile_X0Y5_N4END[5] VPWR VGND sg13cmos5l_antennanp
XFILLER_269_56 VPWR VGND sg13cmos5l_fill_1
X_3916_ Tile_X0Y5_S4BEG[5] _3916_/A VPWR VGND sg13cmos5l_buf_1
XFILLER_338_233 VPWR VGND sg13cmos5l_decap_4
X_3847_ Tile_X0Y5_EE4BEG[4] _3847_/A VPWR VGND sg13cmos5l_buf_1
XFILLER_164_125 VPWR VGND sg13cmos5l_fill_1
XFILLER_285_33 VPWR VGND sg13cmos5l_fill_2
X_3778_ Tile_X0Y4_FrameData_O[0] Tile_X0Y4_FrameData[0] VPWR VGND sg13cmos5l_buf_1
XANTENNA__2809__GATE Tile_X0Y5_FrameStrobe[0] VPWR VGND sg13cmos5l_antennanp
X_2729_ _2729_/Q Tile_X0Y3_FrameData[7] Tile_X0Y5_FrameStrobe[6] VPWR VGND sg13cmos5l_dlhq_1
XANTENNA__0557__A1 Tile_X0Y4_W2MID[1] VPWR VGND sg13cmos5l_antennanp
XANTENNA__2013__D Tile_X0Y1_FrameData[19] VPWR VGND sg13cmos5l_antennanp
XANTENNA__3109__D Tile_X0Y5_FrameData[11] VPWR VGND sg13cmos5l_antennanp
XANTENNA__2948__D Tile_X0Y4_FrameData[28] VPWR VGND sg13cmos5l_antennanp
XANTENNA__1506__A0 Tile_X0Y3_W2MID[2] VPWR VGND sg13cmos5l_antennanp
XANTENNA__1852__D Tile_X0Y0_FrameData[4] VPWR VGND sg13cmos5l_antennanp
XFILLER_120_228 VPWR VGND sg13cmos5l_decap_8
XANTENNA__1521__A3 Tile_X0Y0_S4END[12] VPWR VGND sg13cmos5l_antennanp
XFILLER_234_81 VPWR VGND sg13cmos5l_decap_8
XFILLER_234_92 VPWR VGND sg13cmos5l_fill_2
XFILLER_274_243 VPWR VGND sg13cmos5l_fill_1
XFILLER_47_35 VPWR VGND sg13cmos5l_fill_2
XANTENNA__3422__A Tile_X0Y2_FrameData[24] VPWR VGND sg13cmos5l_antennanp
XFILLER_170_36 VPWR VGND sg13cmos5l_decap_8
XFILLER_274_276 VPWR VGND sg13cmos5l_fill_1
XFILLER_47_68 VPWR VGND sg13cmos5l_decap_4
XANTENNA__2683__D Tile_X0Y3_FrameData[21] VPWR VGND sg13cmos5l_antennanp
XFILLER_103_96 VPWR VGND sg13cmos5l_decap_4
XANTENNA__1037__A2 Tile_X0Y0_S1END[1] VPWR VGND sg13cmos5l_antennanp
XFILLER_179_45 VPWR VGND sg13cmos5l_fill_2
XFILLER_242_184 VPWR VGND sg13cmos5l_decap_8
XFILLER_63_89 VPWR VGND sg13cmos5l_decap_8
XFILLER_6_124 VPWR VGND sg13cmos5l_fill_2
XFILLER_170_106 VPWR VGND sg13cmos5l_decap_8
XANTENNA__3019__D Tile_X0Y4_FrameData[21] VPWR VGND sg13cmos5l_antennanp
XFILLER_128_71 VPWR VGND sg13cmos5l_decap_8
XFILLER_163_180 VPWR VGND sg13cmos5l_decap_8
XANTENNA__1762__D Tile_X0Y0_FrameData[30] VPWR VGND sg13cmos5l_antennanp
XANTENNA__2858__D Tile_X0Y4_FrameData[22] VPWR VGND sg13cmos5l_antennanp
XFILLER_88_86 VPWR VGND sg13cmos5l_fill_1
XANTENNA__1512__A3 Tile_X0Y0_S4END[14] VPWR VGND sg13cmos5l_antennanp
XFILLER_77_164 VPWR VGND sg13cmos5l_decap_4
XFILLER_225_107 VPWR VGND sg13cmos5l_fill_1
XANTENNA__2593__D Tile_X0Y3_FrameData[15] VPWR VGND sg13cmos5l_antennanp
XFILLER_280_224 VPWR VGND sg13cmos5l_decap_4
X_1060_ _1060_/X Tile_X0Y0_W1END[0] Tile_X0Y0_WW4END[12] _1068_/X _1069_/X _1908_/Q
+ _1906_/Q VPWR VGND sg13cmos5l_mux4_1
XFILLER_18_253 VPWR VGND sg13cmos5l_fill_2
XFILLER_37_90 VPWR VGND sg13cmos5l_decap_4
XFILLER_33_267 VPWR VGND sg13cmos5l_decap_8
XFILLER_239_15 VPWR VGND sg13cmos5l_fill_1
X_1962_ _1962_/Q Tile_X0Y0_FrameData[22] Tile_X0Y5_FrameStrobe[8] VPWR VGND sg13cmos5l_dlhq_1
XANTENNA__1937__D Tile_X0Y0_FrameData[15] VPWR VGND sg13cmos5l_antennanp
XANTENNA__2150__GATE Tile_X0Y5_FrameStrobe[5] VPWR VGND sg13cmos5l_antennanp
X_3701_ Tile_X0Y3_FrameData_O[4] Tile_X0Y3_FrameData[4] VPWR VGND sg13cmos5l_buf_1
X_1893_ _1893_/Q Tile_X0Y0_FrameData[27] Tile_X0Y5_FrameStrobe[6] VPWR VGND sg13cmos5l_dlhq_1
X_0913_ _0913_/X _0596_/X _0782_/X _3304_/Q VPWR VGND sg13cmos5l_mux2_1
XANTENNA__2780__GATE Tile_X0Y5_FrameStrobe[8] VPWR VGND sg13cmos5l_antennanp
X_3632_ Tile_X0Y0_E2BEGb[3] _3632_/A VPWR VGND sg13cmos5l_buf_1
X_0844_ _0845_/B Tile_X0Y5_W1END[2] Tile_X0Y5_WW4END[14] Tile_X0Y5_WW4END[6] _0694_/X
+ _3131_/Q _3132_/Q VPWR VGND sg13cmos5l_mux4_1
X_3563_ Tile_X0Y0_FrameStrobe_O[14] Tile_X0Y5_FrameStrobe[14] VPWR VGND sg13cmos5l_buf_1
X_0775_ _0775_/X _0755_/X _0756_/X _0758_/X _0757_/X _3339_/Q _3338_/Q VPWR VGND sg13cmos5l_mux4_1
XANTENNA__1200__A2 Tile_X0Y0_W6END[1] VPWR VGND sg13cmos5l_antennanp
XANTENNA__2165__GATE Tile_X0Y5_FrameStrobe[6] VPWR VGND sg13cmos5l_antennanp
X_2514_ _2514_/Q Tile_X0Y3_FrameData[30] Tile_X0Y5_FrameStrobe[0] VPWR VGND sg13cmos5l_dlhq_1
X_3494_ Tile_X0Y1_E2BEGb[2] _3494_/A VPWR VGND sg13cmos5l_buf_1
XFILLER_45_0 VPWR VGND sg13cmos5l_fill_2
XANTENNA__2768__D Tile_X0Y3_FrameData[0] VPWR VGND sg13cmos5l_antennanp
XANTENNA__2795__GATE Tile_X0Y5_FrameStrobe[0] VPWR VGND sg13cmos5l_antennanp
X_2445_ _2445_/Q Tile_X0Y2_FrameData[19] Tile_X0Y5_FrameStrobe[6] VPWR VGND sg13cmos5l_dlhq_1
X_2376_ _2376_/Q Tile_X0Y2_FrameData[24] Tile_X0Y5_FrameStrobe[4] VPWR VGND sg13cmos5l_dlhq_1
XFILLER_68_142 VPWR VGND sg13cmos5l_fill_1
XFILLER_216_107 VPWR VGND sg13cmos5l_fill_1
XFILLER_271_68 VPWR VGND sg13cmos5l_fill_1
X_1327_ _3523_/A _1326_/X _1325_/X _2209_/Q VPWR VGND sg13cmos5l_mux2_1
X_1258_ _3640_/A Tile_X0Y0_W2MID[4] AXI_M_SOC_BVALID _1148_/X _1078_/X _1882_/Q _1881_/Q
+ VPWR VGND sg13cmos5l_mux4_1
XANTENNA__2103__GATE Tile_X0Y5_FrameStrobe[4] VPWR VGND sg13cmos5l_antennanp
XFILLER_209_192 VPWR VGND sg13cmos5l_decap_8
XFILLER_271_268 VPWR VGND sg13cmos5l_fill_1
X_1189_ _1189_/X Tile_X0Y4_W2MID[3] Tile_X0Y4_W2END[3] Tile_X0Y4_W6END[3] _1319_/X
+ _3040_/Q _3039_/Q VPWR VGND sg13cmos5l_mux4_1
XFILLER_83_189 VPWR VGND sg13cmos5l_decap_8
XANTENNA__2733__GATE Tile_X0Y5_FrameStrobe[6] VPWR VGND sg13cmos5l_antennanp
XFILLER_224_151 VPWR VGND sg13cmos5l_decap_8
XANTENNA__2008__D Tile_X0Y1_FrameData[24] VPWR VGND sg13cmos5l_antennanp
XFILLER_149_15 VPWR VGND sg13cmos5l_decap_8
XFILLER_33_59 VPWR VGND sg13cmos5l_decap_4
XANTENNA__1847__D Tile_X0Y0_FrameData[9] VPWR VGND sg13cmos5l_antennanp
XANTENNA__2118__GATE Tile_X0Y5_FrameStrobe[4] VPWR VGND sg13cmos5l_antennanp
XFILLER_130_8 VPWR VGND sg13cmos5l_decap_8
XFILLER_296_43 VPWR VGND sg13cmos5l_decap_8
XANTENNA__2748__GATE Tile_X0Y5_FrameStrobe[7] VPWR VGND sg13cmos5l_antennanp
XFILLER_137_158 VPWR VGND sg13cmos5l_fill_1
XANTENNA__3417__A Tile_X0Y2_FrameData[19] VPWR VGND sg13cmos5l_antennanp
XANTENNA__2678__D Tile_X0Y3_FrameData[26] VPWR VGND sg13cmos5l_antennanp
XFILLER_160_172 VPWR VGND sg13cmos5l_fill_2
XFILLER_315_28 VPWR VGND sg13cmos5l_fill_2
XANTENNA__3704__X Tile_X0Y3_FrameData_O[7] VPWR VGND sg13cmos5l_antennanp
XFILLER_245_91 VPWR VGND sg13cmos5l_decap_8
XFILLER_58_34 VPWR VGND sg13cmos5l_decap_8
XFILLER_247_210 VPWR VGND sg13cmos5l_decap_4
XFILLER_59_131 VPWR VGND sg13cmos5l_decap_8
XFILLER_247_265 VPWR VGND sg13cmos5l_decap_8
XFILLER_101_294 VPWR VGND sg13cmos5l_fill_1
XFILLER_262_235 VPWR VGND sg13cmos5l_decap_8
XFILLER_74_22 VPWR VGND sg13cmos5l_decap_8
XFILLER_74_134 VPWR VGND sg13cmos5l_decap_8
XANTENNA__1942__GATE Tile_X0Y5_FrameStrobe[7] VPWR VGND sg13cmos5l_antennanp
XANTENNA__3302__D Tile_X0Y5_FrameData[10] VPWR VGND sg13cmos5l_antennanp
XFILLER_114_95 VPWR VGND sg13cmos5l_decap_8
XFILLER_74_167 VPWR VGND sg13cmos5l_fill_1
XFILLER_230_110 VPWR VGND sg13cmos5l_decap_8
XANTENNA__1957__GATE Tile_X0Y5_FrameStrobe[8] VPWR VGND sg13cmos5l_antennanp
XFILLER_230_165 VPWR VGND sg13cmos5l_decap_8
XFILLER_30_237 VPWR VGND sg13cmos5l_fill_2
XFILLER_90_32 VPWR VGND sg13cmos5l_decap_8
XANTENNA__1757__D Tile_X0Y0_FrameData[3] VPWR VGND sg13cmos5l_antennanp
XFILLER_230_176 VPWR VGND sg13cmos5l_fill_2
XANTENNA__0769__A1 Tile_X0Y5_WW4END[12] VPWR VGND sg13cmos5l_antennanp
XFILLER_128_136 VPWR VGND sg13cmos5l_decap_8
XFILLER_183_220 VPWR VGND sg13cmos5l_decap_4
XANTENNA__1430__A2 Tile_X0Y2_W6END[4] VPWR VGND sg13cmos5l_antennanp
XFILLER_143_117 VPWR VGND sg13cmos5l_fill_2
XFILLER_183_275 VPWR VGND sg13cmos5l_fill_1
XFILLER_183_286 VPWR VGND sg13cmos5l_fill_1
XFILLER_99_41 VPWR VGND sg13cmos5l_fill_1
XFILLER_332_206 VPWR VGND sg13cmos5l_decap_4
XANTENNA__1194__A1 Tile_X0Y0_W6END[6] VPWR VGND sg13cmos5l_antennanp
X_0560_ _3901_/A Tile_X0Y5_W1END[2] Tile_X0Y5_W2MID[1] Tile_X0Y5_W2END[1] _0559_/X
+ _3272_/Q _3271_/Q VPWR VGND sg13cmos5l_mux4_1
XANTENNA__2588__D Tile_X0Y3_FrameData[20] VPWR VGND sg13cmos5l_antennanp
XANTENNA__3614__X Tile_X0Y0_EE4BEG[13] VPWR VGND sg13cmos5l_antennanp
X_2230_ _2230_/Q Tile_X0Y1_FrameData[26] Tile_X0Y5_FrameStrobe[8] VPWR VGND sg13cmos5l_dlhq_1
XFILLER_297_198 VPWR VGND sg13cmos5l_fill_2
XFILLER_300_136 VPWR VGND sg13cmos5l_decap_8
XANTENNA__0686__A Tile_X0Y4_W6END[2] VPWR VGND sg13cmos5l_antennanp
X_2161_ _2161_/Q Tile_X0Y1_FrameData[31] Tile_X0Y5_FrameStrobe[6] VPWR VGND sg13cmos5l_dlhq_1
XFILLER_65_112 VPWR VGND sg13cmos5l_fill_2
X_2092_ _2092_/Q Tile_X0Y1_FrameData[4] Tile_X0Y5_FrameStrobe[3] VPWR VGND sg13cmos5l_dlhq_1
X_1112_ _1112_/X Tile_X0Y3_W2MID[0] Tile_X0Y3_W2END[0] Tile_X0Y3_W6END[0] _1351_/X
+ _2762_/Q _2761_/Q VPWR VGND sg13cmos5l_mux4_1
XFILLER_65_156 VPWR VGND sg13cmos5l_fill_1
XANTENNA__1249__A2 Tile_X0Y0_S1END[3] VPWR VGND sg13cmos5l_antennanp
XANTENNA__3212__D Tile_X0Y5_FrameData[4] VPWR VGND sg13cmos5l_antennanp
X_1043_ _1043_/X Tile_X0Y2_W2MID[2] Tile_X0Y2_W2END[2] Tile_X0Y2_W6END[2] _1183_/X
+ _2494_/Q _2493_/Q VPWR VGND sg13cmos5l_mux4_1
XFILLER_206_162 VPWR VGND sg13cmos5l_decap_8
XFILLER_221_110 VPWR VGND sg13cmos5l_decap_8
XFILLER_80_159 VPWR VGND sg13cmos5l_decap_4
X_2994_ _2994_/Q Tile_X0Y4_FrameData[14] Tile_X0Y5_FrameStrobe[6] VPWR VGND sg13cmos5l_dlhq_1
XFILLER_159_250 VPWR VGND sg13cmos5l_decap_4
X_1945_ _1945_/Q Tile_X0Y0_FrameData[7] Tile_X0Y5_FrameStrobe[7] VPWR VGND sg13cmos5l_dlhq_1
XFILLER_119_18 VPWR VGND sg13cmos5l_fill_2
XANTENNA__1421__A2 Tile_X0Y2_W6END[8] VPWR VGND sg13cmos5l_antennanp
XFILLER_266_24 VPWR VGND sg13cmos5l_fill_2
XFILLER_308_258 VPWR VGND sg13cmos5l_fill_1
X_1876_ _1876_/Q Tile_X0Y0_FrameData[12] Tile_X0Y5_FrameStrobe[5] VPWR VGND sg13cmos5l_dlhq_1
XANTENNA__1309__X AXI_M_SOC_AWADDR7 VPWR VGND sg13cmos5l_antennanp
X_3615_ Tile_X0Y0_EE4BEG[14] _3615_/A VPWR VGND sg13cmos5l_buf_1
X_0827_ _3834_/A Tile_X0Y5_N4END[3] _0598_/X _0739_/X _0596_/X _3177_/Q _3178_/Q VPWR
+ VGND sg13cmos5l_mux4_1
XANTENNA__1185__A1 Tile_X0Y1_W2END[4] VPWR VGND sg13cmos5l_antennanp
X_3546_ Tile_X0Y0_N1BEG[1] _3546_/A VPWR VGND sg13cmos5l_buf_1
X_0758_ _0758_/X Tile_X0Y5_WW4END[6] Tile_X0Y5_WW4END[14] Tile_X0Y5_W6END[6] _0695_/X
+ _3148_/Q _3147_/Q VPWR VGND sg13cmos5l_mux4_1
XANTENNA__2498__D Tile_X0Y2_FrameData[30] VPWR VGND sg13cmos5l_antennanp
XFILLER_282_23 VPWR VGND sg13cmos5l_decap_4
XFILLER_88_204 VPWR VGND sg13cmos5l_decap_8
XANTENNA__3524__X Tile_X0Y0_N4BEG[11] VPWR VGND sg13cmos5l_antennanp
X_3477_ Tile_X0Y1_EE4BEG[13] _3477_/A VPWR VGND sg13cmos5l_buf_1
X_0689_ _0689_/X _0684_/X _0685_/Y _0688_/Y VPWR VGND sg13cmos5l_a21o_1
X_2428_ _2428_/Q Tile_X0Y2_FrameData[4] Tile_X0Y5_FrameStrobe[5] VPWR VGND sg13cmos5l_dlhq_1
X_2359_ _2359_/Q Tile_X0Y2_FrameData[9] Tile_X0Y5_FrameStrobe[3] VPWR VGND sg13cmos5l_dlhq_1
XANTENNA__0696__A0 Tile_X0Y5_N1END[2] VPWR VGND sg13cmos5l_antennanp
XFILLER_151_49 VPWR VGND sg13cmos5l_decap_8
XFILLER_185_9 VPWR VGND sg13cmos5l_decap_8
XFILLER_229_276 VPWR VGND sg13cmos5l_decap_4
XFILLER_56_156 VPWR VGND sg13cmos5l_decap_8
XANTENNA__2042__GATE Tile_X0Y5_FrameStrobe[2] VPWR VGND sg13cmos5l_antennanp
XANTENNA__2672__GATE Tile_X0Y5_FrameStrobe[4] VPWR VGND sg13cmos5l_antennanp
XANTENNA__3122__D Tile_X0Y5_FrameData[30] VPWR VGND sg13cmos5l_antennanp
XANTENNA__3700__A Tile_X0Y3_FrameData[3] VPWR VGND sg13cmos5l_antennanp
XFILLER_71_137 VPWR VGND sg13cmos5l_fill_1
XANTENNA__2961__D Tile_X0Y4_FrameData[15] VPWR VGND sg13cmos5l_antennanp
XANTENNA__2057__GATE Tile_X0Y5_FrameStrobe[2] VPWR VGND sg13cmos5l_antennanp
XANTENNA__2687__GATE Tile_X0Y5_FrameStrobe[5] VPWR VGND sg13cmos5l_antennanp
XFILLER_100_53 VPWR VGND sg13cmos5l_decap_8
XFILLER_60_13 VPWR VGND sg13cmos5l_fill_2
XANTENNA__1412__A2 Tile_X0Y2_W6END[1] VPWR VGND sg13cmos5l_antennanp
XFILLER_176_24 VPWR VGND sg13cmos5l_fill_2
XANTENNA__2610__GATE Tile_X0Y5_FrameStrobe[3] VPWR VGND sg13cmos5l_antennanp
XFILLER_176_79 VPWR VGND sg13cmos5l_fill_2
XFILLER_5_19 VPWR VGND sg13cmos5l_fill_2
XFILLER_118_191 VPWR VGND sg13cmos5l_decap_8
XFILLER_279_110 VPWR VGND sg13cmos5l_fill_2
XANTENNA__1176__A1 Tile_X0Y0_W2END[1] VPWR VGND sg13cmos5l_antennanp
XFILLER_140_109 VPWR VGND sg13cmos5l_fill_1
XFILLER_79_215 VPWR VGND sg13cmos5l_fill_2
XANTENNA__0923__A1 Tile_X0Y5_WW4END[1] VPWR VGND sg13cmos5l_antennanp
XANTENNA__2201__D Tile_X0Y1_FrameData[23] VPWR VGND sg13cmos5l_antennanp
XANTENNA__3434__X Tile_X0Y1_FrameData_O[2] VPWR VGND sg13cmos5l_antennanp
XANTENNA__2625__GATE Tile_X0Y5_FrameStrobe[3] VPWR VGND sg13cmos5l_antennanp
XFILLER_94_207 VPWR VGND sg13cmos5l_decap_8
XFILLER_197_0 VPWR VGND sg13cmos5l_decap_4
XFILLER_85_32 VPWR VGND sg13cmos5l_decap_8
XANTENNA__1881__GATE Tile_X0Y5_FrameStrobe[5] VPWR VGND sg13cmos5l_antennanp
XFILLER_47_123 VPWR VGND sg13cmos5l_decap_4
XFILLER_47_189 VPWR VGND sg13cmos5l_decap_8
XANTENNA__3032__D Tile_X0Y4_FrameData[8] VPWR VGND sg13cmos5l_antennanp
XFILLER_235_279 VPWR VGND sg13cmos5l_fill_2
XFILLER_62_137 VPWR VGND sg13cmos5l_decap_4
XANTENNA__1896__GATE Tile_X0Y5_FrameStrobe[6] VPWR VGND sg13cmos5l_antennanp
XFILLER_62_159 VPWR VGND sg13cmos5l_decap_8
XANTENNA__1651__A2 Tile_X0Y4_WW4END[15] VPWR VGND sg13cmos5l_antennanp
XANTENNA__2871__D Tile_X0Y4_FrameData[9] VPWR VGND sg13cmos5l_antennanp
XANTENNA__3609__X Tile_X0Y0_EE4BEG[8] VPWR VGND sg13cmos5l_antennanp
X_1730_ _1730_/Q Tile_X0Y0_FrameData[30] Tile_X0Y5_FrameStrobe[1] VPWR VGND sg13cmos5l_dlhq_1
X_1661_ _3737_/A Tile_X0Y4_W2MID[4] AXI_M_SOC_RDATA1 _1130_/X _1319_/X _2970_/Q _2969_/Q
+ VPWR VGND sg13cmos5l_mux4_1
X_3400_ Tile_X0Y2_FrameData_O[2] Tile_X0Y2_FrameData[2] VPWR VGND sg13cmos5l_buf_1
X_0612_ _0612_/Y _3267_/Q _0608_/X _0611_/Y VPWR VGND sg13cmos5l_a21oi_1
XFILLER_7_285 VPWR VGND sg13cmos5l_fill_2
XANTENNA__1834__GATE Tile_X0Y5_FrameStrobe[4] VPWR VGND sg13cmos5l_antennanp
XFILLER_124_161 VPWR VGND sg13cmos5l_decap_8
XFILLER_131_109 VPWR VGND sg13cmos5l_decap_8
XFILLER_171_267 VPWR VGND sg13cmos5l_fill_2
XFILLER_236_49 VPWR VGND sg13cmos5l_decap_4
XFILLER_313_250 VPWR VGND sg13cmos5l_decap_4
X_3331_ _3331_/Q Tile_X0Y5_FrameData[29] Tile_X0Y5_FrameStrobe[9] VPWR VGND sg13cmos5l_dlhq_1
X_1592_ _1592_/X _1435_/X _0971_/X _1586_/B _1351_/X _2715_/Q _2714_/Q VPWR VGND sg13cmos5l_mux4_1
XANTENNA__2111__D Tile_X0Y1_FrameData[17] VPWR VGND sg13cmos5l_antennanp
XANTENNA__3207__D Tile_X0Y5_FrameData[9] VPWR VGND sg13cmos5l_antennanp
X_0543_ _0543_/Y _3294_/Q VPWR VGND sg13cmos5l_inv_1
X_3262_ _3262_/Q Tile_X0Y5_FrameData[18] Tile_X0Y5_FrameStrobe[6] VPWR VGND sg13cmos5l_dlhq_1
XANTENNA__1950__D Tile_X0Y0_FrameData[2] VPWR VGND sg13cmos5l_antennanp
X_3193_ _3193_/Q Tile_X0Y5_FrameData[23] Tile_X0Y5_FrameStrobe[4] VPWR VGND sg13cmos5l_dlhq_1
X_2213_ _2213_/Q Tile_X0Y1_FrameData[11] Tile_X0Y5_FrameStrobe[7] VPWR VGND sg13cmos5l_dlhq_1
XANTENNA__0678__A0 Tile_X0Y2_W1END[2] VPWR VGND sg13cmos5l_antennanp
XANTENNA__1849__GATE Tile_X0Y5_FrameStrobe[4] VPWR VGND sg13cmos5l_antennanp
XFILLER_226_202 VPWR VGND sg13cmos5l_decap_8
XFILLER_226_213 VPWR VGND sg13cmos5l_fill_2
X_2144_ _2144_/Q Tile_X0Y1_FrameData[16] Tile_X0Y5_FrameStrobe[5] VPWR VGND sg13cmos5l_dlhq_1
XFILLER_226_246 VPWR VGND sg13cmos5l_fill_1
XFILLER_226_257 VPWR VGND sg13cmos5l_fill_2
XFILLER_38_167 VPWR VGND sg13cmos5l_decap_8
X_2075_ _2075_/Q Tile_X0Y1_FrameData[21] Tile_X0Y5_FrameStrobe[3] VPWR VGND sg13cmos5l_dlhq_1
XFILLER_53_137 VPWR VGND sg13cmos5l_decap_8
X_1026_ _1026_/X Tile_X0Y0_W6END[5] _1041_/X _1042_/X _1045_/X _1903_/Q _1905_/Q VPWR
+ VGND sg13cmos5l_mux4_1
XANTENNA__1642__A2 Tile_X0Y4_WW4END[11] VPWR VGND sg13cmos5l_antennanp
XANTENNA__2781__D Tile_X0Y3_FrameData[19] VPWR VGND sg13cmos5l_antennanp
XANTENNA__3519__X Tile_X0Y0_N4BEG[6] VPWR VGND sg13cmos5l_antennanp
X_2977_ _2977_/Q Tile_X0Y4_FrameData[31] Tile_X0Y5_FrameStrobe[6] VPWR VGND sg13cmos5l_dlhq_1
X_1928_ _1928_/Q Tile_X0Y0_FrameData[24] Tile_X0Y5_FrameStrobe[7] VPWR VGND sg13cmos5l_dlhq_1
X_1859_ _1859_/Q Tile_X0Y0_FrameData[29] Tile_X0Y5_FrameStrobe[5] VPWR VGND sg13cmos5l_dlhq_1
XANTENNA__3340__GATE Tile_X0Y5_FrameStrobe[8] VPWR VGND sg13cmos5l_antennanp
XFILLER_146_16 VPWR VGND sg13cmos5l_decap_8
XANTENNA__1158__A1 Tile_X0Y0_W2END[7] VPWR VGND sg13cmos5l_antennanp
XFILLER_122_109 VPWR VGND sg13cmos5l_decap_8
XANTENNA__2021__D Tile_X0Y1_FrameData[11] VPWR VGND sg13cmos5l_antennanp
XANTENNA__3117__D Tile_X0Y5_FrameData[3] VPWR VGND sg13cmos5l_antennanp
XFILLER_304_272 VPWR VGND sg13cmos5l_fill_1
X_3529_ Tile_X0Y0_N2BEGb[0] _3529_/A VPWR VGND sg13cmos5l_buf_1
XFILLER_130_120 VPWR VGND sg13cmos5l_decap_8
XFILLER_295_8 VPWR VGND sg13cmos5l_fill_1
XFILLER_39_25 VPWR VGND sg13cmos5l_decap_8
XANTENNA__1860__D Tile_X0Y0_FrameData[28] VPWR VGND sg13cmos5l_antennanp
XANTENNA__2956__D Tile_X0Y4_FrameData[20] VPWR VGND sg13cmos5l_antennanp
XFILLER_130_186 VPWR VGND sg13cmos5l_decap_8
XFILLER_162_48 VPWR VGND sg13cmos5l_fill_1
XFILLER_39_58 VPWR VGND sg13cmos5l_fill_1
XFILLER_288_7 VPWR VGND sg13cmos5l_decap_8
XFILLER_84_240 VPWR VGND sg13cmos5l_decap_4
XFILLER_84_262 VPWR VGND sg13cmos5l_fill_1
XFILLER_55_35 VPWR VGND sg13cmos5l_decap_8
XANTENNA__3430__A Tile_X0Y2_UserCLK VPWR VGND sg13cmos5l_antennanp
XANTENNA__2691__D Tile_X0Y3_FrameData[13] VPWR VGND sg13cmos5l_antennanp
XFILLER_71_56 VPWR VGND sg13cmos5l_decap_8
XANTENNA__3429__X Tile_X0Y2_FrameData_O[31] VPWR VGND sg13cmos5l_antennanp
XFILLER_197_197 VPWR VGND sg13cmos5l_fill_1
XFILLER_240_293 VPWR VGND sg13cmos5l_fill_2
XANTENNA__3308__GATE Tile_X0Y5_FrameStrobe[7] VPWR VGND sg13cmos5l_antennanp
XFILLER_112_0 VPWR VGND sg13cmos5l_fill_2
XANTENNA__1149__A1 Tile_X0Y1_W2END[5] VPWR VGND sg13cmos5l_antennanp
XANTENNA__2564__GATE Tile_X0Y5_FrameStrobe[1] VPWR VGND sg13cmos5l_antennanp
XANTENNA__3027__D Tile_X0Y4_FrameData[13] VPWR VGND sg13cmos5l_antennanp
XFILLER_96_42 VPWR VGND sg13cmos5l_decap_8
XANTENNA__1770__D Tile_X0Y0_FrameData[22] VPWR VGND sg13cmos5l_antennanp
XANTENNA__2866__D Tile_X0Y4_FrameData[14] VPWR VGND sg13cmos5l_antennanp
XFILLER_310_253 VPWR VGND sg13cmos5l_fill_2
XANTENNA__2579__GATE Tile_X0Y5_FrameStrobe[2] VPWR VGND sg13cmos5l_antennanp
XANTENNA__1321__A1 AXI_M_SOC_RDATA22 VPWR VGND sg13cmos5l_antennanp
XFILLER_208_246 VPWR VGND sg13cmos5l_decap_8
XFILLER_35_104 VPWR VGND sg13cmos5l_fill_1
XANTENNA__1412__X AXI_M_SOC_WDATA9 VPWR VGND sg13cmos5l_antennanp
XFILLER_208_257 VPWR VGND sg13cmos5l_fill_2
XANTENNA__2502__GATE Tile_X0Y5_FrameStrobe[8] VPWR VGND sg13cmos5l_antennanp
XFILLER_35_148 VPWR VGND sg13cmos5l_decap_8
XANTENNA__1085__A0 Tile_X0Y3_W2MID[2] VPWR VGND sg13cmos5l_antennanp
X_2900_ _2900_/Q Tile_X0Y4_FrameData[12] Tile_X0Y5_FrameStrobe[3] VPWR VGND sg13cmos5l_dlhq_1
XFILLER_50_107 VPWR VGND sg13cmos5l_decap_8
XFILLER_188_153 VPWR VGND sg13cmos5l_decap_8
X_3880_ Tile_X0Y5_FrameData_O[21] Tile_X0Y5_FrameData[21] VPWR VGND sg13cmos5l_buf_1
XANTENNA__0970__Y AXI_M_SOC_AWLEN7 VPWR VGND sg13cmos5l_antennanp
XANTENNA__2106__D Tile_X0Y1_FrameData[22] VPWR VGND sg13cmos5l_antennanp
XFILLER_231_293 VPWR VGND sg13cmos5l_fill_2
X_2831_ _2831_/Q Tile_X0Y4_FrameData[17] Tile_X0Y5_FrameStrobe[1] VPWR VGND sg13cmos5l_dlhq_1
XFILLER_84_4 VPWR VGND sg13cmos5l_fill_1
XANTENNA__2517__GATE Tile_X0Y5_FrameStrobe[0] VPWR VGND sg13cmos5l_antennanp
X_2762_ _2762_/Q Tile_X0Y3_FrameData[6] Tile_X0Y5_FrameStrobe[7] VPWR VGND sg13cmos5l_dlhq_1
XFILLER_337_139 VPWR VGND sg13cmos5l_fill_1
XANTENNA__1945__D Tile_X0Y0_FrameData[7] VPWR VGND sg13cmos5l_antennanp
X_1713_ _1713_/Q Tile_X0Y0_FrameData[15] Tile_X0Y5_FrameStrobe[0] VPWR VGND sg13cmos5l_dlhq_1
XANTENNA__1773__GATE Tile_X0Y5_FrameStrobe[2] VPWR VGND sg13cmos5l_antennanp
X_2693_ _2693_/Q Tile_X0Y3_FrameData[11] Tile_X0Y5_FrameStrobe[5] VPWR VGND sg13cmos5l_dlhq_1
XFILLER_6_40 VPWR VGND sg13cmos5l_decap_4
X_1644_ AXI_M_SOC_ARADDR10 Tile_X0Y4_WW4END[2] Tile_X0Y4_WW4END[10] Tile_X0Y4_W6END[10]
+ _1012_/X _2868_/Q _2867_/Q VPWR VGND sg13cmos5l_mux4_1
X_1575_ _1575_/Y _2724_/Q _1271_/X _1574_/Y VPWR VGND sg13cmos5l_a21oi_1
XFILLER_258_102 VPWR VGND sg13cmos5l_decap_8
XFILLER_258_113 VPWR VGND sg13cmos5l_fill_1
XFILLER_258_135 VPWR VGND sg13cmos5l_decap_8
XFILLER_298_293 VPWR VGND sg13cmos5l_fill_2
X_3314_ _3314_/Q Tile_X0Y5_FrameData[30] Tile_X0Y5_FrameStrobe[8] VPWR VGND sg13cmos5l_dlhq_1
XANTENNA__1560__A1 Tile_X0Y3_W2END[0] VPWR VGND sg13cmos5l_antennanp
XANTENNA__1788__GATE Tile_X0Y5_FrameStrobe[2] VPWR VGND sg13cmos5l_antennanp
XANTENNA__2776__D Tile_X0Y3_FrameData[24] VPWR VGND sg13cmos5l_antennanp
X_3245_ _3245_/Q Tile_X0Y5_FrameData[3] Tile_X0Y5_FrameStrobe[5] VPWR VGND sg13cmos5l_dlhq_1
XFILLER_58_229 VPWR VGND sg13cmos5l_decap_8
XANTENNA__3802__X Tile_X0Y4_FrameData_O[24] VPWR VGND sg13cmos5l_antennanp
X_3176_ _3176_/Q Tile_X0Y5_FrameData[8] Tile_X0Y5_FrameStrobe[3] VPWR VGND sg13cmos5l_dlhq_1
XANTENNA__1711__GATE Tile_X0Y5_FrameStrobe[0] VPWR VGND sg13cmos5l_antennanp
X_2127_ _2127_/Q Tile_X0Y1_FrameData[1] Tile_X0Y5_FrameStrobe[4] VPWR VGND sg13cmos5l_dlhq_1
X_2058_ _2058_/Q Tile_X0Y1_FrameData[6] Tile_X0Y5_FrameStrobe[2] VPWR VGND sg13cmos5l_dlhq_1
XANTENNA__1076__A0 Tile_X0Y2_W2MID[3] VPWR VGND sg13cmos5l_antennanp
X_1009_ _3535_/A Tile_X0Y1_W2MID[1] Tile_X0Y1_W2END[1] Tile_X0Y1_W6END[1] _1083_/X
+ _2220_/Q _2219_/Q VPWR VGND sg13cmos5l_mux4_1
XANTENNA__0823__A0 Tile_X0Y5_WW4END[0] VPWR VGND sg13cmos5l_antennanp
XANTENNA__1615__A2 AXI_M_SOC_RDATA2 VPWR VGND sg13cmos5l_antennanp
XANTENNA__1726__GATE Tile_X0Y5_FrameStrobe[0] VPWR VGND sg13cmos5l_antennanp
XFILLER_222_260 VPWR VGND sg13cmos5l_decap_8
XFILLER_222_293 VPWR VGND sg13cmos5l_fill_2
XANTENNA__2016__D Tile_X0Y1_FrameData[16] VPWR VGND sg13cmos5l_antennanp
XFILLER_41_48 VPWR VGND sg13cmos5l_decap_8
XFILLER_194_178 VPWR VGND sg13cmos5l_decap_8
XFILLER_315_9 VPWR VGND sg13cmos5l_fill_2
XANTENNA__1855__D Tile_X0Y0_FrameData[1] VPWR VGND sg13cmos5l_antennanp
XFILLER_289_260 VPWR VGND sg13cmos5l_fill_1
XANTENNA__3294__GATE Tile_X0Y5_FrameStrobe[7] VPWR VGND sg13cmos5l_antennanp
XANTENNA__3425__A Tile_X0Y2_FrameData[27] VPWR VGND sg13cmos5l_antennanp
XFILLER_173_58 VPWR VGND sg13cmos5l_decap_8
XFILLER_1_236 VPWR VGND sg13cmos5l_fill_2
XFILLER_249_102 VPWR VGND sg13cmos5l_decap_4
XFILLER_289_293 VPWR VGND sg13cmos5l_fill_2
XANTENNA__1551__A1 Tile_X0Y3_WW4END[9] VPWR VGND sg13cmos5l_antennanp
XANTENNA__2686__D Tile_X0Y3_FrameData[18] VPWR VGND sg13cmos5l_antennanp
XFILLER_49_218 VPWR VGND sg13cmos5l_decap_4
XFILLER_323_17 VPWR VGND sg13cmos5l_fill_2
XANTENNA__3712__X Tile_X0Y3_FrameData_O[15] VPWR VGND sg13cmos5l_antennanp
XFILLER_103_197 VPWR VGND sg13cmos5l_decap_8
XFILLER_106_96 VPWR VGND sg13cmos5l_decap_8
XFILLER_66_34 VPWR VGND sg13cmos5l_decap_8
XFILLER_257_190 VPWR VGND sg13cmos5l_fill_1
XFILLER_17_115 VPWR VGND sg13cmos5l_fill_1
XFILLER_122_73 VPWR VGND sg13cmos5l_fill_1
XFILLER_17_148 VPWR VGND sg13cmos5l_decap_8
XFILLER_82_22 VPWR VGND sg13cmos5l_decap_8
XFILLER_72_254 VPWR VGND sg13cmos5l_decap_8
XANTENNA__3232__GATE Tile_X0Y5_FrameStrobe[5] VPWR VGND sg13cmos5l_antennanp
XFILLER_198_22 VPWR VGND sg13cmos5l_decap_8
XFILLER_32_107 VPWR VGND sg13cmos5l_fill_1
XANTENNA__0814__A0 Tile_X0Y5_WW4END[9] VPWR VGND sg13cmos5l_antennanp
XANTENNA__1606__A2 Tile_X0Y3_WW4END[1] VPWR VGND sg13cmos5l_antennanp
XANTENNA__3310__D Tile_X0Y5_FrameData[2] VPWR VGND sg13cmos5l_antennanp
XFILLER_82_99 VPWR VGND sg13cmos5l_decap_8
XFILLER_185_123 VPWR VGND sg13cmos5l_fill_1
XFILLER_213_293 VPWR VGND sg13cmos5l_fill_2
XFILLER_40_173 VPWR VGND sg13cmos5l_decap_8
XFILLER_327_0 VPWR VGND sg13cmos5l_fill_2
XANTENNA__3247__GATE Tile_X0Y5_FrameStrobe[5] VPWR VGND sg13cmos5l_antennanp
XANTENNA__1765__D Tile_X0Y0_FrameData[27] VPWR VGND sg13cmos5l_antennanp
XFILLER_126_212 VPWR VGND sg13cmos5l_decap_8
XFILLER_327_194 VPWR VGND sg13cmos5l_decap_4
XFILLER_141_248 VPWR VGND sg13cmos5l_decap_4
X_1360_ _1360_/X _1346_/X _0558_/X Tile_X0Y5_N2MID[6] _1347_/X _2795_/Q _2796_/Q VPWR
+ VGND sg13cmos5l_mux4_1
XANTENNA__2596__D Tile_X0Y3_FrameData[12] VPWR VGND sg13cmos5l_antennanp
XANTENNA__3622__X Tile_X0Y0_E6BEG[5] VPWR VGND sg13cmos5l_antennanp
X_1291_ _3471_/A Tile_X0Y1_WW4END[8] AXI_M_SOC_RDATA29 _0947_/X _1110_/X _2114_/Q
+ _2113_/Q VPWR VGND sg13cmos5l_mux4_1
X_3030_ _3030_/Q Tile_X0Y4_FrameData[10] Tile_X0Y5_FrameStrobe[7] VPWR VGND sg13cmos5l_dlhq_1
XFILLER_48_251 VPWR VGND sg13cmos5l_fill_2
XANTENNA__2441__GATE Tile_X0Y5_FrameStrobe[6] VPWR VGND sg13cmos5l_antennanp
XANTENNA__0805__A0 Tile_X0Y5_W2END[2] VPWR VGND sg13cmos5l_antennanp
XANTENNA__3220__D Tile_X0Y5_FrameData[28] VPWR VGND sg13cmos5l_antennanp
XFILLER_211_219 VPWR VGND sg13cmos5l_decap_4
XANTENNA__2456__GATE Tile_X0Y5_FrameStrobe[6] VPWR VGND sg13cmos5l_antennanp
X_3863_ Tile_X0Y5_FrameData_O[4] Tile_X0Y5_FrameData[4] VPWR VGND sg13cmos5l_buf_1
XFILLER_258_36 VPWR VGND sg13cmos5l_fill_1
X_2814_ _2814_/Q Tile_X0Y4_FrameData[2] Tile_X0Y5_FrameStrobe[0] VPWR VGND sg13cmos5l_dlhq_1
X_3794_ Tile_X0Y4_FrameData_O[16] Tile_X0Y4_FrameData[16] VPWR VGND sg13cmos5l_buf_1
XFILLER_75_0 VPWR VGND sg13cmos5l_decap_8
XFILLER_325_109 VPWR VGND sg13cmos5l_decap_8
XANTENNA__1230__A0 Tile_X0Y0_WW4END[1] VPWR VGND sg13cmos5l_antennanp
X_2745_ _2745_/Q Tile_X0Y3_FrameData[23] Tile_X0Y5_FrameStrobe[7] VPWR VGND sg13cmos5l_dlhq_1
X_2676_ _2676_/Q Tile_X0Y3_FrameData[28] Tile_X0Y5_FrameStrobe[5] VPWR VGND sg13cmos5l_dlhq_1
XFILLER_333_142 VPWR VGND sg13cmos5l_fill_1
X_1627_ _3756_/A AXI_M_SOC_RDATA0 _1039_/X _1040_/X _1016_/X _2900_/Q _2899_/Q VPWR
+ VGND sg13cmos5l_mux4_1
XFILLER_333_175 VPWR VGND sg13cmos5l_fill_2
XFILLER_207_40 VPWR VGND sg13cmos5l_fill_1
X_1558_ AXI_M_SOC_WDATA7 Tile_X0Y3_W2MID[7] Tile_X0Y3_W2END[7] Tile_X0Y3_W6END[7]
+ _1351_/X _2570_/Q _2569_/Q VPWR VGND sg13cmos5l_mux4_1
XFILLER_98_162 VPWR VGND sg13cmos5l_decap_8
XANTENNA__3532__X Tile_X0Y0_N2BEGb[3] VPWR VGND sg13cmos5l_antennanp
X_1489_ _1489_/Y _2442_/Q _1488_/X _2441_/Q VPWR VGND sg13cmos5l_o21ai_1
X_3228_ _3228_/Q Tile_X0Y5_FrameData[20] Tile_X0Y5_FrameStrobe[5] VPWR VGND sg13cmos5l_dlhq_1
XFILLER_39_240 VPWR VGND sg13cmos5l_fill_1
XANTENNA__1297__A0 AXI_M_SOC_RDATA23 VPWR VGND sg13cmos5l_antennanp
XANTENNA__2409__GATE Tile_X0Y5_FrameStrobe[5] VPWR VGND sg13cmos5l_antennanp
XFILLER_100_178 VPWR VGND sg13cmos5l_fill_2
XFILLER_261_119 VPWR VGND sg13cmos5l_fill_2
X_3159_ _3159_/Q Tile_X0Y5_FrameData[25] Tile_X0Y5_FrameStrobe[3] VPWR VGND sg13cmos5l_dlhq_1
XFILLER_299_21 VPWR VGND sg13cmos5l_fill_2
XFILLER_54_276 VPWR VGND sg13cmos5l_fill_1
XANTENNA__3130__D Tile_X0Y5_FrameData[22] VPWR VGND sg13cmos5l_antennanp
XFILLER_52_14 VPWR VGND sg13cmos5l_decap_8
XFILLER_167_112 VPWR VGND sg13cmos5l_decap_8
XFILLER_22_162 VPWR VGND sg13cmos5l_decap_8
XFILLER_167_189 VPWR VGND sg13cmos5l_fill_1
XANTENNA__3707__X Tile_X0Y3_FrameData_O[10] VPWR VGND sg13cmos5l_antennanp
XFILLER_108_212 VPWR VGND sg13cmos5l_fill_1
XFILLER_318_39 VPWR VGND sg13cmos5l_fill_1
XFILLER_184_35 VPWR VGND sg13cmos5l_fill_1
XFILLER_77_44 VPWR VGND sg13cmos5l_decap_8
XANTENNA__3305__D Tile_X0Y5_FrameData[7] VPWR VGND sg13cmos5l_antennanp
XANTENNA__3442__X Tile_X0Y1_FrameData_O[10] VPWR VGND sg13cmos5l_antennanp
XANTENNA__1288__A0 Tile_X0Y1_WW4END[5] VPWR VGND sg13cmos5l_antennanp
XFILLER_277_0 VPWR VGND sg13cmos5l_fill_2
XFILLER_93_32 VPWR VGND sg13cmos5l_decap_8
XFILLER_45_210 VPWR VGND sg13cmos5l_fill_1
XANTENNA__3171__GATE Tile_X0Y5_FrameStrobe[3] VPWR VGND sg13cmos5l_antennanp
XANTENNA__3040__D Tile_X0Y4_FrameData[0] VPWR VGND sg13cmos5l_antennanp
XFILLER_158_101 VPWR VGND sg13cmos5l_decap_8
XANTENNA__1460__A0 Tile_X0Y2_W2END[3] VPWR VGND sg13cmos5l_antennanp
XANTENNA__3186__GATE Tile_X0Y5_FrameStrobe[4] VPWR VGND sg13cmos5l_antennanp
XFILLER_13_195 VPWR VGND sg13cmos5l_fill_1
X_0860_ _0860_/Y Tile_X0Y5_W2END[3] _3122_/Q _3121_/Q VPWR VGND sg13cmos5l_a21oi_1
XFILLER_9_166 VPWR VGND sg13cmos5l_decap_8
XANTENNA__3617__X Tile_X0Y0_E6BEG[0] VPWR VGND sg13cmos5l_antennanp
X_0791_ _3817_/A Tile_X0Y5_W2MID[5] _0765_/X _0790_/X _0656_/X _3244_/Q _3243_/Q VPWR
+ VGND sg13cmos5l_mux4_1
XANTENNA__1212__A0 Tile_X0Y0_W2MID[3] VPWR VGND sg13cmos5l_antennanp
XFILLER_315_120 VPWR VGND sg13cmos5l_decap_4
X_2530_ _2530_/Q Tile_X0Y3_FrameData[14] Tile_X0Y5_FrameStrobe[0] VPWR VGND sg13cmos5l_dlhq_1
X_2461_ _2461_/Q Tile_X0Y2_FrameData[3] Tile_X0Y5_FrameStrobe[6] VPWR VGND sg13cmos5l_dlhq_1
X_1412_ AXI_M_SOC_WDATA9 Tile_X0Y2_WW4END[1] Tile_X0Y2_WW4END[9] Tile_X0Y2_W6END[1]
+ _1388_/X _2342_/Q _2341_/Q VPWR VGND sg13cmos5l_mux4_1
XANTENNA__1515__A1 AXI_M_SOC_RDATA8 VPWR VGND sg13cmos5l_antennanp
X_2392_ _2392_/Q Tile_X0Y2_FrameData[8] Tile_X0Y5_FrameStrobe[4] VPWR VGND sg13cmos5l_dlhq_1
XFILLER_3_30 VPWR VGND sg13cmos5l_decap_8
XANTENNA__3124__GATE Tile_X0Y5_FrameStrobe[2] VPWR VGND sg13cmos5l_antennanp
XANTENNA__3215__D Tile_X0Y5_FrameData[1] VPWR VGND sg13cmos5l_antennanp
XANTENNA__3352__X Tile_X0Y2_E1BEG[2] VPWR VGND sg13cmos5l_antennanp
XFILLER_122_270 VPWR VGND sg13cmos5l_fill_1
X_1343_ _1343_/X Tile_X0Y1_W6END[8] _0959_/X _1268_/X _1110_/X _2214_/Q _2216_/Q VPWR
+ VGND sg13cmos5l_mux4_1
XFILLER_283_211 VPWR VGND sg13cmos5l_fill_2
X_1274_ _3466_/A Tile_X0Y1_WW4END[13] AXI_M_SOC_RDATA24 _0962_/X _1086_/X _2124_/Q
+ _2123_/Q VPWR VGND sg13cmos5l_mux4_1
XFILLER_95_154 VPWR VGND sg13cmos5l_decap_8
XANTENNA__1279__A0 Tile_X0Y1_W2END[1] VPWR VGND sg13cmos5l_antennanp
XANTENNA__2380__GATE Tile_X0Y5_FrameStrobe[4] VPWR VGND sg13cmos5l_antennanp
X_3013_ _3013_/Q Tile_X0Y4_FrameData[27] Tile_X0Y5_FrameStrobe[7] VPWR VGND sg13cmos5l_dlhq_1
XANTENNA__3139__GATE Tile_X0Y5_FrameStrobe[2] VPWR VGND sg13cmos5l_antennanp
XANTENNA__2395__GATE Tile_X0Y5_FrameStrobe[4] VPWR VGND sg13cmos5l_antennanp
XFILLER_196_218 VPWR VGND sg13cmos5l_decap_8
X_3915_ Tile_X0Y5_S4BEG[4] _3915_/A VPWR VGND sg13cmos5l_buf_1
XANTENNA__1451__A0 Tile_X0Y2_WW4END[13] VPWR VGND sg13cmos5l_antennanp
XFILLER_22_39 VPWR VGND sg13cmos5l_decap_8
X_3846_ Tile_X0Y5_EE4BEG[3] _3846_/A VPWR VGND sg13cmos5l_buf_1
XFILLER_338_256 VPWR VGND sg13cmos5l_fill_2
XANTENNA__3527__X Tile_X0Y0_N4BEG[14] VPWR VGND sg13cmos5l_antennanp
XFILLER_138_28 VPWR VGND sg13cmos5l_decap_8
XFILLER_285_23 VPWR VGND sg13cmos5l_fill_1
X_3777_ Tile_X0Y4_EE4BEG[15] _3777_/A VPWR VGND sg13cmos5l_buf_1
X_0989_ _0989_/Y Tile_X0Y5_W6END[2] _3060_/Q _0988_/Y VPWR VGND sg13cmos5l_a21oi_1
XANTENNA__1203__A0 Tile_X0Y0_W2MID[2] VPWR VGND sg13cmos5l_antennanp
X_2728_ _2728_/Q Tile_X0Y3_FrameData[8] Tile_X0Y5_FrameStrobe[6] VPWR VGND sg13cmos5l_dlhq_1
XANTENNA__0557__A2 Tile_X0Y4_W2END[1] VPWR VGND sg13cmos5l_antennanp
XFILLER_105_226 VPWR VGND sg13cmos5l_decap_8
XANTENNA__2333__GATE Tile_X0Y5_FrameStrobe[2] VPWR VGND sg13cmos5l_antennanp
XFILLER_154_27 VPWR VGND sg13cmos5l_decap_4
X_2659_ _2659_/Q Tile_X0Y3_FrameData[13] Tile_X0Y5_FrameStrobe[4] VPWR VGND sg13cmos5l_dlhq_1
XANTENNA__1506__A1 AXI_M_SOC_RDATA11 VPWR VGND sg13cmos5l_antennanp
XANTENNA__2963__GATE Tile_X0Y5_FrameStrobe[5] VPWR VGND sg13cmos5l_antennanp
XANTENNA__3125__D Tile_X0Y5_FrameData[27] VPWR VGND sg13cmos5l_antennanp
XANTENNA__3703__A Tile_X0Y3_FrameData[6] VPWR VGND sg13cmos5l_antennanp
XFILLER_47_14 VPWR VGND sg13cmos5l_decap_8
XANTENNA__2348__GATE Tile_X0Y5_FrameStrobe[3] VPWR VGND sg13cmos5l_antennanp
XANTENNA__2964__D Tile_X0Y4_FrameData[12] VPWR VGND sg13cmos5l_antennanp
XANTENNA__2978__GATE Tile_X0Y5_FrameStrobe[6] VPWR VGND sg13cmos5l_antennanp
XFILLER_86_198 VPWR VGND sg13cmos5l_fill_1
XFILLER_86_187 VPWR VGND sg13cmos5l_decap_8
XFILLER_170_59 VPWR VGND sg13cmos5l_fill_2
XFILLER_27_232 VPWR VGND sg13cmos5l_decap_8
XFILLER_103_64 VPWR VGND sg13cmos5l_decap_8
XFILLER_250_70 VPWR VGND sg13cmos5l_fill_1
XFILLER_250_81 VPWR VGND sg13cmos5l_decap_8
XFILLER_320_29 VPWR VGND sg13cmos5l_fill_2
XANTENNA__1690__A0 Tile_X0Y4_W1END[2] VPWR VGND sg13cmos5l_antennanp
XANTENNA__2901__GATE Tile_X0Y5_FrameStrobe[3] VPWR VGND sg13cmos5l_antennanp
XFILLER_187_207 VPWR VGND sg13cmos5l_fill_2
XFILLER_63_68 VPWR VGND sg13cmos5l_decap_8
XANTENNA__1037__A3 Tile_X0Y0_S4END[1] VPWR VGND sg13cmos5l_antennanp
XFILLER_179_79 VPWR VGND sg13cmos5l_decap_8
XANTENNA__2916__GATE Tile_X0Y5_FrameStrobe[4] VPWR VGND sg13cmos5l_antennanp
XFILLER_10_176 VPWR VGND sg13cmos5l_decap_8
XANTENNA__2204__D Tile_X0Y1_FrameData[20] VPWR VGND sg13cmos5l_antennanp
XANTENNA__3437__X Tile_X0Y1_FrameData_O[5] VPWR VGND sg13cmos5l_antennanp
XFILLER_195_78 VPWR VGND sg13cmos5l_fill_2
XFILLER_128_50 VPWR VGND sg13cmos5l_decap_8
XFILLER_88_65 VPWR VGND sg13cmos5l_decap_8
XANTENNA__3035__D Tile_X0Y4_FrameData[5] VPWR VGND sg13cmos5l_antennanp
XFILLER_265_211 VPWR VGND sg13cmos5l_fill_1
XFILLER_77_132 VPWR VGND sg13cmos5l_fill_1
XANTENNA__2874__D Tile_X0Y4_FrameData[6] VPWR VGND sg13cmos5l_antennanp
XANTENNA__3900__X Tile_X0Y5_S2BEG[5] VPWR VGND sg13cmos5l_antennanp
XFILLER_265_277 VPWR VGND sg13cmos5l_fill_1
XFILLER_233_130 VPWR VGND sg13cmos5l_decap_4
XANTENNA__1681__A0 Tile_X0Y4_W2END[3] VPWR VGND sg13cmos5l_antennanp
XFILLER_160_81 VPWR VGND sg13cmos5l_decap_8
XANTENNA__1420__X AXI_M_SOC_WDATA17 VPWR VGND sg13cmos5l_antennanp
XFILLER_310_51 VPWR VGND sg13cmos5l_decap_8
XANTENNA__1433__A0 Tile_X0Y2_W2MID[1] VPWR VGND sg13cmos5l_antennanp
X_3700_ Tile_X0Y3_FrameData_O[3] Tile_X0Y3_FrameData[3] VPWR VGND sg13cmos5l_buf_1
X_1961_ _1961_/Q Tile_X0Y0_FrameData[23] Tile_X0Y5_FrameStrobe[8] VPWR VGND sg13cmos5l_dlhq_1
X_1892_ _1892_/Q Tile_X0Y0_FrameData[28] Tile_X0Y5_FrameStrobe[6] VPWR VGND sg13cmos5l_dlhq_1
X_0912_ _0912_/Y _0547_/Y _0911_/X _3302_/Q VPWR VGND sg13cmos5l_a21oi_1
X_3631_ Tile_X0Y0_E2BEGb[2] _3631_/A VPWR VGND sg13cmos5l_buf_1
X_0843_ AXI_M_SOC_ARSIZE0 _3331_/Q _0842_/X VPWR VGND sg13cmos5l_nor2b_1
XFILLER_335_237 VPWR VGND sg13cmos5l_fill_1
XANTENNA__2114__D Tile_X0Y1_FrameData[14] VPWR VGND sg13cmos5l_antennanp
X_3562_ Tile_X0Y0_FrameStrobe_O[13] Tile_X0Y5_FrameStrobe[13] VPWR VGND sg13cmos5l_buf_1
XFILLER_335_248 VPWR VGND sg13cmos5l_fill_1
XFILLER_255_26 VPWR VGND sg13cmos5l_fill_2
X_2513_ _2513_/Q Tile_X0Y2_FrameData[31] Tile_X0Y5_FrameStrobe[0] VPWR VGND sg13cmos5l_dlhq_1
X_0774_ _3813_/A Tile_X0Y5_N1END[2] _0771_/X _0990_/B _0773_/X _3251_/Q _3252_/Q VPWR
+ VGND sg13cmos5l_mux4_1
XANTENNA__1953__D Tile_X0Y0_FrameData[31] VPWR VGND sg13cmos5l_antennanp
X_3493_ Tile_X0Y1_E2BEGb[1] _3493_/A VPWR VGND sg13cmos5l_buf_1
XANTENNA__3063__GATE Tile_X0Y5_FrameStrobe[0] VPWR VGND sg13cmos5l_antennanp
X_2444_ _2444_/Q Tile_X0Y2_FrameData[20] Tile_X0Y5_FrameStrobe[6] VPWR VGND sg13cmos5l_dlhq_1
XFILLER_335_70 VPWR VGND sg13cmos5l_fill_1
XFILLER_303_189 VPWR VGND sg13cmos5l_decap_8
X_2375_ _2375_/Q Tile_X0Y2_FrameData[25] Tile_X0Y5_FrameStrobe[4] VPWR VGND sg13cmos5l_dlhq_1
XFILLER_68_121 VPWR VGND sg13cmos5l_fill_2
XFILLER_68_110 VPWR VGND sg13cmos5l_decap_8
XFILLER_38_0 VPWR VGND sg13cmos5l_fill_2
XFILLER_271_47 VPWR VGND sg13cmos5l_fill_1
XFILLER_271_58 VPWR VGND sg13cmos5l_fill_2
X_1326_ _1326_/X Tile_X0Y1_W1END[2] _0941_/X Tile_X0Y1_WW4END[2] _0953_/X _2208_/Q
+ _2210_/Q VPWR VGND sg13cmos5l_mux4_1
XANTENNA__2784__D Tile_X0Y3_FrameData[16] VPWR VGND sg13cmos5l_antennanp
XANTENNA__3078__GATE Tile_X0Y5_FrameStrobe[0] VPWR VGND sg13cmos5l_antennanp
XFILLER_204_41 VPWR VGND sg13cmos5l_decap_4
XANTENNA__3810__X Tile_X0Y4_UserCLKo VPWR VGND sg13cmos5l_antennanp
X_1257_ _3641_/A Tile_X0Y0_W2MID[3] AXI_M_SOC_BRESP0 _1148_/X _1078_/X _1880_/Q _1879_/Q
+ VPWR VGND sg13cmos5l_mux4_1
XFILLER_271_247 VPWR VGND sg13cmos5l_decap_8
X_1188_ _3542_/A Tile_X0Y0_W2MID[2] Tile_X0Y0_W2END[2] Tile_X0Y0_W6END[2] _1045_/X
+ _1950_/Q _1949_/Q VPWR VGND sg13cmos5l_mux4_1
XFILLER_83_168 VPWR VGND sg13cmos5l_decap_8
XANTENNA__3001__GATE Tile_X0Y5_FrameStrobe[6] VPWR VGND sg13cmos5l_antennanp
XFILLER_169_207 VPWR VGND sg13cmos5l_fill_2
XANTENNA__1424__A0 Tile_X0Y2_WW4END[6] VPWR VGND sg13cmos5l_antennanp
XFILLER_33_38 VPWR VGND sg13cmos5l_decap_8
XANTENNA__3016__GATE Tile_X0Y5_FrameStrobe[7] VPWR VGND sg13cmos5l_antennanp
XFILLER_192_232 VPWR VGND sg13cmos5l_fill_2
X_3829_ Tile_X0Y5_E2BEGb[6] _3829_/A VPWR VGND sg13cmos5l_buf_1
XANTENNA__2024__D Tile_X0Y1_FrameData[8] VPWR VGND sg13cmos5l_antennanp
XANTENNA__2272__GATE Tile_X0Y5_FrameStrobe[0] VPWR VGND sg13cmos5l_antennanp
XANTENNA__2959__D Tile_X0Y4_FrameData[17] VPWR VGND sg13cmos5l_antennanp
XANTENNA__1863__D Tile_X0Y0_FrameData[25] VPWR VGND sg13cmos5l_antennanp
XFILLER_58_13 VPWR VGND sg13cmos5l_decap_8
XFILLER_59_110 VPWR VGND sg13cmos5l_decap_8
XANTENNA__2287__GATE Tile_X0Y5_FrameStrobe[1] VPWR VGND sg13cmos5l_antennanp
XANTENNA__3433__A Tile_X0Y1_FrameData[1] VPWR VGND sg13cmos5l_antennanp
XFILLER_181_25 VPWR VGND sg13cmos5l_decap_8
XANTENNA__2694__D Tile_X0Y3_FrameData[10] VPWR VGND sg13cmos5l_antennanp
XFILLER_181_69 VPWR VGND sg13cmos5l_fill_2
XANTENNA__3720__X Tile_X0Y3_FrameData_O[23] VPWR VGND sg13cmos5l_antennanp
XFILLER_59_198 VPWR VGND sg13cmos5l_decap_8
XANTENNA__2210__GATE Tile_X0Y5_FrameStrobe[7] VPWR VGND sg13cmos5l_antennanp
XANTENNA__1663__A0 Tile_X0Y4_W2MID[2] VPWR VGND sg13cmos5l_antennanp
XANTENNA__2840__GATE Tile_X0Y5_FrameStrobe[1] VPWR VGND sg13cmos5l_antennanp
XFILLER_15_213 VPWR VGND sg13cmos5l_fill_2
XFILLER_262_269 VPWR VGND sg13cmos5l_decap_4
XFILLER_15_257 VPWR VGND sg13cmos5l_fill_2
XFILLER_215_174 VPWR VGND sg13cmos5l_decap_8
XFILLER_90_11 VPWR VGND sg13cmos5l_decap_8
XANTENNA__2225__GATE Tile_X0Y5_FrameStrobe[8] VPWR VGND sg13cmos5l_antennanp
XFILLER_130_73 VPWR VGND sg13cmos5l_fill_1
XFILLER_130_84 VPWR VGND sg13cmos5l_decap_8
XFILLER_142_0 VPWR VGND sg13cmos5l_fill_2
XANTENNA__1415__A0 Tile_X0Y2_WW4END[3] VPWR VGND sg13cmos5l_antennanp
XANTENNA__2855__GATE Tile_X0Y5_FrameStrobe[2] VPWR VGND sg13cmos5l_antennanp
XFILLER_90_88 VPWR VGND sg13cmos5l_decap_8
XANTENNA__0769__A2 Tile_X0Y5_W6END[4] VPWR VGND sg13cmos5l_antennanp
XFILLER_23_71 VPWR VGND sg13cmos5l_decap_8
XFILLER_90_99 VPWR VGND sg13cmos5l_fill_1
XFILLER_317_259 VPWR VGND sg13cmos5l_fill_2
XANTENNA__2869__D Tile_X0Y4_FrameData[11] VPWR VGND sg13cmos5l_antennanp
XANTENNA__1773__D Tile_X0Y0_FrameData[19] VPWR VGND sg13cmos5l_antennanp
XANTENNA__1194__A2 Tile_X0Y0_WW4END[14] VPWR VGND sg13cmos5l_antennanp
XFILLER_2_183 VPWR VGND sg13cmos5l_fill_2
XFILLER_300_104 VPWR VGND sg13cmos5l_decap_8
XANTENNA__1415__X AXI_M_SOC_WDATA11 VPWR VGND sg13cmos5l_antennanp
XFILLER_238_222 VPWR VGND sg13cmos5l_decap_8
XFILLER_305_84 VPWR VGND sg13cmos5l_fill_1
X_2160_ _2160_/Q Tile_X0Y1_FrameData[0] Tile_X0Y5_FrameStrobe[5] VPWR VGND sg13cmos5l_dlhq_1
XANTENNA__3630__X Tile_X0Y0_E2BEGb[1] VPWR VGND sg13cmos5l_antennanp
X_2091_ _2091_/Q Tile_X0Y1_FrameData[5] Tile_X0Y5_FrameStrobe[3] VPWR VGND sg13cmos5l_dlhq_1
X_1111_ _3536_/A Tile_X0Y1_W2MID[0] Tile_X0Y1_W2END[0] Tile_X0Y1_W6END[0] _1115_/X
+ _2218_/Q _2217_/Q VPWR VGND sg13cmos5l_mux4_1
XFILLER_65_124 VPWR VGND sg13cmos5l_decap_4
XANTENNA__2808__GATE Tile_X0Y5_FrameStrobe[0] VPWR VGND sg13cmos5l_antennanp
X_1042_ _1042_/X _1057_/X _1036_/X Tile_X0Y0_S1END[1] Tile_X0Y0_S4END[1] _1750_/Q
+ _1749_/Q VPWR VGND sg13cmos5l_mux4_1
XFILLER_80_105 VPWR VGND sg13cmos5l_decap_8
XANTENNA__1249__A3 AXI_M_SOC_BRESP0 VPWR VGND sg13cmos5l_antennanp
XANTENNA__1654__A0 Tile_X0Y4_W2MID[6] VPWR VGND sg13cmos5l_antennanp
XANTENNA__2109__D Tile_X0Y1_FrameData[19] VPWR VGND sg13cmos5l_antennanp
XFILLER_321_94 VPWR VGND sg13cmos5l_fill_1
XANTENNA__1948__D Tile_X0Y0_FrameData[4] VPWR VGND sg13cmos5l_antennanp
XFILLER_21_216 VPWR VGND sg13cmos5l_decap_8
X_2993_ _2993_/Q Tile_X0Y4_FrameData[15] Tile_X0Y5_FrameStrobe[6] VPWR VGND sg13cmos5l_dlhq_1
XANTENNA__1406__A0 AXI_M_SOC_RDATA19 VPWR VGND sg13cmos5l_antennanp
X_1944_ _1944_/Q Tile_X0Y0_FrameData[8] Tile_X0Y5_FrameStrobe[7] VPWR VGND sg13cmos5l_dlhq_1
XFILLER_266_14 VPWR VGND sg13cmos5l_fill_1
X_3614_ Tile_X0Y0_EE4BEG[13] _3614_/A VPWR VGND sg13cmos5l_buf_1
X_1875_ _1875_/Q Tile_X0Y0_FrameData[13] Tile_X0Y5_FrameStrobe[5] VPWR VGND sg13cmos5l_dlhq_1
X_0826_ _3833_/A Tile_X0Y5_N4END[2] _0647_/X _0693_/X _0645_/X _3179_/Q _3180_/Q VPWR
+ VGND sg13cmos5l_mux4_1
XANTENNA__2779__D Tile_X0Y3_FrameData[21] VPWR VGND sg13cmos5l_antennanp
X_3545_ Tile_X0Y0_N1BEG[0] _3545_/A VPWR VGND sg13cmos5l_buf_1
X_0757_ _0757_/X Tile_X0Y5_WW4END[0] Tile_X0Y5_W6END[0] Tile_X0Y5_WW4END[8] _0599_/X
+ _3159_/Q _3160_/Q VPWR VGND sg13cmos5l_mux4_1
XANTENNA__1185__A2 Tile_X0Y1_W6END[11] VPWR VGND sg13cmos5l_antennanp
XANTENNA__3805__X Tile_X0Y4_FrameData_O[27] VPWR VGND sg13cmos5l_antennanp
XFILLER_142_140 VPWR VGND sg13cmos5l_decap_4
X_3476_ Tile_X0Y1_EE4BEG[12] _3476_/A VPWR VGND sg13cmos5l_buf_1
XFILLER_331_251 VPWR VGND sg13cmos5l_fill_1
X_2427_ _2427_/Q Tile_X0Y2_FrameData[5] Tile_X0Y5_FrameStrobe[5] VPWR VGND sg13cmos5l_dlhq_1
X_0688_ _0688_/Y _2787_/Q _0688_/B _0688_/C VPWR VGND sg13cmos5l_nor3_1
XFILLER_88_227 VPWR VGND sg13cmos5l_fill_1
XFILLER_229_200 VPWR VGND sg13cmos5l_decap_8
X_2358_ _2358_/Q Tile_X0Y2_FrameData[10] Tile_X0Y5_FrameStrobe[3] VPWR VGND sg13cmos5l_dlhq_1
XANTENNA__0696__A1 Tile_X0Y5_N4END[2] VPWR VGND sg13cmos5l_antennanp
XANTENNA__3540__X Tile_X0Y0_N2BEG[3] VPWR VGND sg13cmos5l_antennanp
XFILLER_151_28 VPWR VGND sg13cmos5l_decap_8
XFILLER_229_266 VPWR VGND sg13cmos5l_fill_1
X_2289_ _2289_/Q Tile_X0Y2_FrameData[15] Tile_X0Y5_FrameStrobe[1] VPWR VGND sg13cmos5l_dlhq_1
X_1309_ AXI_M_SOC_AWADDR7 Tile_X0Y1_W2MID[7] Tile_X0Y1_W2END[7] Tile_X0Y1_W6END[7]
+ _1115_/X _2026_/Q _2025_/Q VPWR VGND sg13cmos5l_mux4_1
XFILLER_96_293 VPWR VGND sg13cmos5l_fill_2
XFILLER_56_135 VPWR VGND sg13cmos5l_decap_8
XFILLER_71_105 VPWR VGND sg13cmos5l_decap_8
XANTENNA__1645__A0 Tile_X0Y4_W2MID[7] VPWR VGND sg13cmos5l_antennanp
XANTENNA__2019__D Tile_X0Y1_FrameData[13] VPWR VGND sg13cmos5l_antennanp
XFILLER_44_26 VPWR VGND sg13cmos5l_fill_2
XFILLER_44_15 VPWR VGND sg13cmos5l_decap_8
XFILLER_252_280 VPWR VGND sg13cmos5l_fill_1
XFILLER_44_59 VPWR VGND sg13cmos5l_fill_2
XANTENNA__1858__D Tile_X0Y0_FrameData[30] VPWR VGND sg13cmos5l_antennanp
XFILLER_212_133 VPWR VGND sg13cmos5l_fill_2
XFILLER_100_32 VPWR VGND sg13cmos5l_fill_1
XANTENNA__3428__A Tile_X0Y2_FrameData[30] VPWR VGND sg13cmos5l_antennanp
XFILLER_176_58 VPWR VGND sg13cmos5l_decap_8
XANTENNA__2689__D Tile_X0Y3_FrameData[15] VPWR VGND sg13cmos5l_antennanp
XANTENNA__1176__A2 Tile_X0Y0_W6END[1] VPWR VGND sg13cmos5l_antennanp
XANTENNA__3715__X Tile_X0Y3_FrameData_O[18] VPWR VGND sg13cmos5l_antennanp
XFILLER_133_195 VPWR VGND sg13cmos5l_fill_1
XFILLER_79_238 VPWR VGND sg13cmos5l_decap_8
XFILLER_69_67 VPWR VGND sg13cmos5l_decap_8
XFILLER_294_114 VPWR VGND sg13cmos5l_fill_1
XFILLER_272_90 VPWR VGND sg13cmos5l_fill_1
XFILLER_85_11 VPWR VGND sg13cmos5l_decap_8
XFILLER_47_102 VPWR VGND sg13cmos5l_decap_8
XANTENNA__3313__D Tile_X0Y5_FrameData[31] VPWR VGND sg13cmos5l_antennanp
XFILLER_87_293 VPWR VGND sg13cmos5l_fill_2
XANTENNA__3450__X Tile_X0Y1_FrameData_O[18] VPWR VGND sg13cmos5l_antennanp
XFILLER_85_88 VPWR VGND sg13cmos5l_decap_8
XANTENNA__1636__A0 Tile_X0Y4_WW4END[0] VPWR VGND sg13cmos5l_antennanp
XFILLER_18_93 VPWR VGND sg13cmos5l_fill_2
XFILLER_62_116 VPWR VGND sg13cmos5l_decap_8
XANTENNA__2164__GATE Tile_X0Y5_FrameStrobe[6] VPWR VGND sg13cmos5l_antennanp
XANTENNA__1768__D Tile_X0Y0_FrameData[24] VPWR VGND sg13cmos5l_antennanp
XANTENNA__2794__GATE Tile_X0Y5_FrameStrobe[0] VPWR VGND sg13cmos5l_antennanp
XFILLER_156_221 VPWR VGND sg13cmos5l_fill_2
XANTENNA__2179__GATE Tile_X0Y5_FrameStrobe[6] VPWR VGND sg13cmos5l_antennanp
XFILLER_116_107 VPWR VGND sg13cmos5l_fill_1
X_1660_ _3743_/A Tile_X0Y4_W2END[6] AXI_M_SOC_RDATA4 _1049_/X _1360_/X _2958_/Q _2957_/Q
+ VPWR VGND sg13cmos5l_mux4_1
XANTENNA__2599__D Tile_X0Y3_FrameData[9] VPWR VGND sg13cmos5l_antennanp
X_1591_ _3649_/A _1050_/X _0580_/X AXI_M_SOC_RDATA9 AXI_M_SOC_RDATA13 _2712_/Q _2711_/Q
+ VPWR VGND sg13cmos5l_mux4_1
X_0611_ _0611_/Y _3267_/Q _0610_/Y _3266_/Q VPWR VGND sg13cmos5l_o21ai_1
XANTENNA__2102__GATE Tile_X0Y5_FrameStrobe[4] VPWR VGND sg13cmos5l_antennanp
XANTENNA__3625__X Tile_X0Y0_E6BEG[8] VPWR VGND sg13cmos5l_antennanp
XFILLER_124_140 VPWR VGND sg13cmos5l_decap_8
XFILLER_171_257 VPWR VGND sg13cmos5l_decap_8
X_3330_ _3330_/Q Tile_X0Y5_FrameData[28] Tile_X0Y5_FrameStrobe[9] VPWR VGND sg13cmos5l_dlhq_1
X_0542_ _0542_/Y Tile_X0Y0_W6END[2] VPWR VGND sg13cmos5l_inv_1
XANTENNA__2732__GATE Tile_X0Y5_FrameStrobe[6] VPWR VGND sg13cmos5l_antennanp
X_3261_ _3261_/Q Tile_X0Y5_FrameData[19] Tile_X0Y5_FrameStrobe[6] VPWR VGND sg13cmos5l_dlhq_1
XFILLER_252_27 VPWR VGND sg13cmos5l_fill_1
XFILLER_285_158 VPWR VGND sg13cmos5l_decap_4
X_3192_ _3192_/Q Tile_X0Y5_FrameData[24] Tile_X0Y5_FrameStrobe[4] VPWR VGND sg13cmos5l_dlhq_1
X_2212_ _2212_/Q Tile_X0Y1_FrameData[12] Tile_X0Y5_FrameStrobe[7] VPWR VGND sg13cmos5l_dlhq_1
XANTENNA__0678__A1 Tile_X0Y2_W6END[10] VPWR VGND sg13cmos5l_antennanp
XANTENNA__2117__GATE Tile_X0Y5_FrameStrobe[4] VPWR VGND sg13cmos5l_antennanp
XANTENNA__2747__GATE Tile_X0Y5_FrameStrobe[7] VPWR VGND sg13cmos5l_antennanp
XANTENNA__3223__D Tile_X0Y5_FrameData[25] VPWR VGND sg13cmos5l_antennanp
X_2143_ _2143_/Q Tile_X0Y1_FrameData[17] Tile_X0Y5_FrameStrobe[5] VPWR VGND sg13cmos5l_dlhq_1
XFILLER_78_293 VPWR VGND sg13cmos5l_fill_2
XFILLER_38_146 VPWR VGND sg13cmos5l_decap_8
XFILLER_38_113 VPWR VGND sg13cmos5l_decap_8
XANTENNA__3360__X Tile_X0Y2_E2BEG[6] VPWR VGND sg13cmos5l_antennanp
XANTENNA__3801__A Tile_X0Y4_FrameData[23] VPWR VGND sg13cmos5l_antennanp
XFILLER_53_105 VPWR VGND sg13cmos5l_fill_1
XANTENNA__1627__A0 AXI_M_SOC_RDATA0 VPWR VGND sg13cmos5l_antennanp
X_2074_ _2074_/Q Tile_X0Y1_FrameData[22] Tile_X0Y5_FrameStrobe[3] VPWR VGND sg13cmos5l_dlhq_1
X_1025_ _1025_/X _1018_/X _0623_/X Tile_X0Y5_N4END[13] Tile_X0Y0_S4END[9] _2269_/Q
+ _2270_/Q VPWR VGND sg13cmos5l_mux4_1
XFILLER_61_193 VPWR VGND sg13cmos5l_decap_8
X_2976_ _2976_/Q Tile_X0Y4_FrameData[0] Tile_X0Y5_FrameStrobe[5] VPWR VGND sg13cmos5l_dlhq_1
XFILLER_147_254 VPWR VGND sg13cmos5l_decap_8
XFILLER_277_79 VPWR VGND sg13cmos5l_fill_1
X_1927_ _1927_/Q Tile_X0Y0_FrameData[25] Tile_X0Y5_FrameStrobe[7] VPWR VGND sg13cmos5l_dlhq_1
X_1858_ _1858_/Q Tile_X0Y0_FrameData[30] Tile_X0Y5_FrameStrobe[5] VPWR VGND sg13cmos5l_dlhq_1
XANTENNA__1941__GATE Tile_X0Y5_FrameStrobe[7] VPWR VGND sg13cmos5l_antennanp
XFILLER_162_224 VPWR VGND sg13cmos5l_decap_4
X_0809_ _3844_/A Tile_X0Y5_WW4END[14] _0694_/X _0771_/X _0559_/X _3213_/Q _3214_/Q
+ VPWR VGND sg13cmos5l_mux4_1
XANTENNA__1158__A2 Tile_X0Y0_W6END[7] VPWR VGND sg13cmos5l_antennanp
XANTENNA__2302__D Tile_X0Y2_FrameData[2] VPWR VGND sg13cmos5l_antennanp
XANTENNA__3535__X Tile_X0Y0_N2BEGb[6] VPWR VGND sg13cmos5l_antennanp
X_1789_ _1789_/Q Tile_X0Y0_FrameData[3] Tile_X0Y5_FrameStrobe[2] VPWR VGND sg13cmos5l_dlhq_1
X_3528_ Tile_X0Y0_N4BEG[15] _3528_/A VPWR VGND sg13cmos5l_buf_1
XFILLER_162_16 VPWR VGND sg13cmos5l_fill_1
X_3459_ Tile_X0Y1_FrameData_O[27] Tile_X0Y1_FrameData[27] VPWR VGND sg13cmos5l_buf_1
XANTENNA__1956__GATE Tile_X0Y5_FrameStrobe[8] VPWR VGND sg13cmos5l_antennanp
XFILLER_130_165 VPWR VGND sg13cmos5l_decap_8
XANTENNA__3133__D Tile_X0Y5_FrameData[19] VPWR VGND sg13cmos5l_antennanp
XFILLER_291_106 VPWR VGND sg13cmos5l_decap_4
XFILLER_69_293 VPWR VGND sg13cmos5l_fill_2
XANTENNA__3711__A Tile_X0Y3_FrameData[14] VPWR VGND sg13cmos5l_antennanp
XFILLER_284_180 VPWR VGND sg13cmos5l_fill_2
XFILLER_55_14 VPWR VGND sg13cmos5l_decap_8
XANTENNA__1618__A0 Tile_X0Y5_N4END[4] VPWR VGND sg13cmos5l_antennanp
XANTENNA__2972__D Tile_X0Y4_FrameData[4] VPWR VGND sg13cmos5l_antennanp
XFILLER_217_269 VPWR VGND sg13cmos5l_decap_8
XFILLER_111_97 VPWR VGND sg13cmos5l_decap_4
XFILLER_71_35 VPWR VGND sg13cmos5l_decap_8
XFILLER_52_193 VPWR VGND sg13cmos5l_decap_8
XANTENNA__1397__A2 Tile_X0Y0_S4END[10] VPWR VGND sg13cmos5l_antennanp
XFILLER_138_276 VPWR VGND sg13cmos5l_decap_4
XANTENNA__1909__GATE Tile_X0Y5_FrameStrobe[6] VPWR VGND sg13cmos5l_antennanp
XFILLER_299_228 VPWR VGND sg13cmos5l_fill_2
XANTENNA__1149__A2 Tile_X0Y1_W6END[10] VPWR VGND sg13cmos5l_antennanp
XANTENNA__2212__D Tile_X0Y1_FrameData[12] VPWR VGND sg13cmos5l_antennanp
XANTENNA__3308__D Tile_X0Y5_FrameData[4] VPWR VGND sg13cmos5l_antennanp
XANTENNA__3445__X Tile_X0Y1_FrameData_O[13] VPWR VGND sg13cmos5l_antennanp
XFILLER_105_0 VPWR VGND sg13cmos5l_fill_2
XFILLER_106_173 VPWR VGND sg13cmos5l_fill_1
XFILLER_96_10 VPWR VGND sg13cmos5l_fill_1
XFILLER_267_158 VPWR VGND sg13cmos5l_fill_1
XANTENNA__3043__D Tile_X0Y4_FrameData[29] VPWR VGND sg13cmos5l_antennanp
XANTENNA__2882__D Tile_X0Y4_FrameData[30] VPWR VGND sg13cmos5l_antennanp
XFILLER_35_127 VPWR VGND sg13cmos5l_decap_8
XANTENNA__1609__A0 Tile_X0Y4_WW4END[6] VPWR VGND sg13cmos5l_antennanp
XFILLER_290_172 VPWR VGND sg13cmos5l_decap_8
XFILLER_290_183 VPWR VGND sg13cmos5l_fill_1
XFILLER_302_74 VPWR VGND sg13cmos5l_fill_2
XFILLER_90_233 VPWR VGND sg13cmos5l_decap_8
XANTENNA__1085__A1 Tile_X0Y3_W2END[2] VPWR VGND sg13cmos5l_antennanp
XFILLER_188_132 VPWR VGND sg13cmos5l_decap_4
XFILLER_90_277 VPWR VGND sg13cmos5l_fill_1
XFILLER_45_91 VPWR VGND sg13cmos5l_decap_8
X_2830_ _2830_/Q Tile_X0Y4_FrameData[18] Tile_X0Y5_FrameStrobe[1] VPWR VGND sg13cmos5l_dlhq_1
X_2761_ _2761_/Q Tile_X0Y3_FrameData[7] Tile_X0Y5_FrameStrobe[7] VPWR VGND sg13cmos5l_dlhq_1
XANTENNA__0596__A0 Tile_X0Y5_N1END[0] VPWR VGND sg13cmos5l_antennanp
XANTENNA__1388__A2 Tile_X0Y5_N4END[13] VPWR VGND sg13cmos5l_antennanp
XFILLER_247_49 VPWR VGND sg13cmos5l_decap_4
X_2692_ _2692_/Q Tile_X0Y3_FrameData[12] Tile_X0Y5_FrameStrobe[5] VPWR VGND sg13cmos5l_dlhq_1
X_1712_ _1712_/Q Tile_X0Y0_FrameData[16] Tile_X0Y5_FrameStrobe[0] VPWR VGND sg13cmos5l_dlhq_1
XANTENNA_1 Tile_X0Y5_N2MID[7] VPWR VGND sg13cmos5l_antennanp
XANTENNA__2041__GATE Tile_X0Y5_FrameStrobe[2] VPWR VGND sg13cmos5l_antennanp
XFILLER_144_213 VPWR VGND sg13cmos5l_decap_8
XFILLER_144_224 VPWR VGND sg13cmos5l_fill_2
X_1643_ AXI_M_SOC_ARADDR11 Tile_X0Y4_WW4END[3] Tile_X0Y4_WW4END[11] Tile_X0Y4_W6END[11]
+ _1126_/X _2866_/Q _2865_/Q VPWR VGND sg13cmos5l_mux4_1
XFILLER_6_30 VPWR VGND sg13cmos5l_fill_1
XANTENNA__2122__D Tile_X0Y1_FrameData[6] VPWR VGND sg13cmos5l_antennanp
XANTENNA__2671__GATE Tile_X0Y5_FrameStrobe[4] VPWR VGND sg13cmos5l_antennanp
XANTENNA__3218__D Tile_X0Y5_FrameData[30] VPWR VGND sg13cmos5l_antennanp
XANTENNA__3355__X Tile_X0Y2_E2BEG[1] VPWR VGND sg13cmos5l_antennanp
XFILLER_298_250 VPWR VGND sg13cmos5l_decap_4
X_1574_ _1574_/Y _2724_/Q _0553_/Y _2723_/Q VPWR VGND sg13cmos5l_o21ai_1
XANTENNA__1961__D Tile_X0Y0_FrameData[23] VPWR VGND sg13cmos5l_antennanp
XFILLER_263_37 VPWR VGND sg13cmos5l_fill_1
X_3313_ _3313_/Q Tile_X0Y5_FrameData[31] Tile_X0Y5_FrameStrobe[8] VPWR VGND sg13cmos5l_dlhq_1
XANTENNA__1560__A2 Tile_X0Y3_W6END[0] VPWR VGND sg13cmos5l_antennanp
XANTENNA__2056__GATE Tile_X0Y5_FrameStrobe[2] VPWR VGND sg13cmos5l_antennanp
XFILLER_301_276 VPWR VGND sg13cmos5l_fill_1
X_3244_ _3244_/Q Tile_X0Y5_FrameData[4] Tile_X0Y5_FrameStrobe[5] VPWR VGND sg13cmos5l_dlhq_1
XANTENNA__2686__GATE Tile_X0Y5_FrameStrobe[5] VPWR VGND sg13cmos5l_antennanp
XFILLER_112_187 VPWR VGND sg13cmos5l_decap_8
XFILLER_20_0 VPWR VGND sg13cmos5l_fill_2
XANTENNA__1312__A2 Tile_X0Y5_N4END[12] VPWR VGND sg13cmos5l_antennanp
XFILLER_132_19 VPWR VGND sg13cmos5l_fill_1
X_3175_ _3175_/Q Tile_X0Y5_FrameData[9] Tile_X0Y5_FrameStrobe[3] VPWR VGND sg13cmos5l_dlhq_1
XANTENNA__0874__B Tile_X0Y5_W2MID[6] VPWR VGND sg13cmos5l_antennanp
XFILLER_26_105 VPWR VGND sg13cmos5l_decap_8
X_2126_ _2126_/Q Tile_X0Y1_FrameData[2] Tile_X0Y5_FrameStrobe[4] VPWR VGND sg13cmos5l_dlhq_1
XANTENNA__2792__D Tile_X0Y4_FrameData[24] VPWR VGND sg13cmos5l_antennanp
X_2057_ _2057_/Q Tile_X0Y1_FrameData[7] Tile_X0Y5_FrameStrobe[2] VPWR VGND sg13cmos5l_dlhq_1
XANTENNA__1076__A1 Tile_X0Y2_W2END[3] VPWR VGND sg13cmos5l_antennanp
XFILLER_288_23 VPWR VGND sg13cmos5l_fill_1
X_1008_ _1008_/X Tile_X0Y2_W2MID[1] Tile_X0Y2_W2END[1] Tile_X0Y2_W6END[1] _1175_/X
+ _2492_/Q _2491_/Q VPWR VGND sg13cmos5l_mux4_1
XFILLER_288_45 VPWR VGND sg13cmos5l_decap_4
XANTENNA__2624__GATE Tile_X0Y5_FrameStrobe[3] VPWR VGND sg13cmos5l_antennanp
XFILLER_194_135 VPWR VGND sg13cmos5l_decap_8
XFILLER_194_146 VPWR VGND sg13cmos5l_fill_1
X_2959_ _2959_/Q Tile_X0Y4_FrameData[17] Tile_X0Y5_FrameStrobe[5] VPWR VGND sg13cmos5l_dlhq_1
XFILLER_41_27 VPWR VGND sg13cmos5l_decap_8
XANTENNA__1379__A2 Tile_X0Y5_N4END[14] VPWR VGND sg13cmos5l_antennanp
XANTENNA__1880__GATE Tile_X0Y5_FrameStrobe[5] VPWR VGND sg13cmos5l_antennanp
XFILLER_157_38 VPWR VGND sg13cmos5l_decap_8
XANTENNA__2009__GATE Tile_X0Y5_FrameStrobe[1] VPWR VGND sg13cmos5l_antennanp
XANTENNA__2032__D Tile_X0Y1_FrameData[0] VPWR VGND sg13cmos5l_antennanp
XANTENNA__2639__GATE Tile_X0Y5_FrameStrobe[3] VPWR VGND sg13cmos5l_antennanp
XANTENNA__3128__D Tile_X0Y5_FrameData[24] VPWR VGND sg13cmos5l_antennanp
XANTENNA__3706__A Tile_X0Y3_FrameData[9] VPWR VGND sg13cmos5l_antennanp
XANTENNA__1871__D Tile_X0Y0_FrameData[17] VPWR VGND sg13cmos5l_antennanp
XANTENNA__1895__GATE Tile_X0Y5_FrameStrobe[6] VPWR VGND sg13cmos5l_antennanp
XANTENNA__2967__D Tile_X0Y4_FrameData[9] VPWR VGND sg13cmos5l_antennanp
XFILLER_103_132 VPWR VGND sg13cmos5l_decap_4
XFILLER_1_259 VPWR VGND sg13cmos5l_decap_4
XFILLER_249_125 VPWR VGND sg13cmos5l_fill_1
XANTENNA__1551__A2 Tile_X0Y3_W6END[1] VPWR VGND sg13cmos5l_antennanp
XFILLER_103_176 VPWR VGND sg13cmos5l_decap_8
XFILLER_253_70 VPWR VGND sg13cmos5l_decap_4
XANTENNA__3441__A Tile_X0Y1_FrameData[9] VPWR VGND sg13cmos5l_antennanp
XFILLER_264_139 VPWR VGND sg13cmos5l_decap_4
XFILLER_272_172 VPWR VGND sg13cmos5l_decap_4
XFILLER_72_233 VPWR VGND sg13cmos5l_decap_4
XANTENNA__1833__GATE Tile_X0Y5_FrameStrobe[4] VPWR VGND sg13cmos5l_antennanp
XANTENNA__2207__D Tile_X0Y1_FrameData[17] VPWR VGND sg13cmos5l_antennanp
XFILLER_25_182 VPWR VGND sg13cmos5l_fill_1
XFILLER_82_78 VPWR VGND sg13cmos5l_decap_8
XFILLER_198_78 VPWR VGND sg13cmos5l_fill_1
XFILLER_40_152 VPWR VGND sg13cmos5l_decap_8
XANTENNA__1848__GATE Tile_X0Y5_FrameStrobe[4] VPWR VGND sg13cmos5l_antennanp
XFILLER_185_179 VPWR VGND sg13cmos5l_decap_8
XFILLER_222_0 VPWR VGND sg13cmos5l_fill_2
XANTENNA__3038__D Tile_X0Y4_FrameData[2] VPWR VGND sg13cmos5l_antennanp
XFILLER_141_205 VPWR VGND sg13cmos5l_fill_2
XFILLER_147_82 VPWR VGND sg13cmos5l_fill_1
XFILLER_99_119 VPWR VGND sg13cmos5l_fill_1
XANTENNA__1781__D Tile_X0Y0_FrameData[11] VPWR VGND sg13cmos5l_antennanp
XANTENNA__2877__D Tile_X0Y4_FrameData[3] VPWR VGND sg13cmos5l_antennanp
XANTENNA__3903__X Tile_X0Y5_S2BEGb[0] VPWR VGND sg13cmos5l_antennanp
X_1290_ _3472_/A Tile_X0Y1_WW4END[7] AXI_M_SOC_RDATA29 _0944_/X _1115_/X _2112_/Q
+ _2111_/Q VPWR VGND sg13cmos5l_mux4_1
XANTENNA__1423__X AXI_M_SOC_WDATA23 VPWR VGND sg13cmos5l_antennanp
XFILLER_16_160 VPWR VGND sg13cmos5l_decap_8
XANTENNA__2117__D Tile_X0Y1_FrameData[11] VPWR VGND sg13cmos5l_antennanp
XFILLER_16_182 VPWR VGND sg13cmos5l_decap_8
XFILLER_204_294 VPWR VGND sg13cmos5l_fill_1
X_3862_ Tile_X0Y5_FrameData_O[3] Tile_X0Y5_FrameData[3] VPWR VGND sg13cmos5l_buf_1
XANTENNA__1956__D Tile_X0Y0_FrameData[28] VPWR VGND sg13cmos5l_antennanp
X_2813_ _2813_/Q Tile_X0Y4_FrameData[3] Tile_X0Y5_FrameStrobe[0] VPWR VGND sg13cmos5l_dlhq_1
XFILLER_176_157 VPWR VGND sg13cmos5l_fill_1
X_3793_ Tile_X0Y4_FrameData_O[15] Tile_X0Y4_FrameData[15] VPWR VGND sg13cmos5l_buf_1
X_2744_ _2744_/Q Tile_X0Y3_FrameData[24] Tile_X0Y5_FrameStrobe[7] VPWR VGND sg13cmos5l_dlhq_1
XFILLER_68_0 VPWR VGND sg13cmos5l_fill_2
XFILLER_318_184 VPWR VGND sg13cmos5l_decap_8
XANTENNA__1230__A1 AXI_M_SOC_RDATA31 VPWR VGND sg13cmos5l_antennanp
XFILLER_117_246 VPWR VGND sg13cmos5l_fill_1
X_2675_ _2675_/Q Tile_X0Y3_FrameData[29] Tile_X0Y5_FrameStrobe[5] VPWR VGND sg13cmos5l_dlhq_1
XFILLER_318_195 VPWR VGND sg13cmos5l_fill_2
XANTENNA__0869__B Tile_X0Y5_W2MID[5] VPWR VGND sg13cmos5l_antennanp
XFILLER_132_216 VPWR VGND sg13cmos5l_fill_1
XFILLER_207_30 VPWR VGND sg13cmos5l_decap_4
XFILLER_278_209 VPWR VGND sg13cmos5l_fill_2
X_1626_ _3757_/A AXI_M_SOC_RDATA1 _1062_/X _1063_/X _1130_/X _2898_/Q _2897_/Q VPWR
+ VGND sg13cmos5l_mux4_1
XFILLER_333_187 VPWR VGND sg13cmos5l_fill_2
XANTENNA__2787__D Tile_X0Y4_FrameData[29] VPWR VGND sg13cmos5l_antennanp
X_1557_ AXI_M_SOC_WDATA2 Tile_X0Y3_W2MID[2] Tile_X0Y3_W2END[2] Tile_X0Y3_W6END[2]
+ _1216_/X _2580_/Q _2579_/Q VPWR VGND sg13cmos5l_mux4_1
XANTENNA__3813__X Tile_X0Y5_E1BEG[2] VPWR VGND sg13cmos5l_antennanp
XANTENNA__0741__A0 Tile_X0Y5_N1END[3] VPWR VGND sg13cmos5l_antennanp
XFILLER_140_293 VPWR VGND sg13cmos5l_fill_2
XFILLER_290_24 VPWR VGND sg13cmos5l_fill_1
X_1488_ _1488_/X _1314_/X _1370_/X _2443_/Q VPWR VGND sg13cmos5l_mux2_1
XFILLER_100_157 VPWR VGND sg13cmos5l_decap_8
XFILLER_223_40 VPWR VGND sg13cmos5l_fill_1
XFILLER_223_51 VPWR VGND sg13cmos5l_decap_8
XFILLER_246_139 VPWR VGND sg13cmos5l_decap_8
X_3227_ _3227_/Q Tile_X0Y5_FrameData[21] Tile_X0Y5_FrameStrobe[5] VPWR VGND sg13cmos5l_dlhq_1
X_3158_ _3158_/Q Tile_X0Y5_FrameData[26] Tile_X0Y5_FrameStrobe[3] VPWR VGND sg13cmos5l_dlhq_1
XANTENNA__3307__GATE Tile_X0Y5_FrameStrobe[7] VPWR VGND sg13cmos5l_antennanp
XFILLER_199_205 VPWR VGND sg13cmos5l_decap_4
XFILLER_223_95 VPWR VGND sg13cmos5l_decap_8
X_2109_ _2109_/Q Tile_X0Y1_FrameData[19] Tile_X0Y5_FrameStrobe[4] VPWR VGND sg13cmos5l_dlhq_1
XFILLER_36_49 VPWR VGND sg13cmos5l_decap_4
XFILLER_36_38 VPWR VGND sg13cmos5l_decap_4
XFILLER_254_194 VPWR VGND sg13cmos5l_decap_8
X_3089_ _3089_/Q Tile_X0Y5_FrameData[31] Tile_X0Y5_FrameStrobe[1] VPWR VGND sg13cmos5l_dlhq_1
XANTENNA__2027__D Tile_X0Y1_FrameData[5] VPWR VGND sg13cmos5l_antennanp
XANTENNA__2563__GATE Tile_X0Y5_FrameStrobe[1] VPWR VGND sg13cmos5l_antennanp
XANTENNA__1866__D Tile_X0Y0_FrameData[22] VPWR VGND sg13cmos5l_antennanp
XFILLER_210_286 VPWR VGND sg13cmos5l_fill_1
XANTENNA__2578__GATE Tile_X0Y5_FrameStrobe[2] VPWR VGND sg13cmos5l_antennanp
XANTENNA__3436__A Tile_X0Y1_FrameData[4] VPWR VGND sg13cmos5l_antennanp
XFILLER_108_268 VPWR VGND sg13cmos5l_fill_2
XFILLER_123_205 VPWR VGND sg13cmos5l_decap_8
XANTENNA__2501__GATE Tile_X0Y5_FrameStrobe[8] VPWR VGND sg13cmos5l_antennanp
XANTENNA__2697__D Tile_X0Y3_FrameData[7] VPWR VGND sg13cmos5l_antennanp
XFILLER_334_17 VPWR VGND sg13cmos5l_fill_1
XANTENNA__1524__A2 Tile_X0Y5_N4END[10] VPWR VGND sg13cmos5l_antennanp
XANTENNA__3723__X Tile_X0Y3_FrameData_O[26] VPWR VGND sg13cmos5l_antennanp
XFILLER_77_23 VPWR VGND sg13cmos5l_decap_8
XFILLER_131_293 VPWR VGND sg13cmos5l_fill_2
XFILLER_89_196 VPWR VGND sg13cmos5l_decap_8
XANTENNA__1288__A1 AXI_M_SOC_RDATA27 VPWR VGND sg13cmos5l_antennanp
XANTENNA__2516__GATE Tile_X0Y5_FrameStrobe[0] VPWR VGND sg13cmos5l_antennanp
XFILLER_133_84 VPWR VGND sg13cmos5l_decap_4
XFILLER_93_11 VPWR VGND sg13cmos5l_decap_8
XFILLER_172_0 VPWR VGND sg13cmos5l_fill_2
XFILLER_280_90 VPWR VGND sg13cmos5l_fill_1
XANTENNA__1772__GATE Tile_X0Y5_FrameStrobe[2] VPWR VGND sg13cmos5l_antennanp
XANTENNA__3321__D Tile_X0Y5_FrameData[23] VPWR VGND sg13cmos5l_antennanp
XANTENNA__0799__A0 Tile_X0Y5_W2MID[0] VPWR VGND sg13cmos5l_antennanp
XANTENNA__1460__A1 AXI_M_SOC_RDATA17 VPWR VGND sg13cmos5l_antennanp
XANTENNA__1787__GATE Tile_X0Y5_FrameStrobe[2] VPWR VGND sg13cmos5l_antennanp
XFILLER_13_174 VPWR VGND sg13cmos5l_fill_2
XFILLER_198_293 VPWR VGND sg13cmos5l_fill_2
XFILLER_9_112 VPWR VGND sg13cmos5l_decap_8
XANTENNA__1776__D Tile_X0Y0_FrameData[16] VPWR VGND sg13cmos5l_antennanp
X_0790_ _0790_/X Tile_X0Y5_N2MID[2] Tile_X0Y5_N2END[2] _3905_/A _0788_/X _3076_/Q
+ _3075_/Q VPWR VGND sg13cmos5l_mux4_1
XANTENNA__1212__A1 Tile_X0Y0_W2END[3] VPWR VGND sg13cmos5l_antennanp
XANTENNA__1418__X AXI_M_SOC_WDATA19 VPWR VGND sg13cmos5l_antennanp
XANTENNA__1710__GATE Tile_X0Y5_FrameStrobe[0] VPWR VGND sg13cmos5l_antennanp
XFILLER_315_132 VPWR VGND sg13cmos5l_fill_1
X_2460_ _2460_/Q Tile_X0Y2_FrameData[4] Tile_X0Y5_FrameStrobe[6] VPWR VGND sg13cmos5l_dlhq_1
X_1411_ AXI_M_SOC_WDATA10 Tile_X0Y2_WW4END[2] Tile_X0Y2_WW4END[10] Tile_X0Y2_W6END[2]
+ _1380_/X _2340_/Q _2339_/Q VPWR VGND sg13cmos5l_mux4_1
XFILLER_330_135 VPWR VGND sg13cmos5l_decap_8
XFILLER_330_124 VPWR VGND sg13cmos5l_fill_2
XFILLER_330_113 VPWR VGND sg13cmos5l_fill_2
XANTENNA__2400__D Tile_X0Y2_FrameData[0] VPWR VGND sg13cmos5l_antennanp
XANTENNA__3633__X Tile_X0Y0_E2BEGb[4] VPWR VGND sg13cmos5l_antennanp
X_2391_ _2391_/Q Tile_X0Y2_FrameData[9] Tile_X0Y5_FrameStrobe[4] VPWR VGND sg13cmos5l_dlhq_1
XFILLER_330_168 VPWR VGND sg13cmos5l_fill_2
XANTENNA__1725__GATE Tile_X0Y5_FrameStrobe[0] VPWR VGND sg13cmos5l_antennanp
XFILLER_122_293 VPWR VGND sg13cmos5l_fill_2
X_1342_ _1342_/X _1182_/X _1316_/X _1317_/X _1181_/X _2525_/Q _2526_/Q VPWR VGND sg13cmos5l_mux4_1
X_1273_ _3467_/A Tile_X0Y1_WW4END[12] AXI_M_SOC_RDATA25 _0959_/X _1089_/X _2122_/Q
+ _2121_/Q VPWR VGND sg13cmos5l_mux4_1
XANTENNA__1279__A1 AXI_M_SOC_RDATA23 VPWR VGND sg13cmos5l_antennanp
X_3012_ _3012_/Q Tile_X0Y4_FrameData[28] Tile_X0Y5_FrameStrobe[7] VPWR VGND sg13cmos5l_dlhq_1
XFILLER_36_211 VPWR VGND sg13cmos5l_fill_1
XFILLER_236_150 VPWR VGND sg13cmos5l_decap_4
XFILLER_36_233 VPWR VGND sg13cmos5l_decap_4
XANTENNA__3231__D Tile_X0Y5_FrameData[17] VPWR VGND sg13cmos5l_antennanp
XFILLER_51_225 VPWR VGND sg13cmos5l_fill_2
XANTENNA__3293__GATE Tile_X0Y5_FrameStrobe[7] VPWR VGND sg13cmos5l_antennanp
XFILLER_149_102 VPWR VGND sg13cmos5l_decap_4
X_3914_ Tile_X0Y5_S4BEG[3] _3914_/A VPWR VGND sg13cmos5l_buf_1
XANTENNA__1451__A1 AXI_M_SOC_RDATA16 VPWR VGND sg13cmos5l_antennanp
XFILLER_149_124 VPWR VGND sg13cmos5l_decap_8
XFILLER_149_135 VPWR VGND sg13cmos5l_fill_2
XANTENNA__3808__X Tile_X0Y4_FrameData_O[30] VPWR VGND sg13cmos5l_antennanp
X_3845_ Tile_X0Y5_EE4BEG[2] _3845_/A VPWR VGND sg13cmos5l_buf_1
X_3776_ Tile_X0Y4_EE4BEG[14] _3776_/A VPWR VGND sg13cmos5l_buf_1
X_0988_ _0988_/Y _3060_/Q Tile_X0Y5_N1END[2] VPWR VGND sg13cmos5l_nor2b_1
XANTENNA__1203__A1 Tile_X0Y0_W2END[2] VPWR VGND sg13cmos5l_antennanp
X_2727_ _2727_/Q Tile_X0Y3_FrameData[9] Tile_X0Y5_FrameStrobe[6] VPWR VGND sg13cmos5l_dlhq_1
XFILLER_105_205 VPWR VGND sg13cmos5l_decap_8
XFILLER_218_62 VPWR VGND sg13cmos5l_fill_2
XFILLER_306_165 VPWR VGND sg13cmos5l_fill_2
X_2658_ _2658_/Q Tile_X0Y3_FrameData[14] Tile_X0Y5_FrameStrobe[4] VPWR VGND sg13cmos5l_dlhq_1
XANTENNA__2310__D Tile_X0Y2_FrameData[26] VPWR VGND sg13cmos5l_antennanp
XANTENNA__3231__GATE Tile_X0Y5_FrameStrobe[5] VPWR VGND sg13cmos5l_antennanp
XANTENNA__3543__X Tile_X0Y0_N2BEG[6] VPWR VGND sg13cmos5l_antennanp
X_2589_ _2589_/Q Tile_X0Y3_FrameData[19] Tile_X0Y5_FrameStrobe[2] VPWR VGND sg13cmos5l_dlhq_1
X_1609_ _3771_/A Tile_X0Y4_WW4END[6] AXI_M_SOC_RDATA4 _1011_/X _1360_/X _2926_/Q _2925_/Q
+ VPWR VGND sg13cmos5l_mux4_1
XFILLER_113_293 VPWR VGND sg13cmos5l_fill_2
XFILLER_219_128 VPWR VGND sg13cmos5l_fill_1
XFILLER_86_166 VPWR VGND sg13cmos5l_decap_8
XANTENNA__3246__GATE Tile_X0Y5_FrameStrobe[5] VPWR VGND sg13cmos5l_antennanp
XFILLER_27_211 VPWR VGND sg13cmos5l_decap_8
XANTENNA__3141__D Tile_X0Y5_FrameData[11] VPWR VGND sg13cmos5l_antennanp
XFILLER_103_43 VPWR VGND sg13cmos5l_decap_8
XFILLER_27_277 VPWR VGND sg13cmos5l_fill_1
XFILLER_42_203 VPWR VGND sg13cmos5l_decap_8
XANTENNA__1690__A1 Tile_X0Y4_W6END[6] VPWR VGND sg13cmos5l_antennanp
XFILLER_242_164 VPWR VGND sg13cmos5l_fill_2
XANTENNA__2980__D Tile_X0Y4_FrameData[28] VPWR VGND sg13cmos5l_antennanp
XFILLER_179_47 VPWR VGND sg13cmos5l_fill_1
XFILLER_179_58 VPWR VGND sg13cmos5l_decap_8
XFILLER_42_269 VPWR VGND sg13cmos5l_decap_4
XFILLER_144_4 VPWR VGND sg13cmos5l_fill_1
XANTENNA__3718__X Tile_X0Y3_FrameData_O[21] VPWR VGND sg13cmos5l_antennanp
XFILLER_10_133 VPWR VGND sg13cmos5l_decap_4
XFILLER_329_39 VPWR VGND sg13cmos5l_fill_2
XFILLER_10_155 VPWR VGND sg13cmos5l_decap_8
XFILLER_6_126 VPWR VGND sg13cmos5l_fill_1
XFILLER_6_159 VPWR VGND sg13cmos5l_fill_1
XANTENNA__1131__B_N Tile_X0Y5_N1END[3] VPWR VGND sg13cmos5l_antennanp
XANTENNA__2440__GATE Tile_X0Y5_FrameStrobe[6] VPWR VGND sg13cmos5l_antennanp
XFILLER_88_33 VPWR VGND sg13cmos5l_decap_8
XANTENNA__2220__D Tile_X0Y1_FrameData[4] VPWR VGND sg13cmos5l_antennanp
XANTENNA__3316__D Tile_X0Y5_FrameData[28] VPWR VGND sg13cmos5l_antennanp
XANTENNA__3453__X Tile_X0Y1_FrameData_O[21] VPWR VGND sg13cmos5l_antennanp
XANTENNA__2455__GATE Tile_X0Y5_FrameStrobe[6] VPWR VGND sg13cmos5l_antennanp
XFILLER_104_293 VPWR VGND sg13cmos5l_fill_2
XFILLER_280_215 VPWR VGND sg13cmos5l_decap_4
XANTENNA__3051__D Tile_X0Y4_FrameData[21] VPWR VGND sg13cmos5l_antennanp
XANTENNA__1681__A1 AXI_M_SOC_RDATA1 VPWR VGND sg13cmos5l_antennanp
XFILLER_33_225 VPWR VGND sg13cmos5l_decap_4
XANTENNA__2890__D Tile_X0Y4_FrameData[22] VPWR VGND sg13cmos5l_antennanp
XFILLER_310_96 VPWR VGND sg13cmos5l_decap_8
X_1960_ _1960_/Q Tile_X0Y0_FrameData[24] Tile_X0Y5_FrameStrobe[8] VPWR VGND sg13cmos5l_dlhq_1
XANTENNA__1433__A1 Tile_X0Y2_W2END[1] VPWR VGND sg13cmos5l_antennanp
XANTENNA__3628__X Tile_X0Y0_E6BEG[11] VPWR VGND sg13cmos5l_antennanp
X_1891_ _1891_/Q Tile_X0Y0_FrameData[29] Tile_X0Y5_FrameStrobe[6] VPWR VGND sg13cmos5l_dlhq_1
X_0911_ _0911_/X Tile_X0Y5_W1END[0] Tile_X0Y5_WW4END[0] _3304_/Q VPWR VGND sg13cmos5l_mux2_1
XFILLER_53_91 VPWR VGND sg13cmos5l_decap_8
X_3630_ Tile_X0Y0_E2BEGb[1] _3630_/A VPWR VGND sg13cmos5l_buf_1
X_0842_ _0842_/X Tile_X0Y5_W1END[1] Tile_X0Y5_WW4END[13] Tile_X0Y5_WW4END[5] _0645_/X
+ _3133_/Q _3134_/Q VPWR VGND sg13cmos5l_mux4_1
XANTENNA__1197__A0 Tile_X0Y0_WW4END[3] VPWR VGND sg13cmos5l_antennanp
X_3561_ Tile_X0Y0_FrameStrobe_O[12] Tile_X0Y5_FrameStrobe[12] VPWR VGND sg13cmos5l_buf_1
X_0773_ _0773_/X _0762_/X _0763_/X _0761_/X AXI_M_SOC_AWVALID _3348_/Q _3349_/Q VPWR
+ VGND sg13cmos5l_mux4_1
XANTENNA__2408__GATE Tile_X0Y5_FrameStrobe[5] VPWR VGND sg13cmos5l_antennanp
X_2512_ _2512_/Q Tile_X0Y2_FrameData[16] Tile_X0Y5_FrameStrobe[8] VPWR VGND sg13cmos5l_dlhq_1
X_3492_ Tile_X0Y1_E2BEGb[0] _3492_/A VPWR VGND sg13cmos5l_buf_1
XFILLER_5_181 VPWR VGND sg13cmos5l_decap_8
XANTENNA__2130__D Tile_X0Y1_FrameData[30] VPWR VGND sg13cmos5l_antennanp
XANTENNA__3226__D Tile_X0Y5_FrameData[22] VPWR VGND sg13cmos5l_antennanp
XANTENNA__3363__X Tile_X0Y2_E2BEGb[1] VPWR VGND sg13cmos5l_antennanp
XANTENNA__3804__A Tile_X0Y4_FrameData[26] VPWR VGND sg13cmos5l_antennanp
X_2443_ _2443_/Q Tile_X0Y2_FrameData[21] Tile_X0Y5_FrameStrobe[6] VPWR VGND sg13cmos5l_dlhq_1
XFILLER_335_60 VPWR VGND sg13cmos5l_fill_1
XFILLER_102_219 VPWR VGND sg13cmos5l_decap_8
X_2374_ _2374_/Q Tile_X0Y2_FrameData[26] Tile_X0Y5_FrameStrobe[4] VPWR VGND sg13cmos5l_dlhq_1
XFILLER_335_93 VPWR VGND sg13cmos5l_fill_2
XFILLER_256_201 VPWR VGND sg13cmos5l_fill_1
XFILLER_256_223 VPWR VGND sg13cmos5l_decap_8
X_1325_ _1325_/X Tile_X0Y1_W6END[10] _0965_/X _1217_/X _1100_/X _2208_/Q _2210_/Q
+ VPWR VGND sg13cmos5l_mux4_1
XFILLER_68_133 VPWR VGND sg13cmos5l_decap_8
XFILLER_83_103 VPWR VGND sg13cmos5l_decap_4
XFILLER_204_64 VPWR VGND sg13cmos5l_decap_8
XFILLER_204_75 VPWR VGND sg13cmos5l_fill_2
XFILLER_271_215 VPWR VGND sg13cmos5l_decap_8
X_1256_ _3639_/A Tile_X0Y0_W2MID[5] AXI_M_SOC_ARREADY _1147_/X _1045_/X _1884_/Q _1883_/Q
+ VPWR VGND sg13cmos5l_mux4_1
X_1187_ _1187_/X _1091_/X _1185_/X _1186_/X _1093_/X _2257_/Q _2258_/Q VPWR VGND sg13cmos5l_mux4_1
XFILLER_24_225 VPWR VGND sg13cmos5l_fill_1
XFILLER_33_17 VPWR VGND sg13cmos5l_decap_8
XANTENNA__1424__A1 Tile_X0Y2_WW4END[14] VPWR VGND sg13cmos5l_antennanp
XANTENNA__3538__X Tile_X0Y0_N2BEG[1] VPWR VGND sg13cmos5l_antennanp
XFILLER_177_241 VPWR VGND sg13cmos5l_fill_1
XANTENNA__2305__D Tile_X0Y2_FrameData[31] VPWR VGND sg13cmos5l_antennanp
XFILLER_137_105 VPWR VGND sg13cmos5l_fill_2
X_3828_ Tile_X0Y5_E2BEGb[5] _3828_/A VPWR VGND sg13cmos5l_buf_1
XANTENNA__1188__A0 Tile_X0Y0_W2MID[2] VPWR VGND sg13cmos5l_antennanp
XFILLER_137_149 VPWR VGND sg13cmos5l_decap_8
XFILLER_192_255 VPWR VGND sg13cmos5l_decap_4
XFILLER_229_61 VPWR VGND sg13cmos5l_fill_2
XFILLER_229_72 VPWR VGND sg13cmos5l_fill_1
XFILLER_229_83 VPWR VGND sg13cmos5l_fill_2
X_3759_ Tile_X0Y4_E6BEG[9] _3759_/A VPWR VGND sg13cmos5l_buf_1
XANTENNA__3170__GATE Tile_X0Y5_FrameStrobe[3] VPWR VGND sg13cmos5l_antennanp
XFILLER_145_171 VPWR VGND sg13cmos5l_decap_8
XFILLER_3_129 VPWR VGND sg13cmos5l_decap_4
XFILLER_334_293 VPWR VGND sg13cmos5l_fill_2
XANTENNA__2040__D Tile_X0Y1_FrameData[24] VPWR VGND sg13cmos5l_antennanp
XANTENNA__3136__D Tile_X0Y5_FrameData[16] VPWR VGND sg13cmos5l_antennanp
XANTENNA__0950__A3 Tile_X0Y0_S4END[5] VPWR VGND sg13cmos5l_antennanp
XANTENNA__3714__A Tile_X0Y3_FrameData[17] VPWR VGND sg13cmos5l_antennanp
XANTENNA__2975__D Tile_X0Y4_FrameData[1] VPWR VGND sg13cmos5l_antennanp
XFILLER_58_69 VPWR VGND sg13cmos5l_decap_8
XANTENNA__3185__GATE Tile_X0Y5_FrameStrobe[4] VPWR VGND sg13cmos5l_antennanp
XFILLER_114_42 VPWR VGND sg13cmos5l_fill_1
XFILLER_74_114 VPWR VGND sg13cmos5l_fill_2
XFILLER_59_166 VPWR VGND sg13cmos5l_decap_8
XANTENNA__1112__A0 Tile_X0Y3_W2MID[0] VPWR VGND sg13cmos5l_antennanp
XFILLER_215_120 VPWR VGND sg13cmos5l_decap_8
XFILLER_74_57 VPWR VGND sg13cmos5l_decap_8
XANTENNA__1663__A1 AXI_M_SOC_RDATA3 VPWR VGND sg13cmos5l_antennanp
XANTENNA__1415__A1 Tile_X0Y2_WW4END[11] VPWR VGND sg13cmos5l_antennanp
XANTENNA__3123__GATE Tile_X0Y5_FrameStrobe[2] VPWR VGND sg13cmos5l_antennanp
XANTENNA__3448__X Tile_X0Y1_FrameData_O[16] VPWR VGND sg13cmos5l_antennanp
XFILLER_90_67 VPWR VGND sg13cmos5l_decap_8
XANTENNA__2215__D Tile_X0Y1_FrameData[9] VPWR VGND sg13cmos5l_antennanp
XFILLER_135_0 VPWR VGND sg13cmos5l_decap_8
XFILLER_139_94 VPWR VGND sg13cmos5l_fill_2
XFILLER_143_119 VPWR VGND sg13cmos5l_fill_1
XFILLER_302_0 VPWR VGND sg13cmos5l_fill_2
XANTENNA__3138__GATE Tile_X0Y5_FrameStrobe[2] VPWR VGND sg13cmos5l_antennanp
XFILLER_136_182 VPWR VGND sg13cmos5l_fill_2
XANTENNA__3046__D Tile_X0Y4_FrameData[26] VPWR VGND sg13cmos5l_antennanp
XANTENNA__0941__A3 Tile_X0Y0_S4END[6] VPWR VGND sg13cmos5l_antennanp
XANTENNA__2394__GATE Tile_X0Y5_FrameStrobe[4] VPWR VGND sg13cmos5l_antennanp
XFILLER_155_71 VPWR VGND sg13cmos5l_fill_1
XFILLER_2_173 VPWR VGND sg13cmos5l_fill_1
XFILLER_31_8 VPWR VGND sg13cmos5l_fill_2
XANTENNA__2885__D Tile_X0Y4_FrameData[27] VPWR VGND sg13cmos5l_antennanp
XANTENNA__3911__X Tile_X0Y5_S4BEG[0] VPWR VGND sg13cmos5l_antennanp
X_1110_ _1110_/X _1109_/X _1108_/X _1107_/X Tile_X0Y0_S2MID[0] _1991_/Q _1992_/Q VPWR
+ VGND sg13cmos5l_mux4_1
X_2090_ _2090_/Q Tile_X0Y1_FrameData[6] Tile_X0Y5_FrameStrobe[3] VPWR VGND sg13cmos5l_dlhq_1
XFILLER_65_136 VPWR VGND sg13cmos5l_fill_2
XFILLER_48_91 VPWR VGND sg13cmos5l_decap_8
XANTENNA__1103__A0 Tile_X0Y2_W2MID[6] VPWR VGND sg13cmos5l_antennanp
XANTENNA__1431__X AXI_M_SOC_WDATA27 VPWR VGND sg13cmos5l_antennanp
X_1041_ _1041_/X _1057_/X _1036_/X Tile_X0Y0_S1END[1] Tile_X0Y0_S4END[1] _1726_/Q
+ _1725_/Q VPWR VGND sg13cmos5l_mux4_1
XANTENNA__1654__A1 Tile_X0Y4_W2END[6] VPWR VGND sg13cmos5l_antennanp
XFILLER_206_197 VPWR VGND sg13cmos5l_decap_4
XANTENNA__2332__GATE Tile_X0Y5_FrameStrobe[2] VPWR VGND sg13cmos5l_antennanp
XANTENNA__2962__GATE Tile_X0Y5_FrameStrobe[5] VPWR VGND sg13cmos5l_antennanp
X_2992_ _2992_/Q Tile_X0Y4_FrameData[16] Tile_X0Y5_FrameStrobe[6] VPWR VGND sg13cmos5l_dlhq_1
X_1943_ _1943_/Q Tile_X0Y0_FrameData[9] Tile_X0Y5_FrameStrobe[7] VPWR VGND sg13cmos5l_dlhq_1
XANTENNA__2125__D Tile_X0Y1_FrameData[3] VPWR VGND sg13cmos5l_antennanp
XANTENNA__3358__X Tile_X0Y2_E2BEG[4] VPWR VGND sg13cmos5l_antennanp
XANTENNA__2347__GATE Tile_X0Y5_FrameStrobe[3] VPWR VGND sg13cmos5l_antennanp
XFILLER_119_138 VPWR VGND sg13cmos5l_fill_2
X_3613_ Tile_X0Y0_EE4BEG[12] _3613_/A VPWR VGND sg13cmos5l_buf_1
X_1874_ _1874_/Q Tile_X0Y0_FrameData[14] Tile_X0Y5_FrameStrobe[5] VPWR VGND sg13cmos5l_dlhq_1
XANTENNA__1964__D Tile_X0Y0_FrameData[20] VPWR VGND sg13cmos5l_antennanp
XANTENNA__2977__GATE Tile_X0Y5_FrameStrobe[6] VPWR VGND sg13cmos5l_antennanp
XFILLER_134_119 VPWR VGND sg13cmos5l_decap_8
X_0825_ _3832_/A Tile_X0Y5_N4END[1] _0696_/X _0644_/X _0694_/X _3181_/Q _3182_/Q VPWR
+ VGND sg13cmos5l_mux4_1
XFILLER_127_171 VPWR VGND sg13cmos5l_decap_8
X_3544_ Tile_X0Y0_N2BEG[7] _3544_/A VPWR VGND sg13cmos5l_buf_1
X_0756_ _0756_/X Tile_X0Y3_WW4END[0] Tile_X0Y3_WW4END[8] Tile_X0Y3_W6END[8] _1521_/X
+ _2600_/Q _2599_/Q VPWR VGND sg13cmos5l_mux4_1
XFILLER_50_0 VPWR VGND sg13cmos5l_fill_2
XFILLER_316_293 VPWR VGND sg13cmos5l_fill_2
X_3475_ Tile_X0Y1_EE4BEG[11] _3475_/A VPWR VGND sg13cmos5l_buf_1
X_0687_ _0688_/C _2788_/Q _0992_/X VPWR VGND sg13cmos5l_nor2_1
XANTENNA__2900__GATE Tile_X0Y5_FrameStrobe[3] VPWR VGND sg13cmos5l_antennanp
X_2426_ _2426_/Q Tile_X0Y2_FrameData[6] Tile_X0Y5_FrameStrobe[5] VPWR VGND sg13cmos5l_dlhq_1
XANTENNA__2795__D Tile_X0Y4_FrameData[21] VPWR VGND sg13cmos5l_antennanp
XANTENNA__3821__X Tile_X0Y5_E2BEG[6] VPWR VGND sg13cmos5l_antennanp
XFILLER_28_17 VPWR VGND sg13cmos5l_fill_1
XFILLER_28_28 VPWR VGND sg13cmos5l_decap_4
X_2357_ _2357_/Q Tile_X0Y2_FrameData[11] Tile_X0Y5_FrameStrobe[3] VPWR VGND sg13cmos5l_dlhq_1
X_2288_ _2288_/Q Tile_X0Y2_FrameData[16] Tile_X0Y5_FrameStrobe[1] VPWR VGND sg13cmos5l_dlhq_1
X_1308_ AXI_M_SOC_AWADDR2 Tile_X0Y1_W2MID[2] Tile_X0Y1_W2END[2] Tile_X0Y1_W6END[2]
+ _1100_/X _2036_/Q _2035_/Q VPWR VGND sg13cmos5l_mux4_1
XFILLER_56_114 VPWR VGND sg13cmos5l_decap_8
XANTENNA__2915__GATE Tile_X0Y5_FrameStrobe[4] VPWR VGND sg13cmos5l_antennanp
X_1239_ AXI_M_SOC_AWADDR8 Tile_X0Y0_WW4END[0] Tile_X0Y0_WW4END[8] Tile_X0Y0_W6END[0]
+ _1075_/X _1800_/Q _1799_/Q VPWR VGND sg13cmos5l_mux4_1
XANTENNA__1645__A1 Tile_X0Y4_W2END[7] VPWR VGND sg13cmos5l_antennanp
XFILLER_231_51 VPWR VGND sg13cmos5l_decap_8
XANTENNA__2035__D Tile_X0Y1_FrameData[29] VPWR VGND sg13cmos5l_antennanp
XANTENNA__3709__A Tile_X0Y3_FrameData[12] VPWR VGND sg13cmos5l_antennanp
XFILLER_100_88 VPWR VGND sg13cmos5l_decap_8
XFILLER_176_37 VPWR VGND sg13cmos5l_decap_8
XANTENNA__1874__D Tile_X0Y0_FrameData[14] VPWR VGND sg13cmos5l_antennanp
XFILLER_125_119 VPWR VGND sg13cmos5l_decap_8
XFILLER_180_236 VPWR VGND sg13cmos5l_decap_8
XFILLER_307_260 VPWR VGND sg13cmos5l_fill_2
XFILLER_109_86 VPWR VGND sg13cmos5l_fill_2
XFILLER_256_92 VPWR VGND sg13cmos5l_decap_4
XFILLER_307_293 VPWR VGND sg13cmos5l_fill_2
XFILLER_69_46 VPWR VGND sg13cmos5l_decap_8
XANTENNA__3444__A Tile_X0Y1_FrameData[12] VPWR VGND sg13cmos5l_antennanp
XFILLER_125_41 VPWR VGND sg13cmos5l_decap_8
XANTENNA__1333__A0 Tile_X0Y1_W2END[4] VPWR VGND sg13cmos5l_antennanp
XANTENNA__3731__X Tile_X0Y4_E1BEG[1] VPWR VGND sg13cmos5l_antennanp
XFILLER_272_80 VPWR VGND sg13cmos5l_decap_4
XFILLER_85_67 VPWR VGND sg13cmos5l_decap_8
XANTENNA__1636__A1 Tile_X0Y4_W6END[8] VPWR VGND sg13cmos5l_antennanp
XANTENNA__1100__A3 Tile_X0Y0_S2MID[2] VPWR VGND sg13cmos5l_antennanp
XFILLER_141_84 VPWR VGND sg13cmos5l_decap_8
XFILLER_252_0 VPWR VGND sg13cmos5l_fill_2
XANTENNA__3062__GATE Tile_X0Y5_FrameStrobe[0] VPWR VGND sg13cmos5l_antennanp
XFILLER_70_194 VPWR VGND sg13cmos5l_decap_8
XFILLER_156_200 VPWR VGND sg13cmos5l_decap_8
XFILLER_7_210 VPWR VGND sg13cmos5l_fill_1
XANTENNA__1784__D Tile_X0Y0_FrameData[8] VPWR VGND sg13cmos5l_antennanp
XANTENNA__3077__GATE Tile_X0Y5_FrameStrobe[0] VPWR VGND sg13cmos5l_antennanp
XANTENNA__3906__X Tile_X0Y5_S2BEGb[3] VPWR VGND sg13cmos5l_antennanp
XFILLER_171_214 VPWR VGND sg13cmos5l_decap_4
XFILLER_171_236 VPWR VGND sg13cmos5l_decap_8
X_1590_ _3516_/A _2749_/Q _1583_/Y _1589_/Y VPWR VGND sg13cmos5l_o21ai_1
X_0610_ _0610_/Y _3268_/Q _0597_/X _0609_/Y VPWR VGND sg13cmos5l_o21ai_1
XFILLER_7_276 VPWR VGND sg13cmos5l_fill_2
XFILLER_109_193 VPWR VGND sg13cmos5l_decap_8
X_0541_ _0541_/Y Tile_X0Y0_W6END[1] VPWR VGND sg13cmos5l_inv_1
XANTENNA__1426__X AXI_M_SOC_WDATA21 VPWR VGND sg13cmos5l_antennanp
XANTENNA__1572__A0 Tile_X0Y3_W1END[0] VPWR VGND sg13cmos5l_antennanp
XANTENNA__3000__GATE Tile_X0Y5_FrameStrobe[6] VPWR VGND sg13cmos5l_antennanp
XFILLER_316_51 VPWR VGND sg13cmos5l_fill_1
XFILLER_316_40 VPWR VGND sg13cmos5l_fill_1
XFILLER_285_126 VPWR VGND sg13cmos5l_decap_4
X_3260_ _3260_/Q Tile_X0Y5_FrameData[20] Tile_X0Y5_FrameStrobe[6] VPWR VGND sg13cmos5l_dlhq_1
XANTENNA__3641__X Tile_X0Y0_E2BEG[4] VPWR VGND sg13cmos5l_antennanp
X_3191_ _3191_/Q Tile_X0Y5_FrameData[25] Tile_X0Y5_FrameStrobe[4] VPWR VGND sg13cmos5l_dlhq_1
X_2211_ _2211_/Q Tile_X0Y1_FrameData[13] Tile_X0Y5_FrameStrobe[7] VPWR VGND sg13cmos5l_dlhq_1
X_2142_ _2142_/Q Tile_X0Y1_FrameData[18] Tile_X0Y5_FrameStrobe[5] VPWR VGND sg13cmos5l_dlhq_1
XANTENNA__3015__GATE Tile_X0Y5_FrameStrobe[7] VPWR VGND sg13cmos5l_antennanp
XFILLER_226_226 VPWR VGND sg13cmos5l_decap_4
X_2073_ _2073_/Q Tile_X0Y1_FrameData[23] Tile_X0Y5_FrameStrobe[3] VPWR VGND sg13cmos5l_dlhq_1
XFILLER_332_72 VPWR VGND sg13cmos5l_fill_2
X_1024_ _1024_/X Tile_X0Y1_W1END[2] _0965_/X Tile_X0Y1_W6END[6] _0671_/X _2235_/Q
+ _2236_/Q VPWR VGND sg13cmos5l_mux4_1
XANTENNA__1959__D Tile_X0Y0_FrameData[25] VPWR VGND sg13cmos5l_antennanp
XANTENNA__2271__GATE Tile_X0Y5_FrameStrobe[0] VPWR VGND sg13cmos5l_antennanp
XFILLER_241_218 VPWR VGND sg13cmos5l_decap_8
XFILLER_241_229 VPWR VGND sg13cmos5l_fill_1
XFILLER_98_0 VPWR VGND sg13cmos5l_fill_2
XANTENNA__2286__GATE Tile_X0Y5_FrameStrobe[1] VPWR VGND sg13cmos5l_antennanp
XFILLER_277_47 VPWR VGND sg13cmos5l_decap_8
X_2975_ _2975_/Q Tile_X0Y4_FrameData[1] Tile_X0Y5_FrameStrobe[5] VPWR VGND sg13cmos5l_dlhq_1
X_1926_ _1926_/Q Tile_X0Y0_FrameData[26] Tile_X0Y5_FrameStrobe[7] VPWR VGND sg13cmos5l_dlhq_1
XANTENNA__3816__X Tile_X0Y5_E2BEG[1] VPWR VGND sg13cmos5l_antennanp
X_1857_ _1857_/Q Tile_X0Y0_FrameData[31] Tile_X0Y5_FrameStrobe[5] VPWR VGND sg13cmos5l_dlhq_1
X_0808_ _3843_/A Tile_X0Y5_WW4END[15] _0740_/X _0775_/X _0563_/X _3215_/Q _3216_/Q
+ VPWR VGND sg13cmos5l_mux4_1
XFILLER_304_241 VPWR VGND sg13cmos5l_fill_2
X_3527_ Tile_X0Y0_N4BEG[14] _3527_/A VPWR VGND sg13cmos5l_buf_1
X_1788_ _1788_/Q Tile_X0Y0_FrameData[4] Tile_X0Y5_FrameStrobe[2] VPWR VGND sg13cmos5l_dlhq_1
XANTENNA__0905__A3 Tile_X0Y0_S4END[7] VPWR VGND sg13cmos5l_antennanp
XANTENNA__1563__A0 Tile_X0Y3_W2MID[6] VPWR VGND sg13cmos5l_antennanp
XFILLER_226_62 VPWR VGND sg13cmos5l_decap_8
X_0739_ _0739_/X _0738_/X _0737_/X _2170_/Q VPWR VGND sg13cmos5l_mux2_1
XFILLER_170_280 VPWR VGND sg13cmos5l_fill_1
X_3458_ Tile_X0Y1_FrameData_O[26] Tile_X0Y1_FrameData[26] VPWR VGND sg13cmos5l_buf_1
XANTENNA__2224__GATE Tile_X0Y5_FrameStrobe[7] VPWR VGND sg13cmos5l_antennanp
XANTENNA__3551__X Tile_X0Y0_FrameStrobe_O[2] VPWR VGND sg13cmos5l_antennanp
X_2409_ _2409_/Q Tile_X0Y2_FrameData[23] Tile_X0Y5_FrameStrobe[5] VPWR VGND sg13cmos5l_dlhq_1
X_3389_ Tile_X0Y2_EE4BEG[7] _3389_/A VPWR VGND sg13cmos5l_buf_1
XANTENNA__2854__GATE Tile_X0Y5_FrameStrobe[2] VPWR VGND sg13cmos5l_antennanp
XFILLER_29_125 VPWR VGND sg13cmos5l_decap_8
XFILLER_242_50 VPWR VGND sg13cmos5l_decap_8
XFILLER_29_169 VPWR VGND sg13cmos5l_decap_8
XANTENNA__2239__GATE Tile_X0Y5_FrameStrobe[8] VPWR VGND sg13cmos5l_antennanp
XFILLER_44_128 VPWR VGND sg13cmos5l_decap_8
XANTENNA__1869__D Tile_X0Y0_FrameData[19] VPWR VGND sg13cmos5l_antennanp
XANTENNA__2869__GATE Tile_X0Y5_FrameStrobe[2] VPWR VGND sg13cmos5l_antennanp
XFILLER_111_43 VPWR VGND sg13cmos5l_decap_8
XFILLER_197_111 VPWR VGND sg13cmos5l_fill_1
XFILLER_197_133 VPWR VGND sg13cmos5l_decap_8
XFILLER_197_144 VPWR VGND sg13cmos5l_fill_1
XFILLER_71_14 VPWR VGND sg13cmos5l_decap_8
XFILLER_52_172 VPWR VGND sg13cmos5l_decap_8
XANTENNA__3439__A Tile_X0Y1_FrameData[7] VPWR VGND sg13cmos5l_antennanp
XFILLER_138_222 VPWR VGND sg13cmos5l_decap_4
XANTENNA__3726__X Tile_X0Y3_FrameData_O[29] VPWR VGND sg13cmos5l_antennanp
XFILLER_299_207 VPWR VGND sg13cmos5l_decap_8
XANTENNA__2807__GATE Tile_X0Y5_FrameStrobe[0] VPWR VGND sg13cmos5l_antennanp
XFILLER_20_40 VPWR VGND sg13cmos5l_decap_8
XFILLER_4_257 VPWR VGND sg13cmos5l_fill_2
XANTENNA__1554__A0 Tile_X0Y3_WW4END[4] VPWR VGND sg13cmos5l_antennanp
XFILLER_106_152 VPWR VGND sg13cmos5l_decap_8
XFILLER_121_133 VPWR VGND sg13cmos5l_decap_4
XFILLER_267_115 VPWR VGND sg13cmos5l_decap_4
XFILLER_283_90 VPWR VGND sg13cmos5l_decap_8
XANTENNA__1306__A0 AXI_M_SOC_RDATA25 VPWR VGND sg13cmos5l_antennanp
XANTENNA__3324__D Tile_X0Y5_FrameData[20] VPWR VGND sg13cmos5l_antennanp
XANTENNA__3461__X Tile_X0Y1_FrameData_O[29] VPWR VGND sg13cmos5l_antennanp
XFILLER_96_99 VPWR VGND sg13cmos5l_fill_1
XFILLER_96_88 VPWR VGND sg13cmos5l_decap_8
XFILLER_152_72 VPWR VGND sg13cmos5l_decap_4
XFILLER_152_94 VPWR VGND sg13cmos5l_decap_8
XFILLER_302_42 VPWR VGND sg13cmos5l_decap_4
XFILLER_75_286 VPWR VGND sg13cmos5l_fill_1
XANTENNA__1609__A1 AXI_M_SOC_RDATA4 VPWR VGND sg13cmos5l_antennanp
XANTENNA__1779__D Tile_X0Y0_FrameData[13] VPWR VGND sg13cmos5l_antennanp
XANTENNA__1085__A2 Tile_X0Y3_W6END[2] VPWR VGND sg13cmos5l_antennanp
XFILLER_188_111 VPWR VGND sg13cmos5l_decap_8
XFILLER_302_97 VPWR VGND sg13cmos5l_decap_8
XFILLER_45_70 VPWR VGND sg13cmos5l_fill_2
XFILLER_43_183 VPWR VGND sg13cmos5l_decap_8
X_2760_ _2760_/Q Tile_X0Y3_FrameData[8] Tile_X0Y5_FrameStrobe[7] VPWR VGND sg13cmos5l_dlhq_1
XANTENNA__0596__A1 Tile_X0Y5_N4END[0] VPWR VGND sg13cmos5l_antennanp
XANTENNA__1388__A3 Tile_X0Y0_S4END[9] VPWR VGND sg13cmos5l_antennanp
X_2691_ _2691_/Q Tile_X0Y3_FrameData[13] Tile_X0Y5_FrameStrobe[5] VPWR VGND sg13cmos5l_dlhq_1
X_1711_ _1711_/Q Tile_X0Y0_FrameData[17] Tile_X0Y5_FrameStrobe[0] VPWR VGND sg13cmos5l_dlhq_1
XANTENNA_2 Tile_X0Y5_N2MID[7] VPWR VGND sg13cmos5l_antennanp
XANTENNA__2403__D Tile_X0Y2_FrameData[29] VPWR VGND sg13cmos5l_antennanp
XANTENNA__3636__X Tile_X0Y0_E2BEGb[7] VPWR VGND sg13cmos5l_antennanp
XFILLER_177_80 VPWR VGND sg13cmos5l_decap_8
X_1642_ AXI_M_SOC_ARADDR3 Tile_X0Y4_WW4END[3] Tile_X0Y4_W6END[3] Tile_X0Y4_WW4END[11]
+ _0981_/X _2881_/Q _2882_/Q VPWR VGND sg13cmos5l_mux4_1
XFILLER_144_269 VPWR VGND sg13cmos5l_fill_2
XANTENNA__1545__A0 AXI_M_SOC_RDATA11 VPWR VGND sg13cmos5l_antennanp
X_1573_ _1573_/Y _2722_/Q _1573_/B VPWR VGND sg13cmos5l_nand2b_1
XFILLER_298_262 VPWR VGND sg13cmos5l_decap_8
XFILLER_301_200 VPWR VGND sg13cmos5l_fill_1
X_3312_ _3312_/Q Tile_X0Y5_FrameData[0] Tile_X0Y5_FrameStrobe[7] VPWR VGND sg13cmos5l_dlhq_1
XANTENNA__3234__D Tile_X0Y5_FrameData[14] VPWR VGND sg13cmos5l_antennanp
XFILLER_112_166 VPWR VGND sg13cmos5l_decap_8
X_3243_ _3243_/Q Tile_X0Y5_FrameData[5] Tile_X0Y5_FrameStrobe[5] VPWR VGND sg13cmos5l_dlhq_1
XANTENNA__3371__X Tile_X0Y2_E6BEG[1] VPWR VGND sg13cmos5l_antennanp
XANTENNA__1312__A3 Tile_X0Y0_S4END[8] VPWR VGND sg13cmos5l_antennanp
XFILLER_266_181 VPWR VGND sg13cmos5l_decap_8
X_3174_ _3174_/Q Tile_X0Y5_FrameData[10] Tile_X0Y5_FrameStrobe[3] VPWR VGND sg13cmos5l_dlhq_1
X_2125_ _2125_/Q Tile_X0Y1_FrameData[3] Tile_X0Y5_FrameStrobe[4] VPWR VGND sg13cmos5l_dlhq_1
XFILLER_66_264 VPWR VGND sg13cmos5l_fill_2
XFILLER_25_18 VPWR VGND sg13cmos5l_fill_2
X_2056_ _2056_/Q Tile_X0Y1_FrameData[8] Tile_X0Y5_FrameStrobe[2] VPWR VGND sg13cmos5l_dlhq_1
XANTENNA__1076__A2 Tile_X0Y2_W6END[3] VPWR VGND sg13cmos5l_antennanp
X_1007_ _1007_/X _1024_/X _1003_/X Tile_X0Y0_S1END[2] Tile_X0Y0_S4END[2] _1748_/Q
+ _1747_/Q VPWR VGND sg13cmos5l_mux4_1
XFILLER_179_155 VPWR VGND sg13cmos5l_decap_8
X_2958_ _2958_/Q Tile_X0Y4_FrameData[18] Tile_X0Y5_FrameStrobe[5] VPWR VGND sg13cmos5l_dlhq_1
XANTENNA__1379__A3 Tile_X0Y0_S4END[10] VPWR VGND sg13cmos5l_antennanp
X_1909_ _1909_/Q Tile_X0Y0_FrameData[11] Tile_X0Y5_FrameStrobe[6] VPWR VGND sg13cmos5l_dlhq_1
XFILLER_336_141 VPWR VGND sg13cmos5l_fill_2
XANTENNA__2313__D Tile_X0Y2_FrameData[23] VPWR VGND sg13cmos5l_antennanp
XANTENNA__3546__X Tile_X0Y0_N1BEG[1] VPWR VGND sg13cmos5l_antennanp
XFILLER_135_236 VPWR VGND sg13cmos5l_decap_4
X_2889_ _2889_/Q Tile_X0Y4_FrameData[23] Tile_X0Y5_FrameStrobe[3] VPWR VGND sg13cmos5l_dlhq_1
XFILLER_237_72 VPWR VGND sg13cmos5l_fill_2
XANTENNA__1536__A0 Tile_X0Y5_N4END[10] VPWR VGND sg13cmos5l_antennanp
XFILLER_103_100 VPWR VGND sg13cmos5l_fill_1
XFILLER_1_205 VPWR VGND sg13cmos5l_fill_1
XANTENNA__2163__GATE Tile_X0Y5_FrameStrobe[6] VPWR VGND sg13cmos5l_antennanp
XFILLER_173_38 VPWR VGND sg13cmos5l_fill_1
XANTENNA__2793__GATE Tile_X0Y5_FrameStrobe[0] VPWR VGND sg13cmos5l_antennanp
XANTENNA__3144__D Tile_X0Y5_FrameData[8] VPWR VGND sg13cmos5l_antennanp
XFILLER_103_155 VPWR VGND sg13cmos5l_decap_8
XFILLER_106_21 VPWR VGND sg13cmos5l_fill_1
XFILLER_106_32 VPWR VGND sg13cmos5l_decap_8
XANTENNA__3722__A Tile_X0Y3_FrameData[25] VPWR VGND sg13cmos5l_antennanp
XFILLER_264_107 VPWR VGND sg13cmos5l_decap_4
XANTENNA__2983__D Tile_X0Y4_FrameData[25] VPWR VGND sg13cmos5l_antennanp
XFILLER_66_69 VPWR VGND sg13cmos5l_decap_8
XANTENNA__2178__GATE Tile_X0Y5_FrameStrobe[6] VPWR VGND sg13cmos5l_antennanp
XFILLER_82_57 VPWR VGND sg13cmos5l_decap_8
XANTENNA__2101__GATE Tile_X0Y5_FrameStrobe[4] VPWR VGND sg13cmos5l_antennanp
XANTENNA__2731__GATE Tile_X0Y5_FrameStrobe[6] VPWR VGND sg13cmos5l_antennanp
XFILLER_198_57 VPWR VGND sg13cmos5l_decap_8
XFILLER_25_161 VPWR VGND sg13cmos5l_decap_8
XANTENNA__0814__A2 AXI_M_SOC_RVALID VPWR VGND sg13cmos5l_antennanp
XFILLER_15_73 VPWR VGND sg13cmos5l_fill_2
XFILLER_213_273 VPWR VGND sg13cmos5l_fill_2
XANTENNA__2116__GATE Tile_X0Y5_FrameStrobe[4] VPWR VGND sg13cmos5l_antennanp
XFILLER_327_130 VPWR VGND sg13cmos5l_decap_4
XANTENNA__2223__D Tile_X0Y1_FrameData[1] VPWR VGND sg13cmos5l_antennanp
XANTENNA__2746__GATE Tile_X0Y5_FrameStrobe[7] VPWR VGND sg13cmos5l_antennanp
XANTENNA__3319__D Tile_X0Y5_FrameData[25] VPWR VGND sg13cmos5l_antennanp
XANTENNA__3456__X Tile_X0Y1_FrameData_O[24] VPWR VGND sg13cmos5l_antennanp
XFILLER_215_0 VPWR VGND sg13cmos5l_fill_2
XFILLER_327_163 VPWR VGND sg13cmos5l_decap_8
XANTENNA__1527__A0 Tile_X0Y3_WW4END[3] VPWR VGND sg13cmos5l_antennanp
XFILLER_134_280 VPWR VGND sg13cmos5l_fill_2
XANTENNA__3054__D Tile_X0Y4_FrameData[18] VPWR VGND sg13cmos5l_antennanp
XFILLER_295_221 VPWR VGND sg13cmos5l_decap_4
XFILLER_0_260 VPWR VGND sg13cmos5l_fill_2
XANTENNA__2893__D Tile_X0Y4_FrameData[19] VPWR VGND sg13cmos5l_antennanp
XANTENNA__1058__A2 Tile_X0Y5_N4END[12] VPWR VGND sg13cmos5l_antennanp
XANTENNA__1940__GATE Tile_X0Y5_FrameStrobe[7] VPWR VGND sg13cmos5l_antennanp
X_3861_ Tile_X0Y5_FrameData_O[2] Tile_X0Y5_FrameData[2] VPWR VGND sg13cmos5l_buf_1
XANTENNA__1955__GATE Tile_X0Y5_FrameStrobe[8] VPWR VGND sg13cmos5l_antennanp
X_2812_ _2812_/Q Tile_X0Y4_FrameData[4] Tile_X0Y5_FrameStrobe[0] VPWR VGND sg13cmos5l_dlhq_1
X_3792_ Tile_X0Y4_FrameData_O[14] Tile_X0Y4_FrameData[14] VPWR VGND sg13cmos5l_buf_1
X_2743_ _2743_/Q Tile_X0Y3_FrameData[25] Tile_X0Y5_FrameStrobe[7] VPWR VGND sg13cmos5l_dlhq_1
XANTENNA__2133__D Tile_X0Y1_FrameData[27] VPWR VGND sg13cmos5l_antennanp
XANTENNA__3229__D Tile_X0Y5_FrameData[19] VPWR VGND sg13cmos5l_antennanp
XANTENNA__3366__X Tile_X0Y2_E2BEGb[4] VPWR VGND sg13cmos5l_antennanp
XANTENNA__3807__A Tile_X0Y4_FrameData[29] VPWR VGND sg13cmos5l_antennanp
XFILLER_117_225 VPWR VGND sg13cmos5l_decap_8
XFILLER_117_258 VPWR VGND sg13cmos5l_decap_4
X_2674_ _2674_/Q Tile_X0Y3_FrameData[30] Tile_X0Y5_FrameStrobe[5] VPWR VGND sg13cmos5l_dlhq_1
XANTENNA__1518__A0 Tile_X0Y3_W2END[0] VPWR VGND sg13cmos5l_antennanp
XANTENNA__1972__D Tile_X0Y1_FrameData[28] VPWR VGND sg13cmos5l_antennanp
X_1625_ _3758_/A AXI_M_SOC_RDATA2 _1125_/X _0981_/X _1319_/X _2895_/Q _2896_/Q VPWR
+ VGND sg13cmos5l_mux4_1
XFILLER_333_177 VPWR VGND sg13cmos5l_fill_1
XFILLER_207_64 VPWR VGND sg13cmos5l_decap_8
X_1556_ AXI_M_SOC_WDATA3 Tile_X0Y3_W2MID[3] Tile_X0Y3_W2END[3] Tile_X0Y3_W6END[3]
+ _1587_/B _2578_/Q _2577_/Q VPWR VGND sg13cmos5l_mux4_1
XFILLER_98_142 VPWR VGND sg13cmos5l_fill_2
XANTENNA__0741__A1 Tile_X0Y5_N4END[3] VPWR VGND sg13cmos5l_antennanp
X_1487_ _1487_/Y _2443_/Q _1179_/X _1486_/Y VPWR VGND sg13cmos5l_a21oi_1
XFILLER_98_197 VPWR VGND sg13cmos5l_fill_1
XFILLER_100_136 VPWR VGND sg13cmos5l_decap_8
X_3226_ _3226_/Q Tile_X0Y5_FrameData[22] Tile_X0Y5_FrameStrobe[5] VPWR VGND sg13cmos5l_dlhq_1
X_3157_ _3157_/Q Tile_X0Y5_FrameData[27] Tile_X0Y5_FrameStrobe[3] VPWR VGND sg13cmos5l_dlhq_1
XANTENNA__1908__GATE Tile_X0Y5_FrameStrobe[6] VPWR VGND sg13cmos5l_antennanp
X_2108_ _2108_/Q Tile_X0Y1_FrameData[20] Tile_X0Y5_FrameStrobe[4] VPWR VGND sg13cmos5l_dlhq_1
XANTENNA__2308__D Tile_X0Y2_FrameData[28] VPWR VGND sg13cmos5l_antennanp
XFILLER_14_109 VPWR VGND sg13cmos5l_decap_8
X_3088_ _3088_/Q Tile_X0Y5_FrameData[0] Tile_X0Y5_FrameStrobe[0] VPWR VGND sg13cmos5l_dlhq_1
XFILLER_54_256 VPWR VGND sg13cmos5l_decap_8
XANTENNA__1049__A2 Tile_X0Y5_N2MID[1] VPWR VGND sg13cmos5l_antennanp
X_2039_ _2039_/Q Tile_X0Y1_FrameData[25] Tile_X0Y5_FrameStrobe[2] VPWR VGND sg13cmos5l_dlhq_1
XFILLER_146_8 VPWR VGND sg13cmos5l_fill_2
XFILLER_22_131 VPWR VGND sg13cmos5l_decap_8
XFILLER_168_16 VPWR VGND sg13cmos5l_fill_2
XFILLER_168_49 VPWR VGND sg13cmos5l_fill_1
XANTENNA__2043__D Tile_X0Y1_FrameData[21] VPWR VGND sg13cmos5l_antennanp
XANTENNA__3139__D Tile_X0Y5_FrameData[13] VPWR VGND sg13cmos5l_antennanp
XANTENNA__3717__A Tile_X0Y3_FrameData[20] VPWR VGND sg13cmos5l_antennanp
XANTENNA__1221__A2 Tile_X0Y0_S4END[2] VPWR VGND sg13cmos5l_antennanp
XFILLER_184_26 VPWR VGND sg13cmos5l_decap_8
XANTENNA__1509__A0 Tile_X0Y3_W2END[4] VPWR VGND sg13cmos5l_antennanp
XANTENNA__1882__D Tile_X0Y0_FrameData[6] VPWR VGND sg13cmos5l_antennanp
XANTENNA__2978__D Tile_X0Y4_FrameData[30] VPWR VGND sg13cmos5l_antennanp
XFILLER_324_155 VPWR VGND sg13cmos5l_decap_8
XANTENNA__1524__A3 Tile_X0Y0_S4END[14] VPWR VGND sg13cmos5l_antennanp
XFILLER_89_142 VPWR VGND sg13cmos5l_decap_8
XANTENNA__3452__A Tile_X0Y1_FrameData[20] VPWR VGND sg13cmos5l_antennanp
XFILLER_292_224 VPWR VGND sg13cmos5l_fill_2
XANTENNA__2040__GATE Tile_X0Y5_FrameStrobe[2] VPWR VGND sg13cmos5l_antennanp
XANTENNA__2218__D Tile_X0Y1_FrameData[6] VPWR VGND sg13cmos5l_antennanp
XFILLER_165_0 VPWR VGND sg13cmos5l_fill_2
XFILLER_93_67 VPWR VGND sg13cmos5l_decap_8
XFILLER_45_256 VPWR VGND sg13cmos5l_fill_1
XANTENNA__2670__GATE Tile_X0Y5_FrameStrobe[4] VPWR VGND sg13cmos5l_antennanp
XANTENNA__0799__A1 AXI_M_SOC_RLAST VPWR VGND sg13cmos5l_antennanp
XANTENNA__2055__GATE Tile_X0Y5_FrameStrobe[2] VPWR VGND sg13cmos5l_antennanp
XFILLER_13_153 VPWR VGND sg13cmos5l_decap_8
XANTENNA__2685__GATE Tile_X0Y5_FrameStrobe[5] VPWR VGND sg13cmos5l_antennanp
XANTENNA__3049__D Tile_X0Y4_FrameData[23] VPWR VGND sg13cmos5l_antennanp
XFILLER_42_82 VPWR VGND sg13cmos5l_decap_8
XANTENNA__1212__A2 Tile_X0Y0_W6END[3] VPWR VGND sg13cmos5l_antennanp
XFILLER_61_8 VPWR VGND sg13cmos5l_decap_8
XANTENNA__1792__D Tile_X0Y0_FrameData[0] VPWR VGND sg13cmos5l_antennanp
XANTENNA__2888__D Tile_X0Y4_FrameData[24] VPWR VGND sg13cmos5l_antennanp
XFILLER_114_217 VPWR VGND sg13cmos5l_decap_8
XFILLER_54_7 VPWR VGND sg13cmos5l_fill_1
XANTENNA__3914__X Tile_X0Y5_S4BEG[3] VPWR VGND sg13cmos5l_antennanp
X_1410_ AXI_M_SOC_WDATA13 Tile_X0Y2_WW4END[5] Tile_X0Y2_WW4END[13] Tile_X0Y2_W6END[5]
+ _1315_/X _2334_/Q _2333_/Q VPWR VGND sg13cmos5l_mux4_1
XFILLER_330_103 VPWR VGND sg13cmos5l_fill_2
XFILLER_174_92 VPWR VGND sg13cmos5l_fill_2
X_2390_ _2390_/Q Tile_X0Y2_FrameData[10] Tile_X0Y5_FrameStrobe[4] VPWR VGND sg13cmos5l_dlhq_1
XFILLER_122_283 VPWR VGND sg13cmos5l_fill_1
X_1341_ _3505_/A Tile_X0Y1_W2MID[2] AXI_M_SOC_RDATA27 _1100_/X _1086_/X _2150_/Q _2149_/Q
+ VPWR VGND sg13cmos5l_mux4_1
XANTENNA__2623__GATE Tile_X0Y5_FrameStrobe[3] VPWR VGND sg13cmos5l_antennanp
XFILLER_283_213 VPWR VGND sg13cmos5l_fill_1
X_1272_ _3496_/A Tile_X0Y1_W2END[3] AXI_M_SOC_RDATA25 _1094_/X _1089_/X _2136_/Q _2135_/Q
+ VPWR VGND sg13cmos5l_mux4_1
XFILLER_260_17 VPWR VGND sg13cmos5l_fill_2
X_3011_ _3011_/Q Tile_X0Y4_FrameData[29] Tile_X0Y5_FrameStrobe[7] VPWR VGND sg13cmos5l_dlhq_1
XFILLER_95_189 VPWR VGND sg13cmos5l_decap_8
XANTENNA__2008__GATE Tile_X0Y5_FrameStrobe[1] VPWR VGND sg13cmos5l_antennanp
XFILLER_236_173 VPWR VGND sg13cmos5l_decap_8
XANTENNA__2128__D Tile_X0Y1_FrameData[0] VPWR VGND sg13cmos5l_antennanp
XANTENNA__2638__GATE Tile_X0Y5_FrameStrobe[3] VPWR VGND sg13cmos5l_antennanp
XFILLER_51_204 VPWR VGND sg13cmos5l_decap_8
XFILLER_36_256 VPWR VGND sg13cmos5l_fill_1
XFILLER_251_165 VPWR VGND sg13cmos5l_fill_2
XANTENNA__1967__D Tile_X0Y0_FrameData[17] VPWR VGND sg13cmos5l_antennanp
XFILLER_189_250 VPWR VGND sg13cmos5l_fill_1
XFILLER_251_198 VPWR VGND sg13cmos5l_decap_8
XFILLER_269_37 VPWR VGND sg13cmos5l_fill_2
X_3913_ Tile_X0Y5_S4BEG[2] _3913_/A VPWR VGND sg13cmos5l_buf_1
XANTENNA__1894__GATE Tile_X0Y5_FrameStrobe[6] VPWR VGND sg13cmos5l_antennanp
X_3844_ Tile_X0Y5_EE4BEG[1] _3844_/A VPWR VGND sg13cmos5l_buf_1
XFILLER_80_0 VPWR VGND sg13cmos5l_decap_8
XFILLER_338_269 VPWR VGND sg13cmos5l_fill_1
XFILLER_285_14 VPWR VGND sg13cmos5l_decap_8
X_3775_ Tile_X0Y4_EE4BEG[13] _3775_/A VPWR VGND sg13cmos5l_buf_1
X_0987_ _0987_/X Tile_X0Y4_W1END[2] Tile_X0Y4_W6END[6] _1013_/X _0689_/X _3052_/Q
+ _3051_/Q VPWR VGND sg13cmos5l_mux4_1
XANTENNA__1203__A2 Tile_X0Y0_W6END[2] VPWR VGND sg13cmos5l_antennanp
XFILLER_157_180 VPWR VGND sg13cmos5l_decap_8
XFILLER_157_191 VPWR VGND sg13cmos5l_fill_2
XFILLER_306_122 VPWR VGND sg13cmos5l_fill_1
X_2726_ _2726_/Q Tile_X0Y3_FrameData[10] Tile_X0Y5_FrameStrobe[6] VPWR VGND sg13cmos5l_dlhq_1
XANTENNA__2798__D Tile_X0Y4_FrameData[18] VPWR VGND sg13cmos5l_antennanp
XFILLER_218_41 VPWR VGND sg13cmos5l_decap_8
X_2657_ _2657_/Q Tile_X0Y3_FrameData[15] Tile_X0Y5_FrameStrobe[4] VPWR VGND sg13cmos5l_dlhq_1
XANTENNA__3824__X Tile_X0Y5_E2BEGb[1] VPWR VGND sg13cmos5l_antennanp
XFILLER_172_172 VPWR VGND sg13cmos5l_decap_8
XFILLER_218_85 VPWR VGND sg13cmos5l_decap_8
X_1608_ _3772_/A Tile_X0Y4_WW4END[5] AXI_M_SOC_RDATA3 _1039_/X _1318_/X _2924_/Q _2923_/Q
+ VPWR VGND sg13cmos5l_mux4_1
XANTENNA__1832__GATE Tile_X0Y5_FrameStrobe[4] VPWR VGND sg13cmos5l_antennanp
X_2588_ _2588_/Q Tile_X0Y3_FrameData[20] Tile_X0Y5_FrameStrobe[2] VPWR VGND sg13cmos5l_dlhq_1
XFILLER_234_51 VPWR VGND sg13cmos5l_decap_8
X_1539_ _1539_/X _1050_/X _0580_/X Tile_X0Y5_N4END[8] Tile_X0Y0_S4END[12] _2567_/Q
+ _2568_/Q VPWR VGND sg13cmos5l_mux4_1
XFILLER_86_123 VPWR VGND sg13cmos5l_fill_1
XFILLER_234_62 VPWR VGND sg13cmos5l_fill_1
XFILLER_86_145 VPWR VGND sg13cmos5l_decap_8
X_3209_ _3209_/Q Tile_X0Y5_FrameData[7] Tile_X0Y5_FrameStrobe[4] VPWR VGND sg13cmos5l_dlhq_1
XANTENNA__1847__GATE Tile_X0Y5_FrameStrobe[4] VPWR VGND sg13cmos5l_antennanp
XFILLER_103_22 VPWR VGND sg13cmos5l_decap_8
XANTENNA__2038__D Tile_X0Y1_FrameData[26] VPWR VGND sg13cmos5l_antennanp
XFILLER_250_61 VPWR VGND sg13cmos5l_decap_8
XANTENNA__1690__A2 Tile_X0Y4_WW4END[14] VPWR VGND sg13cmos5l_antennanp
XFILLER_63_37 VPWR VGND sg13cmos5l_decap_8
XFILLER_42_237 VPWR VGND sg13cmos5l_decap_8
XANTENNA__1877__D Tile_X0Y0_FrameData[11] VPWR VGND sg13cmos5l_antennanp
XFILLER_179_37 VPWR VGND sg13cmos5l_fill_2
XFILLER_242_198 VPWR VGND sg13cmos5l_fill_2
XFILLER_329_225 VPWR VGND sg13cmos5l_fill_1
XFILLER_329_29 VPWR VGND sg13cmos5l_fill_1
XFILLER_329_247 VPWR VGND sg13cmos5l_decap_4
XANTENNA__3447__A Tile_X0Y1_FrameData[15] VPWR VGND sg13cmos5l_antennanp
XFILLER_155_106 VPWR VGND sg13cmos5l_decap_8
XFILLER_155_117 VPWR VGND sg13cmos5l_fill_2
XFILLER_6_105 VPWR VGND sg13cmos5l_fill_2
XFILLER_6_138 VPWR VGND sg13cmos5l_decap_4
XANTENNA__2501__D Tile_X0Y2_FrameData[27] VPWR VGND sg13cmos5l_antennanp
XANTENNA__3734__X Tile_X0Y4_E2BEG[0] VPWR VGND sg13cmos5l_antennanp
XFILLER_128_85 VPWR VGND sg13cmos5l_decap_4
XFILLER_163_194 VPWR VGND sg13cmos5l_fill_1
XFILLER_104_283 VPWR VGND sg13cmos5l_fill_1
XFILLER_144_73 VPWR VGND sg13cmos5l_decap_4
XANTENNA__3332__D Tile_X0Y5_FrameData[30] VPWR VGND sg13cmos5l_antennanp
XFILLER_282_0 VPWR VGND sg13cmos5l_fill_1
XFILLER_280_238 VPWR VGND sg13cmos5l_fill_2
XANTENNA__1787__D Tile_X0Y0_FrameData[5] VPWR VGND sg13cmos5l_antennanp
XANTENNA__3909__X Tile_X0Y5_S2BEGb[6] VPWR VGND sg13cmos5l_antennanp
X_0910_ _0910_/Y _0548_/Y _0599_/X _0909_/Y VPWR VGND sg13cmos5l_o21ai_1
XFILLER_53_70 VPWR VGND sg13cmos5l_decap_8
XANTENNA__0641__A0 Tile_X0Y4_W1END[1] VPWR VGND sg13cmos5l_antennanp
XANTENNA__1433__A2 Tile_X0Y2_W6END[1] VPWR VGND sg13cmos5l_antennanp
XFILLER_186_264 VPWR VGND sg13cmos5l_decap_8
X_1890_ _1890_/Q Tile_X0Y0_FrameData[30] Tile_X0Y5_FrameStrobe[6] VPWR VGND sg13cmos5l_dlhq_1
XANTENNA__1429__X AXI_M_SOC_WDATA29 VPWR VGND sg13cmos5l_antennanp
X_0841_ AXI_M_SOC_ARBURST1 _3330_/Q _0840_/X VPWR VGND sg13cmos5l_nor2b_1
X_3560_ Tile_X0Y0_FrameStrobe_O[11] Tile_X0Y5_FrameStrobe[11] VPWR VGND sg13cmos5l_buf_1
X_0772_ AXI_M_SOC_AWVALID Tile_X0Y1_WW4END[2] Tile_X0Y1_WW4END[10] Tile_X0Y1_W6END[2]
+ _1217_/X _2068_/Q _2067_/Q VPWR VGND sg13cmos5l_mux4_1
XANTENNA__1197__A1 Tile_X0Y0_WW4END[11] VPWR VGND sg13cmos5l_antennanp
X_2511_ _2511_/Q Tile_X0Y2_FrameData[17] Tile_X0Y5_FrameStrobe[8] VPWR VGND sg13cmos5l_dlhq_1
XANTENNA__2411__D Tile_X0Y2_FrameData[21] VPWR VGND sg13cmos5l_antennanp
XANTENNA__3306__GATE Tile_X0Y5_FrameStrobe[7] VPWR VGND sg13cmos5l_antennanp
XANTENNA__3644__X Tile_X0Y0_E2BEG[7] VPWR VGND sg13cmos5l_antennanp
X_3491_ Tile_X0Y1_E6BEG[11] _3491_/A VPWR VGND sg13cmos5l_buf_1
XFILLER_5_160 VPWR VGND sg13cmos5l_decap_8
X_2442_ _2442_/Q Tile_X0Y2_FrameData[22] Tile_X0Y5_FrameStrobe[6] VPWR VGND sg13cmos5l_dlhq_1
XANTENNA__2562__GATE Tile_X0Y5_FrameStrobe[1] VPWR VGND sg13cmos5l_antennanp
X_2373_ _2373_/Q Tile_X0Y2_FrameData[27] Tile_X0Y5_FrameStrobe[4] VPWR VGND sg13cmos5l_dlhq_1
XFILLER_110_231 VPWR VGND sg13cmos5l_decap_4
X_1324_ _3510_/A _1122_/X _0666_/X AXI_M_SOC_RDATA23 AXI_M_SOC_RDATA27 _2164_/Q _2163_/Q
+ VPWR VGND sg13cmos5l_mux4_1
XANTENNA__3242__D Tile_X0Y5_FrameData[6] VPWR VGND sg13cmos5l_antennanp
X_1255_ _3631_/A Tile_X0Y0_W2END[5] AXI_M_SOC_BRESP1 _1147_/X _1045_/X _1868_/Q _1867_/Q
+ VPWR VGND sg13cmos5l_mux4_1
XFILLER_83_137 VPWR VGND sg13cmos5l_decap_8
XANTENNA__2577__GATE Tile_X0Y5_FrameStrobe[2] VPWR VGND sg13cmos5l_antennanp
X_1186_ _1186_/X Tile_X0Y4_W2MID[4] Tile_X0Y4_W2END[4] Tile_X0Y4_W6END[4] _1130_/X
+ _3042_/Q _3041_/Q VPWR VGND sg13cmos5l_mux4_1
XANTENNA__1672__A2 AXI_M_SOC_RDATA0 VPWR VGND sg13cmos5l_antennanp
XFILLER_169_209 VPWR VGND sg13cmos5l_fill_1
XANTENNA__2500__GATE Tile_X0Y5_FrameStrobe[8] VPWR VGND sg13cmos5l_antennanp
XANTENNA__3819__X Tile_X0Y5_E2BEG[4] VPWR VGND sg13cmos5l_antennanp
XFILLER_177_220 VPWR VGND sg13cmos5l_decap_8
XANTENNA__1424__A2 Tile_X0Y2_W6END[6] VPWR VGND sg13cmos5l_antennanp
XFILLER_149_29 VPWR VGND sg13cmos5l_decap_8
XFILLER_177_231 VPWR VGND sg13cmos5l_fill_2
XFILLER_137_128 VPWR VGND sg13cmos5l_decap_8
XFILLER_229_40 VPWR VGND sg13cmos5l_decap_8
XFILLER_296_57 VPWR VGND sg13cmos5l_fill_2
XFILLER_296_79 VPWR VGND sg13cmos5l_decap_8
X_3827_ Tile_X0Y5_E2BEGb[4] _3827_/A VPWR VGND sg13cmos5l_buf_1
XFILLER_326_217 VPWR VGND sg13cmos5l_decap_8
XANTENNA__2515__GATE Tile_X0Y5_FrameStrobe[0] VPWR VGND sg13cmos5l_antennanp
X_3758_ Tile_X0Y4_E6BEG[8] _3758_/A VPWR VGND sg13cmos5l_buf_1
XANTENNA__1188__A1 Tile_X0Y0_W2END[2] VPWR VGND sg13cmos5l_antennanp
XFILLER_145_150 VPWR VGND sg13cmos5l_decap_8
X_2709_ _2709_/Q Tile_X0Y3_FrameData[27] Tile_X0Y5_FrameStrobe[6] VPWR VGND sg13cmos5l_dlhq_1
XANTENNA__1771__GATE Tile_X0Y5_FrameStrobe[2] VPWR VGND sg13cmos5l_antennanp
XANTENNA__2321__D Tile_X0Y2_FrameData[15] VPWR VGND sg13cmos5l_antennanp
XANTENNA__3554__X Tile_X0Y0_FrameStrobe_O[5] VPWR VGND sg13cmos5l_antennanp
XFILLER_109_8 VPWR VGND sg13cmos5l_decap_8
X_3689_ Tile_X0Y3_EE4BEG[8] _3689_/A VPWR VGND sg13cmos5l_buf_1
XFILLER_59_145 VPWR VGND sg13cmos5l_decap_8
XFILLER_58_48 VPWR VGND sg13cmos5l_decap_8
XANTENNA__1786__GATE Tile_X0Y5_FrameStrobe[2] VPWR VGND sg13cmos5l_antennanp
XFILLER_247_257 VPWR VGND sg13cmos5l_decap_4
XANTENNA__3152__D Tile_X0Y5_FrameData[0] VPWR VGND sg13cmos5l_antennanp
XFILLER_74_14 VPWR VGND sg13cmos5l_decap_4
XANTENNA__1112__A1 Tile_X0Y3_W2END[0] VPWR VGND sg13cmos5l_antennanp
XFILLER_74_36 VPWR VGND sg13cmos5l_decap_8
XANTENNA__2991__D Tile_X0Y4_FrameData[17] VPWR VGND sg13cmos5l_antennanp
XFILLER_15_259 VPWR VGND sg13cmos5l_fill_1
XANTENNA__3729__X Tile_X0Y3_UserCLKo VPWR VGND sg13cmos5l_antennanp
XFILLER_270_293 VPWR VGND sg13cmos5l_fill_2
XFILLER_30_207 VPWR VGND sg13cmos5l_decap_4
XFILLER_90_46 VPWR VGND sg13cmos5l_decap_8
XANTENNA__0623__A0 Tile_X0Y1_W1END[1] VPWR VGND sg13cmos5l_antennanp
XANTENNA__1415__A2 Tile_X0Y2_W6END[3] VPWR VGND sg13cmos5l_antennanp
XANTENNA__1724__GATE Tile_X0Y5_FrameStrobe[0] VPWR VGND sg13cmos5l_antennanp
XFILLER_168_275 VPWR VGND sg13cmos5l_fill_2
XFILLER_128_0 VPWR VGND sg13cmos5l_fill_2
XFILLER_99_11 VPWR VGND sg13cmos5l_fill_2
XANTENNA__1739__GATE Tile_X0Y5_FrameStrobe[1] VPWR VGND sg13cmos5l_antennanp
XANTENNA__2231__D Tile_X0Y1_FrameData[25] VPWR VGND sg13cmos5l_antennanp
XANTENNA__3327__D Tile_X0Y5_FrameData[17] VPWR VGND sg13cmos5l_antennanp
XANTENNA__3464__X Tile_X0Y1_EE4BEG[0] VPWR VGND sg13cmos5l_antennanp
XFILLER_151_120 VPWR VGND sg13cmos5l_decap_4
XFILLER_325_272 VPWR VGND sg13cmos5l_fill_1
XFILLER_151_142 VPWR VGND sg13cmos5l_decap_8
XFILLER_151_175 VPWR VGND sg13cmos5l_decap_8
XFILLER_305_20 VPWR VGND sg13cmos5l_fill_1
XANTENNA__3292__GATE Tile_X0Y5_FrameStrobe[7] VPWR VGND sg13cmos5l_antennanp
XFILLER_297_179 VPWR VGND sg13cmos5l_fill_2
XANTENNA__3062__D Tile_X0Y5_FrameData[26] VPWR VGND sg13cmos5l_antennanp
XFILLER_241_19 VPWR VGND sg13cmos5l_fill_1
XANTENNA__1103__A1 Tile_X0Y2_W2END[6] VPWR VGND sg13cmos5l_antennanp
X_1040_ _1040_/X _1023_/X _0635_/X Tile_X0Y5_N4END[5] _1028_/X _2821_/Q _2822_/Q VPWR
+ VGND sg13cmos5l_mux4_1
XANTENNA__1654__A2 Tile_X0Y4_W6END[6] VPWR VGND sg13cmos5l_antennanp
XFILLER_206_176 VPWR VGND sg13cmos5l_decap_8
XANTENNA__2406__D Tile_X0Y2_FrameData[26] VPWR VGND sg13cmos5l_antennanp
XANTENNA__3639__X Tile_X0Y0_E2BEG[2] VPWR VGND sg13cmos5l_antennanp
XFILLER_221_124 VPWR VGND sg13cmos5l_decap_8
XFILLER_221_135 VPWR VGND sg13cmos5l_fill_2
XFILLER_261_293 VPWR VGND sg13cmos5l_fill_2
X_2991_ _2991_/Q Tile_X0Y4_FrameData[17] Tile_X0Y5_FrameStrobe[6] VPWR VGND sg13cmos5l_dlhq_1
XANTENNA__3230__GATE Tile_X0Y5_FrameStrobe[5] VPWR VGND sg13cmos5l_antennanp
XFILLER_159_231 VPWR VGND sg13cmos5l_fill_2
X_1942_ _1942_/Q Tile_X0Y0_FrameData[10] Tile_X0Y5_FrameStrobe[7] VPWR VGND sg13cmos5l_dlhq_1
XFILLER_119_117 VPWR VGND sg13cmos5l_decap_4
XFILLER_159_264 VPWR VGND sg13cmos5l_fill_2
XFILLER_159_275 VPWR VGND sg13cmos5l_fill_2
XFILLER_308_217 VPWR VGND sg13cmos5l_fill_2
X_1873_ _1873_/Q Tile_X0Y0_FrameData[15] Tile_X0Y5_FrameStrobe[5] VPWR VGND sg13cmos5l_dlhq_1
X_3612_ Tile_X0Y0_EE4BEG[11] _3612_/A VPWR VGND sg13cmos5l_buf_1
X_0824_ _3831_/A Tile_X0Y5_N4END[0] _0742_/X _0595_/X _0740_/X _3183_/Q _3184_/Q VPWR
+ VGND sg13cmos5l_mux4_1
XANTENNA__3245__GATE Tile_X0Y5_FrameStrobe[5] VPWR VGND sg13cmos5l_antennanp
XFILLER_127_150 VPWR VGND sg13cmos5l_decap_8
XFILLER_266_49 VPWR VGND sg13cmos5l_fill_1
XANTENNA__2141__D Tile_X0Y1_FrameData[19] VPWR VGND sg13cmos5l_antennanp
XANTENNA__3237__D Tile_X0Y5_FrameData[11] VPWR VGND sg13cmos5l_antennanp
XANTENNA__3374__X Tile_X0Y2_E6BEG[4] VPWR VGND sg13cmos5l_antennanp
X_3543_ Tile_X0Y0_N2BEG[6] _3543_/A VPWR VGND sg13cmos5l_buf_1
X_0755_ _0755_/X Tile_X0Y5_WW4END[3] Tile_X0Y5_W6END[3] Tile_X0Y5_WW4END[11] _0743_/X
+ _3153_/Q _3154_/Q VPWR VGND sg13cmos5l_mux4_1
X_3474_ Tile_X0Y1_EE4BEG[10] _3474_/A VPWR VGND sg13cmos5l_buf_1
X_0686_ _0688_/B Tile_X0Y4_W6END[2] _2788_/Q VPWR VGND sg13cmos5l_nor2b_1
XFILLER_43_0 VPWR VGND sg13cmos5l_fill_2
XANTENNA__1980__D Tile_X0Y1_FrameData[20] VPWR VGND sg13cmos5l_antennanp
XFILLER_142_186 VPWR VGND sg13cmos5l_decap_8
XFILLER_288_146 VPWR VGND sg13cmos5l_decap_8
X_2425_ _2425_/Q Tile_X0Y2_FrameData[7] Tile_X0Y5_FrameStrobe[5] VPWR VGND sg13cmos5l_dlhq_1
XFILLER_88_218 VPWR VGND sg13cmos5l_decap_8
XFILLER_215_53 VPWR VGND sg13cmos5l_decap_8
XFILLER_296_190 VPWR VGND sg13cmos5l_decap_8
X_2356_ _2356_/Q Tile_X0Y2_FrameData[12] Tile_X0Y5_FrameStrobe[3] VPWR VGND sg13cmos5l_dlhq_1
XFILLER_96_273 VPWR VGND sg13cmos5l_decap_4
XANTENNA__3550__A Tile_X0Y5_FrameStrobe[1] VPWR VGND sg13cmos5l_antennanp
X_2287_ _2287_/Q Tile_X0Y2_FrameData[17] Tile_X0Y5_FrameStrobe[1] VPWR VGND sg13cmos5l_dlhq_1
X_1307_ AXI_M_SOC_AWADDR3 Tile_X0Y1_W2MID[3] Tile_X0Y1_W2END[3] Tile_X0Y1_W6END[3]
+ _1094_/X _2034_/Q _2033_/Q VPWR VGND sg13cmos5l_mux4_1
X_1238_ _3628_/A AXI_M_SOC_AWREADY _1068_/X _1075_/X _1136_/X _1801_/Q _1802_/Q VPWR
+ VGND sg13cmos5l_mux4_1
XANTENNA__1645__A2 Tile_X0Y4_W6END[7] VPWR VGND sg13cmos5l_antennanp
X_1169_ _3525_/A _1168_/X _1167_/X _1943_/Q VPWR VGND sg13cmos5l_mux2_1
XANTENNA__2316__D Tile_X0Y2_FrameData[20] VPWR VGND sg13cmos5l_antennanp
XANTENNA__3549__X Tile_X0Y0_FrameStrobe_O[0] VPWR VGND sg13cmos5l_antennanp
XFILLER_252_293 VPWR VGND sg13cmos5l_fill_2
XANTENNA__0605__A0 Tile_X0Y4_W1END[0] VPWR VGND sg13cmos5l_antennanp
XANTENNA__2454__GATE Tile_X0Y5_FrameStrobe[6] VPWR VGND sg13cmos5l_antennanp
XFILLER_100_67 VPWR VGND sg13cmos5l_decap_8
XFILLER_60_27 VPWR VGND sg13cmos5l_decap_8
XFILLER_60_38 VPWR VGND sg13cmos5l_fill_1
XFILLER_314_209 VPWR VGND sg13cmos5l_decap_8
XANTENNA__2051__D Tile_X0Y1_FrameData[13] VPWR VGND sg13cmos5l_antennanp
XANTENNA__3147__D Tile_X0Y5_FrameData[5] VPWR VGND sg13cmos5l_antennanp
XANTENNA__3725__A Tile_X0Y3_FrameData[28] VPWR VGND sg13cmos5l_antennanp
XFILLER_69_14 VPWR VGND sg13cmos5l_fill_1
XANTENNA__1030__A0 Tile_X0Y4_W1END[1] VPWR VGND sg13cmos5l_antennanp
XANTENNA__2469__GATE Tile_X0Y5_FrameStrobe[7] VPWR VGND sg13cmos5l_antennanp
XFILLER_69_25 VPWR VGND sg13cmos5l_decap_8
XANTENNA__1890__D Tile_X0Y0_FrameData[30] VPWR VGND sg13cmos5l_antennanp
XANTENNA__2986__D Tile_X0Y4_FrameData[22] VPWR VGND sg13cmos5l_antennanp
XFILLER_133_153 VPWR VGND sg13cmos5l_decap_8
XFILLER_133_186 VPWR VGND sg13cmos5l_decap_8
XFILLER_322_275 VPWR VGND sg13cmos5l_fill_2
XFILLER_125_31 VPWR VGND sg13cmos5l_decap_8
XANTENNA__1333__A1 AXI_M_SOC_RDATA26 VPWR VGND sg13cmos5l_antennanp
XANTENNA__3460__A Tile_X0Y1_FrameData[28] VPWR VGND sg13cmos5l_antennanp
XFILLER_85_46 VPWR VGND sg13cmos5l_decap_8
XFILLER_47_137 VPWR VGND sg13cmos5l_fill_2
XANTENNA__1097__A0 Tile_X0Y2_W2MID[5] VPWR VGND sg13cmos5l_antennanp
XANTENNA__2407__GATE Tile_X0Y5_FrameStrobe[5] VPWR VGND sg13cmos5l_antennanp
XFILLER_141_63 VPWR VGND sg13cmos5l_decap_8
XFILLER_18_95 VPWR VGND sg13cmos5l_fill_1
XANTENNA__0844__A0 Tile_X0Y5_W1END[2] VPWR VGND sg13cmos5l_antennanp
XANTENNA__1636__A2 Tile_X0Y4_WW4END[8] VPWR VGND sg13cmos5l_antennanp
XFILLER_203_113 VPWR VGND sg13cmos5l_decap_4
XANTENNA__3459__X Tile_X0Y1_FrameData_O[27] VPWR VGND sg13cmos5l_antennanp
XFILLER_243_293 VPWR VGND sg13cmos5l_fill_2
XFILLER_245_0 VPWR VGND sg13cmos5l_fill_2
XANTENNA__2226__D Tile_X0Y1_FrameData[30] VPWR VGND sg13cmos5l_antennanp
XFILLER_34_50 VPWR VGND sg13cmos5l_decap_8
XFILLER_11_240 VPWR VGND sg13cmos5l_fill_1
XFILLER_34_83 VPWR VGND sg13cmos5l_decap_8
XFILLER_7_255 VPWR VGND sg13cmos5l_decap_8
XANTENNA__3057__D Tile_X0Y4_FrameData[31] VPWR VGND sg13cmos5l_antennanp
XFILLER_109_172 VPWR VGND sg13cmos5l_decap_8
XFILLER_236_19 VPWR VGND sg13cmos5l_decap_8
X_0540_ _0540_/Y Tile_X0Y0_S1END[3] VPWR VGND sg13cmos5l_inv_1
XANTENNA__1572__A1 Tile_X0Y3_WW4END[12] VPWR VGND sg13cmos5l_antennanp
XANTENNA__2896__D Tile_X0Y4_FrameData[16] VPWR VGND sg13cmos5l_antennanp
XFILLER_124_175 VPWR VGND sg13cmos5l_decap_8
XANTENNA__3922__X Tile_X0Y5_S4BEG[11] VPWR VGND sg13cmos5l_antennanp
X_2210_ _2210_/Q Tile_X0Y1_FrameData[14] Tile_X0Y5_FrameStrobe[7] VPWR VGND sg13cmos5l_dlhq_1
X_3190_ _3190_/Q Tile_X0Y5_FrameData[26] Tile_X0Y5_FrameStrobe[4] VPWR VGND sg13cmos5l_dlhq_1
X_2141_ _2141_/Q Tile_X0Y1_FrameData[19] Tile_X0Y5_FrameStrobe[5] VPWR VGND sg13cmos5l_dlhq_1
X_2072_ _2072_/Q Tile_X0Y1_FrameData[24] Tile_X0Y5_FrameStrobe[3] VPWR VGND sg13cmos5l_dlhq_1
XANTENNA__1088__A0 Tile_X0Y0_W1END[0] VPWR VGND sg13cmos5l_antennanp
X_1023_ _1023_/X Tile_X0Y5_W1END[1] _0645_/X Tile_X0Y5_W6END[5] _1022_/Y _3325_/Q
+ _3326_/Q VPWR VGND sg13cmos5l_mux4_1
XANTENNA__0835__A0 AXI_M_SOC_RLAST VPWR VGND sg13cmos5l_antennanp
XFILLER_201_22 VPWR VGND sg13cmos5l_decap_8
XANTENNA__3369__X Tile_X0Y2_E2BEGb[7] VPWR VGND sg13cmos5l_antennanp
XFILLER_234_293 VPWR VGND sg13cmos5l_fill_2
XANTENNA__2136__D Tile_X0Y1_FrameData[24] VPWR VGND sg13cmos5l_antennanp
XFILLER_201_66 VPWR VGND sg13cmos5l_decap_8
X_2974_ _2974_/Q Tile_X0Y4_FrameData[2] Tile_X0Y5_FrameStrobe[5] VPWR VGND sg13cmos5l_dlhq_1
X_1925_ _1925_/Q Tile_X0Y0_FrameData[27] Tile_X0Y5_FrameStrobe[7] VPWR VGND sg13cmos5l_dlhq_1
XANTENNA__1260__A0 Tile_X0Y0_W2MID[1] VPWR VGND sg13cmos5l_antennanp
XANTENNA__1975__D Tile_X0Y1_FrameData[25] VPWR VGND sg13cmos5l_antennanp
XANTENNA__3184__GATE Tile_X0Y5_FrameStrobe[3] VPWR VGND sg13cmos5l_antennanp
X_1856_ _1856_/Q Tile_X0Y0_FrameData[0] Tile_X0Y5_FrameStrobe[4] VPWR VGND sg13cmos5l_dlhq_1
X_1787_ _1787_/Q Tile_X0Y0_FrameData[5] Tile_X0Y5_FrameStrobe[2] VPWR VGND sg13cmos5l_dlhq_1
X_0807_ _3830_/A Tile_X0Y5_W2END[0] _0775_/X _0782_/X _0563_/X _3218_/Q _3217_/Q VPWR
+ VGND sg13cmos5l_mux4_1
XFILLER_293_69 VPWR VGND sg13cmos5l_decap_8
XFILLER_304_220 VPWR VGND sg13cmos5l_decap_8
X_3526_ Tile_X0Y0_N4BEG[13] _3526_/A VPWR VGND sg13cmos5l_buf_1
X_0738_ _0738_/X Tile_X0Y1_W1END[3] _0944_/X Tile_X0Y1_WW4END[15] _0956_/X _2169_/Q
+ _2171_/Q VPWR VGND sg13cmos5l_mux4_1
XANTENNA__1563__A1 Tile_X0Y3_W2END[6] VPWR VGND sg13cmos5l_antennanp
XANTENNA__3199__GATE Tile_X0Y5_FrameStrobe[4] VPWR VGND sg13cmos5l_antennanp
XFILLER_115_164 VPWR VGND sg13cmos5l_decap_4
XFILLER_115_175 VPWR VGND sg13cmos5l_fill_1
XANTENNA__3832__X Tile_X0Y5_E6BEG[1] VPWR VGND sg13cmos5l_antennanp
XFILLER_130_112 VPWR VGND sg13cmos5l_decap_4
XFILLER_130_134 VPWR VGND sg13cmos5l_decap_8
X_3457_ Tile_X0Y1_FrameData_O[25] Tile_X0Y1_FrameData[25] VPWR VGND sg13cmos5l_buf_1
X_0669_ _0670_/C _1972_/Q _1122_/X VPWR VGND sg13cmos5l_nor2_1
XFILLER_162_29 VPWR VGND sg13cmos5l_decap_4
X_2408_ _2408_/Q Tile_X0Y2_FrameData[24] Tile_X0Y5_FrameStrobe[5] VPWR VGND sg13cmos5l_dlhq_1
X_3388_ Tile_X0Y2_EE4BEG[6] _3388_/A VPWR VGND sg13cmos5l_buf_1
XANTENNA__3122__GATE Tile_X0Y5_FrameStrobe[2] VPWR VGND sg13cmos5l_antennanp
X_2339_ _2339_/Q Tile_X0Y2_FrameData[29] Tile_X0Y5_FrameStrobe[3] VPWR VGND sg13cmos5l_dlhq_1
XFILLER_217_227 VPWR VGND sg13cmos5l_decap_4
XFILLER_284_182 VPWR VGND sg13cmos5l_fill_1
XANTENNA__1079__A0 Tile_X0Y1_W1END[0] VPWR VGND sg13cmos5l_antennanp
XFILLER_55_49 VPWR VGND sg13cmos5l_decap_8
XANTENNA__0826__A0 Tile_X0Y5_N4END[2] VPWR VGND sg13cmos5l_antennanp
XANTENNA__3137__GATE Tile_X0Y5_FrameStrobe[2] VPWR VGND sg13cmos5l_antennanp
XFILLER_111_22 VPWR VGND sg13cmos5l_decap_8
XANTENNA__1094__A3 Tile_X0Y0_S2MID[3] VPWR VGND sg13cmos5l_antennanp
XFILLER_225_282 VPWR VGND sg13cmos5l_fill_2
XFILLER_225_293 VPWR VGND sg13cmos5l_fill_2
XANTENNA__2046__D Tile_X0Y1_FrameData[18] VPWR VGND sg13cmos5l_antennanp
XFILLER_240_252 VPWR VGND sg13cmos5l_fill_1
XANTENNA__2393__GATE Tile_X0Y5_FrameStrobe[4] VPWR VGND sg13cmos5l_antennanp
XFILLER_200_116 VPWR VGND sg13cmos5l_decap_8
XANTENNA__1251__A0 Tile_X0Y0_W2MID[6] VPWR VGND sg13cmos5l_antennanp
XANTENNA__1885__D Tile_X0Y0_FrameData[3] VPWR VGND sg13cmos5l_antennanp
XFILLER_153_204 VPWR VGND sg13cmos5l_fill_1
XFILLER_153_226 VPWR VGND sg13cmos5l_fill_1
XANTENNA__3455__A Tile_X0Y1_FrameData[23] VPWR VGND sg13cmos5l_antennanp
XFILLER_106_131 VPWR VGND sg13cmos5l_decap_8
XANTENNA__1554__A1 Tile_X0Y3_WW4END[12] VPWR VGND sg13cmos5l_antennanp
XFILLER_161_270 VPWR VGND sg13cmos5l_fill_1
XANTENNA__2331__GATE Tile_X0Y5_FrameStrobe[2] VPWR VGND sg13cmos5l_antennanp
XANTENNA__3742__X Tile_X0Y4_E2BEGb[0] VPWR VGND sg13cmos5l_antennanp
XANTENNA__2961__GATE Tile_X0Y5_FrameStrobe[5] VPWR VGND sg13cmos5l_antennanp
XFILLER_136_96 VPWR VGND sg13cmos5l_decap_8
XFILLER_96_56 VPWR VGND sg13cmos5l_decap_4
XFILLER_121_189 VPWR VGND sg13cmos5l_fill_2
XFILLER_152_40 VPWR VGND sg13cmos5l_fill_1
XFILLER_208_205 VPWR VGND sg13cmos5l_fill_2
XFILLER_152_51 VPWR VGND sg13cmos5l_decap_8
XFILLER_29_72 VPWR VGND sg13cmos5l_decap_4
XANTENNA__2346__GATE Tile_X0Y5_FrameStrobe[3] VPWR VGND sg13cmos5l_antennanp
XANTENNA__2976__GATE Tile_X0Y5_FrameStrobe[5] VPWR VGND sg13cmos5l_antennanp
XANTENNA__3340__D Tile_X0Y5_FrameData[6] VPWR VGND sg13cmos5l_antennanp
XFILLER_223_219 VPWR VGND sg13cmos5l_fill_1
XFILLER_290_152 VPWR VGND sg13cmos5l_fill_2
XANTENNA__0817__A0 Tile_X0Y5_WW4END[6] VPWR VGND sg13cmos5l_antennanp
XFILLER_216_282 VPWR VGND sg13cmos5l_fill_2
XFILLER_216_293 VPWR VGND sg13cmos5l_fill_2
XFILLER_231_263 VPWR VGND sg13cmos5l_fill_2
XFILLER_91_8 VPWR VGND sg13cmos5l_decap_4
XFILLER_188_167 VPWR VGND sg13cmos5l_fill_2
XFILLER_231_285 VPWR VGND sg13cmos5l_fill_2
XANTENNA__1795__D Tile_X0Y0_FrameData[29] VPWR VGND sg13cmos5l_antennanp
XANTENNA__3917__X Tile_X0Y5_S4BEG[6] VPWR VGND sg13cmos5l_antennanp
X_2690_ _2690_/Q Tile_X0Y3_FrameData[14] Tile_X0Y5_FrameStrobe[5] VPWR VGND sg13cmos5l_dlhq_1
X_1710_ _1710_/Q Tile_X0Y0_FrameData[18] Tile_X0Y5_FrameStrobe[0] VPWR VGND sg13cmos5l_dlhq_1
XFILLER_61_92 VPWR VGND sg13cmos5l_decap_8
XANTENNA_3 Tile_X0Y5_N4END[6] VPWR VGND sg13cmos5l_antennanp
XANTENNA__2914__GATE Tile_X0Y5_FrameStrobe[4] VPWR VGND sg13cmos5l_antennanp
X_1641_ AXI_M_SOC_ARADDR4 Tile_X0Y4_WW4END[4] Tile_X0Y4_WW4END[12] Tile_X0Y4_W6END[4]
+ _1062_/X _2880_/Q _2879_/Q VPWR VGND sg13cmos5l_mux4_1
X_3311_ _3311_/Q Tile_X0Y5_FrameData[1] Tile_X0Y5_FrameStrobe[7] VPWR VGND sg13cmos5l_dlhq_1
X_1572_ _1573_/B Tile_X0Y3_W1END[0] Tile_X0Y3_WW4END[12] Tile_X0Y3_W6END[4] _1539_/X
+ _2724_/Q _2723_/Q VPWR VGND sg13cmos5l_mux4_1
XANTENNA__3652__X Tile_X0Y3_E1BEG[3] VPWR VGND sg13cmos5l_antennanp
XFILLER_112_112 VPWR VGND sg13cmos5l_decap_8
XANTENNA__2929__GATE Tile_X0Y5_FrameStrobe[4] VPWR VGND sg13cmos5l_antennanp
X_3242_ _3242_/Q Tile_X0Y5_FrameData[6] Tile_X0Y5_FrameStrobe[5] VPWR VGND sg13cmos5l_dlhq_1
X_3173_ _3173_/Q Tile_X0Y5_FrameData[11] Tile_X0Y5_FrameStrobe[3] VPWR VGND sg13cmos5l_dlhq_1
X_2124_ _2124_/Q Tile_X0Y1_FrameData[4] Tile_X0Y5_FrameStrobe[4] VPWR VGND sg13cmos5l_dlhq_1
XANTENNA__3250__D Tile_X0Y5_FrameData[30] VPWR VGND sg13cmos5l_antennanp
X_2055_ _2055_/Q Tile_X0Y1_FrameData[9] Tile_X0Y5_FrameStrobe[2] VPWR VGND sg13cmos5l_dlhq_1
XANTENNA__0808__A0 Tile_X0Y5_WW4END[15] VPWR VGND sg13cmos5l_antennanp
XFILLER_207_282 VPWR VGND sg13cmos5l_fill_2
XFILLER_207_293 VPWR VGND sg13cmos5l_fill_2
XFILLER_288_14 VPWR VGND sg13cmos5l_fill_2
X_1006_ _1006_/X _1024_/X _1003_/X Tile_X0Y0_S1END[2] Tile_X0Y0_S4END[2] _1724_/Q
+ _1723_/Q VPWR VGND sg13cmos5l_mux4_1
XFILLER_81_257 VPWR VGND sg13cmos5l_decap_8
XFILLER_34_151 VPWR VGND sg13cmos5l_decap_8
XFILLER_222_230 VPWR VGND sg13cmos5l_decap_8
XFILLER_222_241 VPWR VGND sg13cmos5l_fill_2
XFILLER_222_274 VPWR VGND sg13cmos5l_fill_1
XFILLER_222_285 VPWR VGND sg13cmos5l_fill_2
XFILLER_34_195 VPWR VGND sg13cmos5l_decap_8
XANTENNA__1233__A0 Tile_X0Y0_WW4END[4] VPWR VGND sg13cmos5l_antennanp
XANTENNA__3827__X Tile_X0Y5_E2BEGb[4] VPWR VGND sg13cmos5l_antennanp
X_2957_ _2957_/Q Tile_X0Y4_FrameData[19] Tile_X0Y5_FrameStrobe[5] VPWR VGND sg13cmos5l_dlhq_1
X_2888_ _2888_/Q Tile_X0Y4_FrameData[24] Tile_X0Y5_FrameStrobe[3] VPWR VGND sg13cmos5l_dlhq_1
X_1908_ _1908_/Q Tile_X0Y0_FrameData[12] Tile_X0Y5_FrameStrobe[6] VPWR VGND sg13cmos5l_dlhq_1
X_1839_ _1839_/Q Tile_X0Y0_FrameData[17] Tile_X0Y5_FrameStrobe[4] VPWR VGND sg13cmos5l_dlhq_1
XFILLER_135_259 VPWR VGND sg13cmos5l_fill_1
XFILLER_150_207 VPWR VGND sg13cmos5l_decap_8
XANTENNA__3562__X Tile_X0Y0_FrameStrobe_O[13] VPWR VGND sg13cmos5l_antennanp
X_3509_ Tile_X0Y1_E1BEG[1] _3509_/A VPWR VGND sg13cmos5l_buf_1
XANTENNA__3061__GATE Tile_X0Y5_FrameStrobe[0] VPWR VGND sg13cmos5l_antennanp
XFILLER_66_15 VPWR VGND sg13cmos5l_decap_8
XFILLER_286_7 VPWR VGND sg13cmos5l_decap_8
XFILLER_66_48 VPWR VGND sg13cmos5l_decap_8
XFILLER_57_254 VPWR VGND sg13cmos5l_fill_1
XFILLER_57_265 VPWR VGND sg13cmos5l_fill_1
XANTENNA__3076__GATE Tile_X0Y5_FrameStrobe[0] VPWR VGND sg13cmos5l_antennanp
XANTENNA__3160__D Tile_X0Y5_FrameData[24] VPWR VGND sg13cmos5l_antennanp
XFILLER_272_152 VPWR VGND sg13cmos5l_fill_2
XFILLER_82_36 VPWR VGND sg13cmos5l_decap_8
XANTENNA__1472__A0 Tile_X0Y2_WW4END[6] VPWR VGND sg13cmos5l_antennanp
XFILLER_198_36 VPWR VGND sg13cmos5l_decap_8
XFILLER_15_52 VPWR VGND sg13cmos5l_decap_8
XANTENNA__3737__X Tile_X0Y4_E2BEG[3] VPWR VGND sg13cmos5l_antennanp
XFILLER_278_80 VPWR VGND sg13cmos5l_fill_2
XANTENNA__1224__A0 Tile_X0Y0_WW4END[13] VPWR VGND sg13cmos5l_antennanp
XANTENNA__2504__D Tile_X0Y2_FrameData[24] VPWR VGND sg13cmos5l_antennanp
XFILLER_40_198 VPWR VGND sg13cmos5l_fill_1
XFILLER_40_187 VPWR VGND sg13cmos5l_decap_8
XANTENNA__3014__GATE Tile_X0Y5_FrameStrobe[7] VPWR VGND sg13cmos5l_antennanp
XFILLER_126_226 VPWR VGND sg13cmos5l_decap_8
XFILLER_31_62 VPWR VGND sg13cmos5l_decap_8
XFILLER_208_0 VPWR VGND sg13cmos5l_fill_2
XFILLER_31_73 VPWR VGND sg13cmos5l_fill_1
XANTENNA__1527__A1 AXI_M_SOC_RDATA9 VPWR VGND sg13cmos5l_antennanp
XANTENNA__2270__GATE Tile_X0Y5_FrameStrobe[0] VPWR VGND sg13cmos5l_antennanp
XFILLER_141_207 VPWR VGND sg13cmos5l_fill_1
XFILLER_147_73 VPWR VGND sg13cmos5l_decap_8
XANTENNA__3335__D Tile_X0Y5_FrameData[1] VPWR VGND sg13cmos5l_antennanp
XANTENNA__3472__X Tile_X0Y1_EE4BEG[8] VPWR VGND sg13cmos5l_antennanp
XANTENNA__3029__GATE Tile_X0Y5_FrameStrobe[7] VPWR VGND sg13cmos5l_antennanp
XFILLER_163_50 VPWR VGND sg13cmos5l_decap_4
XANTENNA__2285__GATE Tile_X0Y5_FrameStrobe[1] VPWR VGND sg13cmos5l_antennanp
XFILLER_163_94 VPWR VGND sg13cmos5l_decap_8
XANTENNA__3070__D Tile_X0Y5_FrameData[18] VPWR VGND sg13cmos5l_antennanp
XFILLER_313_97 VPWR VGND sg13cmos5l_fill_2
XANTENNA__1058__A3 Tile_X0Y0_S4END[8] VPWR VGND sg13cmos5l_antennanp
XANTENNA__1463__A0 Tile_X0Y2_W2END[0] VPWR VGND sg13cmos5l_antennanp
X_3860_ Tile_X0Y5_FrameData_O[1] Tile_X0Y5_FrameData[1] VPWR VGND sg13cmos5l_buf_1
XFILLER_31_143 VPWR VGND sg13cmos5l_decap_8
XANTENNA__2223__GATE Tile_X0Y5_FrameStrobe[7] VPWR VGND sg13cmos5l_antennanp
XFILLER_176_137 VPWR VGND sg13cmos5l_fill_1
X_2811_ _2811_/Q Tile_X0Y4_FrameData[5] Tile_X0Y5_FrameStrobe[0] VPWR VGND sg13cmos5l_dlhq_1
X_3791_ Tile_X0Y4_FrameData_O[13] Tile_X0Y4_FrameData[13] VPWR VGND sg13cmos5l_buf_1
XFILLER_82_4 VPWR VGND sg13cmos5l_fill_1
XANTENNA__2414__D Tile_X0Y2_FrameData[18] VPWR VGND sg13cmos5l_antennanp
XANTENNA__2853__GATE Tile_X0Y5_FrameStrobe[2] VPWR VGND sg13cmos5l_antennanp
XANTENNA__3647__X Tile_X0Y0_E1BEG[2] VPWR VGND sg13cmos5l_antennanp
X_2742_ _2742_/Q Tile_X0Y3_FrameData[26] Tile_X0Y5_FrameStrobe[7] VPWR VGND sg13cmos5l_dlhq_1
XFILLER_117_204 VPWR VGND sg13cmos5l_decap_8
XFILLER_318_164 VPWR VGND sg13cmos5l_fill_2
X_2673_ _2673_/Q Tile_X0Y3_FrameData[31] Tile_X0Y5_FrameStrobe[5] VPWR VGND sg13cmos5l_dlhq_1
XFILLER_333_123 VPWR VGND sg13cmos5l_fill_1
XANTENNA__1518__A1 AXI_M_SOC_RDATA6 VPWR VGND sg13cmos5l_antennanp
XANTENNA__2238__GATE Tile_X0Y5_FrameStrobe[8] VPWR VGND sg13cmos5l_antennanp
XFILLER_132_207 VPWR VGND sg13cmos5l_decap_8
X_1624_ _3760_/A AXI_M_SOC_RDATA4 _1039_/X _1029_/X _1360_/X _2891_/Q _2892_/Q VPWR
+ VGND sg13cmos5l_mux4_1
XANTENNA__2868__GATE Tile_X0Y5_FrameStrobe[2] VPWR VGND sg13cmos5l_antennanp
XANTENNA__3245__D Tile_X0Y5_FrameData[3] VPWR VGND sg13cmos5l_antennanp
XANTENNA__3382__X Tile_X0Y2_EE4BEG[0] VPWR VGND sg13cmos5l_antennanp
XFILLER_125_270 VPWR VGND sg13cmos5l_fill_2
X_1555_ AXI_M_SOC_WDATA4 Tile_X0Y3_W2MID[4] Tile_X0Y3_W2END[4] Tile_X0Y3_W6END[4]
+ _1271_/X _2576_/Q _2575_/Q VPWR VGND sg13cmos5l_mux4_1
XFILLER_98_121 VPWR VGND sg13cmos5l_decap_8
XFILLER_246_108 VPWR VGND sg13cmos5l_decap_8
XFILLER_286_255 VPWR VGND sg13cmos5l_decap_4
XFILLER_286_277 VPWR VGND sg13cmos5l_fill_2
X_3225_ _3225_/Q Tile_X0Y5_FrameData[23] Tile_X0Y5_FrameStrobe[5] VPWR VGND sg13cmos5l_dlhq_1
X_1486_ _1486_/Y _2443_/Q _0552_/Y _2442_/Q VPWR VGND sg13cmos5l_o21ai_1
XFILLER_39_221 VPWR VGND sg13cmos5l_fill_2
X_3156_ _3156_/Q Tile_X0Y5_FrameData[28] Tile_X0Y5_FrameStrobe[3] VPWR VGND sg13cmos5l_dlhq_1
XFILLER_54_202 VPWR VGND sg13cmos5l_fill_1
XFILLER_39_276 VPWR VGND sg13cmos5l_fill_2
XFILLER_39_265 VPWR VGND sg13cmos5l_decap_8
XFILLER_36_18 VPWR VGND sg13cmos5l_fill_2
X_3087_ _3087_/Q Tile_X0Y5_FrameData[1] Tile_X0Y5_FrameStrobe[0] VPWR VGND sg13cmos5l_dlhq_1
X_2107_ _2107_/Q Tile_X0Y1_FrameData[21] Tile_X0Y5_FrameStrobe[4] VPWR VGND sg13cmos5l_dlhq_1
XFILLER_54_235 VPWR VGND sg13cmos5l_decap_4
XANTENNA__2806__GATE Tile_X0Y5_FrameStrobe[0] VPWR VGND sg13cmos5l_antennanp
X_2038_ _2038_/Q Tile_X0Y1_FrameData[26] Tile_X0Y5_FrameStrobe[2] VPWR VGND sg13cmos5l_dlhq_1
XANTENNA__1454__A0 Tile_X0Y2_W2MID[6] VPWR VGND sg13cmos5l_antennanp
XFILLER_22_110 VPWR VGND sg13cmos5l_decap_8
XFILLER_52_28 VPWR VGND sg13cmos5l_decap_8
XFILLER_167_126 VPWR VGND sg13cmos5l_decap_8
XANTENNA__1206__A0 Tile_X0Y0_W2MID[5] VPWR VGND sg13cmos5l_antennanp
XANTENNA__2324__D Tile_X0Y2_FrameData[12] VPWR VGND sg13cmos5l_antennanp
XANTENNA__3557__X Tile_X0Y0_FrameStrobe_O[8] VPWR VGND sg13cmos5l_antennanp
XFILLER_139_8 VPWR VGND sg13cmos5l_decap_8
XFILLER_210_266 VPWR VGND sg13cmos5l_fill_2
XFILLER_309_164 VPWR VGND sg13cmos5l_fill_2
XFILLER_306_8 VPWR VGND sg13cmos5l_fill_2
XFILLER_324_123 VPWR VGND sg13cmos5l_fill_1
XFILLER_324_112 VPWR VGND sg13cmos5l_decap_8
XANTENNA__1509__A1 AXI_M_SOC_RDATA10 VPWR VGND sg13cmos5l_antennanp
XANTENNA__3155__D Tile_X0Y5_FrameData[29] VPWR VGND sg13cmos5l_antennanp
XFILLER_117_43 VPWR VGND sg13cmos5l_decap_8
XFILLER_89_121 VPWR VGND sg13cmos5l_decap_8
XANTENNA__2994__D Tile_X0Y4_FrameData[14] VPWR VGND sg13cmos5l_antennanp
XFILLER_277_255 VPWR VGND sg13cmos5l_fill_1
XFILLER_277_266 VPWR VGND sg13cmos5l_fill_1
XFILLER_77_58 VPWR VGND sg13cmos5l_decap_8
XFILLER_292_247 VPWR VGND sg13cmos5l_decap_8
XANTENNA__1693__A0 Tile_X0Y5_W1END[3] VPWR VGND sg13cmos5l_antennanp
XFILLER_93_46 VPWR VGND sg13cmos5l_decap_8
XANTENNA__1445__A0 Tile_X0Y2_WW4END[15] VPWR VGND sg13cmos5l_antennanp
XFILLER_158_0 VPWR VGND sg13cmos5l_fill_2
XFILLER_201_200 VPWR VGND sg13cmos5l_decap_8
XFILLER_158_115 VPWR VGND sg13cmos5l_decap_8
XFILLER_201_244 VPWR VGND sg13cmos5l_fill_2
XANTENNA__2234__D Tile_X0Y1_FrameData[22] VPWR VGND sg13cmos5l_antennanp
XANTENNA__3467__X Tile_X0Y1_EE4BEG[3] VPWR VGND sg13cmos5l_antennanp
XFILLER_201_266 VPWR VGND sg13cmos5l_decap_8
XFILLER_9_147 VPWR VGND sg13cmos5l_fill_2
XFILLER_42_61 VPWR VGND sg13cmos5l_decap_8
XFILLER_325_0 VPWR VGND sg13cmos5l_fill_2
XFILLER_173_107 VPWR VGND sg13cmos5l_decap_4
XFILLER_315_167 VPWR VGND sg13cmos5l_decap_8
XANTENNA__0971__A2 Tile_X0Y5_N4END[11] VPWR VGND sg13cmos5l_antennanp
XANTENNA__3065__D Tile_X0Y5_FrameData[23] VPWR VGND sg13cmos5l_antennanp
XFILLER_181_173 VPWR VGND sg13cmos5l_decap_4
XFILLER_308_86 VPWR VGND sg13cmos5l_decap_8
XFILLER_47_7 VPWR VGND sg13cmos5l_decap_8
XFILLER_315_178 VPWR VGND sg13cmos5l_fill_2
X_1340_ _3504_/A Tile_X0Y1_W2MID[3] AXI_M_SOC_RDATA26 _1094_/X _1089_/X _2152_/Q _2151_/Q
+ VPWR VGND sg13cmos5l_mux4_1
XFILLER_122_251 VPWR VGND sg13cmos5l_decap_8
XFILLER_122_262 VPWR VGND sg13cmos5l_fill_2
XFILLER_324_52 VPWR VGND sg13cmos5l_fill_1
X_1271_ _1271_/X _1189_/X _1269_/X _1270_/X _1190_/X _2528_/Q _2527_/Q VPWR VGND sg13cmos5l_mux4_1
XFILLER_260_29 VPWR VGND sg13cmos5l_fill_1
X_3010_ _3010_/Q Tile_X0Y4_FrameData[30] Tile_X0Y5_FrameStrobe[7] VPWR VGND sg13cmos5l_dlhq_1
XFILLER_95_168 VPWR VGND sg13cmos5l_decap_8
XANTENNA__1684__A0 Tile_X0Y4_W1END[0] VPWR VGND sg13cmos5l_antennanp
XANTENNA__2409__D Tile_X0Y2_FrameData[23] VPWR VGND sg13cmos5l_antennanp
XFILLER_199_90 VPWR VGND sg13cmos5l_fill_2
XFILLER_269_49 VPWR VGND sg13cmos5l_decap_8
X_3912_ Tile_X0Y5_S4BEG[1] _3912_/A VPWR VGND sg13cmos5l_buf_1
XANTENNA__2162__GATE Tile_X0Y5_FrameStrobe[6] VPWR VGND sg13cmos5l_antennanp
X_3843_ Tile_X0Y5_EE4BEG[0] _3843_/A VPWR VGND sg13cmos5l_buf_1
XANTENNA__2144__D Tile_X0Y1_FrameData[16] VPWR VGND sg13cmos5l_antennanp
XANTENNA__2792__GATE Tile_X0Y5_FrameStrobe[0] VPWR VGND sg13cmos5l_antennanp
XANTENNA__3377__X Tile_X0Y2_E6BEG[7] VPWR VGND sg13cmos5l_antennanp
XFILLER_338_237 VPWR VGND sg13cmos5l_fill_1
XFILLER_164_118 VPWR VGND sg13cmos5l_decap_8
X_3774_ Tile_X0Y4_EE4BEG[12] _3774_/A VPWR VGND sg13cmos5l_buf_1
X_0986_ _0986_/X Tile_X0Y1_W1END[3] _0968_/X Tile_X0Y1_W6END[7] _0717_/X _2233_/Q
+ _2234_/Q VPWR VGND sg13cmos5l_mux4_1
XFILLER_73_0 VPWR VGND sg13cmos5l_decap_4
XANTENNA__1983__D Tile_X0Y1_FrameData[17] VPWR VGND sg13cmos5l_antennanp
XANTENNA__2177__GATE Tile_X0Y5_FrameStrobe[6] VPWR VGND sg13cmos5l_antennanp
X_2725_ _2725_/Q Tile_X0Y3_FrameData[11] Tile_X0Y5_FrameStrobe[6] VPWR VGND sg13cmos5l_dlhq_1
XANTENNA__0872__B_N Tile_X0Y5_W6END[6] VPWR VGND sg13cmos5l_antennanp
X_2656_ _2656_/Q Tile_X0Y3_FrameData[16] Tile_X0Y5_FrameStrobe[4] VPWR VGND sg13cmos5l_dlhq_1
XFILLER_8_191 VPWR VGND sg13cmos5l_fill_2
X_1607_ _3514_/A _1606_/X _1605_/X _2755_/Q VPWR VGND sg13cmos5l_mux2_1
XANTENNA__2100__GATE Tile_X0Y5_FrameStrobe[4] VPWR VGND sg13cmos5l_antennanp
XANTENNA__3553__A Tile_X0Y5_FrameStrobe[4] VPWR VGND sg13cmos5l_antennanp
XFILLER_259_222 VPWR VGND sg13cmos5l_decap_4
X_2587_ _2587_/Q Tile_X0Y3_FrameData[21] Tile_X0Y5_FrameStrobe[2] VPWR VGND sg13cmos5l_dlhq_1
XANTENNA__2730__GATE Tile_X0Y5_FrameStrobe[6] VPWR VGND sg13cmos5l_antennanp
X_1538_ _3669_/A Tile_X0Y5_N4END[8] _0971_/X Tile_X0Y0_S4END[12] _1586_/B _2639_/Q
+ _2640_/Q VPWR VGND sg13cmos5l_mux4_1
XANTENNA__3840__X Tile_X0Y5_E6BEG[9] VPWR VGND sg13cmos5l_antennanp
XFILLER_234_74 VPWR VGND sg13cmos5l_decap_8
X_1469_ _3394_/A Tile_X0Y2_WW4END[3] AXI_M_SOC_RDATA17 _1371_/X _1187_/X _2376_/Q
+ _2375_/Q VPWR VGND sg13cmos5l_mux4_1
XFILLER_47_28 VPWR VGND sg13cmos5l_decap_8
XFILLER_274_236 VPWR VGND sg13cmos5l_decap_8
X_3208_ _3208_/Q Tile_X0Y5_FrameData[8] Tile_X0Y5_FrameStrobe[4] VPWR VGND sg13cmos5l_dlhq_1
XANTENNA__1675__A0 Tile_X0Y4_WW4END[15] VPWR VGND sg13cmos5l_antennanp
XANTENNA__2115__GATE Tile_X0Y5_FrameStrobe[4] VPWR VGND sg13cmos5l_antennanp
XANTENNA__2319__D Tile_X0Y2_FrameData[17] VPWR VGND sg13cmos5l_antennanp
X_3139_ _3139_/Q Tile_X0Y5_FrameData[13] Tile_X0Y5_FrameStrobe[2] VPWR VGND sg13cmos5l_dlhq_1
XANTENNA__2745__GATE Tile_X0Y5_FrameStrobe[7] VPWR VGND sg13cmos5l_antennanp
XFILLER_27_246 VPWR VGND sg13cmos5l_fill_2
XFILLER_103_89 VPWR VGND sg13cmos5l_decap_8
XFILLER_242_144 VPWR VGND sg13cmos5l_fill_2
XFILLER_250_95 VPWR VGND sg13cmos5l_fill_2
XANTENNA__1427__A0 Tile_X0Y2_W2MID[7] VPWR VGND sg13cmos5l_antennanp
XFILLER_242_166 VPWR VGND sg13cmos5l_fill_1
XANTENNA__2054__D Tile_X0Y1_FrameData[10] VPWR VGND sg13cmos5l_antennanp
XANTENNA__3728__A Tile_X0Y3_FrameData[31] VPWR VGND sg13cmos5l_antennanp
XFILLER_50_293 VPWR VGND sg13cmos5l_fill_2
XANTENNA__1893__D Tile_X0Y0_FrameData[27] VPWR VGND sg13cmos5l_antennanp
XANTENNA__2989__D Tile_X0Y4_FrameData[19] VPWR VGND sg13cmos5l_antennanp
XFILLER_128_64 VPWR VGND sg13cmos5l_decap_8
XFILLER_163_173 VPWR VGND sg13cmos5l_decap_8
XANTENNA__3463__A Tile_X0Y1_FrameData[31] VPWR VGND sg13cmos5l_antennanp
XFILLER_88_79 VPWR VGND sg13cmos5l_decap_8
XFILLER_104_262 VPWR VGND sg13cmos5l_decap_4
XFILLER_77_113 VPWR VGND sg13cmos5l_fill_2
XANTENNA__3750__X Tile_X0Y4_E6BEG[0] VPWR VGND sg13cmos5l_antennanp
XFILLER_291_80 VPWR VGND sg13cmos5l_fill_2
XANTENNA__1954__GATE Tile_X0Y5_FrameStrobe[8] VPWR VGND sg13cmos5l_antennanp
XFILLER_265_236 VPWR VGND sg13cmos5l_decap_4
XFILLER_265_258 VPWR VGND sg13cmos5l_fill_2
XFILLER_92_105 VPWR VGND sg13cmos5l_decap_8
XFILLER_77_168 VPWR VGND sg13cmos5l_fill_2
XFILLER_77_157 VPWR VGND sg13cmos5l_decap_8
XANTENNA__2229__D Tile_X0Y1_FrameData[27] VPWR VGND sg13cmos5l_antennanp
XFILLER_18_224 VPWR VGND sg13cmos5l_decap_4
XFILLER_275_0 VPWR VGND sg13cmos5l_fill_1
XANTENNA__1130__A2 Tile_X0Y5_N2MID[3] VPWR VGND sg13cmos5l_antennanp
XFILLER_233_111 VPWR VGND sg13cmos5l_fill_2
XFILLER_37_83 VPWR VGND sg13cmos5l_decap_8
XFILLER_37_72 VPWR VGND sg13cmos5l_fill_1
XANTENNA__1969__GATE Tile_X0Y5_FrameStrobe[0] VPWR VGND sg13cmos5l_antennanp
XFILLER_160_73 VPWR VGND sg13cmos5l_fill_1
XFILLER_160_95 VPWR VGND sg13cmos5l_fill_1
XANTENNA__1418__A0 Tile_X0Y2_WW4END[3] VPWR VGND sg13cmos5l_antennanp
X_0840_ _0840_/X Tile_X0Y5_W1END[0] Tile_X0Y5_WW4END[12] Tile_X0Y5_WW4END[4] _0596_/X
+ _3135_/Q _3136_/Q VPWR VGND sg13cmos5l_mux4_1
XANTENNA__2899__D Tile_X0Y4_FrameData[13] VPWR VGND sg13cmos5l_antennanp
X_0771_ _0771_/X _0769_/X _0770_/X _0768_/X _0767_/X _3341_/Q _3340_/Q VPWR VGND sg13cmos5l_mux4_1
XANTENNA__1197__A2 Tile_X0Y0_W6END[3] VPWR VGND sg13cmos5l_antennanp
XANTENNA__3925__X Tile_X0Y5_S4BEG[14] VPWR VGND sg13cmos5l_antennanp
X_2510_ _2510_/Q Tile_X0Y2_FrameData[18] Tile_X0Y5_FrameStrobe[8] VPWR VGND sg13cmos5l_dlhq_1
X_3490_ Tile_X0Y1_E6BEG[10] _3490_/A VPWR VGND sg13cmos5l_buf_1
XANTENNA__1907__GATE Tile_X0Y5_FrameStrobe[6] VPWR VGND sg13cmos5l_antennanp
XFILLER_154_173 VPWR VGND sg13cmos5l_fill_1
XFILLER_185_81 VPWR VGND sg13cmos5l_decap_8
X_2441_ _2441_/Q Tile_X0Y2_FrameData[23] Tile_X0Y5_FrameStrobe[6] VPWR VGND sg13cmos5l_dlhq_1
XFILLER_303_126 VPWR VGND sg13cmos5l_fill_2
X_2372_ _2372_/Q Tile_X0Y2_FrameData[28] Tile_X0Y5_FrameStrobe[4] VPWR VGND sg13cmos5l_dlhq_1
XFILLER_335_95 VPWR VGND sg13cmos5l_fill_1
XFILLER_110_210 VPWR VGND sg13cmos5l_decap_8
X_1323_ _3502_/A Tile_X0Y1_W2MID[5] AXI_M_SOC_RDATA24 _1100_/X _1086_/X _2156_/Q _2155_/Q
+ VPWR VGND sg13cmos5l_mux4_1
XANTENNA__3660__X Tile_X0Y3_E2BEG[7] VPWR VGND sg13cmos5l_antennanp
XFILLER_110_265 VPWR VGND sg13cmos5l_fill_1
X_1254_ _3630_/A Tile_X0Y0_W2END[6] AXI_M_SOC_WREADY _1140_/X _1010_/X _1870_/Q _1869_/Q
+ VPWR VGND sg13cmos5l_mux4_1
XANTENNA__1657__A0 Tile_X0Y4_W2MID[1] VPWR VGND sg13cmos5l_antennanp
XANTENNA__2139__D Tile_X0Y1_FrameData[21] VPWR VGND sg13cmos5l_antennanp
XFILLER_204_55 VPWR VGND sg13cmos5l_decap_4
XANTENNA__1121__A2 Tile_X0Y5_N4END[15] VPWR VGND sg13cmos5l_antennanp
XFILLER_209_163 VPWR VGND sg13cmos5l_fill_1
XFILLER_209_185 VPWR VGND sg13cmos5l_decap_8
X_1185_ _1185_/X Tile_X0Y1_W2MID[4] Tile_X0Y1_W2END[4] Tile_X0Y1_W6END[11] _1094_/X
+ _2190_/Q _2189_/Q VPWR VGND sg13cmos5l_mux4_1
XANTENNA__1672__A3 AXI_M_SOC_RDATA4 VPWR VGND sg13cmos5l_antennanp
XANTENNA__1978__D Tile_X0Y1_FrameData[22] VPWR VGND sg13cmos5l_antennanp
XANTENNA__0880__A1 Tile_X0Y5_W2END[7] VPWR VGND sg13cmos5l_antennanp
XANTENNA__1409__A0 AXI_M_SOC_RDATA17 VPWR VGND sg13cmos5l_antennanp
XFILLER_177_254 VPWR VGND sg13cmos5l_fill_2
XFILLER_296_25 VPWR VGND sg13cmos5l_fill_1
XFILLER_296_36 VPWR VGND sg13cmos5l_decap_8
XFILLER_32_293 VPWR VGND sg13cmos5l_fill_2
X_3826_ Tile_X0Y5_E2BEGb[3] _3826_/A VPWR VGND sg13cmos5l_buf_1
XFILLER_229_63 VPWR VGND sg13cmos5l_fill_1
X_3757_ Tile_X0Y4_E6BEG[7] _3757_/A VPWR VGND sg13cmos5l_buf_1
X_0969_ _0969_/X Tile_X0Y1_W1END[3] Tile_X0Y1_WW4END[15] Tile_X0Y1_WW4END[7] _0968_/X
+ _2041_/Q _2042_/Q VPWR VGND sg13cmos5l_mux4_1
XANTENNA__1188__A2 Tile_X0Y0_W6END[2] VPWR VGND sg13cmos5l_antennanp
XANTENNA__2602__D Tile_X0Y3_FrameData[6] VPWR VGND sg13cmos5l_antennanp
XANTENNA__3835__X Tile_X0Y5_E6BEG[4] VPWR VGND sg13cmos5l_antennanp
X_2708_ _2708_/Q Tile_X0Y3_FrameData[28] Tile_X0Y5_FrameStrobe[6] VPWR VGND sg13cmos5l_dlhq_1
X_3688_ Tile_X0Y3_EE4BEG[7] _3688_/A VPWR VGND sg13cmos5l_buf_1
X_2639_ _2639_/Q Tile_X0Y3_FrameData[1] Tile_X0Y5_FrameStrobe[3] VPWR VGND sg13cmos5l_dlhq_1
XFILLER_58_27 VPWR VGND sg13cmos5l_decap_8
XFILLER_247_203 VPWR VGND sg13cmos5l_decap_8
XFILLER_99_293 VPWR VGND sg13cmos5l_fill_2
XFILLER_59_124 VPWR VGND sg13cmos5l_decap_8
XANTENNA__1360__A2 Tile_X0Y5_N2MID[6] VPWR VGND sg13cmos5l_antennanp
XANTENNA__2054__GATE Tile_X0Y5_FrameStrobe[2] VPWR VGND sg13cmos5l_antennanp
XANTENNA__3570__X Tile_X0Y0_FrameData_O[1] VPWR VGND sg13cmos5l_antennanp
XFILLER_114_11 VPWR VGND sg13cmos5l_fill_1
XANTENNA__1648__A0 Tile_X0Y4_W2MID[2] VPWR VGND sg13cmos5l_antennanp
XANTENNA__2049__D Tile_X0Y1_FrameData[15] VPWR VGND sg13cmos5l_antennanp
XANTENNA__2684__GATE Tile_X0Y5_FrameStrobe[5] VPWR VGND sg13cmos5l_antennanp
XFILLER_74_127 VPWR VGND sg13cmos5l_decap_8
XANTENNA__1112__A2 Tile_X0Y3_W6END[0] VPWR VGND sg13cmos5l_antennanp
XFILLER_114_77 VPWR VGND sg13cmos5l_fill_1
XANTENNA__1888__D Tile_X0Y0_FrameData[0] VPWR VGND sg13cmos5l_antennanp
XFILLER_82_171 VPWR VGND sg13cmos5l_fill_1
XANTENNA__2069__GATE Tile_X0Y5_FrameStrobe[3] VPWR VGND sg13cmos5l_antennanp
XANTENNA__2699__GATE Tile_X0Y5_FrameStrobe[5] VPWR VGND sg13cmos5l_antennanp
XFILLER_90_25 VPWR VGND sg13cmos5l_decap_8
XANTENNA__3458__A Tile_X0Y1_FrameData[26] VPWR VGND sg13cmos5l_antennanp
XFILLER_230_158 VPWR VGND sg13cmos5l_decap_8
XANTENNA__2622__GATE Tile_X0Y5_FrameStrobe[3] VPWR VGND sg13cmos5l_antennanp
XFILLER_183_213 VPWR VGND sg13cmos5l_decap_8
XFILLER_23_293 VPWR VGND sg13cmos5l_fill_2
XFILLER_317_207 VPWR VGND sg13cmos5l_fill_1
XFILLER_128_129 VPWR VGND sg13cmos5l_decap_8
XANTENNA__2512__D Tile_X0Y2_FrameData[16] VPWR VGND sg13cmos5l_antennanp
XANTENNA__3745__X Tile_X0Y4_E2BEGb[3] VPWR VGND sg13cmos5l_antennanp
XFILLER_183_268 VPWR VGND sg13cmos5l_fill_1
XFILLER_286_80 VPWR VGND sg13cmos5l_fill_2
XFILLER_99_34 VPWR VGND sg13cmos5l_decap_8
XANTENNA__2007__GATE Tile_X0Y5_FrameStrobe[1] VPWR VGND sg13cmos5l_antennanp
XANTENNA__2637__GATE Tile_X0Y5_FrameStrobe[3] VPWR VGND sg13cmos5l_antennanp
XFILLER_3_0 VPWR VGND sg13cmos5l_fill_2
XANTENNA__1893__GATE Tile_X0Y5_FrameStrobe[6] VPWR VGND sg13cmos5l_antennanp
XANTENNA__3343__D Tile_X0Y5_FrameData[9] VPWR VGND sg13cmos5l_antennanp
XANTENNA__3480__X Tile_X0Y1_E6BEG[0] VPWR VGND sg13cmos5l_antennanp
XFILLER_65_105 VPWR VGND sg13cmos5l_decap_8
XANTENNA__1639__A0 Tile_X0Y4_WW4END[6] VPWR VGND sg13cmos5l_antennanp
XFILLER_171_50 VPWR VGND sg13cmos5l_decap_4
XFILLER_65_138 VPWR VGND sg13cmos5l_fill_1
XANTENNA__1103__A2 Tile_X0Y2_W6END[6] VPWR VGND sg13cmos5l_antennanp
XFILLER_321_31 VPWR VGND sg13cmos5l_fill_2
XANTENNA__1798__D Tile_X0Y0_FrameData[26] VPWR VGND sg13cmos5l_antennanp
XFILLER_206_155 VPWR VGND sg13cmos5l_decap_8
XFILLER_221_103 VPWR VGND sg13cmos5l_decap_8
X_2990_ _2990_/Q Tile_X0Y4_FrameData[18] Tile_X0Y5_FrameStrobe[6] VPWR VGND sg13cmos5l_dlhq_1
XFILLER_64_92 VPWR VGND sg13cmos5l_decap_8
XANTENNA__1831__GATE Tile_X0Y5_FrameStrobe[4] VPWR VGND sg13cmos5l_antennanp
XFILLER_14_271 VPWR VGND sg13cmos5l_decap_8
XFILLER_159_221 VPWR VGND sg13cmos5l_fill_2
X_1941_ _1941_/Q Tile_X0Y0_FrameData[11] Tile_X0Y5_FrameStrobe[7] VPWR VGND sg13cmos5l_dlhq_1
XFILLER_159_254 VPWR VGND sg13cmos5l_fill_2
X_1872_ _1872_/Q Tile_X0Y0_FrameData[16] Tile_X0Y5_FrameStrobe[5] VPWR VGND sg13cmos5l_dlhq_1
XFILLER_174_235 VPWR VGND sg13cmos5l_decap_8
X_3611_ Tile_X0Y0_EE4BEG[10] _3611_/A VPWR VGND sg13cmos5l_buf_1
X_0823_ _3858_/A Tile_X0Y5_WW4END[0] _0775_/X _0599_/X _0782_/X _3186_/Q _3185_/Q
+ VPWR VGND sg13cmos5l_mux4_1
XANTENNA__1846__GATE Tile_X0Y5_FrameStrobe[4] VPWR VGND sg13cmos5l_antennanp
XANTENNA__2422__D Tile_X0Y2_FrameData[10] VPWR VGND sg13cmos5l_antennanp
XANTENNA__3655__X Tile_X0Y3_E2BEG[2] VPWR VGND sg13cmos5l_antennanp
X_3542_ Tile_X0Y0_N2BEG[5] _3542_/A VPWR VGND sg13cmos5l_buf_1
X_0754_ _3926_/A _0746_/Y _0748_/Y _0753_/Y VPWR VGND sg13cmos5l_a21oi_1
XFILLER_282_16 VPWR VGND sg13cmos5l_decap_8
X_3473_ Tile_X0Y1_EE4BEG[9] _3473_/A VPWR VGND sg13cmos5l_buf_1
X_0685_ _0685_/Y _2788_/Q _2787_/Q VPWR VGND sg13cmos5l_nor2b_1
XFILLER_282_27 VPWR VGND sg13cmos5l_fill_2
X_2424_ _2424_/Q Tile_X0Y2_FrameData[8] Tile_X0Y5_FrameStrobe[5] VPWR VGND sg13cmos5l_dlhq_1
XFILLER_331_265 VPWR VGND sg13cmos5l_fill_2
XANTENNA__3253__D Tile_X0Y5_FrameData[27] VPWR VGND sg13cmos5l_antennanp
XFILLER_215_32 VPWR VGND sg13cmos5l_decap_8
X_2355_ _2355_/Q Tile_X0Y2_FrameData[13] Tile_X0Y5_FrameStrobe[3] VPWR VGND sg13cmos5l_dlhq_1
XFILLER_36_0 VPWR VGND sg13cmos5l_fill_2
XANTENNA__3390__X Tile_X0Y2_EE4BEG[8] VPWR VGND sg13cmos5l_antennanp
X_1306_ _3487_/A AXI_M_SOC_RDATA25 _0919_/X _0947_/X _1094_/X _2082_/Q _2081_/Q VPWR
+ VGND sg13cmos5l_mux4_1
X_2286_ _2286_/Q Tile_X0Y2_FrameData[18] Tile_X0Y5_FrameStrobe[1] VPWR VGND sg13cmos5l_dlhq_1
XFILLER_231_31 VPWR VGND sg13cmos5l_decap_8
X_1237_ _3611_/A Tile_X0Y0_WW4END[5] AXI_M_SOC_BRESP1 _1037_/X _1045_/X _1836_/Q _1835_/Q
+ VPWR VGND sg13cmos5l_mux4_1
XFILLER_56_149 VPWR VGND sg13cmos5l_decap_8
X_1168_ _1168_/X Tile_X0Y0_W1END[0] Tile_X0Y0_WW4END[0] _1068_/X _1069_/X _1944_/Q
+ _1942_/Q VPWR VGND sg13cmos5l_mux4_1
XFILLER_71_119 VPWR VGND sg13cmos5l_decap_8
XANTENNA__0853__A1 Tile_X0Y5_W2END[1] VPWR VGND sg13cmos5l_antennanp
XFILLER_212_114 VPWR VGND sg13cmos5l_fill_2
X_1099_ _1099_/X Tile_X0Y0_W2MID[5] Tile_X0Y0_W2END[5] Tile_X0Y0_W6END[10] _1147_/X
+ _1920_/Q _1919_/Q VPWR VGND sg13cmos5l_mux4_1
XFILLER_100_46 VPWR VGND sg13cmos5l_decap_8
XANTENNA__0605__A1 Tile_X0Y4_W2MID[3] VPWR VGND sg13cmos5l_antennanp
X_3809_ Tile_X0Y4_FrameData_O[31] Tile_X0Y4_FrameData[31] VPWR VGND sg13cmos5l_buf_1
XANTENNA__2332__D Tile_X0Y2_FrameData[4] VPWR VGND sg13cmos5l_antennanp
XANTENNA__3565__X Tile_X0Y0_FrameStrobe_O[16] VPWR VGND sg13cmos5l_antennanp
XFILLER_109_22 VPWR VGND sg13cmos5l_decap_8
XANTENNA__0908__A2 Tile_X0Y5_W6END[8] VPWR VGND sg13cmos5l_antennanp
XFILLER_109_33 VPWR VGND sg13cmos5l_fill_1
XFILLER_118_184 VPWR VGND sg13cmos5l_decap_8
XFILLER_307_262 VPWR VGND sg13cmos5l_fill_1
XANTENNA__1030__A1 Tile_X0Y4_WW4END[1] VPWR VGND sg13cmos5l_antennanp
XFILLER_192_49 VPWR VGND sg13cmos5l_decap_4
XFILLER_79_208 VPWR VGND sg13cmos5l_decap_8
XFILLER_87_230 VPWR VGND sg13cmos5l_decap_8
XANTENNA__3163__D Tile_X0Y5_FrameData[21] VPWR VGND sg13cmos5l_antennanp
XFILLER_197_4 VPWR VGND sg13cmos5l_fill_1
XFILLER_85_25 VPWR VGND sg13cmos5l_decap_8
XFILLER_47_127 VPWR VGND sg13cmos5l_fill_1
XFILLER_47_116 VPWR VGND sg13cmos5l_decap_8
XANTENNA__1097__A1 Tile_X0Y2_W2END[5] VPWR VGND sg13cmos5l_antennanp
XFILLER_141_42 VPWR VGND sg13cmos5l_decap_4
XANTENNA__0844__A1 Tile_X0Y5_WW4END[14] VPWR VGND sg13cmos5l_antennanp
XANTENNA__2507__D Tile_X0Y2_FrameData[21] VPWR VGND sg13cmos5l_antennanp
XANTENNA__3305__GATE Tile_X0Y5_FrameStrobe[7] VPWR VGND sg13cmos5l_antennanp
XFILLER_55_182 VPWR VGND sg13cmos5l_decap_8
XFILLER_70_152 VPWR VGND sg13cmos5l_decap_4
XFILLER_140_0 VPWR VGND sg13cmos5l_decap_8
XFILLER_70_174 VPWR VGND sg13cmos5l_fill_2
XANTENNA__2561__GATE Tile_X0Y5_FrameStrobe[1] VPWR VGND sg13cmos5l_antennanp
XANTENNA__2242__D Tile_X0Y2_FrameData[30] VPWR VGND sg13cmos5l_antennanp
XANTENNA__3338__D Tile_X0Y5_FrameData[4] VPWR VGND sg13cmos5l_antennanp
XANTENNA__3475__X Tile_X0Y1_EE4BEG[11] VPWR VGND sg13cmos5l_antennanp
XANTENNA__2576__GATE Tile_X0Y5_FrameStrobe[1] VPWR VGND sg13cmos5l_antennanp
XFILLER_109_151 VPWR VGND sg13cmos5l_decap_8
XFILLER_50_61 VPWR VGND sg13cmos5l_decap_8
XANTENNA__1572__A2 Tile_X0Y3_W6END[4] VPWR VGND sg13cmos5l_antennanp
XFILLER_124_154 VPWR VGND sg13cmos5l_decap_8
XANTENNA__0780__A0 Tile_X0Y3_W2MID[7] VPWR VGND sg13cmos5l_antennanp
XANTENNA__1324__A2 AXI_M_SOC_RDATA23 VPWR VGND sg13cmos5l_antennanp
XANTENNA__3073__D Tile_X0Y5_FrameData[15] VPWR VGND sg13cmos5l_antennanp
XFILLER_182_82 VPWR VGND sg13cmos5l_decap_8
XFILLER_285_139 VPWR VGND sg13cmos5l_fill_2
XFILLER_59_92 VPWR VGND sg13cmos5l_fill_1
XFILLER_59_81 VPWR VGND sg13cmos5l_decap_8
X_2140_ _2140_/Q Tile_X0Y1_FrameData[20] Tile_X0Y5_FrameStrobe[5] VPWR VGND sg13cmos5l_dlhq_1
XFILLER_78_285 VPWR VGND sg13cmos5l_fill_1
XFILLER_38_127 VPWR VGND sg13cmos5l_fill_2
XFILLER_293_161 VPWR VGND sg13cmos5l_decap_8
X_2071_ _2071_/Q Tile_X0Y1_FrameData[25] Tile_X0Y5_FrameStrobe[3] VPWR VGND sg13cmos5l_dlhq_1
XFILLER_93_233 VPWR VGND sg13cmos5l_decap_4
XFILLER_332_74 VPWR VGND sg13cmos5l_fill_1
XANTENNA__1088__A1 Tile_X0Y0_W2MID[3] VPWR VGND sg13cmos5l_antennanp
XANTENNA__2514__GATE Tile_X0Y5_FrameStrobe[0] VPWR VGND sg13cmos5l_antennanp
XFILLER_219_280 VPWR VGND sg13cmos5l_fill_1
X_1022_ _1022_/Y _3061_/Q _1020_/Y _1021_/Y VPWR VGND sg13cmos5l_o21ai_1
XFILLER_93_277 VPWR VGND sg13cmos5l_fill_2
XANTENNA__2417__D Tile_X0Y2_FrameData[15] VPWR VGND sg13cmos5l_antennanp
XANTENNA__1770__GATE Tile_X0Y5_FrameStrobe[2] VPWR VGND sg13cmos5l_antennanp
XFILLER_201_56 VPWR VGND sg13cmos5l_decap_8
XFILLER_234_283 VPWR VGND sg13cmos5l_fill_1
XFILLER_61_141 VPWR VGND sg13cmos5l_decap_8
XANTENNA__2529__GATE Tile_X0Y5_FrameStrobe[0] VPWR VGND sg13cmos5l_antennanp
X_2973_ _2973_/Q Tile_X0Y4_FrameData[3] Tile_X0Y5_FrameStrobe[5] VPWR VGND sg13cmos5l_dlhq_1
XANTENNA__0599__A0 Tile_X0Y5_N1END[0] VPWR VGND sg13cmos5l_antennanp
XFILLER_277_27 VPWR VGND sg13cmos5l_fill_1
X_1924_ _1924_/Q Tile_X0Y0_FrameData[28] Tile_X0Y5_FrameStrobe[7] VPWR VGND sg13cmos5l_dlhq_1
XANTENNA__1785__GATE Tile_X0Y5_FrameStrobe[2] VPWR VGND sg13cmos5l_antennanp
XFILLER_202_180 VPWR VGND sg13cmos5l_decap_4
XANTENNA__2152__D Tile_X0Y1_FrameData[8] VPWR VGND sg13cmos5l_antennanp
XANTENNA__3248__D Tile_X0Y5_FrameData[0] VPWR VGND sg13cmos5l_antennanp
XANTENNA__3385__X Tile_X0Y2_EE4BEG[3] VPWR VGND sg13cmos5l_antennanp
X_1855_ _1855_/Q Tile_X0Y0_FrameData[1] Tile_X0Y5_FrameStrobe[4] VPWR VGND sg13cmos5l_dlhq_1
X_1786_ _1786_/Q Tile_X0Y0_FrameData[6] Tile_X0Y5_FrameStrobe[2] VPWR VGND sg13cmos5l_dlhq_1
X_0806_ _3829_/A Tile_X0Y5_W2END[1] _0771_/X _0786_/X _0559_/X _3220_/Q _3219_/Q VPWR
+ VGND sg13cmos5l_mux4_1
XANTENNA__1991__D Tile_X0Y1_FrameData[9] VPWR VGND sg13cmos5l_antennanp
XFILLER_115_132 VPWR VGND sg13cmos5l_decap_8
XFILLER_162_249 VPWR VGND sg13cmos5l_fill_1
X_3525_ Tile_X0Y0_N4BEG[12] _3525_/A VPWR VGND sg13cmos5l_buf_1
X_0737_ _0737_/X Tile_X0Y1_W6END[7] _0968_/X _0905_/X _1115_/X _2169_/Q _2171_/Q VPWR
+ VGND sg13cmos5l_mux4_1
XANTENNA__1563__A2 Tile_X0Y3_W6END[6] VPWR VGND sg13cmos5l_antennanp
XFILLER_226_31 VPWR VGND sg13cmos5l_fill_1
XFILLER_304_243 VPWR VGND sg13cmos5l_fill_1
XFILLER_115_187 VPWR VGND sg13cmos5l_decap_4
XFILLER_170_293 VPWR VGND sg13cmos5l_fill_2
XFILLER_304_276 VPWR VGND sg13cmos5l_fill_2
X_3456_ Tile_X0Y1_FrameData_O[24] Tile_X0Y1_FrameData[24] VPWR VGND sg13cmos5l_buf_1
X_0668_ _0670_/B Tile_X0Y1_W6END[2] _1972_/Q VPWR VGND sg13cmos5l_nor2b_1
XFILLER_39_18 VPWR VGND sg13cmos5l_decap_8
XANTENNA__1315__A2 Tile_X0Y5_N4END[13] VPWR VGND sg13cmos5l_antennanp
XANTENNA__3561__A Tile_X0Y5_FrameStrobe[12] VPWR VGND sg13cmos5l_antennanp
XFILLER_130_146 VPWR VGND sg13cmos5l_fill_2
XFILLER_269_191 VPWR VGND sg13cmos5l_decap_4
X_2407_ _2407_/Q Tile_X0Y2_FrameData[25] Tile_X0Y5_FrameStrobe[5] VPWR VGND sg13cmos5l_dlhq_1
X_3387_ Tile_X0Y2_EE4BEG[5] _3387_/A VPWR VGND sg13cmos5l_buf_1
X_0599_ _0599_/X Tile_X0Y5_N1END[0] Tile_X0Y5_N4END[0] _1054_/B _0595_/X _3112_/Q
+ _3111_/Q VPWR VGND sg13cmos5l_mux4_1
XANTENNA__1723__GATE Tile_X0Y5_FrameStrobe[0] VPWR VGND sg13cmos5l_antennanp
XFILLER_130_179 VPWR VGND sg13cmos5l_decap_8
X_2338_ _2338_/Q Tile_X0Y2_FrameData[30] Tile_X0Y5_FrameStrobe[3] VPWR VGND sg13cmos5l_dlhq_1
XFILLER_284_172 VPWR VGND sg13cmos5l_fill_2
X_2269_ _2269_/Q Tile_X0Y2_FrameData[3] Tile_X0Y5_FrameStrobe[0] VPWR VGND sg13cmos5l_dlhq_1
XFILLER_84_255 VPWR VGND sg13cmos5l_decap_8
XFILLER_55_28 VPWR VGND sg13cmos5l_decap_8
XFILLER_37_160 VPWR VGND sg13cmos5l_decap_8
XANTENNA__2327__D Tile_X0Y2_FrameData[9] VPWR VGND sg13cmos5l_antennanp
XANTENNA__1738__GATE Tile_X0Y5_FrameStrobe[1] VPWR VGND sg13cmos5l_antennanp
XFILLER_52_130 VPWR VGND sg13cmos5l_decap_8
XFILLER_71_49 VPWR VGND sg13cmos5l_decap_8
XANTENNA__1251__A1 AXI_M_SOC_RDATA31 VPWR VGND sg13cmos5l_antennanp
XANTENNA__3291__GATE Tile_X0Y5_FrameStrobe[7] VPWR VGND sg13cmos5l_antennanp
XFILLER_187_49 VPWR VGND sg13cmos5l_decap_8
XANTENNA__2062__D Tile_X0Y1_FrameData[2] VPWR VGND sg13cmos5l_antennanp
XANTENNA__3158__D Tile_X0Y5_FrameData[26] VPWR VGND sg13cmos5l_antennanp
XANTENNA__2997__D Tile_X0Y4_FrameData[11] VPWR VGND sg13cmos5l_antennanp
XFILLER_106_110 VPWR VGND sg13cmos5l_decap_8
XFILLER_20_20 VPWR VGND sg13cmos5l_fill_2
XANTENNA__1554__A2 Tile_X0Y3_W6END[4] VPWR VGND sg13cmos5l_antennanp
XFILLER_136_42 VPWR VGND sg13cmos5l_decap_8
XFILLER_20_75 VPWR VGND sg13cmos5l_decap_4
XANTENNA__0762__A0 Tile_X0Y5_WW4END[0] VPWR VGND sg13cmos5l_antennanp
XFILLER_106_198 VPWR VGND sg13cmos5l_decap_8
XFILLER_136_75 VPWR VGND sg13cmos5l_decap_4
XFILLER_161_282 VPWR VGND sg13cmos5l_fill_2
XFILLER_161_293 VPWR VGND sg13cmos5l_fill_2
XFILLER_96_35 VPWR VGND sg13cmos5l_decap_8
XANTENNA__1543__X AXI_M_SOC_ARADDR24 VPWR VGND sg13cmos5l_antennanp
XANTENNA__2237__D Tile_X0Y1_FrameData[19] VPWR VGND sg13cmos5l_antennanp
XANTENNA__3244__GATE Tile_X0Y5_FrameStrobe[5] VPWR VGND sg13cmos5l_antennanp
XFILLER_216_250 VPWR VGND sg13cmos5l_fill_2
XFILLER_43_141 VPWR VGND sg13cmos5l_fill_1
XFILLER_231_253 VPWR VGND sg13cmos5l_fill_2
XANTENNA__3259__GATE Tile_X0Y5_FrameStrobe[6] VPWR VGND sg13cmos5l_antennanp
XFILLER_84_8 VPWR VGND sg13cmos5l_decap_8
XANTENNA__3068__D Tile_X0Y5_FrameData[20] VPWR VGND sg13cmos5l_antennanp
XFILLER_196_190 VPWR VGND sg13cmos5l_decap_8
XFILLER_61_71 VPWR VGND sg13cmos5l_decap_8
X_1640_ AXI_M_SOC_ARADDR5 Tile_X0Y4_WW4END[5] Tile_X0Y4_WW4END[13] Tile_X0Y4_W6END[5]
+ _1039_/X _2878_/Q _2877_/Q VPWR VGND sg13cmos5l_mux4_1
XANTENNA_4 Tile_X0Y5_N4END[6] VPWR VGND sg13cmos5l_antennanp
X_1571_ _3916_/A _1568_/Y _1570_/Y _1566_/Y VPWR VGND sg13cmos5l_o21ai_1
XFILLER_6_44 VPWR VGND sg13cmos5l_fill_2
XANTENNA__2700__D Tile_X0Y3_FrameData[4] VPWR VGND sg13cmos5l_antennanp
X_3310_ _3310_/Q Tile_X0Y5_FrameData[2] Tile_X0Y5_FrameStrobe[7] VPWR VGND sg13cmos5l_dlhq_1
XFILLER_152_293 VPWR VGND sg13cmos5l_fill_2
X_3241_ _3241_/Q Tile_X0Y5_FrameData[7] Tile_X0Y5_FrameStrobe[5] VPWR VGND sg13cmos5l_dlhq_1
X_3172_ _3172_/Q Tile_X0Y5_FrameData[12] Tile_X0Y5_FrameStrobe[3] VPWR VGND sg13cmos5l_dlhq_1
XANTENNA__2453__GATE Tile_X0Y5_FrameStrobe[6] VPWR VGND sg13cmos5l_antennanp
X_2123_ _2123_/Q Tile_X0Y1_FrameData[5] Tile_X0Y5_FrameStrobe[4] VPWR VGND sg13cmos5l_dlhq_1
XFILLER_212_11 VPWR VGND sg13cmos5l_fill_2
XFILLER_26_119 VPWR VGND sg13cmos5l_fill_2
XFILLER_66_266 VPWR VGND sg13cmos5l_fill_1
X_2054_ _2054_/Q Tile_X0Y1_FrameData[10] Tile_X0Y5_FrameStrobe[2] VPWR VGND sg13cmos5l_dlhq_1
XFILLER_81_236 VPWR VGND sg13cmos5l_decap_4
XANTENNA__2147__D Tile_X0Y1_FrameData[13] VPWR VGND sg13cmos5l_antennanp
XANTENNA__2468__GATE Tile_X0Y5_FrameStrobe[7] VPWR VGND sg13cmos5l_antennanp
XFILLER_179_102 VPWR VGND sg13cmos5l_fill_1
XFILLER_212_88 VPWR VGND sg13cmos5l_decap_4
X_1005_ _1005_/X _1024_/X _1003_/X Tile_X0Y0_S1END[2] Tile_X0Y0_S4END[2] _1732_/Q
+ _1731_/Q VPWR VGND sg13cmos5l_mux4_1
XFILLER_34_130 VPWR VGND sg13cmos5l_decap_8
XANTENNA__1986__D Tile_X0Y1_FrameData[14] VPWR VGND sg13cmos5l_antennanp
XFILLER_222_253 VPWR VGND sg13cmos5l_decap_8
X_2956_ _2956_/Q Tile_X0Y4_FrameData[20] Tile_X0Y5_FrameStrobe[5] VPWR VGND sg13cmos5l_dlhq_1
XANTENNA__1233__A1 AXI_M_SOC_BRESP0 VPWR VGND sg13cmos5l_antennanp
X_2887_ _2887_/Q Tile_X0Y4_FrameData[25] Tile_X0Y5_FrameStrobe[3] VPWR VGND sg13cmos5l_dlhq_1
X_1907_ _1907_/Q Tile_X0Y0_FrameData[13] Tile_X0Y5_FrameStrobe[6] VPWR VGND sg13cmos5l_dlhq_1
XFILLER_336_121 VPWR VGND sg13cmos5l_fill_1
XANTENNA__0992__A0 Tile_X0Y5_W1END[2] VPWR VGND sg13cmos5l_antennanp
XANTENNA__3556__A Tile_X0Y5_FrameStrobe[7] VPWR VGND sg13cmos5l_antennanp
X_1838_ _1838_/Q Tile_X0Y0_FrameData[18] Tile_X0Y5_FrameStrobe[4] VPWR VGND sg13cmos5l_dlhq_1
XANTENNA__1536__A2 Tile_X0Y0_S4END[14] VPWR VGND sg13cmos5l_antennanp
XANTENNA__2406__GATE Tile_X0Y5_FrameStrobe[5] VPWR VGND sg13cmos5l_antennanp
XANTENNA__2610__D Tile_X0Y3_FrameData[30] VPWR VGND sg13cmos5l_antennanp
XANTENNA__3843__X Tile_X0Y5_EE4BEG[0] VPWR VGND sg13cmos5l_antennanp
X_1769_ _1769_/Q Tile_X0Y0_FrameData[23] Tile_X0Y5_FrameStrobe[2] VPWR VGND sg13cmos5l_dlhq_1
XFILLER_143_293 VPWR VGND sg13cmos5l_fill_2
XFILLER_249_106 VPWR VGND sg13cmos5l_fill_2
X_3508_ Tile_X0Y1_E1BEG[0] _3508_/A VPWR VGND sg13cmos5l_buf_1
XFILLER_289_286 VPWR VGND sg13cmos5l_fill_1
X_3439_ Tile_X0Y1_FrameData_O[7] Tile_X0Y1_FrameData[7] VPWR VGND sg13cmos5l_buf_1
XFILLER_106_89 VPWR VGND sg13cmos5l_decap_8
XFILLER_257_172 VPWR VGND sg13cmos5l_decap_8
XFILLER_122_11 VPWR VGND sg13cmos5l_fill_2
XFILLER_17_108 VPWR VGND sg13cmos5l_decap_8
XANTENNA__2057__D Tile_X0Y1_FrameData[7] VPWR VGND sg13cmos5l_antennanp
XFILLER_25_130 VPWR VGND sg13cmos5l_decap_8
XFILLER_82_15 VPWR VGND sg13cmos5l_decap_8
XFILLER_198_15 VPWR VGND sg13cmos5l_decap_8
XFILLER_213_231 VPWR VGND sg13cmos5l_decap_8
XANTENNA__1896__D Tile_X0Y0_FrameData[24] VPWR VGND sg13cmos5l_antennanp
XFILLER_15_75 VPWR VGND sg13cmos5l_fill_1
XFILLER_213_286 VPWR VGND sg13cmos5l_fill_1
XFILLER_40_133 VPWR VGND sg13cmos5l_fill_2
XFILLER_185_116 VPWR VGND sg13cmos5l_decap_8
XFILLER_40_166 VPWR VGND sg13cmos5l_decap_8
XANTENNA__1224__A1 AXI_M_SOC_ARREADY VPWR VGND sg13cmos5l_antennanp
XFILLER_278_92 VPWR VGND sg13cmos5l_fill_1
XFILLER_126_205 VPWR VGND sg13cmos5l_decap_8
XANTENNA__0983__A0 Tile_X0Y4_W1END[3] VPWR VGND sg13cmos5l_antennanp
XFILLER_147_52 VPWR VGND sg13cmos5l_decap_8
XFILLER_193_182 VPWR VGND sg13cmos5l_decap_8
XFILLER_327_198 VPWR VGND sg13cmos5l_fill_2
XFILLER_327_187 VPWR VGND sg13cmos5l_decap_8
XANTENNA__2520__D Tile_X0Y3_FrameData[24] VPWR VGND sg13cmos5l_antennanp
XANTENNA__3753__X Tile_X0Y4_E6BEG[3] VPWR VGND sg13cmos5l_antennanp
XFILLER_103_0 VPWR VGND sg13cmos5l_decap_4
XFILLER_141_219 VPWR VGND sg13cmos5l_decap_4
XFILLER_31_96 VPWR VGND sg13cmos5l_decap_8
XFILLER_134_293 VPWR VGND sg13cmos5l_fill_2
XFILLER_48_244 VPWR VGND sg13cmos5l_decap_4
XANTENNA__1160__A0 Tile_X0Y0_W6END[11] VPWR VGND sg13cmos5l_antennanp
XANTENNA__3183__GATE Tile_X0Y5_FrameStrobe[3] VPWR VGND sg13cmos5l_antennanp
XFILLER_56_93 VPWR VGND sg13cmos5l_fill_2
XFILLER_56_82 VPWR VGND sg13cmos5l_decap_8
XANTENNA__1463__A1 AXI_M_SOC_RDATA14 VPWR VGND sg13cmos5l_antennanp
XANTENNA__3198__GATE Tile_X0Y5_FrameStrobe[4] VPWR VGND sg13cmos5l_antennanp
XFILLER_16_196 VPWR VGND sg13cmos5l_fill_2
X_2810_ _2810_/Q Tile_X0Y4_FrameData[6] Tile_X0Y5_FrameStrobe[0] VPWR VGND sg13cmos5l_dlhq_1
X_3790_ Tile_X0Y4_FrameData_O[12] Tile_X0Y4_FrameData[12] VPWR VGND sg13cmos5l_buf_1
XFILLER_72_81 VPWR VGND sg13cmos5l_decap_8
XANTENNA__3121__GATE Tile_X0Y5_FrameStrobe[2] VPWR VGND sg13cmos5l_antennanp
X_2741_ _2741_/Q Tile_X0Y3_FrameData[27] Tile_X0Y5_FrameStrobe[7] VPWR VGND sg13cmos5l_dlhq_1
XFILLER_338_73 VPWR VGND sg13cmos5l_fill_2
XANTENNA__0974__A0 Tile_X0Y5_W2MID[5] VPWR VGND sg13cmos5l_antennanp
X_2672_ _2672_/Q Tile_X0Y3_FrameData[0] Tile_X0Y5_FrameStrobe[4] VPWR VGND sg13cmos5l_dlhq_1
XANTENNA__2430__D Tile_X0Y2_FrameData[2] VPWR VGND sg13cmos5l_antennanp
XANTENNA__3663__X Tile_X0Y3_E2BEGb[2] VPWR VGND sg13cmos5l_antennanp
XFILLER_207_11 VPWR VGND sg13cmos5l_fill_2
X_1623_ _3751_/A Tile_X0Y5_N4END[5] _1012_/X _1028_/X _1013_/X _2909_/Q _2910_/Q VPWR
+ VGND sg13cmos5l_mux4_1
XANTENNA__3136__GATE Tile_X0Y5_FrameStrobe[2] VPWR VGND sg13cmos5l_antennanp
X_1554_ AXI_M_SOC_ARADDR28 Tile_X0Y3_WW4END[4] Tile_X0Y3_WW4END[12] Tile_X0Y3_W6END[4]
+ _1436_/X _2608_/Q _2607_/Q VPWR VGND sg13cmos5l_mux4_1
XFILLER_125_293 VPWR VGND sg13cmos5l_fill_2
X_1485_ _1485_/Y _2441_/Q _1485_/B VPWR VGND sg13cmos5l_nand2b_1
XFILLER_98_144 VPWR VGND sg13cmos5l_fill_1
XANTENNA__2392__GATE Tile_X0Y5_FrameStrobe[4] VPWR VGND sg13cmos5l_antennanp
X_3224_ _3224_/Q Tile_X0Y5_FrameData[24] Tile_X0Y5_FrameStrobe[5] VPWR VGND sg13cmos5l_dlhq_1
.ends
