* NGSPICE file created from DSP.ext - technology: ihp-sg13cmos5l

* Black-box entry subcircuit for sg13cmos5l_fill_1 abstract view
.subckt sg13cmos5l_fill_1 VDD VSS
.ends

* Black-box entry subcircuit for sg13cmos5l_a21oi_1 abstract view
.subckt sg13cmos5l_a21oi_1 Y A1 A2 B1 VDD VSS
.ends

* Black-box entry subcircuit for sg13cmos5l_mux2_1 abstract view
.subckt sg13cmos5l_mux2_1 X A0 A1 S VDD VSS
.ends

* Black-box entry subcircuit for sg13cmos5l_fill_2 abstract view
.subckt sg13cmos5l_fill_2 VDD VSS
.ends

* Black-box entry subcircuit for sg13cmos5l_buf_1 abstract view
.subckt sg13cmos5l_buf_1 X A VDD VSS
.ends

* Black-box entry subcircuit for sg13cmos5l_o21ai_1 abstract view
.subckt sg13cmos5l_o21ai_1 Y A1 A2 B1 VDD VSS
.ends

* Black-box entry subcircuit for sg13cmos5l_dlhq_1 abstract view
.subckt sg13cmos5l_dlhq_1 Q D GATE VDD VSS
.ends

* Black-box entry subcircuit for sg13cmos5l_xor2_1 abstract view
.subckt sg13cmos5l_xor2_1 X A B VDD VSS
.ends

* Black-box entry subcircuit for sg13cmos5l_antennanp abstract view
.subckt sg13cmos5l_antennanp A VDD VSS
.ends

* Black-box entry subcircuit for sg13cmos5l_decap_8 abstract view
.subckt sg13cmos5l_decap_8 VDD VSS
.ends

* Black-box entry subcircuit for sg13cmos5l_decap_4 abstract view
.subckt sg13cmos5l_decap_4 VDD VSS
.ends

* Black-box entry subcircuit for sg13cmos5l_nor2_1 abstract view
.subckt sg13cmos5l_nor2_1 Y A B VDD VSS
.ends

* Black-box entry subcircuit for sg13cmos5l_nand2b_1 abstract view
.subckt sg13cmos5l_nand2b_1 Y A_N B VDD VSS
.ends

* Black-box entry subcircuit for sg13cmos5l_nand2_1 abstract view
.subckt sg13cmos5l_nand2_1 Y A B VDD VSS
.ends

* Black-box entry subcircuit for sg13cmos5l_mux4_1 abstract view
.subckt sg13cmos5l_mux4_1 X A0 A1 A2 A3 S0 S1 VDD VSS
.ends

* Black-box entry subcircuit for sg13cmos5l_inv_1 abstract view
.subckt sg13cmos5l_inv_1 Y A VDD VSS
.ends

* Black-box entry subcircuit for sg13cmos5l_xnor2_1 abstract view
.subckt sg13cmos5l_xnor2_1 Y A B VDD VSS
.ends

* Black-box entry subcircuit for sg13cmos5l_and2_1 abstract view
.subckt sg13cmos5l_and2_1 X A B VDD VSS
.ends

* Black-box entry subcircuit for sg13cmos5l_or2_1 abstract view
.subckt sg13cmos5l_or2_1 X A B VDD VSS
.ends

* Black-box entry subcircuit for sg13cmos5l_dfrbpq_1 abstract view
.subckt sg13cmos5l_dfrbpq_1 Q CLK D RESET_B VDD VSS
.ends

* Black-box entry subcircuit for sg13cmos5l_tiehi abstract view
.subckt sg13cmos5l_tiehi L_HI VDD VSS
.ends

* Black-box entry subcircuit for sg13cmos5l_nand3_1 abstract view
.subckt sg13cmos5l_nand3_1 Y A B C VDD VSS
.ends

* Black-box entry subcircuit for sg13cmos5l_nor2b_1 abstract view
.subckt sg13cmos5l_nor2b_1 Y A B_N VDD VSS
.ends

* Black-box entry subcircuit for sg13cmos5l_a21o_1 abstract view
.subckt sg13cmos5l_a21o_1 X A1 A2 B1 VDD VSS
.ends

* Black-box entry subcircuit for sg13cmos5l_a22oi_1 abstract view
.subckt sg13cmos5l_a22oi_1 Y A1 A2 B1 B2 VDD VSS
.ends

* Black-box entry subcircuit for sg13cmos5l_nand3b_1 abstract view
.subckt sg13cmos5l_nand3b_1 Y A_N B C VDD VSS
.ends

* Black-box entry subcircuit for sg13cmos5l_nor3_1 abstract view
.subckt sg13cmos5l_nor3_1 Y A B C VDD VSS
.ends

* Black-box entry subcircuit for sg13cmos5l_a221oi_1 abstract view
.subckt sg13cmos5l_a221oi_1 Y A1 A2 B1 B2 C1 VDD VSS
.ends

* Black-box entry subcircuit for sg13cmos5l_or3_1 abstract view
.subckt sg13cmos5l_or3_1 X A B C VDD VSS
.ends

* Black-box entry subcircuit for sg13cmos5l_nand4_1 abstract view
.subckt sg13cmos5l_nand4_1 Y A B C D VDD VSS
.ends

* Black-box entry subcircuit for sg13cmos5l_and3_1 abstract view
.subckt sg13cmos5l_and3_1 X A B C VDD VSS
.ends

.subckt DSP Tile_X0Y0_E1BEG[0] Tile_X0Y0_E1BEG[1] Tile_X0Y0_E1BEG[2] Tile_X0Y0_E1BEG[3]
+ Tile_X0Y0_E1END[0] Tile_X0Y0_E1END[1] Tile_X0Y0_E1END[2] Tile_X0Y0_E1END[3] Tile_X0Y0_E2BEG[0]
+ Tile_X0Y0_E2BEG[1] Tile_X0Y0_E2BEG[2] Tile_X0Y0_E2BEG[3] Tile_X0Y0_E2BEG[4] Tile_X0Y0_E2BEG[5]
+ Tile_X0Y0_E2BEG[6] Tile_X0Y0_E2BEG[7] Tile_X0Y0_E2BEGb[0] Tile_X0Y0_E2BEGb[1] Tile_X0Y0_E2BEGb[2]
+ Tile_X0Y0_E2BEGb[3] Tile_X0Y0_E2BEGb[4] Tile_X0Y0_E2BEGb[5] Tile_X0Y0_E2BEGb[6]
+ Tile_X0Y0_E2BEGb[7] Tile_X0Y0_E2END[0] Tile_X0Y0_E2END[1] Tile_X0Y0_E2END[2] Tile_X0Y0_E2END[3]
+ Tile_X0Y0_E2END[4] Tile_X0Y0_E2END[5] Tile_X0Y0_E2END[6] Tile_X0Y0_E2END[7] Tile_X0Y0_E2MID[0]
+ Tile_X0Y0_E2MID[1] Tile_X0Y0_E2MID[2] Tile_X0Y0_E2MID[3] Tile_X0Y0_E2MID[4] Tile_X0Y0_E2MID[5]
+ Tile_X0Y0_E2MID[6] Tile_X0Y0_E2MID[7] Tile_X0Y0_E6BEG[0] Tile_X0Y0_E6BEG[10] Tile_X0Y0_E6BEG[11]
+ Tile_X0Y0_E6BEG[1] Tile_X0Y0_E6BEG[2] Tile_X0Y0_E6BEG[3] Tile_X0Y0_E6BEG[4] Tile_X0Y0_E6BEG[5]
+ Tile_X0Y0_E6BEG[6] Tile_X0Y0_E6BEG[7] Tile_X0Y0_E6BEG[8] Tile_X0Y0_E6BEG[9] Tile_X0Y0_E6END[0]
+ Tile_X0Y0_E6END[10] Tile_X0Y0_E6END[11] Tile_X0Y0_E6END[1] Tile_X0Y0_E6END[2] Tile_X0Y0_E6END[3]
+ Tile_X0Y0_E6END[4] Tile_X0Y0_E6END[5] Tile_X0Y0_E6END[6] Tile_X0Y0_E6END[7] Tile_X0Y0_E6END[8]
+ Tile_X0Y0_E6END[9] Tile_X0Y0_EE4BEG[0] Tile_X0Y0_EE4BEG[10] Tile_X0Y0_EE4BEG[11]
+ Tile_X0Y0_EE4BEG[12] Tile_X0Y0_EE4BEG[13] Tile_X0Y0_EE4BEG[14] Tile_X0Y0_EE4BEG[15]
+ Tile_X0Y0_EE4BEG[1] Tile_X0Y0_EE4BEG[2] Tile_X0Y0_EE4BEG[3] Tile_X0Y0_EE4BEG[4]
+ Tile_X0Y0_EE4BEG[5] Tile_X0Y0_EE4BEG[6] Tile_X0Y0_EE4BEG[7] Tile_X0Y0_EE4BEG[8]
+ Tile_X0Y0_EE4BEG[9] Tile_X0Y0_EE4END[0] Tile_X0Y0_EE4END[10] Tile_X0Y0_EE4END[11]
+ Tile_X0Y0_EE4END[12] Tile_X0Y0_EE4END[13] Tile_X0Y0_EE4END[14] Tile_X0Y0_EE4END[15]
+ Tile_X0Y0_EE4END[1] Tile_X0Y0_EE4END[2] Tile_X0Y0_EE4END[3] Tile_X0Y0_EE4END[4]
+ Tile_X0Y0_EE4END[5] Tile_X0Y0_EE4END[6] Tile_X0Y0_EE4END[7] Tile_X0Y0_EE4END[8]
+ Tile_X0Y0_EE4END[9] Tile_X0Y0_FrameData[0] Tile_X0Y0_FrameData[10] Tile_X0Y0_FrameData[11]
+ Tile_X0Y0_FrameData[12] Tile_X0Y0_FrameData[13] Tile_X0Y0_FrameData[14] Tile_X0Y0_FrameData[15]
+ Tile_X0Y0_FrameData[16] Tile_X0Y0_FrameData[17] Tile_X0Y0_FrameData[18] Tile_X0Y0_FrameData[19]
+ Tile_X0Y0_FrameData[1] Tile_X0Y0_FrameData[20] Tile_X0Y0_FrameData[21] Tile_X0Y0_FrameData[22]
+ Tile_X0Y0_FrameData[23] Tile_X0Y0_FrameData[24] Tile_X0Y0_FrameData[25] Tile_X0Y0_FrameData[26]
+ Tile_X0Y0_FrameData[27] Tile_X0Y0_FrameData[28] Tile_X0Y0_FrameData[29] Tile_X0Y0_FrameData[2]
+ Tile_X0Y0_FrameData[30] Tile_X0Y0_FrameData[31] Tile_X0Y0_FrameData[3] Tile_X0Y0_FrameData[4]
+ Tile_X0Y0_FrameData[5] Tile_X0Y0_FrameData[6] Tile_X0Y0_FrameData[7] Tile_X0Y0_FrameData[8]
+ Tile_X0Y0_FrameData[9] Tile_X0Y0_FrameData_O[0] Tile_X0Y0_FrameData_O[10] Tile_X0Y0_FrameData_O[11]
+ Tile_X0Y0_FrameData_O[12] Tile_X0Y0_FrameData_O[13] Tile_X0Y0_FrameData_O[14] Tile_X0Y0_FrameData_O[15]
+ Tile_X0Y0_FrameData_O[16] Tile_X0Y0_FrameData_O[17] Tile_X0Y0_FrameData_O[18] Tile_X0Y0_FrameData_O[19]
+ Tile_X0Y0_FrameData_O[1] Tile_X0Y0_FrameData_O[20] Tile_X0Y0_FrameData_O[21] Tile_X0Y0_FrameData_O[22]
+ Tile_X0Y0_FrameData_O[23] Tile_X0Y0_FrameData_O[24] Tile_X0Y0_FrameData_O[25] Tile_X0Y0_FrameData_O[26]
+ Tile_X0Y0_FrameData_O[27] Tile_X0Y0_FrameData_O[28] Tile_X0Y0_FrameData_O[29] Tile_X0Y0_FrameData_O[2]
+ Tile_X0Y0_FrameData_O[30] Tile_X0Y0_FrameData_O[31] Tile_X0Y0_FrameData_O[3] Tile_X0Y0_FrameData_O[4]
+ Tile_X0Y0_FrameData_O[5] Tile_X0Y0_FrameData_O[6] Tile_X0Y0_FrameData_O[7] Tile_X0Y0_FrameData_O[8]
+ Tile_X0Y0_FrameData_O[9] Tile_X0Y0_FrameStrobe_O[0] Tile_X0Y0_FrameStrobe_O[10]
+ Tile_X0Y0_FrameStrobe_O[11] Tile_X0Y0_FrameStrobe_O[12] Tile_X0Y0_FrameStrobe_O[13]
+ Tile_X0Y0_FrameStrobe_O[14] Tile_X0Y0_FrameStrobe_O[15] Tile_X0Y0_FrameStrobe_O[16]
+ Tile_X0Y0_FrameStrobe_O[17] Tile_X0Y0_FrameStrobe_O[18] Tile_X0Y0_FrameStrobe_O[19]
+ Tile_X0Y0_FrameStrobe_O[1] Tile_X0Y0_FrameStrobe_O[2] Tile_X0Y0_FrameStrobe_O[3]
+ Tile_X0Y0_FrameStrobe_O[4] Tile_X0Y0_FrameStrobe_O[5] Tile_X0Y0_FrameStrobe_O[6]
+ Tile_X0Y0_FrameStrobe_O[7] Tile_X0Y0_FrameStrobe_O[8] Tile_X0Y0_FrameStrobe_O[9]
+ Tile_X0Y0_N1BEG[0] Tile_X0Y0_N1BEG[1] Tile_X0Y0_N1BEG[2] Tile_X0Y0_N1BEG[3] Tile_X0Y0_N2BEG[0]
+ Tile_X0Y0_N2BEG[1] Tile_X0Y0_N2BEG[2] Tile_X0Y0_N2BEG[3] Tile_X0Y0_N2BEG[4] Tile_X0Y0_N2BEG[5]
+ Tile_X0Y0_N2BEG[6] Tile_X0Y0_N2BEG[7] Tile_X0Y0_N2BEGb[0] Tile_X0Y0_N2BEGb[1] Tile_X0Y0_N2BEGb[2]
+ Tile_X0Y0_N2BEGb[3] Tile_X0Y0_N2BEGb[4] Tile_X0Y0_N2BEGb[5] Tile_X0Y0_N2BEGb[6]
+ Tile_X0Y0_N2BEGb[7] Tile_X0Y0_N4BEG[0] Tile_X0Y0_N4BEG[10] Tile_X0Y0_N4BEG[11] Tile_X0Y0_N4BEG[12]
+ Tile_X0Y0_N4BEG[13] Tile_X0Y0_N4BEG[14] Tile_X0Y0_N4BEG[15] Tile_X0Y0_N4BEG[1] Tile_X0Y0_N4BEG[2]
+ Tile_X0Y0_N4BEG[3] Tile_X0Y0_N4BEG[4] Tile_X0Y0_N4BEG[5] Tile_X0Y0_N4BEG[6] Tile_X0Y0_N4BEG[7]
+ Tile_X0Y0_N4BEG[8] Tile_X0Y0_N4BEG[9] Tile_X0Y0_NN4BEG[0] Tile_X0Y0_NN4BEG[10] Tile_X0Y0_NN4BEG[11]
+ Tile_X0Y0_NN4BEG[12] Tile_X0Y0_NN4BEG[13] Tile_X0Y0_NN4BEG[14] Tile_X0Y0_NN4BEG[15]
+ Tile_X0Y0_NN4BEG[1] Tile_X0Y0_NN4BEG[2] Tile_X0Y0_NN4BEG[3] Tile_X0Y0_NN4BEG[4]
+ Tile_X0Y0_NN4BEG[5] Tile_X0Y0_NN4BEG[6] Tile_X0Y0_NN4BEG[7] Tile_X0Y0_NN4BEG[8]
+ Tile_X0Y0_NN4BEG[9] Tile_X0Y0_S1END[0] Tile_X0Y0_S1END[1] Tile_X0Y0_S1END[2] Tile_X0Y0_S1END[3]
+ Tile_X0Y0_S2END[0] Tile_X0Y0_S2END[1] Tile_X0Y0_S2END[2] Tile_X0Y0_S2END[3] Tile_X0Y0_S2END[4]
+ Tile_X0Y0_S2END[5] Tile_X0Y0_S2END[6] Tile_X0Y0_S2END[7] Tile_X0Y0_S2MID[0] Tile_X0Y0_S2MID[1]
+ Tile_X0Y0_S2MID[2] Tile_X0Y0_S2MID[3] Tile_X0Y0_S2MID[4] Tile_X0Y0_S2MID[5] Tile_X0Y0_S2MID[6]
+ Tile_X0Y0_S2MID[7] Tile_X0Y0_S4END[0] Tile_X0Y0_S4END[10] Tile_X0Y0_S4END[11] Tile_X0Y0_S4END[12]
+ Tile_X0Y0_S4END[13] Tile_X0Y0_S4END[14] Tile_X0Y0_S4END[15] Tile_X0Y0_S4END[1] Tile_X0Y0_S4END[2]
+ Tile_X0Y0_S4END[3] Tile_X0Y0_S4END[4] Tile_X0Y0_S4END[5] Tile_X0Y0_S4END[6] Tile_X0Y0_S4END[7]
+ Tile_X0Y0_S4END[8] Tile_X0Y0_S4END[9] Tile_X0Y0_SS4END[0] Tile_X0Y0_SS4END[10] Tile_X0Y0_SS4END[11]
+ Tile_X0Y0_SS4END[12] Tile_X0Y0_SS4END[13] Tile_X0Y0_SS4END[14] Tile_X0Y0_SS4END[15]
+ Tile_X0Y0_SS4END[1] Tile_X0Y0_SS4END[2] Tile_X0Y0_SS4END[3] Tile_X0Y0_SS4END[4]
+ Tile_X0Y0_SS4END[5] Tile_X0Y0_SS4END[6] Tile_X0Y0_SS4END[7] Tile_X0Y0_SS4END[8]
+ Tile_X0Y0_SS4END[9] Tile_X0Y0_UserCLK Tile_X0Y0_UserCLKo Tile_X0Y0_W1BEG[0] Tile_X0Y0_W1BEG[1]
+ Tile_X0Y0_W1BEG[2] Tile_X0Y0_W1BEG[3] Tile_X0Y0_W1END[0] Tile_X0Y0_W1END[1] Tile_X0Y0_W1END[2]
+ Tile_X0Y0_W1END[3] Tile_X0Y0_W2BEG[0] Tile_X0Y0_W2BEG[1] Tile_X0Y0_W2BEG[2] Tile_X0Y0_W2BEG[3]
+ Tile_X0Y0_W2BEG[4] Tile_X0Y0_W2BEG[5] Tile_X0Y0_W2BEG[6] Tile_X0Y0_W2BEG[7] Tile_X0Y0_W2BEGb[0]
+ Tile_X0Y0_W2BEGb[1] Tile_X0Y0_W2BEGb[2] Tile_X0Y0_W2BEGb[3] Tile_X0Y0_W2BEGb[4]
+ Tile_X0Y0_W2BEGb[5] Tile_X0Y0_W2BEGb[6] Tile_X0Y0_W2BEGb[7] Tile_X0Y0_W2END[0] Tile_X0Y0_W2END[1]
+ Tile_X0Y0_W2END[2] Tile_X0Y0_W2END[3] Tile_X0Y0_W2END[4] Tile_X0Y0_W2END[5] Tile_X0Y0_W2END[6]
+ Tile_X0Y0_W2END[7] Tile_X0Y0_W2MID[0] Tile_X0Y0_W2MID[1] Tile_X0Y0_W2MID[2] Tile_X0Y0_W2MID[3]
+ Tile_X0Y0_W2MID[4] Tile_X0Y0_W2MID[5] Tile_X0Y0_W2MID[6] Tile_X0Y0_W2MID[7] Tile_X0Y0_W6BEG[0]
+ Tile_X0Y0_W6BEG[10] Tile_X0Y0_W6BEG[11] Tile_X0Y0_W6BEG[1] Tile_X0Y0_W6BEG[2] Tile_X0Y0_W6BEG[3]
+ Tile_X0Y0_W6BEG[4] Tile_X0Y0_W6BEG[5] Tile_X0Y0_W6BEG[6] Tile_X0Y0_W6BEG[7] Tile_X0Y0_W6BEG[8]
+ Tile_X0Y0_W6BEG[9] Tile_X0Y0_W6END[0] Tile_X0Y0_W6END[10] Tile_X0Y0_W6END[11] Tile_X0Y0_W6END[1]
+ Tile_X0Y0_W6END[2] Tile_X0Y0_W6END[3] Tile_X0Y0_W6END[4] Tile_X0Y0_W6END[5] Tile_X0Y0_W6END[6]
+ Tile_X0Y0_W6END[7] Tile_X0Y0_W6END[8] Tile_X0Y0_W6END[9] Tile_X0Y0_WW4BEG[0] Tile_X0Y0_WW4BEG[10]
+ Tile_X0Y0_WW4BEG[11] Tile_X0Y0_WW4BEG[12] Tile_X0Y0_WW4BEG[13] Tile_X0Y0_WW4BEG[14]
+ Tile_X0Y0_WW4BEG[15] Tile_X0Y0_WW4BEG[1] Tile_X0Y0_WW4BEG[2] Tile_X0Y0_WW4BEG[3]
+ Tile_X0Y0_WW4BEG[4] Tile_X0Y0_WW4BEG[5] Tile_X0Y0_WW4BEG[6] Tile_X0Y0_WW4BEG[7]
+ Tile_X0Y0_WW4BEG[8] Tile_X0Y0_WW4BEG[9] Tile_X0Y0_WW4END[0] Tile_X0Y0_WW4END[10]
+ Tile_X0Y0_WW4END[11] Tile_X0Y0_WW4END[12] Tile_X0Y0_WW4END[13] Tile_X0Y0_WW4END[14]
+ Tile_X0Y0_WW4END[15] Tile_X0Y0_WW4END[1] Tile_X0Y0_WW4END[2] Tile_X0Y0_WW4END[3]
+ Tile_X0Y0_WW4END[4] Tile_X0Y0_WW4END[5] Tile_X0Y0_WW4END[6] Tile_X0Y0_WW4END[7]
+ Tile_X0Y0_WW4END[8] Tile_X0Y0_WW4END[9] Tile_X0Y1_E1BEG[0] Tile_X0Y1_E1BEG[1] Tile_X0Y1_E1BEG[2]
+ Tile_X0Y1_E1BEG[3] Tile_X0Y1_E1END[0] Tile_X0Y1_E1END[1] Tile_X0Y1_E1END[2] Tile_X0Y1_E1END[3]
+ Tile_X0Y1_E2BEG[0] Tile_X0Y1_E2BEG[1] Tile_X0Y1_E2BEG[2] Tile_X0Y1_E2BEG[3] Tile_X0Y1_E2BEG[4]
+ Tile_X0Y1_E2BEG[5] Tile_X0Y1_E2BEG[6] Tile_X0Y1_E2BEG[7] Tile_X0Y1_E2BEGb[0] Tile_X0Y1_E2BEGb[1]
+ Tile_X0Y1_E2BEGb[2] Tile_X0Y1_E2BEGb[3] Tile_X0Y1_E2BEGb[4] Tile_X0Y1_E2BEGb[5]
+ Tile_X0Y1_E2BEGb[6] Tile_X0Y1_E2BEGb[7] Tile_X0Y1_E2END[0] Tile_X0Y1_E2END[1] Tile_X0Y1_E2END[2]
+ Tile_X0Y1_E2END[3] Tile_X0Y1_E2END[4] Tile_X0Y1_E2END[5] Tile_X0Y1_E2END[6] Tile_X0Y1_E2END[7]
+ Tile_X0Y1_E2MID[0] Tile_X0Y1_E2MID[1] Tile_X0Y1_E2MID[2] Tile_X0Y1_E2MID[3] Tile_X0Y1_E2MID[4]
+ Tile_X0Y1_E2MID[5] Tile_X0Y1_E2MID[6] Tile_X0Y1_E2MID[7] Tile_X0Y1_E6BEG[0] Tile_X0Y1_E6BEG[10]
+ Tile_X0Y1_E6BEG[11] Tile_X0Y1_E6BEG[1] Tile_X0Y1_E6BEG[2] Tile_X0Y1_E6BEG[3] Tile_X0Y1_E6BEG[4]
+ Tile_X0Y1_E6BEG[5] Tile_X0Y1_E6BEG[6] Tile_X0Y1_E6BEG[7] Tile_X0Y1_E6BEG[8] Tile_X0Y1_E6BEG[9]
+ Tile_X0Y1_E6END[0] Tile_X0Y1_E6END[10] Tile_X0Y1_E6END[11] Tile_X0Y1_E6END[1] Tile_X0Y1_E6END[2]
+ Tile_X0Y1_E6END[3] Tile_X0Y1_E6END[4] Tile_X0Y1_E6END[5] Tile_X0Y1_E6END[6] Tile_X0Y1_E6END[7]
+ Tile_X0Y1_E6END[8] Tile_X0Y1_E6END[9] Tile_X0Y1_EE4BEG[0] Tile_X0Y1_EE4BEG[10] Tile_X0Y1_EE4BEG[11]
+ Tile_X0Y1_EE4BEG[12] Tile_X0Y1_EE4BEG[13] Tile_X0Y1_EE4BEG[14] Tile_X0Y1_EE4BEG[15]
+ Tile_X0Y1_EE4BEG[1] Tile_X0Y1_EE4BEG[2] Tile_X0Y1_EE4BEG[3] Tile_X0Y1_EE4BEG[4]
+ Tile_X0Y1_EE4BEG[5] Tile_X0Y1_EE4BEG[6] Tile_X0Y1_EE4BEG[7] Tile_X0Y1_EE4BEG[8]
+ Tile_X0Y1_EE4BEG[9] Tile_X0Y1_EE4END[0] Tile_X0Y1_EE4END[10] Tile_X0Y1_EE4END[11]
+ Tile_X0Y1_EE4END[12] Tile_X0Y1_EE4END[13] Tile_X0Y1_EE4END[14] Tile_X0Y1_EE4END[15]
+ Tile_X0Y1_EE4END[1] Tile_X0Y1_EE4END[2] Tile_X0Y1_EE4END[3] Tile_X0Y1_EE4END[4]
+ Tile_X0Y1_EE4END[5] Tile_X0Y1_EE4END[6] Tile_X0Y1_EE4END[7] Tile_X0Y1_EE4END[8]
+ Tile_X0Y1_EE4END[9] Tile_X0Y1_FrameData[0] Tile_X0Y1_FrameData[10] Tile_X0Y1_FrameData[11]
+ Tile_X0Y1_FrameData[12] Tile_X0Y1_FrameData[13] Tile_X0Y1_FrameData[14] Tile_X0Y1_FrameData[15]
+ Tile_X0Y1_FrameData[16] Tile_X0Y1_FrameData[17] Tile_X0Y1_FrameData[18] Tile_X0Y1_FrameData[19]
+ Tile_X0Y1_FrameData[1] Tile_X0Y1_FrameData[20] Tile_X0Y1_FrameData[21] Tile_X0Y1_FrameData[22]
+ Tile_X0Y1_FrameData[23] Tile_X0Y1_FrameData[24] Tile_X0Y1_FrameData[25] Tile_X0Y1_FrameData[26]
+ Tile_X0Y1_FrameData[27] Tile_X0Y1_FrameData[28] Tile_X0Y1_FrameData[29] Tile_X0Y1_FrameData[2]
+ Tile_X0Y1_FrameData[30] Tile_X0Y1_FrameData[31] Tile_X0Y1_FrameData[3] Tile_X0Y1_FrameData[4]
+ Tile_X0Y1_FrameData[5] Tile_X0Y1_FrameData[6] Tile_X0Y1_FrameData[7] Tile_X0Y1_FrameData[8]
+ Tile_X0Y1_FrameData[9] Tile_X0Y1_FrameData_O[0] Tile_X0Y1_FrameData_O[10] Tile_X0Y1_FrameData_O[11]
+ Tile_X0Y1_FrameData_O[12] Tile_X0Y1_FrameData_O[13] Tile_X0Y1_FrameData_O[14] Tile_X0Y1_FrameData_O[15]
+ Tile_X0Y1_FrameData_O[16] Tile_X0Y1_FrameData_O[17] Tile_X0Y1_FrameData_O[18] Tile_X0Y1_FrameData_O[19]
+ Tile_X0Y1_FrameData_O[1] Tile_X0Y1_FrameData_O[20] Tile_X0Y1_FrameData_O[21] Tile_X0Y1_FrameData_O[22]
+ Tile_X0Y1_FrameData_O[23] Tile_X0Y1_FrameData_O[24] Tile_X0Y1_FrameData_O[25] Tile_X0Y1_FrameData_O[26]
+ Tile_X0Y1_FrameData_O[27] Tile_X0Y1_FrameData_O[28] Tile_X0Y1_FrameData_O[29] Tile_X0Y1_FrameData_O[2]
+ Tile_X0Y1_FrameData_O[30] Tile_X0Y1_FrameData_O[31] Tile_X0Y1_FrameData_O[3] Tile_X0Y1_FrameData_O[4]
+ Tile_X0Y1_FrameData_O[5] Tile_X0Y1_FrameData_O[6] Tile_X0Y1_FrameData_O[7] Tile_X0Y1_FrameData_O[8]
+ Tile_X0Y1_FrameData_O[9] Tile_X0Y1_FrameStrobe[0] Tile_X0Y1_FrameStrobe[10] Tile_X0Y1_FrameStrobe[11]
+ Tile_X0Y1_FrameStrobe[12] Tile_X0Y1_FrameStrobe[13] Tile_X0Y1_FrameStrobe[14] Tile_X0Y1_FrameStrobe[15]
+ Tile_X0Y1_FrameStrobe[16] Tile_X0Y1_FrameStrobe[17] Tile_X0Y1_FrameStrobe[18] Tile_X0Y1_FrameStrobe[19]
+ Tile_X0Y1_FrameStrobe[1] Tile_X0Y1_FrameStrobe[2] Tile_X0Y1_FrameStrobe[3] Tile_X0Y1_FrameStrobe[4]
+ Tile_X0Y1_FrameStrobe[5] Tile_X0Y1_FrameStrobe[6] Tile_X0Y1_FrameStrobe[7] Tile_X0Y1_FrameStrobe[8]
+ Tile_X0Y1_FrameStrobe[9] Tile_X0Y1_N1END[0] Tile_X0Y1_N1END[1] Tile_X0Y1_N1END[2]
+ Tile_X0Y1_N1END[3] Tile_X0Y1_N2END[0] Tile_X0Y1_N2END[1] Tile_X0Y1_N2END[2] Tile_X0Y1_N2END[3]
+ Tile_X0Y1_N2END[4] Tile_X0Y1_N2END[5] Tile_X0Y1_N2END[6] Tile_X0Y1_N2END[7] Tile_X0Y1_N2MID[0]
+ Tile_X0Y1_N2MID[1] Tile_X0Y1_N2MID[2] Tile_X0Y1_N2MID[3] Tile_X0Y1_N2MID[4] Tile_X0Y1_N2MID[5]
+ Tile_X0Y1_N2MID[6] Tile_X0Y1_N2MID[7] Tile_X0Y1_N4END[0] Tile_X0Y1_N4END[10] Tile_X0Y1_N4END[11]
+ Tile_X0Y1_N4END[12] Tile_X0Y1_N4END[13] Tile_X0Y1_N4END[14] Tile_X0Y1_N4END[15]
+ Tile_X0Y1_N4END[1] Tile_X0Y1_N4END[2] Tile_X0Y1_N4END[3] Tile_X0Y1_N4END[4] Tile_X0Y1_N4END[5]
+ Tile_X0Y1_N4END[6] Tile_X0Y1_N4END[7] Tile_X0Y1_N4END[8] Tile_X0Y1_N4END[9] Tile_X0Y1_NN4END[0]
+ Tile_X0Y1_NN4END[10] Tile_X0Y1_NN4END[11] Tile_X0Y1_NN4END[12] Tile_X0Y1_NN4END[13]
+ Tile_X0Y1_NN4END[14] Tile_X0Y1_NN4END[15] Tile_X0Y1_NN4END[1] Tile_X0Y1_NN4END[2]
+ Tile_X0Y1_NN4END[3] Tile_X0Y1_NN4END[4] Tile_X0Y1_NN4END[5] Tile_X0Y1_NN4END[6]
+ Tile_X0Y1_NN4END[7] Tile_X0Y1_NN4END[8] Tile_X0Y1_NN4END[9] Tile_X0Y1_S1BEG[0] Tile_X0Y1_S1BEG[1]
+ Tile_X0Y1_S1BEG[2] Tile_X0Y1_S1BEG[3] Tile_X0Y1_S2BEG[0] Tile_X0Y1_S2BEG[1] Tile_X0Y1_S2BEG[2]
+ Tile_X0Y1_S2BEG[3] Tile_X0Y1_S2BEG[4] Tile_X0Y1_S2BEG[5] Tile_X0Y1_S2BEG[6] Tile_X0Y1_S2BEG[7]
+ Tile_X0Y1_S2BEGb[0] Tile_X0Y1_S2BEGb[1] Tile_X0Y1_S2BEGb[2] Tile_X0Y1_S2BEGb[3]
+ Tile_X0Y1_S2BEGb[4] Tile_X0Y1_S2BEGb[5] Tile_X0Y1_S2BEGb[6] Tile_X0Y1_S2BEGb[7]
+ Tile_X0Y1_S4BEG[0] Tile_X0Y1_S4BEG[10] Tile_X0Y1_S4BEG[11] Tile_X0Y1_S4BEG[12] Tile_X0Y1_S4BEG[13]
+ Tile_X0Y1_S4BEG[14] Tile_X0Y1_S4BEG[15] Tile_X0Y1_S4BEG[1] Tile_X0Y1_S4BEG[2] Tile_X0Y1_S4BEG[3]
+ Tile_X0Y1_S4BEG[4] Tile_X0Y1_S4BEG[5] Tile_X0Y1_S4BEG[6] Tile_X0Y1_S4BEG[7] Tile_X0Y1_S4BEG[8]
+ Tile_X0Y1_S4BEG[9] Tile_X0Y1_SS4BEG[0] Tile_X0Y1_SS4BEG[10] Tile_X0Y1_SS4BEG[11]
+ Tile_X0Y1_SS4BEG[12] Tile_X0Y1_SS4BEG[13] Tile_X0Y1_SS4BEG[14] Tile_X0Y1_SS4BEG[15]
+ Tile_X0Y1_SS4BEG[1] Tile_X0Y1_SS4BEG[2] Tile_X0Y1_SS4BEG[3] Tile_X0Y1_SS4BEG[4]
+ Tile_X0Y1_SS4BEG[5] Tile_X0Y1_SS4BEG[6] Tile_X0Y1_SS4BEG[7] Tile_X0Y1_SS4BEG[8]
+ Tile_X0Y1_SS4BEG[9] Tile_X0Y1_UserCLK Tile_X0Y1_UserCLKo Tile_X0Y1_W1BEG[0] Tile_X0Y1_W1BEG[1]
+ Tile_X0Y1_W1BEG[2] Tile_X0Y1_W1BEG[3] Tile_X0Y1_W1END[0] Tile_X0Y1_W1END[1] Tile_X0Y1_W1END[2]
+ Tile_X0Y1_W1END[3] Tile_X0Y1_W2BEG[0] Tile_X0Y1_W2BEG[1] Tile_X0Y1_W2BEG[2] Tile_X0Y1_W2BEG[3]
+ Tile_X0Y1_W2BEG[4] Tile_X0Y1_W2BEG[5] Tile_X0Y1_W2BEG[6] Tile_X0Y1_W2BEG[7] Tile_X0Y1_W2BEGb[0]
+ Tile_X0Y1_W2BEGb[1] Tile_X0Y1_W2BEGb[2] Tile_X0Y1_W2BEGb[3] Tile_X0Y1_W2BEGb[4]
+ Tile_X0Y1_W2BEGb[5] Tile_X0Y1_W2BEGb[6] Tile_X0Y1_W2BEGb[7] Tile_X0Y1_W2END[0] Tile_X0Y1_W2END[1]
+ Tile_X0Y1_W2END[2] Tile_X0Y1_W2END[3] Tile_X0Y1_W2END[4] Tile_X0Y1_W2END[5] Tile_X0Y1_W2END[6]
+ Tile_X0Y1_W2END[7] Tile_X0Y1_W2MID[0] Tile_X0Y1_W2MID[1] Tile_X0Y1_W2MID[2] Tile_X0Y1_W2MID[3]
+ Tile_X0Y1_W2MID[4] Tile_X0Y1_W2MID[5] Tile_X0Y1_W2MID[6] Tile_X0Y1_W2MID[7] Tile_X0Y1_W6BEG[0]
+ Tile_X0Y1_W6BEG[10] Tile_X0Y1_W6BEG[11] Tile_X0Y1_W6BEG[1] Tile_X0Y1_W6BEG[2] Tile_X0Y1_W6BEG[3]
+ Tile_X0Y1_W6BEG[4] Tile_X0Y1_W6BEG[5] Tile_X0Y1_W6BEG[6] Tile_X0Y1_W6BEG[7] Tile_X0Y1_W6BEG[8]
+ Tile_X0Y1_W6BEG[9] Tile_X0Y1_W6END[0] Tile_X0Y1_W6END[10] Tile_X0Y1_W6END[11] Tile_X0Y1_W6END[1]
+ Tile_X0Y1_W6END[2] Tile_X0Y1_W6END[3] Tile_X0Y1_W6END[4] Tile_X0Y1_W6END[5] Tile_X0Y1_W6END[6]
+ Tile_X0Y1_W6END[7] Tile_X0Y1_W6END[8] Tile_X0Y1_W6END[9] Tile_X0Y1_WW4BEG[0] Tile_X0Y1_WW4BEG[10]
+ Tile_X0Y1_WW4BEG[11] Tile_X0Y1_WW4BEG[12] Tile_X0Y1_WW4BEG[13] Tile_X0Y1_WW4BEG[14]
+ Tile_X0Y1_WW4BEG[15] Tile_X0Y1_WW4BEG[1] Tile_X0Y1_WW4BEG[2] Tile_X0Y1_WW4BEG[3]
+ Tile_X0Y1_WW4BEG[4] Tile_X0Y1_WW4BEG[5] Tile_X0Y1_WW4BEG[6] Tile_X0Y1_WW4BEG[7]
+ Tile_X0Y1_WW4BEG[8] Tile_X0Y1_WW4BEG[9] Tile_X0Y1_WW4END[0] Tile_X0Y1_WW4END[10]
+ Tile_X0Y1_WW4END[11] Tile_X0Y1_WW4END[12] Tile_X0Y1_WW4END[13] Tile_X0Y1_WW4END[14]
+ Tile_X0Y1_WW4END[15] Tile_X0Y1_WW4END[1] Tile_X0Y1_WW4END[2] Tile_X0Y1_WW4END[3]
+ Tile_X0Y1_WW4END[4] Tile_X0Y1_WW4END[5] Tile_X0Y1_WW4END[6] Tile_X0Y1_WW4END[7]
+ Tile_X0Y1_WW4END[8] Tile_X0Y1_WW4END[9] VGND VPWR
XFILLER_79_380 VPWR VGND sg13cmos5l_fill_1
X_3155_ _3155_/Y _6096_/Q _3152_/Y _3154_/Y VPWR VGND sg13cmos5l_a21oi_1
XFILLER_39_255 VPWR VGND sg13cmos5l_fill_1
X_3086_ _3086_/X Tile_X0Y0_E2END[4] Tile_X0Y0_W2END[4] _5652_/Q VPWR VGND sg13cmos5l_mux2_1
XFILLER_39_299 VPWR VGND sg13cmos5l_fill_2
X_6845_ Tile_X0Y1_W6BEG[5] Tile_X0Y1_W6END[7] VPWR VGND sg13cmos5l_buf_1
X_6776_ Tile_X0Y1_S2BEG[5] _6776_/A VPWR VGND sg13cmos5l_buf_1
X_3988_ _3988_/Y Tile_X0Y0_S1END[1] _5714_/Q _3987_/Y VPWR VGND sg13cmos5l_o21ai_1
XFILLER_10_317 VPWR VGND sg13cmos5l_fill_1
X_5727_ _5727_/Q Tile_X0Y0_FrameData[3] Tile_X0Y1_FrameStrobe[4] VPWR VGND sg13cmos5l_dlhq_1
X_2939_ _2939_/Y _6062_/Q _2892_/Y _2938_/Y VPWR VGND sg13cmos5l_a21oi_1
X_5658_ _5658_/Q Tile_X0Y0_FrameData[8] Tile_X0Y1_FrameStrobe[2] VPWR VGND sg13cmos5l_dlhq_1
X_5589_ _5589_/Q Tile_X0Y0_FrameData[13] Tile_X0Y1_FrameStrobe[0] VPWR VGND sg13cmos5l_dlhq_1
X_4609_ _4611_/B _4609_/A _4609_/B VPWR VGND sg13cmos5l_xor2_1
XANTENNA_202 Tile_X0Y1_W2MID[6] VPWR VGND sg13cmos5l_antennanp
XANTENNA_213 Tile_X0Y1_W2MID[7] VPWR VGND sg13cmos5l_antennanp
XANTENNA_224 Tile_X0Y0_E2MID[5] VPWR VGND sg13cmos5l_antennanp
XANTENNA_235 Tile_X0Y0_S4END[5] VPWR VGND sg13cmos5l_antennanp
XANTENNA_246 Tile_X0Y0_S4END[5] VPWR VGND sg13cmos5l_antennanp
XANTENNA_257 Tile_X0Y0_W2END[7] VPWR VGND sg13cmos5l_antennanp
XANTENNA_268 Tile_X0Y1_FrameData[29] VPWR VGND sg13cmos5l_antennanp
XFILLER_53_291 VPWR VGND sg13cmos5l_fill_1
XFILLER_5_343 VPWR VGND sg13cmos5l_decap_8
XANTENNA__6794__X Tile_X0Y1_S4BEG[7] VPWR VGND sg13cmos5l_antennanp
XFILLER_3_78 VPWR VGND sg13cmos5l_decap_4
XFILLER_67_81 VPWR VGND sg13cmos5l_fill_1
X_4960_ _4960_/Y _5604_/Q _4937_/Y _4959_/Y VPWR VGND sg13cmos5l_a21oi_1
X_4891_ _4891_/Y _5607_/Q _4891_/B VPWR VGND sg13cmos5l_nor2_1
X_3911_ _3911_/Y _3913_/A _3913_/B VPWR VGND sg13cmos5l_nand2b_1
X_6630_ Tile_X0Y0_NN4BEG[8] _6630_/A VPWR VGND sg13cmos5l_buf_1
X_3842_ _3842_/Y _6213_/Q _3842_/B VPWR VGND sg13cmos5l_nand2_1
X_6561_ Tile_X0Y0_FrameData_O[27] Tile_X0Y0_FrameData[27] VPWR VGND sg13cmos5l_buf_1
X_5512_ _5512_/X Tile_X0Y1_E1END[2] _4503_/Y Tile_X0Y1_W1END[2] _3916_/Y _6312_/Q
+ _6314_/Q VPWR VGND sg13cmos5l_mux4_1
X_3773_ _3773_/Y _6027_/Q _3772_/Y _6294_/Q VPWR VGND sg13cmos5l_o21ai_1
X_6492_ Tile_X0Y0_E2BEG[2] _6492_/A VPWR VGND sg13cmos5l_buf_1
X_2724_ _2724_/Y Tile_X0Y0_E2MID[6] VPWR VGND sg13cmos5l_inv_1
XFILLER_66_0 VPWR VGND sg13cmos5l_fill_2
X_5443_ _5446_/B _6108_/Q _5439_/X _5442_/Y VPWR VGND sg13cmos5l_o21ai_1
X_5374_ _5374_/Y _6138_/Q _5374_/B VPWR VGND sg13cmos5l_nand2_1
X_4325_ _4325_/Y _6282_/Q _5420_/B _4324_/Y VPWR VGND sg13cmos5l_o21ai_1
X_4256_ _4258_/B _4256_/A _4256_/B VPWR VGND sg13cmos5l_xnor2_1
X_4187_ _4187_/Y _4137_/A _4709_/A _4186_/Y VPWR VGND sg13cmos5l_a21oi_1
X_3207_ _3729_/B _2886_/Y _3201_/A _3205_/Y _3186_/X _5919_/Q _5920_/Q VPWR VGND sg13cmos5l_mux4_1
X_3138_ _6786_/A _3138_/A VPWR VGND sg13cmos5l_inv_1
XFILLER_103_46 VPWR VGND sg13cmos5l_fill_1
X_3069_ _3069_/Y _5696_/Q _3069_/B VPWR VGND sg13cmos5l_nand2b_1
XFILLER_63_17 VPWR VGND sg13cmos5l_fill_2
X_6828_ Tile_X0Y1_W2BEG[4] Tile_X0Y1_W2END[4] VPWR VGND sg13cmos5l_buf_1
X_6759_ Tile_X0Y1_FrameData_O[24] Tile_X0Y1_FrameData[24] VPWR VGND sg13cmos5l_buf_1
XFILLER_12_10 VPWR VGND sg13cmos5l_fill_1
XFILLER_104_230 VPWR VGND sg13cmos5l_fill_2
XFILLER_73_320 VPWR VGND sg13cmos5l_fill_1
XFILLER_18_258 VPWR VGND sg13cmos5l_fill_1
XFILLER_73_364 VPWR VGND sg13cmos5l_fill_1
XFILLER_26_291 VPWR VGND sg13cmos5l_fill_2
XANTENNA__6789__X Tile_X0Y1_S4BEG[2] VPWR VGND sg13cmos5l_antennanp
X_5090_ _5090_/Y _5729_/Q _5090_/B VPWR VGND sg13cmos5l_nor2_1
X_4110_ _4110_/X _4111_/A _4111_/B VPWR VGND sg13cmos5l_and2_1
XFILLER_68_114 VPWR VGND sg13cmos5l_fill_2
X_4041_ _4215_/B _4041_/A _4041_/B VPWR VGND sg13cmos5l_or2_1
XFILLER_110_266 VPWR VGND sg13cmos5l_decap_4
XFILLER_64_320 VPWR VGND sg13cmos5l_fill_2
X_5992_ _5992_/Q Tile_X0Y1_UserCLK _5992_/D _6446_/L_HI VPWR VGND sg13cmos5l_dfrbpq_1
X_4943_ _4943_/Y _6423_/Q _5546_/B _4942_/Y VPWR VGND sg13cmos5l_o21ai_1
X_6613_ Tile_X0Y0_N4BEG[7] Tile_X0Y1_N4END[15] VPWR VGND sg13cmos5l_buf_1
X_4874_ _4874_/Y _4875_/A _4875_/B VPWR VGND sg13cmos5l_nor2_1
X_3825_ _3825_/Y Tile_X0Y0_E6END[1] _5666_/Q _3824_/Y VPWR VGND sg13cmos5l_a21oi_1
XANTENNA__6699__X Tile_X0Y1_E2BEGb[0] VPWR VGND sg13cmos5l_antennanp
X_6544_ Tile_X0Y0_FrameData_O[10] Tile_X0Y0_FrameData[10] VPWR VGND sg13cmos5l_buf_1
X_3756_ _3756_/X Tile_X0Y0_S4END[6] _6694_/A _6026_/Q VPWR VGND sg13cmos5l_mux2_1
X_6475_ _6475_/L_HI VPWR VGND sg13cmos5l_tiehi
X_2707_ _2707_/Y _5629_/Q VPWR VGND sg13cmos5l_inv_1
X_5426_ _6818_/A _5426_/A _5426_/B VPWR VGND sg13cmos5l_nor2_1
X_3687_ _3687_/Y _2786_/Y _6104_/Q _3686_/Y VPWR VGND sg13cmos5l_a21oi_1
X_5357_ _5357_/X _3458_/A _5420_/B _6370_/Q VPWR VGND sg13cmos5l_mux2_1
X_5288_ _5295_/A _6395_/Q _5288_/B VPWR VGND sg13cmos5l_nor2_1
X_4308_ _4308_/Y _6016_/Q _4308_/B _4308_/C VPWR VGND sg13cmos5l_nand3_1
X_4239_ _4330_/B _4239_/A _4239_/B VPWR VGND sg13cmos5l_xor2_1
XFILLER_0_35 VPWR VGND sg13cmos5l_decap_8
XFILLER_14_250 VPWR VGND sg13cmos5l_fill_1
X_4590_ _4593_/C _4590_/A _4590_/B VPWR VGND sg13cmos5l_xnor2_1
X_3610_ _3610_/Y Tile_X0Y0_SS4END[7] _6036_/Q _3609_/Y VPWR VGND sg13cmos5l_a21oi_1
X_3541_ _3541_/Y _5656_/Q _4934_/Y VPWR VGND sg13cmos5l_nor2_1
X_6260_ _6260_/Q Tile_X0Y1_FrameData[8] Tile_X0Y1_FrameStrobe[7] VPWR VGND sg13cmos5l_dlhq_1
X_3472_ _3472_/Y _3473_/B VPWR VGND sg13cmos5l_inv_1
X_6191_ _6191_/Q Tile_X0Y1_FrameData[13] Tile_X0Y1_FrameStrobe[5] VPWR VGND sg13cmos5l_dlhq_1
X_5211_ _5211_/X _4127_/A _4665_/X _5881_/Q VPWR VGND sg13cmos5l_mux2_1
X_5142_ _5142_/Y _5926_/Q _5141_/X _5925_/Q VPWR VGND sg13cmos5l_o21ai_1
XFILLER_29_0 VPWR VGND sg13cmos5l_fill_1
X_5073_ _5074_/A _5949_/Q _5072_/X _5071_/Y VPWR VGND sg13cmos5l_o21ai_1
X_4024_ _4024_/Y _4024_/A _5600_/Q VPWR VGND sg13cmos5l_nand2_1
X_5975_ _5975_/Q Tile_X0Y0_FrameData[11] Tile_X0Y1_FrameStrobe[12] VPWR VGND sg13cmos5l_dlhq_1
X_4926_ _4926_/Y _4927_/B _5006_/A VPWR VGND sg13cmos5l_nor2b_1
X_4857_ _4857_/X _5579_/Q _4851_/X _4856_/Y VPWR VGND sg13cmos5l_a21o_1
X_3808_ _3808_/X _6053_/Q _3808_/B VPWR VGND sg13cmos5l_and2_1
X_6527_ Tile_X0Y0_EE4BEG[9] Tile_X0Y0_EE4END[13] VPWR VGND sg13cmos5l_buf_1
X_4788_ _4788_/Y _5578_/Q Tile_X0Y0_S4END[3] _5577_/Q VPWR VGND sg13cmos5l_o21ai_1
X_3739_ _3739_/Y _5440_/B _6120_/Q VPWR VGND sg13cmos5l_nor2b_1
X_6458_ _6458_/L_HI VPWR VGND sg13cmos5l_tiehi
XFILLER_107_7 VPWR VGND sg13cmos5l_decap_8
X_5409_ _6816_/A _5407_/X _5408_/X _6345_/Q VPWR VGND sg13cmos5l_mux2_1
X_6389_ _6389_/Q Tile_X0Y1_FrameData[7] Tile_X0Y1_FrameStrobe[11] VPWR VGND sg13cmos5l_dlhq_1
XFILLER_34_63 VPWR VGND sg13cmos5l_fill_2
XFILLER_109_141 VPWR VGND sg13cmos5l_fill_2
XFILLER_59_71 VPWR VGND sg13cmos5l_decap_8
XFILLER_19_331 VPWR VGND sg13cmos5l_fill_1
XFILLER_19_364 VPWR VGND sg13cmos5l_fill_1
XFILLER_34_323 VPWR VGND sg13cmos5l_fill_1
X_5760_ _5760_/Q Tile_X0Y0_FrameData[2] Tile_X0Y1_FrameStrobe[5] VPWR VGND sg13cmos5l_dlhq_1
X_2972_ _2972_/Y _6171_/Q _2970_/X _2971_/Y VPWR VGND sg13cmos5l_o21ai_1
XFILLER_61_175 VPWR VGND sg13cmos5l_decap_8
X_5691_ _5691_/Q Tile_X0Y0_FrameData[7] Tile_X0Y1_FrameStrobe[3] VPWR VGND sg13cmos5l_dlhq_1
X_4711_ _4721_/A _4712_/A _4712_/B _4712_/C VPWR VGND sg13cmos5l_o21ai_1
X_4642_ _4642_/Y _5708_/Q Tile_X0Y0_E1END[2] VPWR VGND sg13cmos5l_nor2_1
X_4573_ _4574_/B _4263_/A _4683_/A _4570_/Y VPWR VGND sg13cmos5l_o21ai_1
X_6312_ _6312_/Q Tile_X0Y1_FrameData[20] Tile_X0Y1_FrameStrobe[9] VPWR VGND sg13cmos5l_dlhq_1
X_3524_ _3531_/B _6136_/Q _3522_/Y _3523_/Y VPWR VGND sg13cmos5l_a21o_1
X_6243_ _6243_/Q Tile_X0Y1_FrameData[25] Tile_X0Y1_FrameStrobe[7] VPWR VGND sg13cmos5l_dlhq_1
X_3455_ _3455_/Y _2847_/Y _3451_/X _3454_/Y VPWR VGND sg13cmos5l_o21ai_1
XFILLER_103_317 VPWR VGND sg13cmos5l_fill_2
X_6174_ _6174_/Q Tile_X0Y1_FrameData[30] Tile_X0Y1_FrameStrobe[5] VPWR VGND sg13cmos5l_dlhq_1
X_3386_ _3386_/Y _6091_/Q _3385_/X _2854_/Y VPWR VGND sg13cmos5l_a21oi_1
X_5125_ _5125_/Y _5125_/A VPWR VGND sg13cmos5l_inv_1
XFILLER_111_361 VPWR VGND sg13cmos5l_fill_1
XFILLER_111_350 VPWR VGND sg13cmos5l_fill_1
X_5056_ _5056_/Y _5056_/A _5955_/Q VPWR VGND sg13cmos5l_nor2b_1
XFILLER_84_223 VPWR VGND sg13cmos5l_fill_2
X_4007_ _4007_/Y _4007_/A _4111_/A VPWR VGND sg13cmos5l_nand2_1
XFILLER_37_150 VPWR VGND sg13cmos5l_fill_1
XFILLER_25_312 VPWR VGND sg13cmos5l_fill_2
XFILLER_111_13 VPWR VGND sg13cmos5l_decap_4
XFILLER_111_24 VPWR VGND sg13cmos5l_fill_1
X_5958_ _5958_/Q Tile_X0Y0_FrameData[28] Tile_X0Y1_FrameStrobe[12] VPWR VGND sg13cmos5l_dlhq_1
XFILLER_71_17 VPWR VGND sg13cmos5l_fill_1
X_4909_ _4909_/X _4908_/Y _5569_/Q _6423_/Q VPWR VGND sg13cmos5l_mux2_1
X_5889_ _5889_/Q Tile_X0Y0_FrameData[1] Tile_X0Y1_FrameStrobe[9] VPWR VGND sg13cmos5l_dlhq_1
XFILLER_106_100 VPWR VGND sg13cmos5l_fill_1
XFILLER_20_76 VPWR VGND sg13cmos5l_fill_2
XFILLER_96_47 VPWR VGND sg13cmos5l_fill_2
XFILLER_16_367 VPWR VGND sg13cmos5l_fill_1
XFILLER_6_23 VPWR VGND sg13cmos5l_fill_1
XFILLER_6_12 VPWR VGND sg13cmos5l_fill_2
XANTENNA__6797__X Tile_X0Y1_S4BEG[10] VPWR VGND sg13cmos5l_antennanp
XANTENNA_5 Tile_X0Y0_E2END[7] VPWR VGND sg13cmos5l_antennanp
X_3240_ _3240_/X _2889_/Y _2890_/Y _5692_/Q VPWR VGND sg13cmos5l_mux2_1
X_3171_ _3171_/X _2891_/Y _5450_/B _3168_/Y _3162_/Y _6420_/Q _6419_/Q VPWR VGND sg13cmos5l_mux4_1
XFILLER_66_234 VPWR VGND sg13cmos5l_decap_4
XFILLER_66_289 VPWR VGND sg13cmos5l_fill_2
X_6861_ Tile_X0Y1_WW4BEG[9] Tile_X0Y1_WW4END[13] VPWR VGND sg13cmos5l_buf_1
XFILLER_34_131 VPWR VGND sg13cmos5l_fill_1
X_5812_ _5812_/Q Tile_X0Y0_FrameData[14] Tile_X0Y1_FrameStrobe[7] VPWR VGND sg13cmos5l_dlhq_1
X_6792_ Tile_X0Y1_S4BEG[5] Tile_X0Y0_S4END[13] VPWR VGND sg13cmos5l_buf_1
XFILLER_34_153 VPWR VGND sg13cmos5l_fill_2
X_5743_ _5743_/Q Tile_X0Y0_FrameData[19] Tile_X0Y1_FrameStrobe[5] VPWR VGND sg13cmos5l_dlhq_1
XFILLER_96_0 VPWR VGND sg13cmos5l_fill_1
X_2955_ _2955_/X Tile_X0Y0_E2END[2] _5058_/B Tile_X0Y0_E6END[0] Tile_X0Y1_N2MID[2]
+ _2707_/Y _5630_/Q VPWR VGND sg13cmos5l_mux4_1
X_5674_ _5674_/Q Tile_X0Y0_FrameData[24] Tile_X0Y1_FrameStrobe[3] VPWR VGND sg13cmos5l_dlhq_1
X_2886_ _2886_/Y _4943_/Y VPWR VGND sg13cmos5l_inv_1
X_4625_ _4625_/X Tile_X0Y1_N2MID[7] Tile_X0Y0_EE4END[2] Tile_X0Y0_S2END[7] Tile_X0Y0_W2END[7]
+ _5746_/Q _5745_/Q VPWR VGND sg13cmos5l_mux4_1
X_4556_ _4556_/Y _4550_/Y _4555_/Y _4554_/Y VPWR VGND sg13cmos5l_o21ai_1
XANTENNA__6500__X Tile_X0Y0_E2BEGb[2] VPWR VGND sg13cmos5l_antennanp
X_3507_ _3507_/Y _2826_/Y _6236_/Q _6235_/Q VPWR VGND sg13cmos5l_a21oi_1
X_4487_ _4593_/A _4488_/A _4488_/B VPWR VGND sg13cmos5l_nand2_1
X_6226_ _6226_/Q Tile_X0Y1_FrameData[10] Tile_X0Y1_FrameStrobe[6] VPWR VGND sg13cmos5l_dlhq_1
X_3438_ _3438_/Y _2756_/Y _5650_/Q _5649_/Q VPWR VGND sg13cmos5l_a21oi_1
X_6157_ _6157_/Q Tile_X0Y1_FrameData[15] Tile_X0Y1_FrameStrobe[4] VPWR VGND sg13cmos5l_dlhq_1
X_3369_ _3369_/Y _6082_/Q _3366_/Y _3368_/Y VPWR VGND sg13cmos5l_a21oi_1
XFILLER_106_46 VPWR VGND sg13cmos5l_decap_8
X_5108_ _5114_/A _5935_/Q _5108_/B VPWR VGND sg13cmos5l_nor2_1
X_6088_ _6088_/Q Tile_X0Y1_FrameData[20] Tile_X0Y1_FrameStrobe[2] VPWR VGND sg13cmos5l_dlhq_1
X_5039_ _6620_/A Tile_X0Y1_N2MID[0] Tile_X0Y1_N4END[7] Tile_X0Y0_W6END[1] _4937_/Y
+ _5964_/Q _5963_/Q VPWR VGND sg13cmos5l_mux4_1
XFILLER_57_289 VPWR VGND sg13cmos5l_fill_2
XFILLER_56_50 VPWR VGND sg13cmos5l_fill_2
XFILLER_63_226 VPWR VGND sg13cmos5l_fill_1
XFILLER_63_204 VPWR VGND sg13cmos5l_fill_1
X_2740_ _2740_/Y Tile_X0Y0_E2MID[5] VPWR VGND sg13cmos5l_inv_1
XFILLER_31_189 VPWR VGND sg13cmos5l_fill_2
XFILLER_8_341 VPWR VGND sg13cmos5l_decap_8
X_4410_ _4410_/Y _6046_/Q _5374_/B _4409_/Y VPWR VGND sg13cmos5l_a21oi_1
X_5390_ _5390_/Y _6364_/Q _5390_/B VPWR VGND sg13cmos5l_nor2_1
X_4341_ _4341_/Y _4334_/Y _4337_/Y _4340_/Y VPWR VGND sg13cmos5l_o21ai_1
X_4272_ _4272_/Y _4273_/A _4273_/B VPWR VGND sg13cmos5l_nor2b_1
X_6011_ _6011_/Q Tile_X0Y1_UserCLK _6011_/D _6465_/L_HI VPWR VGND sg13cmos5l_dfrbpq_1
X_3223_ _3223_/Y Tile_X0Y0_S1END[1] _5618_/Q _3222_/Y VPWR VGND sg13cmos5l_o21ai_1
X_3154_ _3154_/Y _6096_/Q _3153_/X _6095_/Q VPWR VGND sg13cmos5l_o21ai_1
XFILLER_11_0 VPWR VGND sg13cmos5l_fill_2
X_3085_ _3085_/Y _3085_/A _3085_/B VPWR VGND sg13cmos5l_nand2_1
XFILLER_39_278 VPWR VGND sg13cmos5l_fill_1
X_6844_ Tile_X0Y1_W6BEG[4] Tile_X0Y1_W6END[6] VPWR VGND sg13cmos5l_buf_1
X_6775_ Tile_X0Y1_S2BEG[4] _6775_/A VPWR VGND sg13cmos5l_buf_1
X_3987_ _3987_/Y _2756_/Y _5714_/Q _5713_/Q VPWR VGND sg13cmos5l_a21oi_1
X_5726_ _5726_/Q Tile_X0Y0_FrameData[4] Tile_X0Y1_FrameStrobe[4] VPWR VGND sg13cmos5l_dlhq_1
X_2938_ _2938_/Y _6062_/Q _4503_/Y VPWR VGND sg13cmos5l_nor2_1
X_5657_ _5657_/Q Tile_X0Y0_FrameData[9] Tile_X0Y1_FrameStrobe[2] VPWR VGND sg13cmos5l_dlhq_1
X_2869_ _2869_/Y _5681_/Q VPWR VGND sg13cmos5l_inv_1
X_5588_ _5588_/Q Tile_X0Y0_FrameData[14] Tile_X0Y1_FrameStrobe[0] VPWR VGND sg13cmos5l_dlhq_1
X_4608_ _4692_/B _4609_/A _4609_/B VPWR VGND sg13cmos5l_and2_1
X_4539_ _4546_/A _5677_/Q _4539_/B VPWR VGND sg13cmos5l_nor2_1
X_6209_ _6209_/Q Tile_X0Y1_FrameData[27] Tile_X0Y1_FrameStrobe[6] VPWR VGND sg13cmos5l_dlhq_1
XANTENNA_203 Tile_X0Y1_W2MID[6] VPWR VGND sg13cmos5l_antennanp
XANTENNA_214 Tile_X0Y1_W2MID[7] VPWR VGND sg13cmos5l_antennanp
XANTENNA_225 Tile_X0Y0_E2MID[5] VPWR VGND sg13cmos5l_antennanp
XANTENNA_236 Tile_X0Y0_S4END[5] VPWR VGND sg13cmos5l_antennanp
XANTENNA_247 Tile_X0Y0_S4END[5] VPWR VGND sg13cmos5l_antennanp
XANTENNA_258 Tile_X0Y1_FrameData[29] VPWR VGND sg13cmos5l_antennanp
XANTENNA_269 Tile_X0Y1_FrameData[29] VPWR VGND sg13cmos5l_antennanp
XFILLER_5_377 VPWR VGND sg13cmos5l_decap_4
XFILLER_68_307 VPWR VGND sg13cmos5l_fill_1
XFILLER_95_137 VPWR VGND sg13cmos5l_fill_2
X_4890_ _4891_/B _5610_/Q _4888_/Y _4889_/Y VPWR VGND sg13cmos5l_a21oi_1
X_3910_ _3913_/B _3910_/A _3910_/B VPWR VGND sg13cmos5l_xor2_1
X_3841_ _3842_/B _6214_/Q _2915_/A _3840_/Y VPWR VGND sg13cmos5l_o21ai_1
X_6560_ Tile_X0Y0_FrameData_O[26] Tile_X0Y0_FrameData[26] VPWR VGND sg13cmos5l_buf_1
X_3772_ _3772_/Y Tile_X0Y1_E2END[3] _6028_/Q _3771_/Y VPWR VGND sg13cmos5l_a21oi_1
X_5511_ _6850_/A _5503_/Y _5505_/Y _5510_/Y VPWR VGND sg13cmos5l_o21ai_1
X_2723_ _3626_/A Tile_X0Y1_N2MID[7] VPWR VGND sg13cmos5l_inv_1
X_6491_ Tile_X0Y0_E2BEG[1] _6491_/A VPWR VGND sg13cmos5l_buf_1
X_5442_ _5442_/Y _6108_/Q _5441_/Y _2801_/Y VPWR VGND sg13cmos5l_a21oi_1
X_5373_ _5387_/A _6139_/Q _5366_/X _5372_/Y VPWR VGND sg13cmos5l_o21ai_1
X_4324_ _4324_/Y _6281_/Q _4324_/B VPWR VGND sg13cmos5l_nor2_1
X_4255_ _4472_/A _4255_/A VPWR VGND sg13cmos5l_inv_1
X_4186_ _4186_/Y _4186_/A _4708_/A VPWR VGND sg13cmos5l_nor2_1
X_3206_ _3206_/X _3203_/B _3204_/X _3206_/S VPWR VGND sg13cmos5l_mux2_1
X_3137_ _3138_/A _3137_/A _3137_/B VPWR VGND sg13cmos5l_and2_1
X_3068_ _3069_/B Tile_X0Y1_N4END[5] Tile_X0Y0_EE4END[1] _5698_/Q VPWR VGND sg13cmos5l_mux2_1
X_6827_ Tile_X0Y1_W2BEG[3] Tile_X0Y1_W2END[3] VPWR VGND sg13cmos5l_buf_1
X_6758_ Tile_X0Y1_FrameData_O[23] Tile_X0Y1_FrameData[23] VPWR VGND sg13cmos5l_buf_1
X_5709_ _5709_/Q Tile_X0Y0_FrameData[21] Tile_X0Y1_FrameStrobe[4] VPWR VGND sg13cmos5l_dlhq_1
X_6689_ Tile_X0Y1_E1BEG[2] _6689_/A VPWR VGND sg13cmos5l_buf_1
XFILLER_18_248 VPWR VGND sg13cmos5l_fill_1
XFILLER_5_196 VPWR VGND sg13cmos5l_fill_1
X_4040_ _4041_/B _4137_/A _4570_/A _4571_/A _4138_/A VPWR VGND sg13cmos5l_a22oi_1
X_5991_ _5991_/Q Tile_X0Y1_UserCLK _5991_/D _6445_/L_HI VPWR VGND sg13cmos5l_dfrbpq_1
X_4942_ _4942_/Y _5566_/Q _6423_/Q VPWR VGND sg13cmos5l_nand2_1
X_6612_ Tile_X0Y0_N4BEG[6] Tile_X0Y1_N4END[14] VPWR VGND sg13cmos5l_buf_1
X_4873_ _5010_/A _4941_/A _4941_/B _4825_/Y VPWR VGND sg13cmos5l_a21oi_1
X_3824_ _3824_/Y _5666_/Q Tile_X0Y0_E2END[1] VPWR VGND sg13cmos5l_nor2b_1
X_6543_ Tile_X0Y0_FrameData_O[9] Tile_X0Y0_FrameData[9] VPWR VGND sg13cmos5l_buf_1
X_3755_ _3755_/Y _3749_/Y _3752_/Y _3754_/Y VPWR VGND sg13cmos5l_o21ai_1
X_6474_ _6474_/L_HI VPWR VGND sg13cmos5l_tiehi
X_3686_ _3686_/Y Tile_X0Y1_W2END[2] _6104_/Q _6102_/Q VPWR VGND sg13cmos5l_o21ai_1
X_5425_ _5426_/B _2799_/Y _5423_/Y _5424_/Y VPWR VGND sg13cmos5l_a21oi_1
X_5356_ _5356_/Y _6369_/Q _5354_/X _5355_/Y VPWR VGND sg13cmos5l_a21oi_1
XFILLER_58_18 VPWR VGND sg13cmos5l_decap_4
X_5287_ _5288_/B Tile_X0Y1_N1END[1] Tile_X0Y1_E1END[1] Tile_X0Y1_W1END[1] _5390_/B
+ _6397_/Q _6396_/Q VPWR VGND sg13cmos5l_mux4_1
X_4307_ _4329_/A _6425_/Q _5558_/Q VPWR VGND sg13cmos5l_nand2_1
XFILLER_59_115 VPWR VGND sg13cmos5l_decap_4
X_4238_ _4330_/A _4233_/Y _4354_/B _4232_/Y VPWR VGND sg13cmos5l_o21ai_1
X_4169_ _4170_/A _2771_/Y _5626_/Q _4168_/Y VPWR VGND sg13cmos5l_a21oi_1
XFILLER_109_345 VPWR VGND sg13cmos5l_decap_4
XFILLER_109_367 VPWR VGND sg13cmos5l_fill_1
XFILLER_0_14 VPWR VGND sg13cmos5l_decap_8
XFILLER_61_324 VPWR VGND sg13cmos5l_fill_1
XFILLER_61_379 VPWR VGND sg13cmos5l_fill_2
X_3540_ _3540_/Y _5656_/Q _2894_/Y _3539_/Y VPWR VGND sg13cmos5l_a21oi_1
X_5210_ _5210_/Y _5881_/Q _4909_/X _5209_/Y VPWR VGND sg13cmos5l_o21ai_1
X_3471_ _3473_/B Tile_X0Y1_N2END[2] Tile_X0Y1_E2END[2] Tile_X0Y0_S2MID[2] Tile_X0Y1_WW4END[2]
+ _6194_/Q _6193_/Q VPWR VGND sg13cmos5l_mux4_1
XFILLER_50_4 VPWR VGND sg13cmos5l_decap_8
X_6190_ _6190_/Q Tile_X0Y1_FrameData[14] Tile_X0Y1_FrameStrobe[5] VPWR VGND sg13cmos5l_dlhq_1
X_5141_ _5141_/X _4937_/Y _4909_/X _5062_/B _5009_/Y _5928_/Q _5927_/Q VPWR VGND sg13cmos5l_mux4_1
X_5072_ _5072_/X Tile_X0Y0_E1END[1] _3172_/Y _5011_/X Tile_X0Y0_W1END[1] _2775_/Y
+ _5950_/Q VPWR VGND sg13cmos5l_mux4_1
X_4023_ _4027_/A _5600_/Q _3258_/A _4022_/Y VPWR VGND sg13cmos5l_a21oi_1
XFILLER_49_192 VPWR VGND sg13cmos5l_decap_8
XFILLER_37_321 VPWR VGND sg13cmos5l_fill_2
XFILLER_52_335 VPWR VGND sg13cmos5l_fill_1
X_5974_ _5974_/Q Tile_X0Y0_FrameData[12] Tile_X0Y1_FrameStrobe[12] VPWR VGND sg13cmos5l_dlhq_1
X_4925_ _4927_/B _6425_/Q _5570_/Q _4923_/X _4924_/Y VPWR VGND sg13cmos5l_a22oi_1
X_4856_ _4856_/Y _5579_/Q _4853_/Y _5841_/Q VPWR VGND sg13cmos5l_o21ai_1
XANTENNA__6503__X Tile_X0Y0_E2BEGb[5] VPWR VGND sg13cmos5l_antennanp
X_3807_ _3808_/B _3806_/Y _6055_/Q _3807_/C VPWR VGND sg13cmos5l_nand3b_1
X_6526_ Tile_X0Y0_EE4BEG[8] Tile_X0Y0_EE4END[12] VPWR VGND sg13cmos5l_buf_1
X_4787_ _4823_/A _6425_/Q _5566_/Q VPWR VGND sg13cmos5l_nand2_1
XFILLER_109_13 VPWR VGND sg13cmos5l_fill_2
X_3738_ _3738_/Y _6120_/Q _2891_/Y _3737_/Y VPWR VGND sg13cmos5l_a21oi_1
X_6457_ _6457_/L_HI VPWR VGND sg13cmos5l_tiehi
X_3669_ _3669_/Y _6032_/Q Tile_X0Y1_NN4END[1] VPWR VGND sg13cmos5l_nor2b_1
X_5408_ _5408_/X _5262_/X _3643_/A _3714_/Y _3799_/X _6346_/Q _6347_/Q VPWR VGND sg13cmos5l_mux4_1
X_6388_ _6388_/Q Tile_X0Y1_FrameData[8] Tile_X0Y1_FrameStrobe[11] VPWR VGND sg13cmos5l_dlhq_1
X_5339_ _6734_/A _5338_/X _5337_/X _6375_/Q VPWR VGND sg13cmos5l_mux2_1
XFILLER_70_176 VPWR VGND sg13cmos5l_fill_2
XFILLER_43_379 VPWR VGND sg13cmos5l_fill_2
XFILLER_34_97 VPWR VGND sg13cmos5l_fill_2
XFILLER_109_197 VPWR VGND sg13cmos5l_fill_1
XFILLER_59_61 VPWR VGND sg13cmos5l_fill_2
X_2971_ _2971_/Y _6169_/Q _2971_/B VPWR VGND sg13cmos5l_nor2_1
XFILLER_34_379 VPWR VGND sg13cmos5l_fill_2
X_5690_ _5690_/Q Tile_X0Y0_FrameData[8] Tile_X0Y1_FrameStrobe[3] VPWR VGND sg13cmos5l_dlhq_1
X_4710_ _4712_/C _4710_/A _4710_/B VPWR VGND sg13cmos5l_xnor2_1
X_4641_ _4641_/Y _5708_/Q Tile_X0Y0_W1END[2] _4640_/Y VPWR VGND sg13cmos5l_a21oi_1
X_4572_ _4612_/A _4572_/A _4609_/A VPWR VGND sg13cmos5l_nand2_1
X_6311_ _6311_/Q Tile_X0Y1_FrameData[21] Tile_X0Y1_FrameStrobe[9] VPWR VGND sg13cmos5l_dlhq_1
X_3523_ _3523_/Y _6136_/Q _3520_/X _6135_/Q VPWR VGND sg13cmos5l_o21ai_1
X_6242_ _6242_/Q Tile_X0Y1_FrameData[26] Tile_X0Y1_FrameStrobe[7] VPWR VGND sg13cmos5l_dlhq_1
X_3454_ _3454_/Y _6085_/Q _3454_/B VPWR VGND sg13cmos5l_nor2_1
X_6173_ _6173_/Q Tile_X0Y1_FrameData[31] Tile_X0Y1_FrameStrobe[5] VPWR VGND sg13cmos5l_dlhq_1
X_3385_ _3385_/X _4409_/B _2892_/Y _2891_/Y _2895_/Y _6090_/Q _6092_/Q VPWR VGND sg13cmos5l_mux4_1
X_5124_ _5125_/A _5933_/Q _5121_/Y _5932_/Q VPWR VGND sg13cmos5l_o21ai_1
XFILLER_69_254 VPWR VGND sg13cmos5l_fill_2
X_5055_ _5055_/Y _5957_/Q _4909_/X _5054_/Y VPWR VGND sg13cmos5l_o21ai_1
X_4006_ _4111_/A _4254_/A _4263_/A VPWR VGND sg13cmos5l_nor2_1
X_5957_ _5957_/Q Tile_X0Y0_FrameData[29] Tile_X0Y1_FrameStrobe[12] VPWR VGND sg13cmos5l_dlhq_1
XFILLER_25_379 VPWR VGND sg13cmos5l_fill_2
X_4908_ _4908_/Y _4908_/A _4908_/B VPWR VGND sg13cmos5l_xnor2_1
X_5888_ _5888_/Q Tile_X0Y0_FrameData[2] Tile_X0Y1_FrameStrobe[9] VPWR VGND sg13cmos5l_dlhq_1
X_4839_ _4840_/B _4837_/X _4838_/Y _5613_/Q VPWR VGND sg13cmos5l_a21oi_1
X_6509_ Tile_X0Y0_E6BEG[3] Tile_X0Y0_E6END[5] VPWR VGND sg13cmos5l_buf_1
XFILLER_29_31 VPWR VGND sg13cmos5l_fill_1
XFILLER_28_140 VPWR VGND sg13cmos5l_fill_1
XANTENNA_6 Tile_X0Y0_E2END[7] VPWR VGND sg13cmos5l_antennanp
X_3170_ _3170_/X _6420_/Q _3162_/Y _3169_/Y VPWR VGND sg13cmos5l_a21o_1
X_6860_ Tile_X0Y1_WW4BEG[8] Tile_X0Y1_WW4END[12] VPWR VGND sg13cmos5l_buf_1
XFILLER_34_121 VPWR VGND sg13cmos5l_fill_1
X_5811_ _5811_/Q Tile_X0Y0_FrameData[15] Tile_X0Y1_FrameStrobe[7] VPWR VGND sg13cmos5l_dlhq_1
X_6791_ Tile_X0Y1_S4BEG[4] Tile_X0Y0_S4END[12] VPWR VGND sg13cmos5l_buf_1
XFILLER_34_176 VPWR VGND sg13cmos5l_fill_1
X_5742_ _5742_/Q Tile_X0Y0_FrameData[20] Tile_X0Y1_FrameStrobe[5] VPWR VGND sg13cmos5l_dlhq_1
X_2954_ _5058_/B _4503_/Y _2917_/X _2952_/A _2935_/X _6422_/Q _6421_/Q VPWR VGND sg13cmos5l_mux4_1
X_5673_ _5673_/Q Tile_X0Y0_FrameData[25] Tile_X0Y1_FrameStrobe[3] VPWR VGND sg13cmos5l_dlhq_1
X_2885_ _2885_/Y _5011_/X VPWR VGND sg13cmos5l_inv_1
X_4624_ _4627_/A _5585_/Q _4620_/X _4623_/Y VPWR VGND sg13cmos5l_a21oi_1
X_4555_ _4555_/Y _5583_/Q _4552_/Y _5845_/Q VPWR VGND sg13cmos5l_o21ai_1
X_3506_ _3509_/B _6236_/Q _6786_/A _3505_/Y VPWR VGND sg13cmos5l_o21ai_1
X_4486_ _4488_/B _4486_/A _4486_/B VPWR VGND sg13cmos5l_xnor2_1
X_6225_ _6225_/Q Tile_X0Y1_FrameData[11] Tile_X0Y1_FrameStrobe[6] VPWR VGND sg13cmos5l_dlhq_1
X_3437_ _3437_/X _3172_/Y Tile_X0Y0_E1END[1] Tile_X0Y1_N2MID[5] Tile_X0Y0_E2END[5]
+ _5649_/Q _5650_/Q VPWR VGND sg13cmos5l_mux4_1
XFILLER_106_25 VPWR VGND sg13cmos5l_decap_8
X_6156_ _6156_/Q Tile_X0Y1_FrameData[16] Tile_X0Y1_FrameStrobe[4] VPWR VGND sg13cmos5l_dlhq_1
X_3368_ _3368_/Y _6082_/Q _3367_/X _2863_/Y VPWR VGND sg13cmos5l_o21ai_1
XFILLER_97_360 VPWR VGND sg13cmos5l_decap_8
X_5107_ _5108_/B _3063_/X Tile_X0Y0_S1END[3] Tile_X0Y0_E1END[3] _4911_/X _5936_/Q
+ _5937_/Q VPWR VGND sg13cmos5l_mux4_1
X_6087_ _6087_/Q Tile_X0Y1_FrameData[21] Tile_X0Y1_FrameStrobe[2] VPWR VGND sg13cmos5l_dlhq_1
X_3299_ _5197_/B _4737_/B _2741_/Y _2740_/Y _2742_/Y _5789_/Q _5790_/Q VPWR VGND sg13cmos5l_mux4_1
XFILLER_57_268 VPWR VGND sg13cmos5l_fill_1
XFILLER_111_192 VPWR VGND sg13cmos5l_fill_1
X_5038_ _6619_/A Tile_X0Y1_N2MID[3] Tile_X0Y1_N4END[6] Tile_X0Y0_E6END[0] _5011_/X
+ _5966_/Q _5965_/Q VPWR VGND sg13cmos5l_mux4_1
XFILLER_72_216 VPWR VGND sg13cmos5l_fill_1
XFILLER_40_135 VPWR VGND sg13cmos5l_fill_2
XFILLER_56_62 VPWR VGND sg13cmos5l_fill_1
XFILLER_56_290 VPWR VGND sg13cmos5l_fill_1
XANTENNA__6601__X Tile_X0Y0_N2BEGb[3] VPWR VGND sg13cmos5l_antennanp
X_4340_ _4340_/Y _6283_/Q _4340_/B VPWR VGND sg13cmos5l_nor2_1
X_4271_ _4273_/B _4271_/A _4271_/B VPWR VGND sg13cmos5l_xor2_1
X_6010_ _6010_/Q Tile_X0Y1_UserCLK _6010_/D _6464_/L_HI VPWR VGND sg13cmos5l_dfrbpq_1
X_3222_ _3222_/Y _2748_/Y _5618_/Q _5617_/Q VPWR VGND sg13cmos5l_a21oi_1
X_3153_ _3153_/X _4409_/B _2892_/Y _6094_/Q VPWR VGND sg13cmos5l_mux2_1
X_3084_ _3085_/B Tile_X0Y1_N2MID[4] Tile_X0Y0_S2END[4] Tile_X0Y0_E1END[2] Tile_X0Y0_S4END[0]
+ _5652_/Q _5654_/Q VPWR VGND sg13cmos5l_mux4_1
X_6843_ Tile_X0Y1_W6BEG[3] Tile_X0Y1_W6END[5] VPWR VGND sg13cmos5l_buf_1
XFILLER_62_293 VPWR VGND sg13cmos5l_decap_4
XFILLER_62_271 VPWR VGND sg13cmos5l_fill_2
X_6774_ Tile_X0Y1_S2BEG[3] _6774_/A VPWR VGND sg13cmos5l_buf_1
X_3986_ _3986_/X _3172_/Y Tile_X0Y0_E1END[1] Tile_X0Y1_N2MID[5] Tile_X0Y0_E2END[5]
+ _5713_/Q _5714_/Q VPWR VGND sg13cmos5l_mux4_1
X_5725_ _5725_/Q Tile_X0Y0_FrameData[5] Tile_X0Y1_FrameStrobe[4] VPWR VGND sg13cmos5l_dlhq_1
X_2937_ _2937_/Y _6062_/Q _2895_/Y _2936_/Y VPWR VGND sg13cmos5l_a21oi_1
X_5656_ _5656_/Q Tile_X0Y0_FrameData[10] Tile_X0Y1_FrameStrobe[2] VPWR VGND sg13cmos5l_dlhq_1
XANTENNA__6511__X Tile_X0Y0_E6BEG[5] VPWR VGND sg13cmos5l_antennanp
X_4607_ _4609_/B _4607_/A _4607_/B VPWR VGND sg13cmos5l_xor2_1
X_2868_ _2868_/Y _5999_/Q VPWR VGND sg13cmos5l_inv_1
X_5587_ _5587_/Q Tile_X0Y0_FrameData[15] Tile_X0Y1_FrameStrobe[0] VPWR VGND sg13cmos5l_dlhq_1
X_2799_ _2799_/Y _6340_/Q VPWR VGND sg13cmos5l_inv_1
X_4538_ _4539_/B _4940_/Y _4934_/Y _4943_/Y _4937_/Y _5678_/Q _5676_/Q VPWR VGND sg13cmos5l_mux4_1
X_4469_ _4474_/A _4599_/A _4602_/A VPWR VGND sg13cmos5l_nor2_1
X_6208_ _6208_/Q Tile_X0Y1_FrameData[28] Tile_X0Y1_FrameStrobe[6] VPWR VGND sg13cmos5l_dlhq_1
X_6139_ _6139_/Q Tile_X0Y1_FrameData[1] Tile_X0Y1_FrameStrobe[3] VPWR VGND sg13cmos5l_dlhq_1
XANTENNA_204 Tile_X0Y1_W2MID[6] VPWR VGND sg13cmos5l_antennanp
XANTENNA_215 Tile_X0Y1_W2MID[7] VPWR VGND sg13cmos5l_antennanp
XANTENNA_226 Tile_X0Y0_E2MID[7] VPWR VGND sg13cmos5l_antennanp
XANTENNA_237 Tile_X0Y0_S4END[5] VPWR VGND sg13cmos5l_antennanp
XANTENNA_248 Tile_X0Y0_S4END[5] VPWR VGND sg13cmos5l_antennanp
XANTENNA_259 Tile_X0Y1_FrameData[29] VPWR VGND sg13cmos5l_antennanp
XFILLER_60_208 VPWR VGND sg13cmos5l_fill_1
XFILLER_3_14 VPWR VGND sg13cmos5l_decap_8
XFILLER_88_190 VPWR VGND sg13cmos5l_decap_8
X_3840_ _3840_/Y Tile_X0Y1_W2MID[1] _6214_/Q VPWR VGND sg13cmos5l_nand2_1
X_3771_ _3771_/Y _6028_/Q Tile_X0Y1_N4END[3] VPWR VGND sg13cmos5l_nor2b_1
X_5510_ _5510_/Y _6317_/Q _5506_/X _5509_/Y VPWR VGND sg13cmos5l_o21ai_1
X_2722_ _2722_/Y Tile_X0Y0_W2END[7] VPWR VGND sg13cmos5l_inv_1
X_6490_ Tile_X0Y0_E2BEG[0] _6490_/A VPWR VGND sg13cmos5l_buf_1
X_5441_ _5441_/Y _6106_/Q _2888_/Y _5440_/Y VPWR VGND sg13cmos5l_o21ai_1
X_5372_ _5372_/Y _6137_/Q _5372_/B VPWR VGND sg13cmos5l_nor2_1
X_4323_ _4324_/B _6207_/Q _4319_/Y _4322_/Y VPWR VGND sg13cmos5l_a21oi_1
X_4254_ _4255_/A _4254_/A _4708_/A VPWR VGND sg13cmos5l_nor2_1
X_4185_ _4708_/A _6427_/Q _5993_/D _4184_/Y VPWR VGND sg13cmos5l_o21ai_1
X_3205_ _3205_/Y _5779_/Q _3204_/X _3203_/X VPWR VGND sg13cmos5l_o21ai_1
X_3136_ _3137_/B _5635_/Q _3136_/B _3136_/C VPWR VGND sg13cmos5l_nand3_1
X_3067_ _3067_/Y _5696_/Q _3066_/X _5697_/Q VPWR VGND sg13cmos5l_a21oi_1
XANTENNA__6506__X Tile_X0Y0_E6BEG[0] VPWR VGND sg13cmos5l_antennanp
XFILLER_82_366 VPWR VGND sg13cmos5l_fill_2
X_6826_ Tile_X0Y1_W2BEG[2] _6826_/A VPWR VGND sg13cmos5l_buf_1
X_6757_ Tile_X0Y1_FrameData_O[22] Tile_X0Y1_FrameData[22] VPWR VGND sg13cmos5l_buf_1
X_5708_ _5708_/Q Tile_X0Y0_FrameData[22] Tile_X0Y1_FrameStrobe[4] VPWR VGND sg13cmos5l_dlhq_1
X_3969_ _3969_/Y _4621_/B _5594_/Q VPWR VGND sg13cmos5l_nor2_1
XFILLER_10_127 VPWR VGND sg13cmos5l_fill_2
X_6688_ Tile_X0Y1_E1BEG[1] _6688_/A VPWR VGND sg13cmos5l_buf_1
X_5639_ _5639_/Q Tile_X0Y0_FrameData[27] Tile_X0Y1_FrameStrobe[2] VPWR VGND sg13cmos5l_dlhq_1
XFILLER_2_348 VPWR VGND sg13cmos5l_decap_8
XFILLER_2_359 VPWR VGND sg13cmos5l_fill_1
XFILLER_58_363 VPWR VGND sg13cmos5l_fill_1
XFILLER_5_142 VPWR VGND sg13cmos5l_fill_2
X_5990_ _5990_/Q Tile_X0Y1_UserCLK _5990_/D _6444_/L_HI VPWR VGND sg13cmos5l_dfrbpq_1
XFILLER_94_92 VPWR VGND sg13cmos5l_fill_1
X_4941_ _5546_/B _4941_/A _4941_/B VPWR VGND sg13cmos5l_xnor2_1
XFILLER_17_260 VPWR VGND sg13cmos5l_fill_2
X_4872_ _4941_/B _4872_/A _4872_/B VPWR VGND sg13cmos5l_xnor2_1
X_6611_ Tile_X0Y0_N4BEG[5] Tile_X0Y1_N4END[13] VPWR VGND sg13cmos5l_buf_1
X_3823_ _3823_/X Tile_X0Y0_W2END[1] Tile_X0Y0_W6END[1] _5666_/Q VPWR VGND sg13cmos5l_mux2_1
X_6542_ Tile_X0Y0_FrameData_O[8] Tile_X0Y0_FrameData[8] VPWR VGND sg13cmos5l_buf_1
X_3754_ _3754_/Y _6292_/Q _5498_/B _6291_/Q VPWR VGND sg13cmos5l_a21oi_1
X_6473_ _6473_/L_HI VPWR VGND sg13cmos5l_tiehi
X_3685_ _3685_/Y _6102_/Q _3682_/X _6103_/Q VPWR VGND sg13cmos5l_a21oi_1
X_5424_ _5424_/Y _5420_/Y _5421_/Y _6339_/Q VPWR VGND sg13cmos5l_o21ai_1
X_5355_ _5355_/Y _6369_/Q _5353_/X VPWR VGND sg13cmos5l_nor2b_1
X_5286_ _6632_/A _5282_/Y _5285_/Y _5280_/Y VPWR VGND sg13cmos5l_a21oi_1
X_4306_ _4306_/Y _4390_/B _4390_/A VPWR VGND sg13cmos5l_nand2b_1
XFILLER_99_285 VPWR VGND sg13cmos5l_fill_2
X_4237_ _4354_/B _4381_/B _4381_/A VPWR VGND sg13cmos5l_nand2b_1
X_4168_ _4168_/Y Tile_X0Y0_W2END[3] _5626_/Q _5625_/Q VPWR VGND sg13cmos5l_o21ai_1
XFILLER_67_182 VPWR VGND sg13cmos5l_fill_2
X_4099_ _4683_/A _6428_/Q _5984_/D _4098_/Y VPWR VGND sg13cmos5l_o21ai_1
X_3119_ _3119_/Y Tile_X0Y0_W1END[2] _5638_/Q VPWR VGND sg13cmos5l_nand2_1
X_6809_ Tile_X0Y1_SS4BEG[6] Tile_X0Y0_SS4END[14] VPWR VGND sg13cmos5l_buf_1
XFILLER_23_263 VPWR VGND sg13cmos5l_fill_1
XFILLER_109_357 VPWR VGND sg13cmos5l_fill_2
XFILLER_61_314 VPWR VGND sg13cmos5l_fill_2
X_3470_ _3792_/A _3470_/A _3470_/B VPWR VGND sg13cmos5l_nand2_1
X_5140_ _5140_/X _5245_/B _5243_/B _3942_/Y _3276_/Y _5927_/Q _5928_/Q VPWR VGND sg13cmos5l_mux4_1
X_5071_ _5071_/Y _5950_/Q _5067_/Y _5070_/Y VPWR VGND sg13cmos5l_o21ai_1
X_4022_ _4022_/Y Tile_X0Y0_W2END[7] _5600_/Q _5599_/Q VPWR VGND sg13cmos5l_o21ai_1
XFILLER_64_152 VPWR VGND sg13cmos5l_fill_1
X_5973_ _5973_/Q Tile_X0Y0_FrameData[13] Tile_X0Y1_FrameStrobe[12] VPWR VGND sg13cmos5l_dlhq_1
X_4924_ _4924_/Y _6426_/Q _2762_/Y _6425_/Q VPWR VGND sg13cmos5l_a21oi_1
X_4855_ _4855_/X _6599_/A Tile_X0Y0_E2MID[1] Tile_X0Y0_S2MID[1] Tile_X0Y0_W2MID[1]
+ _5772_/Q _5771_/Q VPWR VGND sg13cmos5l_mux4_1
X_4786_ _4786_/Y _4875_/A _4875_/B VPWR VGND sg13cmos5l_nand2_1
X_3806_ _3806_/Y _6054_/Q _2895_/Y _3805_/Y VPWR VGND sg13cmos5l_a21oi_1
X_6525_ Tile_X0Y0_EE4BEG[7] Tile_X0Y0_EE4END[11] VPWR VGND sg13cmos5l_buf_1
X_3737_ _3737_/Y _6120_/Q _4503_/Y VPWR VGND sg13cmos5l_nor2_1
XFILLER_109_36 VPWR VGND sg13cmos5l_fill_2
X_6456_ _6456_/L_HI VPWR VGND sg13cmos5l_tiehi
X_3668_ _3668_/X Tile_X0Y0_S4END[5] _6773_/A _6032_/Q VPWR VGND sg13cmos5l_mux2_1
XFILLER_69_18 VPWR VGND sg13cmos5l_fill_2
XFILLER_106_349 VPWR VGND sg13cmos5l_decap_8
X_5407_ _5407_/X Tile_X0Y1_N1END[3] Tile_X0Y1_E1END[3] Tile_X0Y1_W1END[3] _3916_/Y
+ _6347_/Q _6346_/Q VPWR VGND sg13cmos5l_mux4_1
X_6387_ _6387_/Q Tile_X0Y1_FrameData[9] Tile_X0Y1_FrameStrobe[11] VPWR VGND sg13cmos5l_dlhq_1
X_3599_ _3599_/Y _6162_/Q _2888_/Y _3598_/Y VPWR VGND sg13cmos5l_o21ai_1
X_5338_ _5338_/X Tile_X0Y1_N1END[1] Tile_X0Y1_E1END[1] _3217_/Y _5390_/B _6377_/Q
+ _6376_/Q VPWR VGND sg13cmos5l_mux4_1
X_5269_ _6630_/A _5268_/X _5267_/X _6404_/Q VPWR VGND sg13cmos5l_mux2_1
XFILLER_7_226 VPWR VGND sg13cmos5l_fill_1
XFILLER_7_215 VPWR VGND sg13cmos5l_fill_1
XFILLER_1_0 VPWR VGND sg13cmos5l_decap_8
XFILLER_19_355 VPWR VGND sg13cmos5l_decap_8
XFILLER_19_377 VPWR VGND sg13cmos5l_decap_4
X_2970_ _2970_/X Tile_X0Y1_N2END[1] Tile_X0Y1_N4END[1] Tile_X0Y1_E6END[1] Tile_X0Y0_SS4END[5]
+ _6172_/Q _6170_/Q VPWR VGND sg13cmos5l_mux4_1
XANTENNA__6604__X Tile_X0Y0_N2BEGb[6] VPWR VGND sg13cmos5l_antennanp
X_4640_ _4640_/Y _5708_/Q _4640_/B VPWR VGND sg13cmos5l_nor2_1
X_6310_ _6310_/Q Tile_X0Y1_FrameData[22] Tile_X0Y1_FrameStrobe[9] VPWR VGND sg13cmos5l_dlhq_1
X_4571_ _4609_/A _4571_/A _4709_/B VPWR VGND sg13cmos5l_and2_1
X_3522_ _3522_/Y _6134_/Q _2888_/Y _3521_/Y VPWR VGND sg13cmos5l_o21ai_1
X_6241_ _6241_/Q Tile_X0Y1_FrameData[27] Tile_X0Y1_FrameStrobe[7] VPWR VGND sg13cmos5l_dlhq_1
X_3453_ _3454_/B _6086_/Q _3453_/B VPWR VGND sg13cmos5l_nor2_1
X_6172_ _6172_/Q Tile_X0Y1_FrameData[0] Tile_X0Y1_FrameStrobe[4] VPWR VGND sg13cmos5l_dlhq_1
XFILLER_103_319 VPWR VGND sg13cmos5l_fill_1
X_5123_ _5123_/X _2776_/Y _3276_/Y _5122_/Y VPWR VGND sg13cmos5l_a21o_1
X_3384_ _3384_/X _4515_/Y _4509_/Y _5390_/B _5374_/B _6092_/Q _6090_/Q VPWR VGND sg13cmos5l_mux4_1
XFILLER_111_341 VPWR VGND sg13cmos5l_decap_8
X_5054_ _5054_/Y _5957_/Q _5209_/B _5956_/Q VPWR VGND sg13cmos5l_a21oi_1
XFILLER_69_288 VPWR VGND sg13cmos5l_fill_2
X_4005_ _4005_/Y _4253_/A _4570_/A _4038_/C VPWR VGND sg13cmos5l_a21oi_1
XFILLER_84_247 VPWR VGND sg13cmos5l_fill_2
X_5956_ _5956_/Q Tile_X0Y0_FrameData[30] Tile_X0Y1_FrameStrobe[12] VPWR VGND sg13cmos5l_dlhq_1
XANTENNA__6514__X Tile_X0Y0_E6BEG[8] VPWR VGND sg13cmos5l_antennanp
X_5887_ _5887_/Q Tile_X0Y0_FrameData[3] Tile_X0Y1_FrameStrobe[9] VPWR VGND sg13cmos5l_dlhq_1
X_4907_ _4908_/B _4907_/A _4907_/B VPWR VGND sg13cmos5l_and2_1
X_4838_ _4838_/Y _5612_/Q _2886_/Y _5614_/Q VPWR VGND sg13cmos5l_a21oi_1
X_4769_ _4769_/Y _5800_/Q _4769_/B VPWR VGND sg13cmos5l_nand2b_1
X_6508_ Tile_X0Y0_E6BEG[2] Tile_X0Y0_E6END[4] VPWR VGND sg13cmos5l_buf_1
X_6439_ _6439_/L_HI VPWR VGND sg13cmos5l_tiehi
XFILLER_106_157 VPWR VGND sg13cmos5l_fill_2
XFILLER_61_96 VPWR VGND sg13cmos5l_fill_2
XANTENNA_7 Tile_X0Y0_E2END[7] VPWR VGND sg13cmos5l_antennanp
XFILLER_98_317 VPWR VGND sg13cmos5l_fill_1
XFILLER_66_247 VPWR VGND sg13cmos5l_fill_2
XFILLER_81_206 VPWR VGND sg13cmos5l_fill_1
X_5810_ _5810_/Q Tile_X0Y0_FrameData[16] Tile_X0Y1_FrameStrobe[7] VPWR VGND sg13cmos5l_dlhq_1
X_6790_ Tile_X0Y1_S4BEG[3] Tile_X0Y0_S4END[11] VPWR VGND sg13cmos5l_buf_1
X_5741_ _5741_/Q Tile_X0Y0_FrameData[21] Tile_X0Y1_FrameStrobe[5] VPWR VGND sg13cmos5l_dlhq_1
X_2953_ _2953_/X _4409_/B _2916_/X _2952_/Y _2934_/X _6422_/Q _6421_/Q VPWR VGND sg13cmos5l_mux4_1
X_5672_ _5672_/Q Tile_X0Y0_FrameData[26] Tile_X0Y1_FrameStrobe[3] VPWR VGND sg13cmos5l_dlhq_1
X_2884_ _2884_/Y _5625_/Q VPWR VGND sg13cmos5l_inv_1
X_4623_ _4623_/Y _5585_/Q _4622_/Y _5848_/Q VPWR VGND sg13cmos5l_o21ai_1
X_4554_ _4554_/Y _5845_/Q _5243_/B VPWR VGND sg13cmos5l_nand2b_1
X_3505_ _3505_/Y _2828_/Y _6236_/Q _2844_/Y VPWR VGND sg13cmos5l_a21oi_1
X_6224_ _6224_/Q Tile_X0Y1_FrameData[12] Tile_X0Y1_FrameStrobe[6] VPWR VGND sg13cmos5l_dlhq_1
X_4485_ _4486_/B _4485_/A _4485_/B VPWR VGND sg13cmos5l_xnor2_1
X_3436_ _3436_/Y _2846_/Y _3435_/X _5647_/Q VPWR VGND sg13cmos5l_o21ai_1
X_6155_ _6155_/Q Tile_X0Y1_FrameData[17] Tile_X0Y1_FrameStrobe[4] VPWR VGND sg13cmos5l_dlhq_1
X_3367_ _3367_/X Tile_X0Y1_N1END[3] Tile_X0Y1_E1END[3] Tile_X0Y1_N2END[7] Tile_X0Y1_E2END[7]
+ _6083_/Q _6084_/Q VPWR VGND sg13cmos5l_mux4_1
XANTENNA__6509__X Tile_X0Y0_E6BEG[3] VPWR VGND sg13cmos5l_antennanp
X_6086_ _6086_/Q Tile_X0Y1_FrameData[22] Tile_X0Y1_FrameStrobe[2] VPWR VGND sg13cmos5l_dlhq_1
X_5106_ _6530_/A _5105_/X _5104_/X _5938_/Q VPWR VGND sg13cmos5l_mux2_1
XFILLER_111_160 VPWR VGND sg13cmos5l_decap_4
X_5037_ _6618_/A Tile_X0Y1_N2MID[2] Tile_X0Y1_N4END[5] Tile_X0Y0_E6END[1] _4943_/Y
+ _5968_/Q _5967_/Q VPWR VGND sg13cmos5l_mux4_1
X_3298_ _6603_/A _4737_/B VPWR VGND sg13cmos5l_inv_1
XFILLER_13_306 VPWR VGND sg13cmos5l_fill_2
XFILLER_13_328 VPWR VGND sg13cmos5l_fill_2
X_5939_ _5939_/Q Tile_X0Y0_FrameData[15] Tile_X0Y1_FrameStrobe[11] VPWR VGND sg13cmos5l_dlhq_1
XFILLER_15_78 VPWR VGND sg13cmos5l_fill_1
XFILLER_21_372 VPWR VGND sg13cmos5l_decap_4
XFILLER_8_376 VPWR VGND sg13cmos5l_decap_4
X_4270_ _4271_/B _4270_/A _4270_/B VPWR VGND sg13cmos5l_xor2_1
X_3221_ _3221_/Y _5617_/Q _3218_/X _3220_/Y VPWR VGND sg13cmos5l_o21ai_1
X_3152_ _3152_/Y _6094_/Q _2888_/Y _3151_/Y VPWR VGND sg13cmos5l_o21ai_1
XFILLER_94_331 VPWR VGND sg13cmos5l_fill_2
X_3083_ _3083_/Y _3085_/A _3076_/X _3082_/Y VPWR VGND sg13cmos5l_a21oi_1
XFILLER_94_375 VPWR VGND sg13cmos5l_decap_4
X_6842_ Tile_X0Y1_W6BEG[2] Tile_X0Y1_W6END[4] VPWR VGND sg13cmos5l_buf_1
X_6773_ Tile_X0Y1_S2BEG[2] _6773_/A VPWR VGND sg13cmos5l_buf_1
X_3985_ _3994_/A _3985_/A _3985_/B VPWR VGND sg13cmos5l_nor2_1
X_5724_ _5724_/Q Tile_X0Y0_FrameData[6] Tile_X0Y1_FrameStrobe[4] VPWR VGND sg13cmos5l_dlhq_1
X_2936_ _2936_/Y _6062_/Q _4518_/Y VPWR VGND sg13cmos5l_nor2_1
X_5655_ _5655_/Q Tile_X0Y0_FrameData[11] Tile_X0Y1_FrameStrobe[2] VPWR VGND sg13cmos5l_dlhq_1
X_2867_ _2867_/Y _6113_/Q VPWR VGND sg13cmos5l_inv_1
X_4606_ _4692_/A _4607_/A _4607_/B VPWR VGND sg13cmos5l_and2_1
X_5586_ _5586_/Q Tile_X0Y0_FrameData[16] Tile_X0Y1_FrameStrobe[0] VPWR VGND sg13cmos5l_dlhq_1
X_2798_ _2798_/Y _6350_/Q VPWR VGND sg13cmos5l_inv_1
X_4537_ _4537_/Y _4535_/Y _4536_/Y _5675_/Q VPWR VGND sg13cmos5l_a21oi_1
X_4468_ _4476_/A _4139_/B _4472_/A _4257_/Y VPWR VGND sg13cmos5l_o21ai_1
X_6207_ _6207_/Q Tile_X0Y1_FrameData[29] Tile_X0Y1_FrameStrobe[6] VPWR VGND sg13cmos5l_dlhq_1
X_3419_ _3419_/Y _6058_/Q _3418_/X _2875_/Y VPWR VGND sg13cmos5l_o21ai_1
XFILLER_89_147 VPWR VGND sg13cmos5l_fill_1
X_6138_ _6138_/Q Tile_X0Y1_FrameData[2] Tile_X0Y1_FrameStrobe[3] VPWR VGND sg13cmos5l_dlhq_1
X_4399_ _4399_/Y _4399_/A _6046_/Q VPWR VGND sg13cmos5l_nor2b_1
X_6069_ _6069_/Q Tile_X0Y1_FrameData[7] Tile_X0Y1_FrameStrobe[1] VPWR VGND sg13cmos5l_dlhq_1
XANTENNA_205 Tile_X0Y1_W2MID[6] VPWR VGND sg13cmos5l_antennanp
XANTENNA_216 Tile_X0Y1_W2MID[7] VPWR VGND sg13cmos5l_antennanp
XFILLER_26_33 VPWR VGND sg13cmos5l_fill_1
XANTENNA_227 Tile_X0Y0_E2MID[7] VPWR VGND sg13cmos5l_antennanp
XANTENNA_238 Tile_X0Y0_S4END[5] VPWR VGND sg13cmos5l_antennanp
XANTENNA_249 Tile_X0Y0_S4END[5] VPWR VGND sg13cmos5l_antennanp
XFILLER_26_44 VPWR VGND sg13cmos5l_fill_1
XANTENNA__6702__X Tile_X0Y1_E2BEGb[3] VPWR VGND sg13cmos5l_antennanp
XFILLER_101_0 VPWR VGND sg13cmos5l_fill_1
XFILLER_107_91 VPWR VGND sg13cmos5l_fill_2
XFILLER_67_62 VPWR VGND sg13cmos5l_fill_2
XFILLER_83_83 VPWR VGND sg13cmos5l_fill_2
XFILLER_44_283 VPWR VGND sg13cmos5l_fill_2
X_3770_ _3770_/X Tile_X0Y1_W2END[3] _6601_/A _6028_/Q VPWR VGND sg13cmos5l_mux2_1
XANTENNA__6612__X Tile_X0Y0_N4BEG[6] VPWR VGND sg13cmos5l_antennanp
X_2721_ _4621_/B Tile_X0Y0_E2END[3] VPWR VGND sg13cmos5l_inv_1
X_5440_ _5440_/Y _6106_/Q _5440_/B VPWR VGND sg13cmos5l_nand2_1
X_5371_ _5372_/B _6138_/Q _5367_/X _5370_/Y VPWR VGND sg13cmos5l_a21oi_1
X_4322_ _4322_/Y _6207_/Q _4321_/Y _6282_/Q VPWR VGND sg13cmos5l_o21ai_1
X_4253_ _4256_/B _4253_/A _4709_/A VPWR VGND sg13cmos5l_nand2_1
X_3204_ _3204_/X _6599_/A Tile_X0Y0_E2MID[1] _5780_/Q VPWR VGND sg13cmos5l_mux2_1
X_4184_ _4184_/Y _5993_/Q _6427_/Q VPWR VGND sg13cmos5l_nand2b_1
X_3135_ _3136_/C _5636_/Q _3131_/Y _3134_/Y VPWR VGND sg13cmos5l_o21ai_1
X_3066_ _3066_/X Tile_X0Y0_E6END[1] Tile_X0Y0_S2END[1] _5698_/Q VPWR VGND sg13cmos5l_mux2_1
X_6825_ Tile_X0Y1_W2BEG[1] _6825_/A VPWR VGND sg13cmos5l_buf_1
X_6756_ Tile_X0Y1_FrameData_O[21] Tile_X0Y1_FrameData[21] VPWR VGND sg13cmos5l_buf_1
X_3968_ _3968_/X Tile_X0Y0_WW4END[2] _6592_/A _5594_/Q VPWR VGND sg13cmos5l_mux2_1
XANTENNA__6522__X Tile_X0Y0_EE4BEG[4] VPWR VGND sg13cmos5l_antennanp
X_5707_ _5707_/Q Tile_X0Y0_FrameData[23] Tile_X0Y1_FrameStrobe[4] VPWR VGND sg13cmos5l_dlhq_1
X_2919_ _2919_/Y _2918_/X _2926_/B VPWR VGND sg13cmos5l_nand2b_1
XFILLER_50_286 VPWR VGND sg13cmos5l_fill_1
X_6687_ Tile_X0Y1_E1BEG[0] _6687_/A VPWR VGND sg13cmos5l_buf_1
X_3899_ _4470_/A _4471_/A VPWR VGND sg13cmos5l_inv_1
X_5638_ _5638_/Q Tile_X0Y0_FrameData[28] Tile_X0Y1_FrameStrobe[2] VPWR VGND sg13cmos5l_dlhq_1
X_5569_ _5569_/Q Tile_X0Y1_UserCLK _5569_/D _6483_/L_HI VPWR VGND sg13cmos5l_dfrbpq_1
XFILLER_2_327 VPWR VGND sg13cmos5l_fill_2
XFILLER_58_320 VPWR VGND sg13cmos5l_fill_1
XFILLER_85_150 VPWR VGND sg13cmos5l_fill_1
XFILLER_26_272 VPWR VGND sg13cmos5l_fill_2
XFILLER_53_86 VPWR VGND sg13cmos5l_fill_1
XFILLER_110_214 VPWR VGND sg13cmos5l_fill_2
XANTENNA__6607__X Tile_X0Y0_N4BEG[1] VPWR VGND sg13cmos5l_antennanp
XFILLER_64_334 VPWR VGND sg13cmos5l_fill_1
X_4940_ _4940_/Y _6423_/Q _5542_/B _4939_/Y VPWR VGND sg13cmos5l_o21ai_1
XFILLER_17_272 VPWR VGND sg13cmos5l_fill_2
X_4871_ _4941_/A _4910_/A _4869_/Y _4867_/Y VPWR VGND sg13cmos5l_o21ai_1
X_6610_ Tile_X0Y0_N4BEG[4] Tile_X0Y1_N4END[12] VPWR VGND sg13cmos5l_buf_1
X_3822_ _3822_/X Tile_X0Y1_NN4END[5] Tile_X0Y0_E1END[3] Tile_X0Y0_S2END[1] Tile_X0Y0_S4END[1]
+ _5666_/Q _5664_/Q VPWR VGND sg13cmos5l_mux4_1
X_6541_ Tile_X0Y0_FrameData_O[7] Tile_X0Y0_FrameData[7] VPWR VGND sg13cmos5l_buf_1
X_3753_ _5498_/B _2734_/Y _2814_/Y _3093_/Y _2813_/Y _6218_/Q _6217_/Q VPWR VGND sg13cmos5l_mux4_1
X_6472_ _6472_/L_HI VPWR VGND sg13cmos5l_tiehi
X_3684_ _3684_/Y _6102_/Q _3684_/B VPWR VGND sg13cmos5l_nand2b_1
X_5423_ _5423_/Y _6341_/Q _5493_/B _5422_/Y VPWR VGND sg13cmos5l_a21oi_1
X_5354_ _5354_/X _4515_/Y _4509_/Y _4518_/Y _5390_/B _6370_/Q _6368_/Q VPWR VGND sg13cmos5l_mux4_1
X_4305_ _4390_/B _4305_/A _4305_/B VPWR VGND sg13cmos5l_xnor2_1
X_5285_ _5285_/Y _5285_/A _6398_/Q VPWR VGND sg13cmos5l_nor2b_1
X_4236_ _4381_/B _3910_/A _3910_/B _3908_/Y VPWR VGND sg13cmos5l_a21oi_1
X_4167_ _4167_/Y Tile_X0Y0_S2END[3] _5626_/Q _4166_/Y VPWR VGND sg13cmos5l_o21ai_1
XANTENNA__6517__X Tile_X0Y0_E6BEG[11] VPWR VGND sg13cmos5l_antennanp
X_3118_ _3118_/X _2709_/Y _2729_/Y _3118_/S VPWR VGND sg13cmos5l_mux2_1
X_4098_ _4098_/Y _5984_/Q _6428_/Q VPWR VGND sg13cmos5l_nand2b_1
X_3049_ _3050_/B _3049_/A VPWR VGND sg13cmos5l_inv_1
X_6808_ Tile_X0Y1_SS4BEG[5] Tile_X0Y0_SS4END[13] VPWR VGND sg13cmos5l_buf_1
X_6739_ Tile_X0Y1_FrameData_O[4] Tile_X0Y1_FrameData[4] VPWR VGND sg13cmos5l_buf_1
XFILLER_0_49 VPWR VGND sg13cmos5l_decap_8
XFILLER_80_62 VPWR VGND sg13cmos5l_fill_2
X_5070_ _5070_/Y _5070_/A _5949_/Q VPWR VGND sg13cmos5l_nor2b_1
X_4021_ _4021_/Y _5862_/Q _5245_/B _5861_/Q VPWR VGND sg13cmos5l_a21oi_1
XFILLER_37_323 VPWR VGND sg13cmos5l_fill_1
XFILLER_64_120 VPWR VGND sg13cmos5l_fill_2
X_5972_ _5972_/Q Tile_X0Y0_FrameData[14] Tile_X0Y1_FrameStrobe[12] VPWR VGND sg13cmos5l_dlhq_1
X_4923_ _4923_/X _6426_/Q _6012_/D VPWR VGND sg13cmos5l_or2_1
X_4854_ _4854_/X Tile_X0Y1_NN4END[6] Tile_X0Y0_S2END[1] Tile_X0Y0_E2END[1] Tile_X0Y0_W2END[1]
+ _5739_/Q _5740_/Q VPWR VGND sg13cmos5l_mux4_1
X_4785_ _4875_/B _4785_/A _4785_/B VPWR VGND sg13cmos5l_nand2_1
X_3805_ _3805_/Y _6054_/Q _3916_/Y _6056_/Q VPWR VGND sg13cmos5l_o21ai_1
X_6524_ Tile_X0Y0_EE4BEG[6] Tile_X0Y0_EE4END[10] VPWR VGND sg13cmos5l_buf_1
X_3736_ _3746_/A _6117_/Q _3736_/B _3736_/C VPWR VGND sg13cmos5l_nor3_1
XANTENNA__6800__X Tile_X0Y1_S4BEG[13] VPWR VGND sg13cmos5l_antennanp
XFILLER_109_15 VPWR VGND sg13cmos5l_fill_1
X_6455_ _6455_/L_HI VPWR VGND sg13cmos5l_tiehi
X_3667_ _6773_/A _6097_/Q _3666_/Y _3662_/Y VPWR VGND sg13cmos5l_o21ai_1
X_5406_ _6815_/A _5402_/Y _5405_/Y _5400_/Y VPWR VGND sg13cmos5l_a21oi_1
X_6386_ _6386_/Q Tile_X0Y1_FrameData[10] Tile_X0Y1_FrameStrobe[11] VPWR VGND sg13cmos5l_dlhq_1
X_3598_ _3598_/Y _6162_/Q _5440_/B VPWR VGND sg13cmos5l_nand2_1
X_5337_ _5337_/X _5422_/B _3458_/A _5420_/B _3488_/X _6377_/Q _6376_/Q VPWR VGND sg13cmos5l_mux4_1
X_5268_ _5268_/X Tile_X0Y1_N1END[2] Tile_X0Y1_E1END[2] Tile_X0Y1_W1END[2] _4503_/Y
+ _6406_/Q _6405_/Q VPWR VGND sg13cmos5l_mux4_1
X_4219_ _4228_/B _4219_/A _4219_/B VPWR VGND sg13cmos5l_xnor2_1
X_5199_ _6642_/A _5885_/Q _5198_/Y _5196_/X VPWR VGND sg13cmos5l_o21ai_1
XFILLER_55_175 VPWR VGND sg13cmos5l_decap_8
XFILLER_70_178 VPWR VGND sg13cmos5l_fill_1
XANTENNA__6710__X Tile_X0Y1_E6BEG[3] VPWR VGND sg13cmos5l_antennanp
XFILLER_109_177 VPWR VGND sg13cmos5l_fill_1
XFILLER_61_156 VPWR VGND sg13cmos5l_fill_2
X_4570_ _4570_/Y _4570_/A _4709_/B VPWR VGND sg13cmos5l_nand2_1
XANTENNA__6620__X Tile_X0Y0_N4BEG[14] VPWR VGND sg13cmos5l_antennanp
X_3521_ _3521_/Y _6134_/Q _5440_/B VPWR VGND sg13cmos5l_nand2_1
X_6240_ _6240_/Q Tile_X0Y1_FrameData[28] Tile_X0Y1_FrameStrobe[7] VPWR VGND sg13cmos5l_dlhq_1
X_3452_ _3453_/B Tile_X0Y1_N1END[2] Tile_X0Y1_E1END[2] Tile_X0Y1_N2END[6] Tile_X0Y1_E2END[6]
+ _6087_/Q _6088_/Q VPWR VGND sg13cmos5l_mux4_1
X_6171_ _6171_/Q Tile_X0Y1_FrameData[1] Tile_X0Y1_FrameStrobe[4] VPWR VGND sg13cmos5l_dlhq_1
X_3383_ _3383_/Y _6602_/A VPWR VGND sg13cmos5l_inv_1
X_5122_ _5122_/Y _2776_/Y _3973_/X _5933_/Q VPWR VGND sg13cmos5l_o21ai_1
XFILLER_111_320 VPWR VGND sg13cmos5l_decap_8
XFILLER_69_278 VPWR VGND sg13cmos5l_fill_2
XFILLER_27_0 VPWR VGND sg13cmos5l_fill_2
X_5053_ _5056_/A _2774_/Y _4127_/Y _5052_/Y VPWR VGND sg13cmos5l_a21oi_1
X_4004_ _4038_/C _4188_/A _4263_/A VPWR VGND sg13cmos5l_nor2_1
XFILLER_92_292 VPWR VGND sg13cmos5l_fill_2
XFILLER_111_38 VPWR VGND sg13cmos5l_fill_1
X_5955_ _5955_/Q Tile_X0Y0_FrameData[31] Tile_X0Y1_FrameStrobe[12] VPWR VGND sg13cmos5l_dlhq_1
XFILLER_111_49 VPWR VGND sg13cmos5l_decap_8
X_5886_ _5886_/Q Tile_X0Y0_FrameData[4] Tile_X0Y1_FrameStrobe[9] VPWR VGND sg13cmos5l_dlhq_1
X_4906_ _4906_/Y _4907_/B VPWR VGND sg13cmos5l_inv_1
XFILLER_52_189 VPWR VGND sg13cmos5l_fill_1
X_4837_ _4837_/X _5612_/Q _4940_/Y VPWR VGND sg13cmos5l_or2_1
XANTENNA__6530__X Tile_X0Y0_EE4BEG[12] VPWR VGND sg13cmos5l_antennanp
X_4768_ _4768_/Y _5800_/Q _4766_/Y _4767_/Y VPWR VGND sg13cmos5l_a21oi_1
X_6507_ Tile_X0Y0_E6BEG[1] Tile_X0Y0_E6END[3] VPWR VGND sg13cmos5l_buf_1
X_4699_ _4701_/C _4657_/A _4593_/Y _4616_/B _4616_/A _4594_/A VPWR VGND sg13cmos5l_a221oi_1
X_3719_ _4254_/A _6428_/Q _5980_/D _3718_/Y VPWR VGND sg13cmos5l_o21ai_1
X_6438_ _6438_/L_HI VPWR VGND sg13cmos5l_tiehi
XFILLER_106_125 VPWR VGND sg13cmos5l_decap_8
X_6369_ _6369_/Q Tile_X0Y1_FrameData[27] Tile_X0Y1_FrameStrobe[11] VPWR VGND sg13cmos5l_dlhq_1
XFILLER_102_364 VPWR VGND sg13cmos5l_fill_1
XFILLER_75_237 VPWR VGND sg13cmos5l_fill_1
XANTENNA__6705__X Tile_X0Y1_E2BEGb[6] VPWR VGND sg13cmos5l_antennanp
XANTENNA_8 Tile_X0Y0_E2END[7] VPWR VGND sg13cmos5l_antennanp
XANTENNA__6615__X Tile_X0Y0_N4BEG[9] VPWR VGND sg13cmos5l_antennanp
X_5740_ _5740_/Q Tile_X0Y0_FrameData[22] Tile_X0Y1_FrameStrobe[5] VPWR VGND sg13cmos5l_dlhq_1
X_2952_ _2952_/Y _2952_/A VPWR VGND sg13cmos5l_inv_1
X_5671_ _5671_/Q Tile_X0Y0_FrameData[27] Tile_X0Y1_FrameStrobe[3] VPWR VGND sg13cmos5l_dlhq_1
X_2883_ _2883_/Y _6245_/Q VPWR VGND sg13cmos5l_inv_1
X_4622_ _4622_/Y _5586_/Q Tile_X0Y1_N4END[7] _4621_/Y VPWR VGND sg13cmos5l_o21ai_1
X_4553_ _4553_/X Tile_X0Y1_N2MID[3] Tile_X0Y0_S2END[3] Tile_X0Y0_E2END[3] Tile_X0Y0_WW4END[1]
+ _5743_/Q _5744_/Q VPWR VGND sg13cmos5l_mux4_1
X_4484_ _4484_/Y _4485_/A _4485_/B VPWR VGND sg13cmos5l_nand2_1
X_3504_ _3504_/X Tile_X0Y1_N2MID[6] Tile_X0Y1_W2MID[6] _6785_/A _6601_/A _6267_/Q
+ _6268_/Q VPWR VGND sg13cmos5l_mux4_1
X_6223_ _6223_/Q Tile_X0Y1_FrameData[13] Tile_X0Y1_FrameStrobe[6] VPWR VGND sg13cmos5l_dlhq_1
X_3435_ _3435_/X _4707_/Y _4909_/X _4911_/X _5009_/Y _5648_/Q _5650_/Q VPWR VGND sg13cmos5l_mux4_1
X_6154_ _6154_/Q Tile_X0Y1_FrameData[18] Tile_X0Y1_FrameStrobe[4] VPWR VGND sg13cmos5l_dlhq_1
X_3366_ _3366_/Y _3366_/A VPWR VGND sg13cmos5l_inv_1
X_6085_ _6085_/Q Tile_X0Y1_FrameData[23] Tile_X0Y1_FrameStrobe[2] VPWR VGND sg13cmos5l_dlhq_1
X_5105_ _5105_/X _4944_/X Tile_X0Y0_S1END[2] Tile_X0Y0_E1END[2] _4707_/Y _5939_/Q
+ _5940_/Q VPWR VGND sg13cmos5l_mux4_1
X_3297_ _4737_/B _3284_/Y _3287_/Y _3295_/X _3296_/Y VPWR VGND sg13cmos5l_a22oi_1
X_5036_ _6589_/A _5969_/Q _5035_/Y _5033_/X VPWR VGND sg13cmos5l_o21ai_1
XFILLER_111_183 VPWR VGND sg13cmos5l_decap_4
XANTENNA__6525__X Tile_X0Y0_EE4BEG[7] VPWR VGND sg13cmos5l_antennanp
X_5938_ _5938_/Q Tile_X0Y0_FrameData[16] Tile_X0Y1_FrameStrobe[11] VPWR VGND sg13cmos5l_dlhq_1
XFILLER_25_178 VPWR VGND sg13cmos5l_fill_2
X_5869_ _5869_/Q Tile_X0Y0_FrameData[21] Tile_X0Y1_FrameStrobe[9] VPWR VGND sg13cmos5l_dlhq_1
XFILLER_8_355 VPWR VGND sg13cmos5l_decap_8
X_3220_ _3220_/Y _5617_/Q _3219_/X _5616_/Q VPWR VGND sg13cmos5l_a21oi_1
X_3151_ _3151_/Y _6094_/Q _5422_/B VPWR VGND sg13cmos5l_nand2_1
X_3082_ _3082_/Y _5654_/Q _3078_/Y _3081_/Y VPWR VGND sg13cmos5l_a21oi_1
XFILLER_94_365 VPWR VGND sg13cmos5l_fill_2
XFILLER_54_207 VPWR VGND sg13cmos5l_fill_1
XFILLER_47_292 VPWR VGND sg13cmos5l_fill_2
X_6841_ Tile_X0Y1_W6BEG[1] Tile_X0Y1_W6END[3] VPWR VGND sg13cmos5l_buf_1
XFILLER_62_273 VPWR VGND sg13cmos5l_fill_1
X_6772_ Tile_X0Y1_S2BEG[1] _6772_/A VPWR VGND sg13cmos5l_buf_1
X_3984_ _3985_/B _2861_/Y _3983_/X _5711_/Q VPWR VGND sg13cmos5l_o21ai_1
X_5723_ _5723_/Q Tile_X0Y0_FrameData[7] Tile_X0Y1_FrameStrobe[4] VPWR VGND sg13cmos5l_dlhq_1
X_2935_ _2935_/X Tile_X0Y1_N4END[2] Tile_X0Y1_E2END[2] Tile_X0Y1_W2END[7] _6693_/A
+ _6034_/Q _6033_/Q VPWR VGND sg13cmos5l_mux4_1
X_5654_ _5654_/Q Tile_X0Y0_FrameData[12] Tile_X0Y1_FrameStrobe[2] VPWR VGND sg13cmos5l_dlhq_1
X_2866_ _4339_/A _6284_/Q VPWR VGND sg13cmos5l_inv_1
X_4605_ _4607_/B _4605_/A _4605_/B VPWR VGND sg13cmos5l_xor2_1
X_5585_ _5585_/Q Tile_X0Y0_FrameData[17] Tile_X0Y1_FrameStrobe[0] VPWR VGND sg13cmos5l_dlhq_1
X_2797_ _2797_/Y Tile_X0Y0_S4END[4] VPWR VGND sg13cmos5l_inv_1
X_4536_ _4536_/Y _5676_/Q _4533_/Y _5677_/Q VPWR VGND sg13cmos5l_a21oi_1
X_4467_ _4485_/A _4268_/A _4268_/B _4259_/Y VPWR VGND sg13cmos5l_o21ai_1
X_6206_ _6206_/Q Tile_X0Y1_FrameData[30] Tile_X0Y1_FrameStrobe[6] VPWR VGND sg13cmos5l_dlhq_1
X_4398_ _4399_/A _2714_/Y _6048_/Q _4397_/Y VPWR VGND sg13cmos5l_a21oi_1
X_3418_ _3418_/X Tile_X0Y1_N1END[1] Tile_X0Y1_E1END[1] Tile_X0Y1_N2END[5] Tile_X0Y1_E2END[5]
+ _6059_/Q _6060_/Q VPWR VGND sg13cmos5l_mux4_1
X_6137_ _6137_/Q Tile_X0Y1_FrameData[3] Tile_X0Y1_FrameStrobe[3] VPWR VGND sg13cmos5l_dlhq_1
X_3349_ _6830_/A _3349_/A VPWR VGND sg13cmos5l_inv_1
X_6068_ _6068_/Q Tile_X0Y1_FrameData[8] Tile_X0Y1_FrameStrobe[1] VPWR VGND sg13cmos5l_dlhq_1
XANTENNA_206 Tile_X0Y1_W2MID[6] VPWR VGND sg13cmos5l_antennanp
X_5019_ _5019_/X _4934_/Y _5011_/X _5632_/Q VPWR VGND sg13cmos5l_mux2_1
XANTENNA_217 Tile_X0Y1_W2MID[7] VPWR VGND sg13cmos5l_antennanp
XANTENNA_228 Tile_X0Y0_E2MID[7] VPWR VGND sg13cmos5l_antennanp
XANTENNA_239 Tile_X0Y0_S4END[5] VPWR VGND sg13cmos5l_antennanp
XFILLER_53_273 VPWR VGND sg13cmos5l_fill_2
XFILLER_5_336 VPWR VGND sg13cmos5l_decap_8
XFILLER_107_231 VPWR VGND sg13cmos5l_fill_2
XFILLER_107_286 VPWR VGND sg13cmos5l_decap_4
XFILLER_91_302 VPWR VGND sg13cmos5l_fill_2
XFILLER_76_354 VPWR VGND sg13cmos5l_fill_2
XFILLER_91_379 VPWR VGND sg13cmos5l_fill_2
X_2720_ _2720_/Y _6003_/Q VPWR VGND sg13cmos5l_inv_1
XFILLER_12_181 VPWR VGND sg13cmos5l_fill_2
X_5370_ _5370_/Y _6138_/Q _5369_/Y _6139_/Q VPWR VGND sg13cmos5l_o21ai_1
X_4321_ _4321_/Y Tile_X0Y1_E2MID[5] _6208_/Q _4320_/Y VPWR VGND sg13cmos5l_a21oi_1
X_4252_ _4258_/A _4471_/A _4681_/A VPWR VGND sg13cmos5l_nand2_1
X_3203_ _3203_/X _3206_/S _3203_/B VPWR VGND sg13cmos5l_or2_1
X_4183_ _5993_/D _4180_/Y _4182_/Y _4160_/Y VPWR VGND sg13cmos5l_o21ai_1
X_3134_ _3134_/Y _5637_/Q _3134_/B VPWR VGND sg13cmos5l_nor2_1
X_3065_ _3065_/Y _5698_/Q _3063_/X _3064_/Y VPWR VGND sg13cmos5l_o21ai_1
XFILLER_82_368 VPWR VGND sg13cmos5l_fill_1
X_6824_ Tile_X0Y1_W2BEG[0] Tile_X0Y1_W2END[0] VPWR VGND sg13cmos5l_buf_1
XANTENNA__6803__X Tile_X0Y1_SS4BEG[0] VPWR VGND sg13cmos5l_antennanp
X_6755_ Tile_X0Y1_FrameData_O[20] Tile_X0Y1_FrameData[20] VPWR VGND sg13cmos5l_buf_1
X_3967_ _6592_/A _3965_/Y _3966_/Y _3959_/Y VPWR VGND sg13cmos5l_o21ai_1
XFILLER_50_276 VPWR VGND sg13cmos5l_fill_2
XFILLER_50_265 VPWR VGND sg13cmos5l_fill_2
X_5706_ _5706_/Q Tile_X0Y0_FrameData[24] Tile_X0Y1_FrameStrobe[4] VPWR VGND sg13cmos5l_dlhq_1
X_2918_ _2918_/X Tile_X0Y1_N4END[3] Tile_X0Y1_E2END[3] Tile_X0Y1_W2END[3] Tile_X0Y1_W6END[1]
+ _6132_/Q _6130_/Q VPWR VGND sg13cmos5l_mux4_1
X_6686_ Tile_X0Y0_WW4BEG[15] _6686_/A VPWR VGND sg13cmos5l_buf_1
X_3898_ _4471_/A _5981_/D _5981_/Q _6428_/Q VPWR VGND sg13cmos5l_mux2_1
X_5637_ _5637_/Q Tile_X0Y0_FrameData[29] Tile_X0Y1_FrameStrobe[2] VPWR VGND sg13cmos5l_dlhq_1
X_2849_ _2849_/Y _6257_/Q VPWR VGND sg13cmos5l_inv_1
X_5568_ _5568_/Q Tile_X0Y1_UserCLK _5568_/D _6484_/L_HI VPWR VGND sg13cmos5l_dfrbpq_1
X_4519_ _4519_/X _4519_/A _4519_/B VPWR VGND sg13cmos5l_xor2_1
X_5499_ _5499_/Y _6318_/Q _5342_/B _5498_/Y VPWR VGND sg13cmos5l_a21oi_1
XANTENNA__6713__X Tile_X0Y1_E6BEG[6] VPWR VGND sg13cmos5l_antennanp
XFILLER_45_9 VPWR VGND sg13cmos5l_fill_1
XFILLER_68_129 VPWR VGND sg13cmos5l_fill_1
XFILLER_110_226 VPWR VGND sg13cmos5l_fill_1
XFILLER_76_173 VPWR VGND sg13cmos5l_fill_1
XFILLER_64_313 VPWR VGND sg13cmos5l_decap_8
X_4870_ _4910_/B _4870_/A _4870_/B VPWR VGND sg13cmos5l_xor2_1
XANTENNA__6623__X Tile_X0Y0_NN4BEG[1] VPWR VGND sg13cmos5l_antennanp
X_3821_ _3821_/X _6246_/Q _5522_/C _3820_/Y VPWR VGND sg13cmos5l_a21o_1
X_6540_ Tile_X0Y0_FrameData_O[6] Tile_X0Y0_FrameData[6] VPWR VGND sg13cmos5l_buf_1
X_3752_ _3752_/Y _6249_/Q _3751_/Y _2812_/Y VPWR VGND sg13cmos5l_o21ai_1
X_6471_ _6471_/L_HI VPWR VGND sg13cmos5l_tiehi
X_3683_ _3684_/B Tile_X0Y1_NN4END[2] Tile_X0Y1_E1END[0] _6104_/Q VPWR VGND sg13cmos5l_mux2_1
X_5422_ _5422_/Y _6341_/Q _5422_/B VPWR VGND sg13cmos5l_nor2_1
X_5353_ _5353_/X Tile_X0Y1_E1END[2] _4503_/Y Tile_X0Y1_W1END[2] _3916_/Y _6368_/Q
+ _6370_/Q VPWR VGND sg13cmos5l_mux4_1
X_4304_ _4390_/A _4304_/A _4304_/B VPWR VGND sg13cmos5l_nand2_1
X_5284_ _5285_/A _6400_/Q _3472_/Y _5283_/Y VPWR VGND sg13cmos5l_a21oi_1
X_4235_ _4381_/A _4235_/A _4235_/B VPWR VGND sg13cmos5l_xnor2_1
XFILLER_101_237 VPWR VGND sg13cmos5l_fill_1
X_4166_ _4166_/Y _2745_/Y _5626_/Q _5625_/Q VPWR VGND sg13cmos5l_a21oi_1
X_3117_ _3117_/X _5637_/Q _3116_/X _5636_/Q VPWR VGND sg13cmos5l_a21o_1
XFILLER_67_184 VPWR VGND sg13cmos5l_fill_1
XFILLER_55_324 VPWR VGND sg13cmos5l_fill_1
X_4097_ _5984_/D _4090_/Y _4092_/Y _4096_/Y VPWR VGND sg13cmos5l_o21ai_1
XFILLER_55_357 VPWR VGND sg13cmos5l_fill_2
X_3048_ _3049_/A _4707_/Y _4909_/X _4911_/X _5062_/B _5644_/Q _5646_/Q VPWR VGND sg13cmos5l_mux4_1
XANTENNA__6533__X Tile_X0Y0_EE4BEG[15] VPWR VGND sg13cmos5l_antennanp
X_6807_ Tile_X0Y1_SS4BEG[4] Tile_X0Y0_SS4END[12] VPWR VGND sg13cmos5l_buf_1
X_4999_ _4999_/Y _4999_/A _6497_/A VPWR VGND sg13cmos5l_nor2_1
X_6738_ Tile_X0Y1_FrameData_O[3] Tile_X0Y1_FrameData[3] VPWR VGND sg13cmos5l_buf_1
X_6669_ Tile_X0Y0_W6BEG[10] _6669_/A VPWR VGND sg13cmos5l_buf_1
XFILLER_109_326 VPWR VGND sg13cmos5l_decap_4
XFILLER_2_114 VPWR VGND sg13cmos5l_decap_4
XANTENNA__6708__X Tile_X0Y1_E6BEG[1] VPWR VGND sg13cmos5l_antennanp
XFILLER_46_302 VPWR VGND sg13cmos5l_fill_1
XFILLER_0_28 VPWR VGND sg13cmos5l_decap_8
XFILLER_61_316 VPWR VGND sg13cmos5l_fill_1
XANTENNA__6618__X Tile_X0Y0_N4BEG[12] VPWR VGND sg13cmos5l_antennanp
X_4020_ _4020_/X _5862_/Q _4020_/B VPWR VGND sg13cmos5l_or2_1
XFILLER_96_279 VPWR VGND sg13cmos5l_decap_4
X_5971_ _5971_/Q Tile_X0Y0_FrameData[15] Tile_X0Y1_FrameStrobe[12] VPWR VGND sg13cmos5l_dlhq_1
XFILLER_64_176 VPWR VGND sg13cmos5l_fill_2
XFILLER_37_379 VPWR VGND sg13cmos5l_fill_2
X_4922_ _6012_/D _4913_/Y _4916_/Y _4920_/Y _4921_/Y VPWR VGND sg13cmos5l_a22oi_1
XFILLER_100_18 VPWR VGND sg13cmos5l_fill_2
X_4853_ _4853_/Y Tile_X0Y0_EE4END[3] _5580_/Q _4852_/Y VPWR VGND sg13cmos5l_o21ai_1
X_4784_ _4785_/B _6426_/Q _6009_/D _4783_/Y VPWR VGND sg13cmos5l_o21ai_1
X_3804_ _3807_/C _6054_/Q _4503_/Y _3803_/Y VPWR VGND sg13cmos5l_o21ai_1
X_6523_ Tile_X0Y0_EE4BEG[5] Tile_X0Y0_EE4END[9] VPWR VGND sg13cmos5l_buf_1
X_3735_ _3736_/C _6118_/Q _3735_/B VPWR VGND sg13cmos5l_nor2_1
X_6454_ _6454_/L_HI VPWR VGND sg13cmos5l_tiehi
XFILLER_109_27 VPWR VGND sg13cmos5l_fill_1
X_5405_ _5405_/Y _5405_/A _6348_/Q VPWR VGND sg13cmos5l_nor2b_1
X_3666_ _3666_/Y _6099_/Q _3663_/X _3665_/Y VPWR VGND sg13cmos5l_a21oi_1
XFILLER_109_49 VPWR VGND sg13cmos5l_decap_4
X_6385_ _6385_/Q Tile_X0Y1_FrameData[11] Tile_X0Y1_FrameStrobe[11] VPWR VGND sg13cmos5l_dlhq_1
X_3597_ _3597_/X _4515_/Y _4509_/Y _5390_/B _5374_/B _6164_/Q _6162_/Q VPWR VGND sg13cmos5l_mux4_1
X_5336_ _6733_/A _5328_/Y _5330_/Y _5332_/Y _5335_/Y VPWR VGND sg13cmos5l_a22oi_1
X_5267_ _5267_/X _5374_/B _3481_/A _3575_/B _4348_/X _6405_/Q _6406_/Q VPWR VGND sg13cmos5l_mux4_1
XANTENNA__6528__X Tile_X0Y0_EE4BEG[10] VPWR VGND sg13cmos5l_antennanp
X_4218_ _4219_/B _4218_/A _4218_/B VPWR VGND sg13cmos5l_xnor2_1
X_5198_ _5198_/Y _5886_/Q _4940_/Y _5197_/Y VPWR VGND sg13cmos5l_o21ai_1
X_4149_ _4149_/Y _4226_/B _4226_/A VPWR VGND sg13cmos5l_nor2b_1
XFILLER_50_11 VPWR VGND sg13cmos5l_fill_2
XFILLER_78_202 VPWR VGND sg13cmos5l_fill_2
XFILLER_105_362 VPWR VGND sg13cmos5l_decap_4
XFILLER_19_313 VPWR VGND sg13cmos5l_fill_1
X_3520_ _3520_/X _2891_/Y _2892_/Y _6134_/Q VPWR VGND sg13cmos5l_mux2_1
X_3451_ _3451_/X Tile_X0Y1_W1END[0] Tile_X0Y1_W1END[2] _3278_/Y Tile_X0Y0_S2MID[6]
+ _6088_/Q _2857_/Y VPWR VGND sg13cmos5l_mux4_1
X_6170_ _6170_/Q Tile_X0Y1_FrameData[2] Tile_X0Y1_FrameStrobe[4] VPWR VGND sg13cmos5l_dlhq_1
X_3382_ _6602_/A _4123_/B _4123_/C VPWR VGND sg13cmos5l_nand2_1
X_5121_ _5121_/Y _5934_/Q _5062_/B _5120_/Y VPWR VGND sg13cmos5l_o21ai_1
XFILLER_69_246 VPWR VGND sg13cmos5l_fill_2
XFILLER_111_354 VPWR VGND sg13cmos5l_decap_8
X_5052_ _5052_/Y _2774_/Y _4553_/X _5956_/Q VPWR VGND sg13cmos5l_o21ai_1
X_4003_ _4263_/A _4571_/A VPWR VGND sg13cmos5l_inv_1
XFILLER_1_93 VPWR VGND sg13cmos5l_decap_4
XFILLER_111_17 VPWR VGND sg13cmos5l_fill_1
X_5954_ _5954_/Q Tile_X0Y0_FrameData[0] Tile_X0Y1_FrameStrobe[11] VPWR VGND sg13cmos5l_dlhq_1
XFILLER_52_135 VPWR VGND sg13cmos5l_fill_2
XFILLER_40_308 VPWR VGND sg13cmos5l_decap_4
X_5885_ _5885_/Q Tile_X0Y0_FrameData[5] Tile_X0Y1_FrameStrobe[9] VPWR VGND sg13cmos5l_dlhq_1
X_4905_ _4907_/B _5006_/A _4905_/B _4905_/C VPWR VGND sg13cmos5l_or3_1
X_4836_ _4836_/Y _5612_/Q _2887_/Y _4835_/Y VPWR VGND sg13cmos5l_a21oi_1
XANTENNA__6811__X Tile_X0Y1_SS4BEG[8] VPWR VGND sg13cmos5l_antennanp
X_6506_ Tile_X0Y0_E6BEG[0] Tile_X0Y0_E6END[2] VPWR VGND sg13cmos5l_buf_1
X_4767_ _4767_/Y Tile_X0Y0_W2MID[2] _5800_/Q _5799_/Q VPWR VGND sg13cmos5l_o21ai_1
X_4698_ _4701_/B _4698_/A _4698_/B VPWR VGND sg13cmos5l_xnor2_1
X_3718_ _3718_/Y _5980_/Q _6428_/Q VPWR VGND sg13cmos5l_nand2b_1
X_6437_ _6437_/L_HI VPWR VGND sg13cmos5l_tiehi
X_3649_ _3649_/Y _6223_/Q _3648_/Y _6298_/Q VPWR VGND sg13cmos5l_o21ai_1
X_6368_ _6368_/Q Tile_X0Y1_FrameData[28] Tile_X0Y1_FrameStrobe[11] VPWR VGND sg13cmos5l_dlhq_1
XFILLER_106_159 VPWR VGND sg13cmos5l_fill_1
X_5319_ _5319_/Y _6383_/Q _5262_/X _5318_/Y VPWR VGND sg13cmos5l_o21ai_1
X_6299_ _6299_/Q Tile_X0Y1_FrameData[1] Tile_X0Y1_FrameStrobe[8] VPWR VGND sg13cmos5l_dlhq_1
XFILLER_28_198 VPWR VGND sg13cmos5l_fill_1
XANTENNA__6721__X Tile_X0Y1_EE4BEG[2] VPWR VGND sg13cmos5l_antennanp
XANTENNA_9 Tile_X0Y0_E2END[7] VPWR VGND sg13cmos5l_antennanp
X_2951_ _2952_/A _2950_/X _2942_/X _6061_/Q VPWR VGND sg13cmos5l_mux2_1
X_5670_ _5670_/Q Tile_X0Y0_FrameData[28] Tile_X0Y1_FrameStrobe[3] VPWR VGND sg13cmos5l_dlhq_1
XANTENNA__6631__X Tile_X0Y0_NN4BEG[9] VPWR VGND sg13cmos5l_antennanp
X_4621_ _4621_/Y _5586_/Q _4621_/B VPWR VGND sg13cmos5l_nand2_1
X_2882_ _2882_/Y _5997_/Q VPWR VGND sg13cmos5l_inv_1
X_4552_ _4552_/Y Tile_X0Y1_NN4END[6] _5584_/Q _4551_/Y VPWR VGND sg13cmos5l_o21ai_1
X_4483_ _4485_/B _4483_/A _4483_/B VPWR VGND sg13cmos5l_xnor2_1
X_3503_ _3620_/B _6785_/A VPWR VGND sg13cmos5l_inv_1
X_6222_ _6222_/Q Tile_X0Y1_FrameData[14] Tile_X0Y1_FrameStrobe[6] VPWR VGND sg13cmos5l_dlhq_1
X_3434_ _3434_/Y _5649_/Q _3434_/B VPWR VGND sg13cmos5l_nor2_1
X_6153_ _6153_/Q Tile_X0Y1_FrameData[19] Tile_X0Y1_FrameStrobe[4] VPWR VGND sg13cmos5l_dlhq_1
X_3365_ _3366_/A Tile_X0Y0_S2MID[7] Tile_X0Y1_W1END[3] _3325_/Y Tile_X0Y1_W1END[1]
+ _6083_/Q _2862_/Y VPWR VGND sg13cmos5l_mux4_1
XFILLER_106_39 VPWR VGND sg13cmos5l_decap_8
X_6084_ _6084_/Q Tile_X0Y1_FrameData[24] Tile_X0Y1_FrameStrobe[2] VPWR VGND sg13cmos5l_dlhq_1
X_5104_ _5104_/X _4937_/Y _5204_/B _4018_/Y _4794_/B _5939_/Q _5940_/Q VPWR VGND sg13cmos5l_mux4_1
X_3296_ _3296_/Y _3296_/A _6149_/Q VPWR VGND sg13cmos5l_nor2b_1
X_5035_ _5035_/Y _5970_/Q _5011_/X _5034_/Y VPWR VGND sg13cmos5l_o21ai_1
XANTENNA__6806__X Tile_X0Y1_SS4BEG[3] VPWR VGND sg13cmos5l_antennanp
XFILLER_65_271 VPWR VGND sg13cmos5l_decap_8
X_5937_ _5937_/Q Tile_X0Y0_FrameData[17] Tile_X0Y1_FrameStrobe[11] VPWR VGND sg13cmos5l_dlhq_1
XANTENNA__6541__X Tile_X0Y0_FrameData_O[7] VPWR VGND sg13cmos5l_antennanp
X_5868_ _5868_/Q Tile_X0Y0_FrameData[22] Tile_X0Y1_FrameStrobe[9] VPWR VGND sg13cmos5l_dlhq_1
X_5799_ _5799_/Q Tile_X0Y0_FrameData[27] Tile_X0Y1_FrameStrobe[7] VPWR VGND sg13cmos5l_dlhq_1
X_4819_ _4819_/X _5839_/Q _4819_/B _4819_/C VPWR VGND sg13cmos5l_or3_1
XFILLER_88_330 VPWR VGND sg13cmos5l_fill_1
XANTENNA__6716__X Tile_X0Y1_E6BEG[9] VPWR VGND sg13cmos5l_antennanp
XFILLER_56_87 VPWR VGND sg13cmos5l_fill_1
XFILLER_71_252 VPWR VGND sg13cmos5l_decap_4
XFILLER_12_330 VPWR VGND sg13cmos5l_fill_1
XFILLER_8_323 VPWR VGND sg13cmos5l_fill_1
XFILLER_98_127 VPWR VGND sg13cmos5l_decap_8
X_3150_ _3150_/X _4515_/Y _4509_/Y _5390_/B _5374_/B _6096_/Q _6094_/Q VPWR VGND sg13cmos5l_mux4_1
X_3081_ _3081_/Y _5654_/Q _3080_/Y _5653_/Q VPWR VGND sg13cmos5l_o21ai_1
XFILLER_94_333 VPWR VGND sg13cmos5l_fill_1
XANTENNA__6626__X Tile_X0Y0_NN4BEG[4] VPWR VGND sg13cmos5l_antennanp
X_6840_ Tile_X0Y1_W6BEG[0] Tile_X0Y1_W6END[2] VPWR VGND sg13cmos5l_buf_1
X_6771_ Tile_X0Y1_S2BEG[0] _6771_/A VPWR VGND sg13cmos5l_buf_1
X_5722_ _5722_/Q Tile_X0Y0_FrameData[8] Tile_X0Y1_FrameStrobe[4] VPWR VGND sg13cmos5l_dlhq_1
X_3983_ _3983_/X _4707_/Y _4909_/X _4911_/X _5009_/Y _5712_/Q _5714_/Q VPWR VGND sg13cmos5l_mux4_1
X_2934_ _2934_/X _4344_/A _3888_/A _2810_/Y _2933_/A _6034_/Q _6033_/Q VPWR VGND sg13cmos5l_mux4_1
XFILLER_87_0 VPWR VGND sg13cmos5l_fill_1
X_5653_ _5653_/Q Tile_X0Y0_FrameData[13] Tile_X0Y1_FrameStrobe[2] VPWR VGND sg13cmos5l_dlhq_1
X_2865_ _2865_/Y _5813_/Q VPWR VGND sg13cmos5l_inv_1
X_5584_ _5584_/Q Tile_X0Y0_FrameData[18] Tile_X0Y1_FrameStrobe[0] VPWR VGND sg13cmos5l_dlhq_1
X_4604_ _4689_/B _4605_/A _4605_/B VPWR VGND sg13cmos5l_nor2_1
X_4535_ _4535_/Y _5676_/Q _4535_/B VPWR VGND sg13cmos5l_nand2b_1
X_2796_ _2796_/Y _6363_/Q VPWR VGND sg13cmos5l_inv_1
X_4466_ _4466_/Y _4486_/A VPWR VGND sg13cmos5l_inv_1
X_6205_ _6205_/Q Tile_X0Y1_FrameData[31] Tile_X0Y1_FrameStrobe[6] VPWR VGND sg13cmos5l_dlhq_1
X_4397_ _4397_/Y Tile_X0Y0_S2MID[0] _6048_/Q _6047_/Q VPWR VGND sg13cmos5l_o21ai_1
X_3417_ _3417_/X _3217_/A _3325_/A _2741_/Y _2790_/Y _6060_/Q _6059_/Q VPWR VGND sg13cmos5l_mux4_1
X_6136_ _6136_/Q Tile_X0Y1_FrameData[4] Tile_X0Y1_FrameStrobe[3] VPWR VGND sg13cmos5l_dlhq_1
X_3348_ _3349_/A _3348_/A _3348_/B VPWR VGND sg13cmos5l_nor2_1
X_6067_ _6067_/Q Tile_X0Y1_FrameData[9] Tile_X0Y1_FrameStrobe[1] VPWR VGND sg13cmos5l_dlhq_1
X_3279_ _3279_/Y Tile_X0Y0_S2MID[6] _3279_/B VPWR VGND sg13cmos5l_nor2_1
XFILLER_85_377 VPWR VGND sg13cmos5l_decap_4
XANTENNA__6536__X Tile_X0Y0_FrameData_O[2] VPWR VGND sg13cmos5l_antennanp
XANTENNA_207 Tile_X0Y1_W2MID[6] VPWR VGND sg13cmos5l_antennanp
X_5018_ _5018_/Y _5631_/Q _5018_/B VPWR VGND sg13cmos5l_nand2b_1
XANTENNA_218 Tile_X0Y1_W2MID[7] VPWR VGND sg13cmos5l_antennanp
XANTENNA_229 Tile_X0Y0_E2MID[7] VPWR VGND sg13cmos5l_antennanp
XFILLER_107_93 VPWR VGND sg13cmos5l_fill_1
X_4320_ _4320_/Y _4320_/A _6208_/Q VPWR VGND sg13cmos5l_nor2_1
X_4251_ _4260_/A _4191_/A _4187_/Y _4189_/Y VPWR VGND sg13cmos5l_o21ai_1
X_3202_ _3203_/B Tile_X0Y0_S2MID[1] Tile_X0Y0_W2MID[1] _5780_/Q VPWR VGND sg13cmos5l_mux2_1
X_4182_ _4182_/Y _5850_/Q _4181_/X _5849_/Q VPWR VGND sg13cmos5l_o21ai_1
XFILLER_67_333 VPWR VGND sg13cmos5l_fill_2
X_3133_ _3134_/B _5638_/Q _2885_/Y _3132_/Y VPWR VGND sg13cmos5l_a21oi_1
X_3064_ _3064_/Y _2760_/Y _5698_/Q _5696_/Q VPWR VGND sg13cmos5l_a21oi_1
XFILLER_94_163 VPWR VGND sg13cmos5l_fill_1
X_6823_ Tile_X0Y1_W1BEG[3] _6823_/A VPWR VGND sg13cmos5l_buf_1
X_6754_ Tile_X0Y1_FrameData_O[19] Tile_X0Y1_FrameData[19] VPWR VGND sg13cmos5l_buf_1
X_3966_ _3966_/Y _5721_/Q _3960_/X _5719_/Q VPWR VGND sg13cmos5l_o21ai_1
X_5705_ _5705_/Q Tile_X0Y0_FrameData[25] Tile_X0Y1_FrameStrobe[4] VPWR VGND sg13cmos5l_dlhq_1
X_6685_ Tile_X0Y0_WW4BEG[14] _6685_/A VPWR VGND sg13cmos5l_buf_1
X_2917_ _2917_/X Tile_X0Y1_N2MID[1] Tile_X0Y1_E2MID[1] _6780_/A Tile_X0Y1_W2MID[1]
+ _6222_/Q _6221_/Q VPWR VGND sg13cmos5l_mux4_1
X_5636_ _5636_/Q Tile_X0Y0_FrameData[30] Tile_X0Y1_FrameStrobe[2] VPWR VGND sg13cmos5l_dlhq_1
X_3897_ _5981_/D _3876_/X _3877_/X _3896_/X _3895_/X _6304_/Q _6303_/Q VPWR VGND sg13cmos5l_mux4_1
X_2848_ _3475_/A _6258_/Q VPWR VGND sg13cmos5l_inv_1
X_5567_ _5567_/Q Tile_X0Y1_UserCLK _5567_/D _6485_/L_HI VPWR VGND sg13cmos5l_dfrbpq_1
X_2779_ _2779_/Y _5904_/Q VPWR VGND sg13cmos5l_inv_1
X_5498_ _5498_/Y _6318_/Q _5498_/B VPWR VGND sg13cmos5l_nor2_1
X_4518_ _4518_/Y _6423_/Q _5536_/B _4517_/Y VPWR VGND sg13cmos5l_o21ai_1
XFILLER_2_329 VPWR VGND sg13cmos5l_fill_1
X_4449_ _4449_/Y _4447_/Y _4448_/Y _6110_/Q VPWR VGND sg13cmos5l_o21ai_1
X_6119_ _6119_/Q Tile_X0Y1_FrameData[21] Tile_X0Y1_FrameStrobe[3] VPWR VGND sg13cmos5l_dlhq_1
XFILLER_49_300 VPWR VGND sg13cmos5l_fill_1
XFILLER_64_303 VPWR VGND sg13cmos5l_decap_4
XFILLER_17_230 VPWR VGND sg13cmos5l_fill_2
XFILLER_72_380 VPWR VGND sg13cmos5l_fill_1
X_3820_ _3820_/Y Tile_X0Y1_W2MID[0] _6246_/Q _6245_/Q VPWR VGND sg13cmos5l_o21ai_1
XFILLER_32_266 VPWR VGND sg13cmos5l_fill_1
X_3751_ _3751_/Y Tile_X0Y1_E2MID[2] _6250_/Q _3750_/Y VPWR VGND sg13cmos5l_a21oi_1
XFILLER_32_299 VPWR VGND sg13cmos5l_fill_2
X_6470_ _6470_/L_HI VPWR VGND sg13cmos5l_tiehi
X_3682_ _3682_/X Tile_X0Y0_S4END[6] Tile_X0Y0_SS4END[6] _6104_/Q VPWR VGND sg13cmos5l_mux2_1
X_5421_ _5421_/Y _2800_/Y _3896_/X _6340_/Q VPWR VGND sg13cmos5l_o21ai_1
X_5352_ _6717_/A _6371_/Q _5351_/Y _5347_/X VPWR VGND sg13cmos5l_o21ai_1
X_4303_ _4304_/B _6426_/Q _6001_/D _4302_/Y VPWR VGND sg13cmos5l_o21ai_1
X_5283_ _5283_/Y _6400_/Q _5342_/B _6399_/Q VPWR VGND sg13cmos5l_o21ai_1
XFILLER_59_119 VPWR VGND sg13cmos5l_fill_2
XFILLER_59_108 VPWR VGND sg13cmos5l_decap_8
X_4234_ _4354_/A _4234_/A _4234_/B VPWR VGND sg13cmos5l_xnor2_1
X_4165_ _4165_/X Tile_X0Y0_E2END[3] Tile_X0Y0_E6END[1] _3172_/Y Tile_X0Y1_N2MID[3]
+ _5626_/Q _2884_/Y VPWR VGND sg13cmos5l_mux4_1
X_3116_ _3116_/X Tile_X0Y0_E1END[0] Tile_X0Y0_E2END[0] _5638_/Q VPWR VGND sg13cmos5l_mux2_1
XFILLER_67_163 VPWR VGND sg13cmos5l_fill_2
X_4096_ _4096_/Y _4096_/A _4096_/B VPWR VGND sg13cmos5l_nand2_1
X_3047_ _6826_/A _3045_/Y _3046_/Y _3039_/Y VPWR VGND sg13cmos5l_o21ai_1
XFILLER_82_166 VPWR VGND sg13cmos5l_fill_2
XANTENNA__6814__X Tile_X0Y1_SS4BEG[11] VPWR VGND sg13cmos5l_antennanp
XFILLER_70_328 VPWR VGND sg13cmos5l_fill_2
X_6806_ Tile_X0Y1_SS4BEG[3] Tile_X0Y0_SS4END[11] VPWR VGND sg13cmos5l_buf_1
XFILLER_23_244 VPWR VGND sg13cmos5l_fill_2
X_4998_ _6497_/A _4984_/Y _4990_/Y _4997_/Y VPWR VGND sg13cmos5l_o21ai_1
X_6737_ Tile_X0Y1_FrameData_O[2] Tile_X0Y1_FrameData[2] VPWR VGND sg13cmos5l_buf_1
X_3949_ _4599_/A _4681_/A VPWR VGND sg13cmos5l_inv_1
X_6668_ Tile_X0Y0_W6BEG[9] Tile_X0Y0_W6END[11] VPWR VGND sg13cmos5l_buf_1
X_5619_ _5619_/Q Tile_X0Y0_FrameData[15] Tile_X0Y1_FrameStrobe[1] VPWR VGND sg13cmos5l_dlhq_1
X_6599_ Tile_X0Y0_N2BEGb[1] _6599_/A VPWR VGND sg13cmos5l_buf_1
XFILLER_109_349 VPWR VGND sg13cmos5l_fill_1
XFILLER_58_141 VPWR VGND sg13cmos5l_fill_2
XFILLER_58_185 VPWR VGND sg13cmos5l_fill_1
XANTENNA__6724__X Tile_X0Y1_EE4BEG[5] VPWR VGND sg13cmos5l_antennanp
XFILLER_89_95 VPWR VGND sg13cmos5l_fill_1
X_5970_ _5970_/Q Tile_X0Y0_FrameData[16] Tile_X0Y1_FrameStrobe[12] VPWR VGND sg13cmos5l_dlhq_1
XANTENNA__6634__X Tile_X0Y0_NN4BEG[12] VPWR VGND sg13cmos5l_antennanp
X_4921_ _4921_/Y _5830_/Q _4921_/B VPWR VGND sg13cmos5l_nor2_1
X_4852_ _4852_/Y Tile_X0Y0_S4END[0] _5580_/Q VPWR VGND sg13cmos5l_nand2b_1
X_3803_ _3803_/Y _6054_/Q _2892_/Y _6056_/Q VPWR VGND sg13cmos5l_a21oi_1
X_4783_ _4783_/Y _6426_/Q _2754_/Y _6425_/Q VPWR VGND sg13cmos5l_a21oi_1
X_6522_ Tile_X0Y0_EE4BEG[4] Tile_X0Y0_EE4END[8] VPWR VGND sg13cmos5l_buf_1
X_3734_ _3735_/B Tile_X0Y1_N1END[2] Tile_X0Y1_E1END[2] Tile_X0Y1_N2END[6] Tile_X0Y1_E2END[6]
+ _6119_/Q _6120_/Q VPWR VGND sg13cmos5l_mux4_1
X_6453_ _6453_/L_HI VPWR VGND sg13cmos5l_tiehi
X_3665_ _3665_/Y _6099_/Q _3664_/X VPWR VGND sg13cmos5l_nor2b_1
X_5404_ _5405_/A _2798_/Y _3481_/Y _5403_/Y VPWR VGND sg13cmos5l_a21oi_1
X_6384_ _6384_/Q Tile_X0Y1_FrameData[12] Tile_X0Y1_FrameStrobe[11] VPWR VGND sg13cmos5l_dlhq_1
X_3596_ _3605_/A _6161_/Q _3596_/B _3596_/C VPWR VGND sg13cmos5l_nor3_1
X_5335_ _5335_/Y _5335_/A _6378_/Q VPWR VGND sg13cmos5l_nor2b_1
XANTENNA__6809__X Tile_X0Y1_SS4BEG[6] VPWR VGND sg13cmos5l_antennanp
X_5266_ _6617_/A Tile_X0Y1_N2END[1] Tile_X0Y1_N4END[0] Tile_X0Y1_W6END[0] _5262_/X
+ _6408_/Q _6407_/Q VPWR VGND sg13cmos5l_mux4_1
X_4217_ _4217_/Y _4218_/A _4218_/B VPWR VGND sg13cmos5l_nor2b_1
X_5197_ _5197_/Y _5886_/Q _5197_/B VPWR VGND sg13cmos5l_nand2_1
X_4148_ _4226_/B _4148_/A _4148_/B VPWR VGND sg13cmos5l_xnor2_1
X_4079_ _4081_/B _4205_/A _4602_/A VPWR VGND sg13cmos5l_nor2_1
XANTENNA__6544__X Tile_X0Y0_FrameData_O[10] VPWR VGND sg13cmos5l_antennanp
XFILLER_11_247 VPWR VGND sg13cmos5l_fill_1
XFILLER_50_34 VPWR VGND sg13cmos5l_fill_1
XFILLER_105_341 VPWR VGND sg13cmos5l_decap_8
XANTENNA__6719__X Tile_X0Y1_EE4BEG[0] VPWR VGND sg13cmos5l_antennanp
XFILLER_93_206 VPWR VGND sg13cmos5l_fill_2
XFILLER_75_20 VPWR VGND sg13cmos5l_fill_1
XFILLER_93_239 VPWR VGND sg13cmos5l_fill_1
XFILLER_19_369 VPWR VGND sg13cmos5l_fill_2
XFILLER_27_380 VPWR VGND sg13cmos5l_fill_1
X_3450_ _3450_/Y _2857_/Y _3449_/X _6085_/Q VPWR VGND sg13cmos5l_o21ai_1
X_3381_ _4123_/C _6154_/Q _3378_/X _3380_/Y VPWR VGND sg13cmos5l_a21o_1
XANTENNA__6629__X Tile_X0Y0_NN4BEG[7] VPWR VGND sg13cmos5l_antennanp
X_5120_ _5120_/Y _5934_/Q _5243_/B VPWR VGND sg13cmos5l_nand2_1
X_5051_ _5051_/Y _5955_/Q _5051_/B VPWR VGND sg13cmos5l_nor2_1
X_4002_ _4571_/A _6427_/Q _4000_/A _4001_/Y VPWR VGND sg13cmos5l_o21ai_1
X_5953_ _5953_/Q Tile_X0Y0_FrameData[1] Tile_X0Y1_FrameStrobe[11] VPWR VGND sg13cmos5l_dlhq_1
XFILLER_52_158 VPWR VGND sg13cmos5l_fill_1
X_5884_ _5884_/Q Tile_X0Y0_FrameData[6] Tile_X0Y1_FrameStrobe[9] VPWR VGND sg13cmos5l_dlhq_1
X_4904_ _4907_/A _4905_/B _4905_/C _5006_/A VPWR VGND sg13cmos5l_o21ai_1
X_4835_ _4835_/Y _5612_/Q _4934_/Y _5614_/Q VPWR VGND sg13cmos5l_o21ai_1
X_4766_ _4766_/Y _6496_/A VPWR VGND sg13cmos5l_inv_1
X_6505_ Tile_X0Y0_E2BEGb[7] Tile_X0Y0_E2MID[7] VPWR VGND sg13cmos5l_buf_1
X_3717_ _5980_/D _6305_/Q _3708_/Y _3715_/Y _3716_/Y VPWR VGND sg13cmos5l_a22oi_1
X_4697_ _4865_/A _4698_/A _4698_/B VPWR VGND sg13cmos5l_or2_1
X_6436_ _6436_/L_HI VPWR VGND sg13cmos5l_tiehi
X_3648_ _3648_/Y Tile_X0Y1_E2MID[5] _6224_/Q _3647_/Y VPWR VGND sg13cmos5l_a21oi_1
X_6367_ _6367_/Q Tile_X0Y1_FrameData[29] Tile_X0Y1_FrameStrobe[11] VPWR VGND sg13cmos5l_dlhq_1
X_3579_ _3579_/Y _6266_/Q Tile_X0Y1_W2MID[2] VPWR VGND sg13cmos5l_nor2b_1
XANTENNA__6539__X Tile_X0Y0_FrameData_O[5] VPWR VGND sg13cmos5l_antennanp
X_5318_ _5318_/Y _6383_/Q _5468_/B VPWR VGND sg13cmos5l_nand2_1
X_6298_ _6298_/Q Tile_X0Y1_FrameData[2] Tile_X0Y1_FrameStrobe[8] VPWR VGND sg13cmos5l_dlhq_1
X_5249_ _5249_/X _4937_/Y _4909_/X _5062_/B _5009_/Y _5872_/Q _5871_/Q VPWR VGND sg13cmos5l_mux4_1
XFILLER_43_158 VPWR VGND sg13cmos5l_fill_2
XFILLER_105_160 VPWR VGND sg13cmos5l_decap_4
XFILLER_105_182 VPWR VGND sg13cmos5l_fill_2
XFILLER_66_206 VPWR VGND sg13cmos5l_fill_1
XFILLER_66_228 VPWR VGND sg13cmos5l_fill_2
XFILLER_19_155 VPWR VGND sg13cmos5l_fill_2
X_2950_ _2950_/X _2949_/Y _2947_/Y _2943_/X _2945_/Y _6064_/Q _6063_/Q VPWR VGND sg13cmos5l_mux4_1
X_2881_ _2881_/Y _6288_/Q VPWR VGND sg13cmos5l_inv_1
XFILLER_42_191 VPWR VGND sg13cmos5l_fill_2
X_4620_ _4620_/X Tile_X0Y0_W2END[3] _6593_/A _5586_/Q VPWR VGND sg13cmos5l_mux2_1
X_4551_ _4551_/Y _4551_/A _5584_/Q VPWR VGND sg13cmos5l_nand2_1
X_4482_ _4482_/Y _4483_/B VPWR VGND sg13cmos5l_inv_1
X_3502_ _6785_/A _5639_/Q _3493_/Y _3495_/Y _3501_/Y VPWR VGND sg13cmos5l_a22oi_1
X_6221_ _6221_/Q Tile_X0Y1_FrameData[15] Tile_X0Y1_FrameStrobe[6] VPWR VGND sg13cmos5l_dlhq_1
X_3433_ _3434_/B _4940_/Y _4934_/Y _5011_/X _4937_/Y _5650_/Q _5648_/Q VPWR VGND sg13cmos5l_mux4_1
X_6152_ _6152_/Q Tile_X0Y1_FrameData[20] Tile_X0Y1_FrameStrobe[4] VPWR VGND sg13cmos5l_dlhq_1
XFILLER_106_18 VPWR VGND sg13cmos5l_decap_8
X_5103_ _6489_/A _5941_/Q _5102_/Y _5100_/X VPWR VGND sg13cmos5l_o21ai_1
X_3364_ _3364_/Y _6083_/Q _3363_/X _2863_/Y VPWR VGND sg13cmos5l_a21oi_1
XFILLER_32_0 VPWR VGND sg13cmos5l_fill_2
X_6083_ _6083_/Q Tile_X0Y1_FrameData[25] Tile_X0Y1_FrameStrobe[2] VPWR VGND sg13cmos5l_dlhq_1
X_3295_ _3295_/X _2837_/Y _3291_/Y _3294_/Y VPWR VGND sg13cmos5l_a21o_1
XFILLER_111_141 VPWR VGND sg13cmos5l_fill_2
X_5034_ _5034_/Y _5970_/Q _5197_/B VPWR VGND sg13cmos5l_nand2_1
XFILLER_65_250 VPWR VGND sg13cmos5l_fill_1
X_5936_ _5936_/Q Tile_X0Y0_FrameData[18] Tile_X0Y1_FrameStrobe[11] VPWR VGND sg13cmos5l_dlhq_1
XANTENNA__6822__X Tile_X0Y1_W1BEG[2] VPWR VGND sg13cmos5l_antennanp
X_5867_ _5867_/Q Tile_X0Y0_FrameData[23] Tile_X0Y1_FrameStrobe[9] VPWR VGND sg13cmos5l_dlhq_1
X_5798_ _5798_/Q Tile_X0Y0_FrameData[28] Tile_X0Y1_FrameStrobe[7] VPWR VGND sg13cmos5l_dlhq_1
X_4818_ _4819_/C _4818_/A _4818_/B VPWR VGND sg13cmos5l_nor2_1
X_4749_ _4749_/Y _6426_/Q _2758_/Y _6425_/Q VPWR VGND sg13cmos5l_a21oi_1
X_6419_ _6419_/Q Tile_X0Y1_FrameData[9] Tile_X0Y1_FrameStrobe[12] VPWR VGND sg13cmos5l_dlhq_1
XFILLER_56_66 VPWR VGND sg13cmos5l_decap_4
XANTENNA__6732__X Tile_X0Y1_EE4BEG[13] VPWR VGND sg13cmos5l_antennanp
XFILLER_71_297 VPWR VGND sg13cmos5l_fill_1
XFILLER_8_302 VPWR VGND sg13cmos5l_fill_2
XFILLER_72_98 VPWR VGND sg13cmos5l_fill_1
X_3080_ _3080_/Y _5652_/Q _2890_/Y _3079_/Y VPWR VGND sg13cmos5l_a21oi_1
XFILLER_39_217 VPWR VGND sg13cmos5l_fill_1
XFILLER_47_294 VPWR VGND sg13cmos5l_fill_1
X_6770_ Tile_X0Y1_S1BEG[3] _6770_/A VPWR VGND sg13cmos5l_buf_1
X_3982_ _3985_/A _5713_/Q _3982_/B VPWR VGND sg13cmos5l_nor2_1
XANTENNA__6642__X Tile_X0Y0_W1BEG[3] VPWR VGND sg13cmos5l_antennanp
X_5721_ _5721_/Q Tile_X0Y0_FrameData[9] Tile_X0Y1_FrameStrobe[4] VPWR VGND sg13cmos5l_dlhq_1
X_2933_ _6693_/A _2933_/A VPWR VGND sg13cmos5l_inv_1
XFILLER_62_297 VPWR VGND sg13cmos5l_fill_2
X_5652_ _5652_/Q Tile_X0Y0_FrameData[14] Tile_X0Y1_FrameStrobe[2] VPWR VGND sg13cmos5l_dlhq_1
X_2864_ _2864_/Y _6000_/Q VPWR VGND sg13cmos5l_inv_1
X_5583_ _5583_/Q Tile_X0Y0_FrameData[19] Tile_X0Y1_FrameStrobe[0] VPWR VGND sg13cmos5l_dlhq_1
X_4603_ _4605_/B _4603_/A _4603_/B VPWR VGND sg13cmos5l_xor2_1
X_2795_ _2795_/Y _6379_/Q VPWR VGND sg13cmos5l_inv_1
XFILLER_30_194 VPWR VGND sg13cmos5l_fill_1
X_4534_ _4535_/B _4944_/X Tile_X0Y1_N2MID[6] _5678_/Q VPWR VGND sg13cmos5l_mux2_1
X_4465_ _4486_/A _4262_/Y _4267_/B _4265_/Y VPWR VGND sg13cmos5l_o21ai_1
XFILLER_89_128 VPWR VGND sg13cmos5l_fill_2
XFILLER_89_106 VPWR VGND sg13cmos5l_fill_2
X_6204_ _6204_/Q Tile_X0Y1_FrameData[0] Tile_X0Y1_FrameStrobe[5] VPWR VGND sg13cmos5l_dlhq_1
X_4396_ _4396_/Y _6048_/Q _3208_/Y _4395_/Y VPWR VGND sg13cmos5l_o21ai_1
X_3416_ _3852_/B _3409_/Y _3411_/Y _3413_/Y _3415_/Y _2875_/Y VPWR VGND sg13cmos5l_a221oi_1
X_6135_ _6135_/Q Tile_X0Y1_FrameData[5] Tile_X0Y1_FrameStrobe[3] VPWR VGND sg13cmos5l_dlhq_1
X_3347_ _3348_/B _6051_/Q _3344_/Y _3346_/Y VPWR VGND sg13cmos5l_a21oi_1
XANTENNA__6817__X Tile_X0Y1_SS4BEG[14] VPWR VGND sg13cmos5l_antennanp
X_6066_ _6066_/Q Tile_X0Y1_FrameData[10] Tile_X0Y1_FrameStrobe[1] VPWR VGND sg13cmos5l_dlhq_1
X_5017_ _5018_/B _3063_/X Tile_X0Y1_N2MID[1] Tile_X0Y0_S2END[1] Tile_X0Y0_S4END[1]
+ _5634_/Q _5632_/Q VPWR VGND sg13cmos5l_mux4_1
X_3278_ _3278_/Y _5455_/B VPWR VGND sg13cmos5l_inv_1
XANTENNA_208 Tile_X0Y1_W2MID[6] VPWR VGND sg13cmos5l_antennanp
XANTENNA_219 Tile_X0Y1_W2MID[7] VPWR VGND sg13cmos5l_antennanp
XFILLER_53_275 VPWR VGND sg13cmos5l_fill_1
XFILLER_26_69 VPWR VGND sg13cmos5l_fill_1
XANTENNA__6552__X Tile_X0Y0_FrameData_O[18] VPWR VGND sg13cmos5l_antennanp
X_5919_ _5919_/Q Tile_X0Y0_FrameData[3] Tile_X0Y1_FrameStrobe[10] VPWR VGND sg13cmos5l_dlhq_1
XANTENNA__6727__X Tile_X0Y1_EE4BEG[8] VPWR VGND sg13cmos5l_antennanp
X_4250_ _4270_/A _4192_/A _4192_/B _4199_/Y VPWR VGND sg13cmos5l_a21oi_1
X_4181_ _4181_/X Tile_X0Y1_N2MID[0] Tile_X0Y0_EE4END[1] Tile_X0Y0_S2END[0] Tile_X0Y0_W2END[0]
+ _5748_/Q _5747_/Q VPWR VGND sg13cmos5l_mux4_1
X_3201_ _6493_/A _3201_/A VPWR VGND sg13cmos5l_inv_1
XANTENNA__6637__X Tile_X0Y0_NN4BEG[15] VPWR VGND sg13cmos5l_antennanp
X_3132_ _3132_/Y _5638_/Q _4943_/Y _5636_/Q VPWR VGND sg13cmos5l_o21ai_1
XFILLER_67_312 VPWR VGND sg13cmos5l_fill_1
X_3063_ _3063_/X _5390_/B _6826_/A _3715_/B _3031_/X _6415_/Q _6416_/Q VPWR VGND sg13cmos5l_mux4_1
X_6822_ Tile_X0Y1_W1BEG[2] _6822_/A VPWR VGND sg13cmos5l_buf_1
XFILLER_90_370 VPWR VGND sg13cmos5l_fill_1
X_6753_ Tile_X0Y1_FrameData_O[18] Tile_X0Y1_FrameData[18] VPWR VGND sg13cmos5l_buf_1
X_3965_ _3965_/Y _5722_/Q _3962_/Y _3964_/Y VPWR VGND sg13cmos5l_a21oi_1
X_5704_ _5704_/Q Tile_X0Y0_FrameData[26] Tile_X0Y1_FrameStrobe[4] VPWR VGND sg13cmos5l_dlhq_1
X_6684_ Tile_X0Y0_WW4BEG[13] _6684_/A VPWR VGND sg13cmos5l_buf_1
X_3896_ _3896_/X Tile_X0Y1_N2END[0] Tile_X0Y1_E2END[0] Tile_X0Y0_S2MID[0] Tile_X0Y1_WW4END[3]
+ _6198_/Q _6197_/Q VPWR VGND sg13cmos5l_mux4_1
X_2916_ _2916_/X _2760_/Y _2843_/Y _2915_/A _2842_/Y _6222_/Q _6221_/Q VPWR VGND sg13cmos5l_mux4_1
X_5635_ _5635_/Q Tile_X0Y0_FrameData[31] Tile_X0Y1_FrameStrobe[2] VPWR VGND sg13cmos5l_dlhq_1
X_2847_ _2847_/Y _6086_/Q VPWR VGND sg13cmos5l_inv_1
X_5566_ _5566_/Q Tile_X0Y1_UserCLK _5566_/D _6466_/L_HI VPWR VGND sg13cmos5l_dfrbpq_1
X_2778_ _2778_/Y Tile_X0Y0_S2END[2] VPWR VGND sg13cmos5l_inv_1
X_5497_ _6867_/A _5497_/A _5497_/B VPWR VGND sg13cmos5l_nor2_1
X_4517_ _4517_/Y _6423_/Q _5556_/Q VPWR VGND sg13cmos5l_nand2_1
X_4448_ _4448_/Y _6112_/Q Tile_X0Y0_SS4END[4] _6111_/Q VPWR VGND sg13cmos5l_o21ai_1
X_4379_ _4380_/B _6426_/Q _5998_/D _4378_/Y VPWR VGND sg13cmos5l_o21ai_1
XANTENNA__6547__X Tile_X0Y0_FrameData_O[13] VPWR VGND sg13cmos5l_antennanp
X_6118_ _6118_/Q Tile_X0Y1_FrameData[22] Tile_X0Y1_FrameStrobe[3] VPWR VGND sg13cmos5l_dlhq_1
X_6049_ _6049_/Q Tile_X0Y1_FrameData[27] Tile_X0Y1_FrameStrobe[1] VPWR VGND sg13cmos5l_dlhq_1
XFILLER_49_334 VPWR VGND sg13cmos5l_fill_2
XFILLER_72_370 VPWR VGND sg13cmos5l_fill_1
X_3750_ _3750_/Y _6250_/Q Tile_X0Y1_N2MID[2] VPWR VGND sg13cmos5l_nor2b_1
X_3681_ _3725_/A _4138_/A _4477_/A VPWR VGND sg13cmos5l_nand2_1
X_5420_ _5420_/Y _6341_/Q _5420_/B VPWR VGND sg13cmos5l_nor2_1
X_5351_ _5351_/Y _6373_/Q _5349_/X _5350_/Y VPWR VGND sg13cmos5l_a21oi_1
X_5282_ _5282_/Y _6400_/Q _5440_/B _5281_/Y VPWR VGND sg13cmos5l_o21ai_1
X_4302_ _4302_/Y _6426_/Q _2860_/Y _6425_/Q VPWR VGND sg13cmos5l_a21oi_1
XFILLER_99_234 VPWR VGND sg13cmos5l_fill_2
X_4233_ _4233_/Y _4234_/B _4234_/A VPWR VGND sg13cmos5l_nor2b_1
X_4164_ _4164_/Y _2884_/Y _4163_/X _5623_/Q VPWR VGND sg13cmos5l_o21ai_1
X_4095_ _4096_/B _5860_/Q _5197_/B _5859_/Q VPWR VGND sg13cmos5l_a21oi_1
X_3115_ _3115_/Y _3118_/S _2953_/X _3114_/Y VPWR VGND sg13cmos5l_a21oi_1
X_3046_ _3046_/Y _6067_/Q _3040_/X _6065_/Q VPWR VGND sg13cmos5l_o21ai_1
XFILLER_23_223 VPWR VGND sg13cmos5l_fill_1
X_6805_ Tile_X0Y1_SS4BEG[2] Tile_X0Y0_SS4END[10] VPWR VGND sg13cmos5l_buf_1
X_6736_ Tile_X0Y1_FrameData_O[1] Tile_X0Y1_FrameData[1] VPWR VGND sg13cmos5l_buf_1
X_4997_ _4997_/Y _5668_/Q _4991_/X _4996_/Y VPWR VGND sg13cmos5l_o21ai_1
XANTENNA__6830__X Tile_X0Y1_W2BEG[6] VPWR VGND sg13cmos5l_antennanp
X_3948_ _4681_/A _5991_/D _5991_/Q _6427_/Q VPWR VGND sg13cmos5l_mux2_1
X_6667_ Tile_X0Y0_W6BEG[8] Tile_X0Y0_W6END[10] VPWR VGND sg13cmos5l_buf_1
X_3879_ _3879_/Y _6070_/Q _2891_/Y _3878_/Y VPWR VGND sg13cmos5l_o21ai_1
X_5618_ _5618_/Q Tile_X0Y0_FrameData[16] Tile_X0Y1_FrameStrobe[1] VPWR VGND sg13cmos5l_dlhq_1
X_6598_ Tile_X0Y0_N2BEGb[0] _6598_/A VPWR VGND sg13cmos5l_buf_1
X_5549_ _5569_/D _5551_/A _4908_/Y VPWR VGND sg13cmos5l_nor2b_1
XFILLER_3_7 VPWR VGND sg13cmos5l_decap_8
XFILLER_64_33 VPWR VGND sg13cmos5l_decap_4
XANTENNA__6740__X Tile_X0Y1_FrameData_O[5] VPWR VGND sg13cmos5l_antennanp
XFILLER_49_142 VPWR VGND sg13cmos5l_fill_2
X_4920_ _4920_/Y _2761_/Y _6596_/A _4919_/Y VPWR VGND sg13cmos5l_o21ai_1
X_4851_ _4851_/X Tile_X0Y0_WW4END[1] _2993_/Y _5580_/Q VPWR VGND sg13cmos5l_mux2_1
X_3802_ _3802_/X _6055_/Q _3802_/B VPWR VGND sg13cmos5l_or2_1
XANTENNA__6650__X Tile_X0Y0_W2BEG[7] VPWR VGND sg13cmos5l_antennanp
X_4782_ _6009_/D _4779_/Y _4781_/Y _4773_/Y VPWR VGND sg13cmos5l_o21ai_1
X_6521_ Tile_X0Y0_EE4BEG[3] Tile_X0Y0_EE4END[7] VPWR VGND sg13cmos5l_buf_1
X_3733_ _3736_/B _3729_/Y _3730_/Y _3732_/Y _6119_/Q _2811_/Y VPWR VGND sg13cmos5l_a221oi_1
X_6452_ _6452_/L_HI VPWR VGND sg13cmos5l_tiehi
X_3664_ _3664_/X Tile_X0Y1_NN4END[3] Tile_X0Y1_E1END[1] Tile_X0Y0_S2MID[3] Tile_X0Y0_S4END[7]
+ _6100_/Q _6098_/Q VPWR VGND sg13cmos5l_mux4_1
X_5403_ _5403_/Y _2798_/Y _4285_/X _6349_/Q VPWR VGND sg13cmos5l_o21ai_1
X_6383_ _6383_/Q Tile_X0Y1_FrameData[13] Tile_X0Y1_FrameStrobe[11] VPWR VGND sg13cmos5l_dlhq_1
X_3595_ _3596_/C _6162_/Q _3591_/X _3594_/Y VPWR VGND sg13cmos5l_a21oi_1
X_5334_ _5335_/A _6380_/Q _3614_/Y _5333_/Y VPWR VGND sg13cmos5l_a21oi_1
X_5265_ _6616_/A Tile_X0Y1_N2END[0] Tile_X0Y1_W6END[1] Tile_X0Y1_N4END[3] _5374_/B
+ _6409_/Q _6410_/Q VPWR VGND sg13cmos5l_mux4_1
X_5196_ _5196_/X _5886_/Q _3323_/Y _5195_/Y VPWR VGND sg13cmos5l_a21o_1
X_4216_ _4219_/A _4216_/A _4602_/A VPWR VGND sg13cmos5l_nor2_1
X_4147_ _4226_/A _4147_/A _4147_/B VPWR VGND sg13cmos5l_nand2_1
XFILLER_28_348 VPWR VGND sg13cmos5l_fill_2
XANTENNA__6825__X Tile_X0Y1_W2BEG[1] VPWR VGND sg13cmos5l_antennanp
X_4078_ _4602_/A _6428_/Q _5982_/Q _4077_/Y VPWR VGND sg13cmos5l_a21oi_1
X_3029_ _3029_/Y _5697_/Q _3023_/X _5695_/Q VPWR VGND sg13cmos5l_o21ai_1
XFILLER_34_58 VPWR VGND sg13cmos5l_fill_1
XANTENNA__6560__X Tile_X0Y0_FrameData_O[26] VPWR VGND sg13cmos5l_antennanp
X_6719_ Tile_X0Y1_EE4BEG[0] Tile_X0Y1_EE4END[4] VPWR VGND sg13cmos5l_buf_1
XFILLER_93_218 VPWR VGND sg13cmos5l_decap_4
XANTENNA__6735__X Tile_X0Y1_FrameData_O[0] VPWR VGND sg13cmos5l_antennanp
XFILLER_61_137 VPWR VGND sg13cmos5l_fill_2
X_3380_ _3380_/Y _6154_/Q _3379_/X _2817_/Y VPWR VGND sg13cmos5l_o21ai_1
X_5050_ _5051_/B Tile_X0Y0_E1END[3] _4911_/X _3063_/X Tile_X0Y0_W1END[3] _5956_/Q
+ _2774_/Y VPWR VGND sg13cmos5l_mux4_1
XFILLER_69_248 VPWR VGND sg13cmos5l_fill_1
XFILLER_111_334 VPWR VGND sg13cmos5l_decap_8
X_4001_ _4001_/Y _6427_/Q _5990_/Q VPWR VGND sg13cmos5l_nand2_1
XFILLER_77_270 VPWR VGND sg13cmos5l_fill_2
XANTENNA__6645__X Tile_X0Y0_W2BEG[2] VPWR VGND sg13cmos5l_antennanp
X_5952_ _5952_/Q Tile_X0Y0_FrameData[2] Tile_X0Y1_FrameStrobe[11] VPWR VGND sg13cmos5l_dlhq_1
X_4903_ _4905_/C _6425_/Q _4903_/B _4903_/C VPWR VGND sg13cmos5l_nor3_1
X_5883_ _5883_/Q Tile_X0Y0_FrameData[7] Tile_X0Y1_FrameStrobe[9] VPWR VGND sg13cmos5l_dlhq_1
X_4834_ _4834_/Y _5611_/Q _4834_/B _4834_/C VPWR VGND sg13cmos5l_nor3_1
X_4765_ _6496_/A _5671_/Q _4756_/Y _4758_/Y _4764_/Y VPWR VGND sg13cmos5l_a22oi_1
X_6504_ Tile_X0Y0_E2BEGb[6] Tile_X0Y0_E2MID[6] VPWR VGND sg13cmos5l_buf_1
X_3716_ _3716_/Y _2871_/Y _3714_/Y _6305_/Q VPWR VGND sg13cmos5l_a21oi_1
X_4696_ _4698_/B _4696_/A _4696_/B VPWR VGND sg13cmos5l_xor2_1
X_6435_ _6435_/L_HI VPWR VGND sg13cmos5l_tiehi
X_3647_ _3647_/Y _4320_/A _6224_/Q VPWR VGND sg13cmos5l_nor2_1
X_6366_ _6366_/Q Tile_X0Y1_FrameData[30] Tile_X0Y1_FrameStrobe[11] VPWR VGND sg13cmos5l_dlhq_1
X_3578_ _3578_/Y _6265_/Q _3578_/B VPWR VGND sg13cmos5l_nand2b_1
X_5317_ _5321_/A _2793_/Y _3643_/Y _5316_/Y VPWR VGND sg13cmos5l_a21oi_1
X_6297_ _6297_/Q Tile_X0Y1_FrameData[3] Tile_X0Y1_FrameStrobe[8] VPWR VGND sg13cmos5l_dlhq_1
X_5248_ _5248_/Y _5248_/A _5870_/Q VPWR VGND sg13cmos5l_nor2b_1
X_5179_ _5183_/A _5898_/Q _5243_/B _5178_/Y VPWR VGND sg13cmos5l_a21oi_1
XANTENNA__6555__X Tile_X0Y0_FrameData_O[21] VPWR VGND sg13cmos5l_antennanp
XFILLER_86_86 VPWR VGND sg13cmos5l_fill_1
X_2880_ _2880_/Y _5998_/Q VPWR VGND sg13cmos5l_inv_1
XFILLER_30_354 VPWR VGND sg13cmos5l_fill_1
XFILLER_30_365 VPWR VGND sg13cmos5l_fill_2
X_4550_ _4550_/Y _5584_/Q _3201_/A _4549_/Y VPWR VGND sg13cmos5l_a21oi_1
X_4481_ _4483_/B _4481_/A _4481_/B VPWR VGND sg13cmos5l_xor2_1
X_3501_ _3501_/Y _5639_/Q _3501_/B VPWR VGND sg13cmos5l_nor2_1
X_6220_ _6220_/Q Tile_X0Y1_FrameData[16] Tile_X0Y1_FrameStrobe[6] VPWR VGND sg13cmos5l_dlhq_1
X_3432_ _3432_/Y _6290_/Q _3162_/Y _3431_/Y VPWR VGND sg13cmos5l_a21oi_1
X_6151_ _6151_/Q Tile_X0Y1_FrameData[21] Tile_X0Y1_FrameStrobe[4] VPWR VGND sg13cmos5l_dlhq_1
X_3363_ _3363_/X _2891_/Y _4409_/B _2895_/Y _2892_/Y _2862_/Y _6082_/Q VPWR VGND sg13cmos5l_mux4_1
X_5102_ _5102_/Y _5942_/Q _4937_/Y _5101_/Y VPWR VGND sg13cmos5l_o21ai_1
X_6082_ _6082_/Q Tile_X0Y1_FrameData[26] Tile_X0Y1_FrameStrobe[2] VPWR VGND sg13cmos5l_dlhq_1
X_3294_ _3294_/Y _3292_/Y _3293_/Y _6151_/Q VPWR VGND sg13cmos5l_o21ai_1
X_5033_ _5033_/X _5970_/Q _3323_/Y _5032_/Y VPWR VGND sg13cmos5l_a21o_1
XFILLER_111_164 VPWR VGND sg13cmos5l_fill_2
XFILLER_65_295 VPWR VGND sg13cmos5l_fill_1
XFILLER_25_126 VPWR VGND sg13cmos5l_fill_1
X_5935_ _5935_/Q Tile_X0Y0_FrameData[19] Tile_X0Y1_FrameStrobe[11] VPWR VGND sg13cmos5l_dlhq_1
XFILLER_80_254 VPWR VGND sg13cmos5l_fill_2
X_5866_ _5866_/Q Tile_X0Y0_FrameData[24] Tile_X0Y1_FrameStrobe[9] VPWR VGND sg13cmos5l_dlhq_1
X_4817_ _4818_/B _5840_/Q _4817_/B VPWR VGND sg13cmos5l_nand2_1
X_5797_ _5797_/Q Tile_X0Y0_FrameData[29] Tile_X0Y1_FrameStrobe[7] VPWR VGND sg13cmos5l_dlhq_1
XFILLER_21_376 VPWR VGND sg13cmos5l_fill_1
X_4748_ _4748_/X _6426_/Q _6010_/D VPWR VGND sg13cmos5l_or2_1
X_4679_ _4704_/A _4679_/A _4679_/B VPWR VGND sg13cmos5l_nand2_1
X_6418_ _6418_/Q Tile_X0Y1_FrameData[10] Tile_X0Y1_FrameStrobe[12] VPWR VGND sg13cmos5l_dlhq_1
X_6349_ _6349_/Q Tile_X0Y1_FrameData[15] Tile_X0Y1_FrameStrobe[10] VPWR VGND sg13cmos5l_dlhq_1
XFILLER_56_295 VPWR VGND sg13cmos5l_fill_2
XFILLER_16_148 VPWR VGND sg13cmos5l_decap_4
XFILLER_8_314 VPWR VGND sg13cmos5l_fill_1
XFILLER_8_369 VPWR VGND sg13cmos5l_decap_8
XFILLER_79_376 VPWR VGND sg13cmos5l_fill_1
XFILLER_94_379 VPWR VGND sg13cmos5l_fill_2
XFILLER_47_262 VPWR VGND sg13cmos5l_fill_2
X_3981_ _3982_/B _4940_/Y _4934_/Y _5011_/X _4937_/Y _5714_/Q _5712_/Q VPWR VGND sg13cmos5l_mux4_1
X_5720_ _5720_/Q Tile_X0Y0_FrameData[10] Tile_X0Y1_FrameStrobe[4] VPWR VGND sg13cmos5l_dlhq_1
X_2932_ _2933_/A _2919_/Y _2924_/Y _2926_/Y _2931_/Y VPWR VGND sg13cmos5l_a22oi_1
XFILLER_62_287 VPWR VGND sg13cmos5l_fill_1
X_5651_ _5651_/Q Tile_X0Y0_FrameData[15] Tile_X0Y1_FrameStrobe[2] VPWR VGND sg13cmos5l_dlhq_1
X_2863_ _2863_/Y _6081_/Q VPWR VGND sg13cmos5l_inv_1
XFILLER_30_162 VPWR VGND sg13cmos5l_fill_1
X_5582_ _5582_/Q Tile_X0Y0_FrameData[20] Tile_X0Y1_FrameStrobe[0] VPWR VGND sg13cmos5l_dlhq_1
X_4602_ _4689_/A _4602_/A _4708_/A _4603_/B VPWR VGND sg13cmos5l_nor3_1
X_2794_ _2794_/Y _6382_/Q VPWR VGND sg13cmos5l_inv_1
X_4533_ _4533_/Y _5678_/Q _2729_/Y _4532_/Y VPWR VGND sg13cmos5l_o21ai_1
X_6203_ _6203_/Q Tile_X0Y1_FrameData[1] Tile_X0Y1_FrameStrobe[5] VPWR VGND sg13cmos5l_dlhq_1
X_4464_ _4488_/A _4271_/A _4271_/B _4269_/Y VPWR VGND sg13cmos5l_o21ai_1
X_4395_ _4395_/Y _6048_/Q _5455_/B _6047_/Q VPWR VGND sg13cmos5l_a21oi_1
X_3415_ _3415_/Y _6058_/Q _3414_/X _2872_/Y VPWR VGND sg13cmos5l_a21oi_1
X_6134_ _6134_/Q Tile_X0Y1_FrameData[6] Tile_X0Y1_FrameStrobe[3] VPWR VGND sg13cmos5l_dlhq_1
X_3346_ _3346_/Y _6051_/Q _3345_/X _6049_/Q VPWR VGND sg13cmos5l_o21ai_1
X_6065_ _6065_/Q Tile_X0Y1_FrameData[11] Tile_X0Y1_FrameStrobe[1] VPWR VGND sg13cmos5l_dlhq_1
X_5016_ _5016_/Y _5631_/Q _5015_/X _5014_/Y VPWR VGND sg13cmos5l_a21oi_1
X_3277_ _5455_/B _2887_/Y _3258_/A _3276_/Y _3236_/X _5915_/Q _5916_/Q VPWR VGND sg13cmos5l_mux4_1
XANTENNA_209 Tile_X0Y1_W2MID[6] VPWR VGND sg13cmos5l_antennanp
XFILLER_26_26 VPWR VGND sg13cmos5l_fill_2
XANTENNA__6833__X Tile_X0Y1_W2BEGb[1] VPWR VGND sg13cmos5l_antennanp
X_5918_ _5918_/Q Tile_X0Y0_FrameData[4] Tile_X0Y1_FrameStrobe[10] VPWR VGND sg13cmos5l_dlhq_1
X_5849_ _5849_/Q Tile_X0Y0_FrameData[9] Tile_X0Y1_FrameStrobe[8] VPWR VGND sg13cmos5l_dlhq_1
XFILLER_42_36 VPWR VGND sg13cmos5l_fill_1
XFILLER_5_317 VPWR VGND sg13cmos5l_fill_2
XANTENNA__6743__X Tile_X0Y1_FrameData_O[8] VPWR VGND sg13cmos5l_antennanp
X_4180_ _4180_/Y _4180_/A _4180_/B VPWR VGND sg13cmos5l_nor2_1
X_3200_ _3201_/A _5683_/Q _3191_/Y _3199_/Y VPWR VGND sg13cmos5l_a21o_1
X_3131_ _3131_/Y _5638_/Q _4934_/Y _3130_/Y VPWR VGND sg13cmos5l_a21oi_1
XFILLER_79_195 VPWR VGND sg13cmos5l_fill_1
XFILLER_67_335 VPWR VGND sg13cmos5l_fill_1
X_3062_ _3715_/B Tile_X0Y1_N2MID[5] Tile_X0Y1_E2MID[5] _6784_/A Tile_X0Y1_W2MID[5]
+ _6232_/Q _6231_/Q VPWR VGND sg13cmos5l_mux4_1
XANTENNA__6653__X Tile_X0Y0_W2BEGb[2] VPWR VGND sg13cmos5l_antennanp
X_6821_ Tile_X0Y1_W1BEG[1] _6821_/A VPWR VGND sg13cmos5l_buf_1
XFILLER_90_360 VPWR VGND sg13cmos5l_fill_2
X_6752_ Tile_X0Y1_FrameData_O[17] Tile_X0Y1_FrameData[17] VPWR VGND sg13cmos5l_buf_1
X_3964_ _3964_/Y _5722_/Q _3963_/X _5721_/Q VPWR VGND sg13cmos5l_o21ai_1
XFILLER_92_0 VPWR VGND sg13cmos5l_fill_2
X_5703_ _5703_/Q Tile_X0Y0_FrameData[27] Tile_X0Y1_FrameStrobe[4] VPWR VGND sg13cmos5l_dlhq_1
X_6683_ Tile_X0Y0_WW4BEG[12] _6683_/A VPWR VGND sg13cmos5l_buf_1
X_3895_ _3895_/X Tile_X0Y1_N4END[0] Tile_X0Y0_S4END[4] Tile_X0Y1_E6END[0] _6825_/A
+ _6037_/Q _6038_/Q VPWR VGND sg13cmos5l_mux4_1
X_2915_ _6780_/A _2915_/A VPWR VGND sg13cmos5l_inv_1
X_5634_ _5634_/Q Tile_X0Y0_FrameData[0] Tile_X0Y1_FrameStrobe[1] VPWR VGND sg13cmos5l_dlhq_1
X_2846_ _2846_/Y _5649_/Q VPWR VGND sg13cmos5l_inv_1
XFILLER_12_28 VPWR VGND sg13cmos5l_fill_2
X_5565_ _5565_/Q Tile_X0Y1_UserCLK _5565_/D _6467_/L_HI VPWR VGND sg13cmos5l_dfrbpq_1
X_2777_ _2777_/Y _5929_/Q VPWR VGND sg13cmos5l_inv_1
X_5496_ _5497_/B _6320_/Q _5492_/X _5495_/Y VPWR VGND sg13cmos5l_a21oi_1
X_4516_ _5536_/B _4516_/A _4516_/B VPWR VGND sg13cmos5l_xor2_1
XFILLER_2_309 VPWR VGND sg13cmos5l_fill_1
X_4447_ _4447_/Y _4447_/A Tile_X0Y1_WW4END[0] VPWR VGND sg13cmos5l_nor2_1
XANTENNA__6828__X Tile_X0Y1_W2BEG[4] VPWR VGND sg13cmos5l_antennanp
X_6117_ _6117_/Q Tile_X0Y1_FrameData[23] Tile_X0Y1_FrameStrobe[3] VPWR VGND sg13cmos5l_dlhq_1
X_4378_ _4378_/Y _6426_/Q _2880_/Y _6425_/Q VPWR VGND sg13cmos5l_a21oi_1
X_3329_ _3337_/A _6114_/Q _3326_/X _3328_/Y VPWR VGND sg13cmos5l_a21oi_1
XFILLER_58_346 VPWR VGND sg13cmos5l_fill_1
X_6048_ _6048_/Q Tile_X0Y1_FrameData[28] Tile_X0Y1_FrameStrobe[1] VPWR VGND sg13cmos5l_dlhq_1
XFILLER_85_198 VPWR VGND sg13cmos5l_decap_4
XFILLER_73_338 VPWR VGND sg13cmos5l_fill_1
XANTENNA__6563__X Tile_X0Y0_FrameData_O[29] VPWR VGND sg13cmos5l_antennanp
XFILLER_78_10 VPWR VGND sg13cmos5l_fill_1
XANTENNA__6738__X Tile_X0Y1_FrameData_O[3] VPWR VGND sg13cmos5l_antennanp
XFILLER_1_353 VPWR VGND sg13cmos5l_decap_4
XFILLER_1_331 VPWR VGND sg13cmos5l_decap_8
XFILLER_78_87 VPWR VGND sg13cmos5l_fill_1
XFILLER_64_327 VPWR VGND sg13cmos5l_decap_8
X_3680_ _3680_/Y _4186_/A _4261_/A VPWR VGND sg13cmos5l_nor2_1
X_5350_ _5350_/Y _6373_/Q _5348_/X VPWR VGND sg13cmos5l_nor2b_1
X_5281_ _5281_/Y _6400_/Q _5498_/B _6399_/Q VPWR VGND sg13cmos5l_a21oi_1
X_4301_ _6001_/D _4301_/A _4301_/B VPWR VGND sg13cmos5l_or2_1
XANTENNA__6648__X Tile_X0Y0_W2BEG[5] VPWR VGND sg13cmos5l_antennanp
X_4232_ _4232_/Y _4234_/A _4234_/B VPWR VGND sg13cmos5l_nand2b_1
X_4163_ _4163_/X _4911_/X _4909_/X _4943_/Y _5062_/B _5624_/Q _5626_/Q VPWR VGND sg13cmos5l_mux4_1
X_4094_ _4096_/A _5860_/Q _5209_/B VPWR VGND sg13cmos5l_nand2b_1
X_3114_ _3114_/Y Tile_X0Y1_N2MID[0] _3118_/S _2835_/Y VPWR VGND sg13cmos5l_o21ai_1
X_3045_ _3045_/Y _6068_/Q _3042_/Y _3044_/Y VPWR VGND sg13cmos5l_a21oi_1
XFILLER_23_202 VPWR VGND sg13cmos5l_fill_1
X_6804_ Tile_X0Y1_SS4BEG[1] Tile_X0Y0_SS4END[9] VPWR VGND sg13cmos5l_buf_1
X_4996_ _4996_/Y _4993_/Y _4995_/Y _5667_/Q VPWR VGND sg13cmos5l_a21oi_1
X_6735_ Tile_X0Y1_FrameData_O[0] Tile_X0Y1_FrameData[0] VPWR VGND sg13cmos5l_buf_1
X_3947_ _5991_/D _3943_/Y _3946_/Y _5853_/Q VPWR VGND sg13cmos5l_mux2_1
X_6666_ Tile_X0Y0_W6BEG[7] Tile_X0Y0_W6END[9] VPWR VGND sg13cmos5l_buf_1
X_3878_ _3878_/Y _6070_/Q _5262_/X VPWR VGND sg13cmos5l_nand2_1
X_5617_ _5617_/Q Tile_X0Y0_FrameData[17] Tile_X0Y1_FrameStrobe[1] VPWR VGND sg13cmos5l_dlhq_1
X_6597_ Tile_X0Y0_N2BEG[7] _6597_/A VPWR VGND sg13cmos5l_buf_1
X_2829_ _2829_/Y _5986_/Q VPWR VGND sg13cmos5l_inv_1
X_5548_ _5568_/D _5551_/A _5548_/B VPWR VGND sg13cmos5l_nor2_1
XANTENNA__6558__X Tile_X0Y0_FrameData_O[24] VPWR VGND sg13cmos5l_antennanp
X_5479_ _5479_/X _6324_/Q _3729_/B _5478_/Y VPWR VGND sg13cmos5l_a21o_1
XFILLER_100_251 VPWR VGND sg13cmos5l_fill_1
XFILLER_14_279 VPWR VGND sg13cmos5l_fill_2
XFILLER_14_268 VPWR VGND sg13cmos5l_fill_1
XFILLER_108_362 VPWR VGND sg13cmos5l_decap_4
XFILLER_89_290 VPWR VGND sg13cmos5l_fill_1
XFILLER_1_194 VPWR VGND sg13cmos5l_fill_1
XFILLER_64_157 VPWR VGND sg13cmos5l_fill_2
X_4850_ _4859_/B Tile_X0Y0_E2MID[0] Tile_X0Y0_W2MID[0] Tile_X0Y0_S2MID[0] _6648_/A
+ _5803_/Q _5804_/Q VPWR VGND sg13cmos5l_mux4_1
XFILLER_60_341 VPWR VGND sg13cmos5l_fill_2
X_3801_ _3802_/B _4515_/Y _4509_/Y _4518_/Y _5374_/B _6056_/Q _6054_/Q VPWR VGND sg13cmos5l_mux4_1
X_6520_ Tile_X0Y0_EE4BEG[2] Tile_X0Y0_EE4END[6] VPWR VGND sg13cmos5l_buf_1
X_4781_ _4781_/Y _5838_/Q _5043_/A _5837_/Q VPWR VGND sg13cmos5l_o21ai_1
X_3732_ _3732_/Y _2715_/Y _6120_/Q _3731_/Y VPWR VGND sg13cmos5l_a21oi_1
X_6451_ _6451_/L_HI VPWR VGND sg13cmos5l_tiehi
X_3663_ _3663_/X Tile_X0Y1_E2END[3] Tile_X0Y1_W2END[3] Tile_X0Y1_E6END[1] Tile_X0Y1_W6END[1]
+ _6098_/Q _6100_/Q VPWR VGND sg13cmos5l_mux4_1
X_5402_ _5402_/Y _6350_/Q _5374_/B _5401_/Y VPWR VGND sg13cmos5l_o21ai_1
X_6382_ _6382_/Q Tile_X0Y1_FrameData[14] Tile_X0Y1_FrameStrobe[11] VPWR VGND sg13cmos5l_dlhq_1
X_5333_ _5333_/Y _6380_/Q _5342_/B _6379_/Q VPWR VGND sg13cmos5l_o21ai_1
X_3594_ _3594_/Y _6162_/Q _3593_/Y _6163_/Q VPWR VGND sg13cmos5l_o21ai_1
XFILLER_55_0 VPWR VGND sg13cmos5l_decap_4
X_5264_ _6615_/A Tile_X0Y1_N2END[3] Tile_X0Y1_N4END[2] Tile_X0Y1_E6END[0] _5390_/B
+ _6412_/Q _6411_/Q VPWR VGND sg13cmos5l_mux4_1
X_5195_ _5195_/Y _5886_/Q _6781_/A _5885_/Q VPWR VGND sg13cmos5l_o21ai_1
X_4215_ _4228_/A _4215_/A _4215_/B VPWR VGND sg13cmos5l_xnor2_1
X_4146_ _4148_/B _4146_/A _4146_/B VPWR VGND sg13cmos5l_xor2_1
XFILLER_28_327 VPWR VGND sg13cmos5l_fill_2
X_4077_ _4077_/Y _6428_/Q _4077_/B VPWR VGND sg13cmos5l_nor2_1
X_3028_ _3028_/Y _5698_/Q _3027_/Y _2820_/Y VPWR VGND sg13cmos5l_a21oi_1
XFILLER_55_168 VPWR VGND sg13cmos5l_decap_4
XFILLER_51_330 VPWR VGND sg13cmos5l_fill_2
XANTENNA__6841__X Tile_X0Y1_W6BEG[1] VPWR VGND sg13cmos5l_antennanp
X_4979_ _4979_/Y _5700_/Q _4972_/X _4978_/Y VPWR VGND sg13cmos5l_o21ai_1
XFILLER_11_227 VPWR VGND sg13cmos5l_fill_2
X_6718_ Tile_X0Y1_E6BEG[11] _6718_/A VPWR VGND sg13cmos5l_buf_1
X_6649_ Tile_X0Y0_W2BEG[6] _6649_/A VPWR VGND sg13cmos5l_buf_1
XFILLER_109_115 VPWR VGND sg13cmos5l_fill_1
XFILLER_59_78 VPWR VGND sg13cmos5l_fill_2
XANTENNA__6751__X Tile_X0Y1_FrameData_O[16] VPWR VGND sg13cmos5l_antennanp
XFILLER_10_260 VPWR VGND sg13cmos5l_fill_2
XFILLER_111_313 VPWR VGND sg13cmos5l_decap_8
X_4000_ _5990_/D _4000_/A VPWR VGND sg13cmos5l_inv_1
X_5951_ _5951_/Q Tile_X0Y0_FrameData[3] Tile_X0Y1_FrameStrobe[11] VPWR VGND sg13cmos5l_dlhq_1
X_4902_ _4903_/C _6011_/Q _6426_/Q VPWR VGND sg13cmos5l_nor2b_1
XANTENNA__6661__X Tile_X0Y0_W6BEG[2] VPWR VGND sg13cmos5l_antennanp
X_5882_ _5882_/Q Tile_X0Y0_FrameData[8] Tile_X0Y1_FrameStrobe[9] VPWR VGND sg13cmos5l_dlhq_1
X_4833_ _4834_/C _5612_/Q _4829_/X _4832_/Y VPWR VGND sg13cmos5l_a21oi_1
XFILLER_60_171 VPWR VGND sg13cmos5l_fill_1
X_4764_ _4764_/Y _5671_/Q _4764_/B VPWR VGND sg13cmos5l_nor2_1
X_6503_ Tile_X0Y0_E2BEGb[5] Tile_X0Y0_E2MID[5] VPWR VGND sg13cmos5l_buf_1
X_3715_ _3715_/Y _6306_/Q _3715_/B VPWR VGND sg13cmos5l_nand2_1
X_6434_ _6434_/L_HI VPWR VGND sg13cmos5l_tiehi
X_4695_ _4715_/B _4695_/A VPWR VGND sg13cmos5l_inv_1
X_3646_ _3646_/Y _6224_/Q _3061_/A _3645_/Y VPWR VGND sg13cmos5l_o21ai_1
X_6365_ _6365_/Q Tile_X0Y1_FrameData[31] Tile_X0Y1_FrameStrobe[11] VPWR VGND sg13cmos5l_dlhq_1
X_3577_ _3578_/B _6266_/Q _6781_/A _3576_/Y VPWR VGND sg13cmos5l_a21oi_1
X_6296_ _6296_/Q Tile_X0Y1_FrameData[4] Tile_X0Y1_FrameStrobe[8] VPWR VGND sg13cmos5l_dlhq_1
X_5316_ _5316_/Y _2793_/Y _3775_/X _6382_/Q VPWR VGND sg13cmos5l_o21ai_1
X_5247_ _5248_/A _5871_/Q _5244_/Y _5245_/X _5246_/Y VPWR VGND sg13cmos5l_a22oi_1
XANTENNA__6836__X Tile_X0Y1_W2BEGb[4] VPWR VGND sg13cmos5l_antennanp
XFILLER_102_357 VPWR VGND sg13cmos5l_decap_8
X_5178_ _5178_/Y _5898_/Q _5062_/B _2781_/Y VPWR VGND sg13cmos5l_o21ai_1
X_4129_ _4129_/Y _2740_/Y _5782_/Q _5781_/Q VPWR VGND sg13cmos5l_a21oi_1
XFILLER_83_296 VPWR VGND sg13cmos5l_fill_1
XANTENNA__6571__X Tile_X0Y0_FrameStrobe_O[5] VPWR VGND sg13cmos5l_antennanp
XFILLER_101_42 VPWR VGND sg13cmos5l_fill_1
XFILLER_101_64 VPWR VGND sg13cmos5l_fill_1
XFILLER_101_86 VPWR VGND sg13cmos5l_fill_2
XFILLER_61_79 VPWR VGND sg13cmos5l_fill_2
XANTENNA__6746__X Tile_X0Y1_FrameData_O[11] VPWR VGND sg13cmos5l_antennanp
XFILLER_15_352 VPWR VGND sg13cmos5l_decap_8
XFILLER_15_374 VPWR VGND sg13cmos5l_decap_8
X_3500_ _3501_/B _5642_/Q _3498_/Y _3499_/Y VPWR VGND sg13cmos5l_a21oi_1
X_4480_ _4481_/B _4480_/A _4572_/A VPWR VGND sg13cmos5l_xnor2_1
X_3431_ _3431_/Y _6290_/Q _3430_/X _6289_/Q VPWR VGND sg13cmos5l_o21ai_1
X_6150_ _6150_/Q Tile_X0Y1_FrameData[22] Tile_X0Y1_FrameStrobe[4] VPWR VGND sg13cmos5l_dlhq_1
X_3362_ _3362_/X _6083_/Q _3362_/B VPWR VGND sg13cmos5l_or2_1
X_5101_ _5101_/Y _5942_/Q _5197_/B VPWR VGND sg13cmos5l_nand2_1
X_6081_ _6081_/Q Tile_X0Y1_FrameData[27] Tile_X0Y1_FrameStrobe[2] VPWR VGND sg13cmos5l_dlhq_1
X_3293_ _3293_/Y _3279_/B _5422_/B _6150_/Q VPWR VGND sg13cmos5l_o21ai_1
XANTENNA__6656__X Tile_X0Y0_W2BEGb[5] VPWR VGND sg13cmos5l_antennanp
X_5032_ _5032_/Y _5970_/Q _6645_/A _5969_/Q VPWR VGND sg13cmos5l_o21ai_1
XFILLER_111_187 VPWR VGND sg13cmos5l_fill_2
XFILLER_111_176 VPWR VGND sg13cmos5l_decap_8
XFILLER_80_211 VPWR VGND sg13cmos5l_fill_1
XFILLER_65_285 VPWR VGND sg13cmos5l_fill_1
X_5934_ _5934_/Q Tile_X0Y0_FrameData[20] Tile_X0Y1_FrameStrobe[11] VPWR VGND sg13cmos5l_dlhq_1
X_5865_ _5865_/Q Tile_X0Y0_FrameData[25] Tile_X0Y1_FrameStrobe[9] VPWR VGND sg13cmos5l_dlhq_1
X_4816_ _4818_/A _5770_/Q _2751_/Y _4815_/Y VPWR VGND sg13cmos5l_a21oi_1
X_5796_ _5796_/Q Tile_X0Y0_FrameData[30] Tile_X0Y1_FrameStrobe[7] VPWR VGND sg13cmos5l_dlhq_1
X_4747_ _6010_/D _4735_/Y _4736_/Y _4746_/X VPWR VGND sg13cmos5l_o21ai_1
X_4678_ _4679_/B _6426_/Q _6006_/D _4677_/Y VPWR VGND sg13cmos5l_o21ai_1
X_6417_ _6417_/Q Tile_X0Y1_FrameData[11] Tile_X0Y1_FrameStrobe[12] VPWR VGND sg13cmos5l_dlhq_1
X_3629_ _3629_/Y _3625_/X _3628_/Y _6301_/Q VPWR VGND sg13cmos5l_a21oi_1
X_6348_ _6348_/Q Tile_X0Y1_FrameData[16] Tile_X0Y1_FrameStrobe[10] VPWR VGND sg13cmos5l_dlhq_1
X_6279_ _6279_/Q Tile_X0Y1_FrameData[21] Tile_X0Y1_FrameStrobe[8] VPWR VGND sg13cmos5l_dlhq_1
XANTENNA__6566__X Tile_X0Y0_FrameStrobe_O[0] VPWR VGND sg13cmos5l_antennanp
XFILLER_56_252 VPWR VGND sg13cmos5l_decap_8
XFILLER_56_241 VPWR VGND sg13cmos5l_fill_1
XFILLER_12_355 VPWR VGND sg13cmos5l_decap_4
XFILLER_8_348 VPWR VGND sg13cmos5l_decap_8
XFILLER_79_311 VPWR VGND sg13cmos5l_fill_1
XFILLER_62_200 VPWR VGND sg13cmos5l_fill_2
XFILLER_47_285 VPWR VGND sg13cmos5l_fill_2
X_3980_ _3980_/Y _3979_/Y _5856_/Q _3980_/C VPWR VGND sg13cmos5l_nand3b_1
X_2931_ _2931_/Y _2929_/Y _2930_/Y _6131_/Q VPWR VGND sg13cmos5l_a21oi_1
X_5650_ _5650_/Q Tile_X0Y0_FrameData[16] Tile_X0Y1_FrameStrobe[2] VPWR VGND sg13cmos5l_dlhq_1
X_4601_ _4603_/B _4601_/A _4709_/A VPWR VGND sg13cmos5l_nand2_1
X_2862_ _2862_/Y _6084_/Q VPWR VGND sg13cmos5l_inv_1
XFILLER_30_152 VPWR VGND sg13cmos5l_fill_2
X_5581_ _5581_/Q Tile_X0Y0_FrameData[21] Tile_X0Y1_FrameStrobe[0] VPWR VGND sg13cmos5l_dlhq_1
X_2793_ _2793_/Y _6383_/Q VPWR VGND sg13cmos5l_inv_1
X_4532_ _4532_/Y Tile_X0Y0_S1END[2] _5678_/Q VPWR VGND sg13cmos5l_nand2_1
X_4463_ _4492_/A _4274_/A _4274_/B _4272_/Y VPWR VGND sg13cmos5l_a21o_1
X_6202_ _6202_/Q Tile_X0Y1_FrameData[2] Tile_X0Y1_FrameStrobe[5] VPWR VGND sg13cmos5l_dlhq_1
X_3414_ _3414_/X _5262_/X _5422_/B _6060_/Q VPWR VGND sg13cmos5l_mux2_1
X_4394_ _4496_/A _6425_/Q _5561_/Q VPWR VGND sg13cmos5l_nand2_1
X_6133_ _6133_/Q Tile_X0Y1_FrameData[7] Tile_X0Y1_FrameStrobe[3] VPWR VGND sg13cmos5l_dlhq_1
X_3345_ _3345_/X _4515_/Y _4509_/Y _4518_/Y _5390_/B _6052_/Q _6050_/Q VPWR VGND sg13cmos5l_mux4_1
X_6064_ _6064_/Q Tile_X0Y1_FrameData[12] Tile_X0Y1_FrameStrobe[1] VPWR VGND sg13cmos5l_dlhq_1
X_3276_ _3276_/Y _5180_/B VPWR VGND sg13cmos5l_inv_1
X_5015_ _5015_/X _4911_/X _4909_/X _4943_/Y _5062_/B _5632_/Q _5634_/Q VPWR VGND sg13cmos5l_mux4_1
XFILLER_53_266 VPWR VGND sg13cmos5l_fill_2
X_5917_ _5917_/Q Tile_X0Y0_FrameData[5] Tile_X0Y1_FrameStrobe[10] VPWR VGND sg13cmos5l_dlhq_1
X_5848_ _5848_/Q Tile_X0Y0_FrameData[10] Tile_X0Y1_FrameStrobe[8] VPWR VGND sg13cmos5l_dlhq_1
X_5779_ _5779_/Q Tile_X0Y0_FrameData[15] Tile_X0Y1_FrameStrobe[6] VPWR VGND sg13cmos5l_dlhq_1
XFILLER_29_241 VPWR VGND sg13cmos5l_fill_1
XFILLER_12_174 VPWR VGND sg13cmos5l_decap_4
XFILLER_8_189 VPWR VGND sg13cmos5l_fill_2
X_3130_ _3130_/Y _5638_/Q _4940_/Y VPWR VGND sg13cmos5l_nor2b_1
X_3061_ _6784_/A _3061_/A VPWR VGND sg13cmos5l_inv_1
XFILLER_75_380 VPWR VGND sg13cmos5l_fill_1
X_6820_ Tile_X0Y1_W1BEG[0] _6820_/A VPWR VGND sg13cmos5l_buf_1
X_6751_ Tile_X0Y1_FrameData_O[16] Tile_X0Y1_FrameData[16] VPWR VGND sg13cmos5l_buf_1
X_3963_ _3963_/X _2889_/Y _2890_/Y _5720_/Q VPWR VGND sg13cmos5l_mux2_1
X_5702_ _5702_/Q Tile_X0Y0_FrameData[28] Tile_X0Y1_FrameStrobe[4] VPWR VGND sg13cmos5l_dlhq_1
X_6682_ Tile_X0Y0_WW4BEG[11] Tile_X0Y0_WW4END[15] VPWR VGND sg13cmos5l_buf_1
X_3894_ _6825_/A _6069_/Q _3885_/X _3893_/Y VPWR VGND sg13cmos5l_a21o_1
X_2914_ _2915_/A _2905_/Y _2906_/Y _2910_/Y _2913_/Y VPWR VGND sg13cmos5l_a22oi_1
X_5633_ _5633_/Q Tile_X0Y0_FrameData[1] Tile_X0Y1_FrameStrobe[1] VPWR VGND sg13cmos5l_dlhq_1
X_2845_ _2845_/Y _6131_/Q VPWR VGND sg13cmos5l_inv_1
X_5564_ _5564_/Q Tile_X0Y1_UserCLK _5564_/D _6468_/L_HI VPWR VGND sg13cmos5l_dfrbpq_1
X_4515_ _4515_/Y _6423_/Q _5532_/B _4514_/Y VPWR VGND sg13cmos5l_o21ai_1
X_2776_ _2776_/Y _5934_/Q VPWR VGND sg13cmos5l_inv_1
X_5495_ _5495_/Y _6320_/Q _5494_/Y _6319_/Q VPWR VGND sg13cmos5l_o21ai_1
X_4446_ _4446_/Y _4447_/A _3729_/B _6111_/Q VPWR VGND sg13cmos5l_a21oi_1
X_4377_ _5998_/D _4375_/Y _4376_/Y _4368_/Y VPWR VGND sg13cmos5l_o21ai_1
X_6116_ _6116_/Q Tile_X0Y1_FrameData[24] Tile_X0Y1_FrameStrobe[3] VPWR VGND sg13cmos5l_dlhq_1
X_3328_ _3328_/Y _6114_/Q _3327_/X _2867_/Y VPWR VGND sg13cmos5l_o21ai_1
XFILLER_58_303 VPWR VGND sg13cmos5l_fill_2
X_6047_ _6047_/Q Tile_X0Y1_FrameData[29] Tile_X0Y1_FrameStrobe[1] VPWR VGND sg13cmos5l_dlhq_1
X_3259_ _3259_/X Tile_X0Y1_N2END[4] Tile_X0Y1_N4END[0] Tile_X0Y1_E6END[0] Tile_X0Y0_S2MID[4]
+ _6160_/Q _6158_/Q VPWR VGND sg13cmos5l_mux4_1
XFILLER_37_48 VPWR VGND sg13cmos5l_fill_2
XANTENNA__6844__X Tile_X0Y1_W6BEG[4] VPWR VGND sg13cmos5l_antennanp
XFILLER_5_159 VPWR VGND sg13cmos5l_fill_1
XFILLER_110_219 VPWR VGND sg13cmos5l_decap_8
XFILLER_49_336 VPWR VGND sg13cmos5l_fill_1
XANTENNA__6754__X Tile_X0Y1_FrameData_O[19] VPWR VGND sg13cmos5l_antennanp
XFILLER_91_158 VPWR VGND sg13cmos5l_fill_1
XFILLER_91_147 VPWR VGND sg13cmos5l_fill_1
XFILLER_32_203 VPWR VGND sg13cmos5l_fill_2
X_5280_ _5280_/Y _6398_/Q _5280_/B VPWR VGND sg13cmos5l_nor2_1
X_4300_ _4301_/B _6279_/Q _4300_/B _4300_/C VPWR VGND sg13cmos5l_nor3_1
XFILLER_99_236 VPWR VGND sg13cmos5l_fill_1
X_4231_ _4234_/B _4231_/A _4231_/B VPWR VGND sg13cmos5l_xor2_1
X_4162_ _4162_/Y _5625_/Q _4162_/B VPWR VGND sg13cmos5l_nor2_1
X_4093_ _5209_/B _3383_/Y _2757_/Y _2738_/Y _3093_/Y _5822_/Q _5821_/Q VPWR VGND sg13cmos5l_mux4_1
X_3113_ _3113_/Y _3113_/A _3113_/B VPWR VGND sg13cmos5l_nor2_1
XANTENNA__6664__X Tile_X0Y0_W6BEG[5] VPWR VGND sg13cmos5l_antennanp
X_3044_ _3044_/Y _6068_/Q _3043_/X _6067_/Q VPWR VGND sg13cmos5l_o21ai_1
XFILLER_48_380 VPWR VGND sg13cmos5l_fill_1
X_6803_ Tile_X0Y1_SS4BEG[0] Tile_X0Y0_SS4END[8] VPWR VGND sg13cmos5l_buf_1
X_4995_ _4995_/Y _5669_/Q _4994_/X _2763_/Y VPWR VGND sg13cmos5l_a21oi_1
XFILLER_90_191 VPWR VGND sg13cmos5l_fill_2
X_6734_ Tile_X0Y1_EE4BEG[15] _6734_/A VPWR VGND sg13cmos5l_buf_1
X_3946_ _3946_/Y _5854_/Q _3186_/X _3945_/Y VPWR VGND sg13cmos5l_a21oi_1
X_6665_ Tile_X0Y0_W6BEG[6] Tile_X0Y0_W6END[8] VPWR VGND sg13cmos5l_buf_1
X_3877_ _3877_/X Tile_X0Y1_N2MID[1] Tile_X0Y1_E2MID[1] _6780_/A Tile_X0Y1_W2MID[1]
+ _6230_/Q _6229_/Q VPWR VGND sg13cmos5l_mux4_1
XFILLER_109_319 VPWR VGND sg13cmos5l_decap_8
X_5616_ _5616_/Q Tile_X0Y0_FrameData[18] Tile_X0Y1_FrameStrobe[1] VPWR VGND sg13cmos5l_dlhq_1
X_6596_ Tile_X0Y0_N2BEG[6] _6596_/A VPWR VGND sg13cmos5l_buf_1
X_2828_ _2828_/Y Tile_X0Y1_W2MID[7] VPWR VGND sg13cmos5l_inv_1
X_5547_ _5567_/D _5551_/A _5010_/Y VPWR VGND sg13cmos5l_nor2b_1
X_2759_ _2759_/Y _5833_/Q VPWR VGND sg13cmos5l_inv_1
XANTENNA__6839__X Tile_X0Y1_W2BEGb[7] VPWR VGND sg13cmos5l_antennanp
X_5478_ _5478_/Y Tile_X0Y1_N1END[0] _6324_/Q _2805_/Y VPWR VGND sg13cmos5l_o21ai_1
X_4429_ _4429_/Y _6078_/Q _4426_/Y _4428_/Y VPWR VGND sg13cmos5l_a21oi_1
XFILLER_58_111 VPWR VGND sg13cmos5l_fill_2
XFILLER_58_100 VPWR VGND sg13cmos5l_decap_8
XANTENNA__6574__X Tile_X0Y0_FrameStrobe_O[8] VPWR VGND sg13cmos5l_antennanp
XFILLER_104_75 VPWR VGND sg13cmos5l_decap_8
XFILLER_22_291 VPWR VGND sg13cmos5l_fill_2
XFILLER_108_341 VPWR VGND sg13cmos5l_decap_8
XANTENNA__6749__X Tile_X0Y1_FrameData_O[14] VPWR VGND sg13cmos5l_antennanp
XFILLER_49_144 VPWR VGND sg13cmos5l_fill_1
XFILLER_49_199 VPWR VGND sg13cmos5l_fill_2
X_4780_ _5043_/A Tile_X0Y1_N2MID[3] Tile_X0Y0_SS4END[0] Tile_X0Y0_E2END[3] Tile_X0Y0_W2END[3]
+ _5735_/Q _5736_/Q VPWR VGND sg13cmos5l_mux4_1
X_3800_ _3800_/Y _6288_/Q _3799_/X _6287_/Q VPWR VGND sg13cmos5l_o21ai_1
X_3731_ _3731_/Y Tile_X0Y0_S2MID[6] _6120_/Q VPWR VGND sg13cmos5l_nor2_1
X_6450_ _6450_/L_HI VPWR VGND sg13cmos5l_tiehi
X_3662_ _3662_/Y _6097_/Q _3662_/B _3662_/C VPWR VGND sg13cmos5l_nand3_1
X_5401_ _5401_/Y _6350_/Q _5500_/B _6349_/Q VPWR VGND sg13cmos5l_a21oi_1
X_6381_ _6381_/Q Tile_X0Y1_FrameData[15] Tile_X0Y1_FrameStrobe[11] VPWR VGND sg13cmos5l_dlhq_1
X_3593_ _3593_/Y _6164_/Q Tile_X0Y1_E2END[3] _3592_/Y VPWR VGND sg13cmos5l_a21oi_1
XANTENNA__6659__X Tile_X0Y0_W6BEG[0] VPWR VGND sg13cmos5l_antennanp
X_5332_ _5332_/Y _6380_/Q _5440_/B _5331_/Y VPWR VGND sg13cmos5l_o21ai_1
X_5263_ _6614_/A Tile_X0Y1_N2END[2] Tile_X0Y1_N4END[1] Tile_X0Y1_E6END[1] _4518_/Y
+ _6414_/Q _6413_/Q VPWR VGND sg13cmos5l_mux4_1
X_5194_ _6641_/A _4909_/X _6780_/A _5180_/B _3237_/Y _5887_/Q _5888_/Q VPWR VGND sg13cmos5l_mux4_1
X_4214_ _4214_/Y _4241_/B _4241_/A VPWR VGND sg13cmos5l_nand2b_1
X_4145_ _4146_/B _4145_/A _4145_/B VPWR VGND sg13cmos5l_xnor2_1
X_4076_ _5982_/D _4077_/B VPWR VGND sg13cmos5l_inv_1
XFILLER_55_158 VPWR VGND sg13cmos5l_fill_2
X_3027_ _3027_/Y _5696_/Q _2886_/Y _3026_/Y VPWR VGND sg13cmos5l_o21ai_1
XFILLER_51_320 VPWR VGND sg13cmos5l_fill_1
X_4978_ _4978_/Y _4974_/Y _4977_/Y _5699_/Q VPWR VGND sg13cmos5l_a21oi_1
X_6717_ Tile_X0Y1_E6BEG[10] _6717_/A VPWR VGND sg13cmos5l_buf_1
X_3929_ _3930_/A _2746_/Y _5682_/Q _3928_/Y VPWR VGND sg13cmos5l_a21oi_1
X_6648_ Tile_X0Y0_W2BEG[5] _6648_/A VPWR VGND sg13cmos5l_buf_1
XANTENNA__6569__X Tile_X0Y0_FrameStrobe_O[3] VPWR VGND sg13cmos5l_antennanp
X_6579_ Tile_X0Y0_FrameStrobe_O[13] Tile_X0Y1_FrameStrobe[13] VPWR VGND sg13cmos5l_buf_1
XFILLER_105_377 VPWR VGND sg13cmos5l_decap_4
XFILLER_105_366 VPWR VGND sg13cmos5l_fill_1
XFILLER_105_355 VPWR VGND sg13cmos5l_decap_8
XFILLER_91_99 VPWR VGND sg13cmos5l_fill_1
XFILLER_77_272 VPWR VGND sg13cmos5l_fill_1
XFILLER_1_42 VPWR VGND sg13cmos5l_decap_8
X_5950_ _5950_/Q Tile_X0Y0_FrameData[4] Tile_X0Y1_FrameStrobe[11] VPWR VGND sg13cmos5l_dlhq_1
X_4901_ _4903_/B _6426_/Q _6011_/D VPWR VGND sg13cmos5l_nor2_1
X_5881_ _5881_/Q Tile_X0Y0_FrameData[9] Tile_X0Y1_FrameStrobe[9] VPWR VGND sg13cmos5l_dlhq_1
XANTENNA_190 Tile_X0Y1_W2MID[3] VPWR VGND sg13cmos5l_antennanp
X_4832_ _4832_/Y _5612_/Q _4831_/Y _5613_/Q VPWR VGND sg13cmos5l_o21ai_1
X_4763_ _4764_/B _5674_/Q _4761_/Y _4762_/Y VPWR VGND sg13cmos5l_a21oi_1
X_6502_ Tile_X0Y0_E2BEGb[4] Tile_X0Y0_E2MID[4] VPWR VGND sg13cmos5l_buf_1
X_4694_ _4695_/A _4696_/B _4696_/A VPWR VGND sg13cmos5l_nor2b_1
X_3714_ _3714_/Y _5468_/B VPWR VGND sg13cmos5l_inv_1
X_6433_ _6433_/L_HI VPWR VGND sg13cmos5l_tiehi
X_3645_ _3645_/Y _6224_/Q Tile_X0Y1_W2MID[5] VPWR VGND sg13cmos5l_nand2_1
X_6364_ _6364_/Q Tile_X0Y1_FrameData[0] Tile_X0Y1_FrameStrobe[10] VPWR VGND sg13cmos5l_dlhq_1
X_3576_ _3576_/Y _6266_/Q Tile_X0Y1_E2MID[2] VPWR VGND sg13cmos5l_nor2b_1
X_6295_ _6295_/Q Tile_X0Y1_FrameData[5] Tile_X0Y1_FrameStrobe[8] VPWR VGND sg13cmos5l_dlhq_1
X_5315_ _6731_/A _5305_/Y _5308_/Y _5312_/X _5314_/Y VPWR VGND sg13cmos5l_a22oi_1
X_5246_ _5246_/Y _5872_/Q _5204_/B _5871_/Q VPWR VGND sg13cmos5l_a21oi_1
XFILLER_102_369 VPWR VGND sg13cmos5l_fill_2
X_5177_ _5177_/Y _5896_/Q _5177_/B VPWR VGND sg13cmos5l_nor2_1
X_4128_ _4128_/Y _4121_/X _4122_/Y _4125_/A _4125_/B _5852_/Q VPWR VGND sg13cmos5l_a221oi_1
XFILLER_68_294 VPWR VGND sg13cmos5l_fill_2
XFILLER_110_380 VPWR VGND sg13cmos5l_fill_1
X_4059_ _4059_/Y _5716_/Q _2886_/Y _4058_/Y VPWR VGND sg13cmos5l_o21ai_1
XANTENNA__6852__X Tile_X0Y1_WW4BEG[0] VPWR VGND sg13cmos5l_antennanp
XFILLER_36_191 VPWR VGND sg13cmos5l_fill_1
XFILLER_101_10 VPWR VGND sg13cmos5l_fill_2
XANTENNA__6762__X Tile_X0Y1_FrameData_O[27] VPWR VGND sg13cmos5l_antennanp
X_3430_ _3430_/X Tile_X0Y1_N2END[5] Tile_X0Y1_E2END[5] Tile_X0Y0_SS4END[5] Tile_X0Y1_W2END[5]
+ _6184_/Q _6183_/Q VPWR VGND sg13cmos5l_mux4_1
X_3361_ _3362_/B _4515_/Y _4509_/Y _4518_/Y _5390_/B _6084_/Q _6082_/Q VPWR VGND sg13cmos5l_mux4_1
X_6080_ _6080_/Q Tile_X0Y1_FrameData[28] Tile_X0Y1_FrameStrobe[2] VPWR VGND sg13cmos5l_dlhq_1
X_5100_ _5100_/X _5942_/Q _3323_/Y _5099_/Y VPWR VGND sg13cmos5l_a21o_1
X_5031_ _6588_/A _4943_/Y _6644_/A _5180_/B _3237_/Y _5971_/Q _5972_/Q VPWR VGND sg13cmos5l_mux4_1
X_3292_ _3292_/Y _6152_/Q _5262_/X VPWR VGND sg13cmos5l_nor2_1
XANTENNA__6672__X Tile_X0Y0_WW4BEG[1] VPWR VGND sg13cmos5l_antennanp
X_5933_ _5933_/Q Tile_X0Y0_FrameData[21] Tile_X0Y1_FrameStrobe[11] VPWR VGND sg13cmos5l_dlhq_1
X_5864_ _5864_/Q Tile_X0Y0_FrameData[26] Tile_X0Y1_FrameStrobe[9] VPWR VGND sg13cmos5l_dlhq_1
X_4815_ _4815_/Y _5770_/Q Tile_X0Y0_S2MID[7] _5769_/Q VPWR VGND sg13cmos5l_o21ai_1
X_5795_ _5795_/Q Tile_X0Y0_FrameData[31] Tile_X0Y1_FrameStrobe[7] VPWR VGND sg13cmos5l_dlhq_1
X_4746_ _4746_/X _5835_/Q _4746_/B _4746_/C VPWR VGND sg13cmos5l_or3_1
X_4677_ _4677_/Y _6426_/Q _2743_/Y _6425_/Q VPWR VGND sg13cmos5l_a21oi_1
X_6416_ _6416_/Q Tile_X0Y1_FrameData[12] Tile_X0Y1_FrameStrobe[12] VPWR VGND sg13cmos5l_dlhq_1
X_3628_ _3628_/Y _3626_/Y _3627_/Y _2816_/Y VPWR VGND sg13cmos5l_a21oi_1
X_6347_ _6347_/Q Tile_X0Y1_FrameData[17] Tile_X0Y1_FrameStrobe[10] VPWR VGND sg13cmos5l_dlhq_1
XANTENNA__6847__X Tile_X0Y1_W6BEG[7] VPWR VGND sg13cmos5l_antennanp
X_3559_ _3559_/Y Tile_X0Y1_W2END[4] _6128_/Q _6126_/Q VPWR VGND sg13cmos5l_o21ai_1
XFILLER_0_227 VPWR VGND sg13cmos5l_fill_1
XFILLER_0_216 VPWR VGND sg13cmos5l_fill_2
X_6278_ _6278_/Q Tile_X0Y1_FrameData[22] Tile_X0Y1_FrameStrobe[8] VPWR VGND sg13cmos5l_dlhq_1
X_5229_ _5229_/Y _5875_/Q _5229_/B VPWR VGND sg13cmos5l_nand2_1
XANTENNA__6582__X Tile_X0Y0_FrameStrobe_O[16] VPWR VGND sg13cmos5l_antennanp
XFILLER_16_139 VPWR VGND sg13cmos5l_fill_2
XFILLER_71_256 VPWR VGND sg13cmos5l_fill_1
XANTENNA_90 Tile_X0Y0_SS4END[2] VPWR VGND sg13cmos5l_antennanp
XANTENNA__6757__X Tile_X0Y1_FrameData_O[22] VPWR VGND sg13cmos5l_antennanp
XFILLER_97_65 VPWR VGND sg13cmos5l_fill_1
XANTENNA__6492__X Tile_X0Y0_E2BEG[2] VPWR VGND sg13cmos5l_antennanp
X_2930_ _2930_/Y _6132_/Q _2927_/X _2926_/B VPWR VGND sg13cmos5l_a21oi_1
X_4600_ _4685_/A _4600_/A _4708_/A VPWR VGND sg13cmos5l_nor2_1
X_2861_ _2861_/Y _5713_/Q VPWR VGND sg13cmos5l_inv_1
X_5580_ _5580_/Q Tile_X0Y0_FrameData[22] Tile_X0Y1_FrameStrobe[0] VPWR VGND sg13cmos5l_dlhq_1
X_2792_ _2792_/Y _6385_/Q VPWR VGND sg13cmos5l_inv_1
X_4531_ _4531_/Y _5677_/Q _4531_/B _4531_/C VPWR VGND sg13cmos5l_nand3_1
XFILLER_7_360 VPWR VGND sg13cmos5l_fill_2
X_4462_ _4493_/A _4277_/A _4277_/B _4275_/Y VPWR VGND sg13cmos5l_a21oi_1
X_6201_ _6201_/Q Tile_X0Y1_FrameData[3] Tile_X0Y1_FrameStrobe[5] VPWR VGND sg13cmos5l_dlhq_1
X_3413_ _3413_/Y _6060_/Q _4503_/Y _3412_/Y VPWR VGND sg13cmos5l_o21ai_1
X_4393_ _4498_/A _4519_/A _4519_/B _4278_/Y VPWR VGND sg13cmos5l_a21oi_1
XANTENNA__6667__X Tile_X0Y0_W6BEG[8] VPWR VGND sg13cmos5l_antennanp
X_6132_ _6132_/Q Tile_X0Y1_FrameData[8] Tile_X0Y1_FrameStrobe[3] VPWR VGND sg13cmos5l_dlhq_1
X_3344_ _3344_/Y _3344_/A VPWR VGND sg13cmos5l_inv_1
XFILLER_30_0 VPWR VGND sg13cmos5l_fill_2
X_6063_ _6063_/Q Tile_X0Y1_FrameData[13] Tile_X0Y1_FrameStrobe[1] VPWR VGND sg13cmos5l_dlhq_1
X_3275_ _5180_/B _6601_/A Tile_X0Y0_S2MID[3] Tile_X0Y0_E2MID[3] Tile_X0Y0_W2MID[3]
+ _5767_/Q _5768_/Q VPWR VGND sg13cmos5l_mux4_1
X_5014_ _5014_/Y _5631_/Q _5013_/X VPWR VGND sg13cmos5l_nor2b_1
XFILLER_97_197 VPWR VGND sg13cmos5l_fill_2
X_5916_ _5916_/Q Tile_X0Y0_FrameData[6] Tile_X0Y1_FrameStrobe[10] VPWR VGND sg13cmos5l_dlhq_1
XFILLER_53_289 VPWR VGND sg13cmos5l_fill_2
X_5847_ _5847_/Q Tile_X0Y0_FrameData[11] Tile_X0Y1_FrameStrobe[8] VPWR VGND sg13cmos5l_dlhq_1
X_5778_ _5778_/Q Tile_X0Y0_FrameData[16] Tile_X0Y1_FrameStrobe[6] VPWR VGND sg13cmos5l_dlhq_1
X_4729_ _4729_/Y Tile_X0Y0_WW4END[3] _5574_/Q _5573_/Q VPWR VGND sg13cmos5l_o21ai_1
XANTENNA__6577__X Tile_X0Y0_FrameStrobe_O[11] VPWR VGND sg13cmos5l_antennanp
XFILLER_107_42 VPWR VGND sg13cmos5l_decap_8
XFILLER_29_264 VPWR VGND sg13cmos5l_fill_1
XANTENNA__6487__X Tile_X0Y0_E1BEG[1] VPWR VGND sg13cmos5l_antennanp
X_3060_ _3061_/A _3059_/Y _3052_/Y _5643_/Q VPWR VGND sg13cmos5l_mux2_1
X_6750_ Tile_X0Y1_FrameData_O[15] Tile_X0Y1_FrameData[15] VPWR VGND sg13cmos5l_buf_1
XFILLER_35_278 VPWR VGND sg13cmos5l_fill_1
X_5701_ _5701_/Q Tile_X0Y0_FrameData[29] Tile_X0Y1_FrameStrobe[4] VPWR VGND sg13cmos5l_dlhq_1
X_3962_ _3962_/Y _5720_/Q _2886_/Y _3961_/Y VPWR VGND sg13cmos5l_o21ai_1
X_6681_ Tile_X0Y0_WW4BEG[10] Tile_X0Y0_WW4END[14] VPWR VGND sg13cmos5l_buf_1
X_3893_ _3893_/Y _6069_/Q _3893_/B _3893_/C VPWR VGND sg13cmos5l_nor3_1
X_2913_ _2913_/Y _2913_/A _5659_/Q VPWR VGND sg13cmos5l_nor2b_1
X_5632_ _5632_/Q Tile_X0Y0_FrameData[2] Tile_X0Y1_FrameStrobe[1] VPWR VGND sg13cmos5l_dlhq_1
X_2844_ _2844_/Y _6235_/Q VPWR VGND sg13cmos5l_inv_1
X_5563_ _5563_/Q Tile_X0Y1_UserCLK _5563_/D _6469_/L_HI VPWR VGND sg13cmos5l_dfrbpq_1
XFILLER_78_0 VPWR VGND sg13cmos5l_fill_2
X_4514_ _4514_/Y _6423_/Q _5552_/Q VPWR VGND sg13cmos5l_nand2_1
X_2775_ _2775_/Y _5951_/Q VPWR VGND sg13cmos5l_inv_1
X_5494_ _5494_/Y _6321_/Q _5422_/B _5493_/Y VPWR VGND sg13cmos5l_o21ai_1
X_4445_ _4445_/Y _6112_/Q _5455_/B VPWR VGND sg13cmos5l_nand2_1
X_4376_ _4376_/Y _4370_/Y _4373_/Y _6285_/Q VPWR VGND sg13cmos5l_o21ai_1
X_6115_ _6115_/Q Tile_X0Y1_FrameData[25] Tile_X0Y1_FrameStrobe[3] VPWR VGND sg13cmos5l_dlhq_1
X_3327_ _3327_/X Tile_X0Y1_N1END[3] Tile_X0Y1_E1END[3] Tile_X0Y1_N2END[7] Tile_X0Y1_E2END[7]
+ _6115_/Q _6116_/Q VPWR VGND sg13cmos5l_mux4_1
X_6046_ _6046_/Q Tile_X0Y1_FrameData[30] Tile_X0Y1_FrameStrobe[1] VPWR VGND sg13cmos5l_dlhq_1
X_3258_ _6491_/A _3258_/A VPWR VGND sg13cmos5l_inv_1
X_3189_ _3189_/X _3189_/A _3189_/B VPWR VGND sg13cmos5l_and2_1
XANTENNA__6860__X Tile_X0Y1_WW4BEG[8] VPWR VGND sg13cmos5l_antennanp
XFILLER_64_307 VPWR VGND sg13cmos5l_fill_1
XFILLER_17_223 VPWR VGND sg13cmos5l_fill_1
XANTENNA__6770__X Tile_X0Y1_S1BEG[3] VPWR VGND sg13cmos5l_antennanp
XFILLER_32_215 VPWR VGND sg13cmos5l_fill_2
X_4230_ _4234_/A _4235_/A _3905_/Y _4229_/B VPWR VGND sg13cmos5l_a21o_1
XFILLER_4_20 VPWR VGND sg13cmos5l_decap_8
X_4161_ _4162_/B _4940_/Y _4934_/Y _5011_/X _4937_/Y _5626_/Q _5624_/Q VPWR VGND sg13cmos5l_mux4_1
X_4092_ _4092_/Y _5860_/Q _4091_/X _5859_/Q VPWR VGND sg13cmos5l_o21ai_1
X_3112_ _3113_/B _5687_/Q _3112_/B VPWR VGND sg13cmos5l_nand2_1
X_3043_ _3043_/X _2891_/Y _2892_/Y _6066_/Q VPWR VGND sg13cmos5l_mux2_1
X_6802_ Tile_X0Y1_S4BEG[15] _6802_/A VPWR VGND sg13cmos5l_buf_1
XFILLER_63_351 VPWR VGND sg13cmos5l_fill_1
X_4994_ _4994_/X Tile_X0Y0_SS4END[0] Tile_X0Y0_WW4END[0] _5670_/Q VPWR VGND sg13cmos5l_mux2_1
XANTENNA__6680__X Tile_X0Y0_WW4BEG[9] VPWR VGND sg13cmos5l_antennanp
X_6733_ Tile_X0Y1_EE4BEG[14] _6733_/A VPWR VGND sg13cmos5l_buf_1
X_3945_ _3945_/Y _5854_/Q _3945_/B VPWR VGND sg13cmos5l_nor2_1
XFILLER_23_18 VPWR VGND sg13cmos5l_fill_2
X_6664_ Tile_X0Y0_W6BEG[5] Tile_X0Y0_W6END[7] VPWR VGND sg13cmos5l_buf_1
X_5615_ _5615_/Q Tile_X0Y0_FrameData[19] Tile_X0Y1_FrameStrobe[1] VPWR VGND sg13cmos5l_dlhq_1
X_3876_ _3876_/X Tile_X0Y1_N2MID[0] Tile_X0Y1_E2MID[0] _6779_/A _2952_/A _6262_/Q
+ _6261_/Q VPWR VGND sg13cmos5l_mux4_1
X_6595_ Tile_X0Y0_N2BEG[5] _6595_/A VPWR VGND sg13cmos5l_buf_1
X_2827_ _3626_/B _6228_/Q VPWR VGND sg13cmos5l_inv_1
X_5546_ _5566_/D _5551_/A _5546_/B VPWR VGND sg13cmos5l_nor2_1
X_2758_ _2758_/Y _6010_/Q VPWR VGND sg13cmos5l_inv_1
X_5477_ _6865_/A _5477_/A _5477_/B VPWR VGND sg13cmos5l_nor2_1
X_4428_ _4428_/Y _6078_/Q _4427_/X _4424_/A VPWR VGND sg13cmos5l_o21ai_1
X_4359_ _4359_/Y _6244_/Q Tile_X0Y1_N2MID[6] VPWR VGND sg13cmos5l_nor2b_1
XFILLER_58_123 VPWR VGND sg13cmos5l_fill_1
XANTENNA__6855__X Tile_X0Y1_WW4BEG[3] VPWR VGND sg13cmos5l_antennanp
X_6029_ _6029_/Q Tile_X0Y1_FrameData[15] Tile_X0Y1_FrameStrobe[0] VPWR VGND sg13cmos5l_dlhq_1
XANTENNA__6590__X Tile_X0Y0_N2BEG[0] VPWR VGND sg13cmos5l_antennanp
XFILLER_14_248 VPWR VGND sg13cmos5l_fill_2
XFILLER_108_320 VPWR VGND sg13cmos5l_decap_8
XFILLER_8_0 VPWR VGND sg13cmos5l_fill_2
XFILLER_49_101 VPWR VGND sg13cmos5l_fill_2
XANTENNA__6765__X Tile_X0Y1_FrameData_O[30] VPWR VGND sg13cmos5l_antennanp
XFILLER_64_148 VPWR VGND sg13cmos5l_decap_4
XFILLER_64_126 VPWR VGND sg13cmos5l_fill_1
XFILLER_45_351 VPWR VGND sg13cmos5l_fill_1
X_3730_ _3730_/Y _6120_/Q _5455_/B _6119_/Q VPWR VGND sg13cmos5l_a21oi_1
X_3661_ _3662_/C _2870_/Y _3658_/Y _3660_/Y VPWR VGND sg13cmos5l_o21ai_1
X_5400_ _5400_/Y _6348_/Q _5400_/B VPWR VGND sg13cmos5l_nor2_1
X_6380_ _6380_/Q Tile_X0Y1_FrameData[16] Tile_X0Y1_FrameStrobe[11] VPWR VGND sg13cmos5l_dlhq_1
X_3592_ _3592_/Y _6164_/Q Tile_X0Y1_E1END[1] VPWR VGND sg13cmos5l_nor2b_1
X_5331_ _5331_/Y _6380_/Q _5498_/B _6379_/Q VPWR VGND sg13cmos5l_a21oi_1
X_5262_ _5262_/X _5261_/X _5559_/Q _6423_/Q VPWR VGND sg13cmos5l_mux2_1
X_5193_ _6640_/A _5889_/Q _5192_/Y _5190_/X VPWR VGND sg13cmos5l_o21ai_1
X_4213_ _4241_/B _4213_/A _4213_/B VPWR VGND sg13cmos5l_xor2_1
XANTENNA__6675__X Tile_X0Y0_WW4BEG[4] VPWR VGND sg13cmos5l_antennanp
X_4144_ _4144_/Y _4145_/A _4145_/B VPWR VGND sg13cmos5l_nand2_1
XFILLER_55_115 VPWR VGND sg13cmos5l_fill_1
XFILLER_28_329 VPWR VGND sg13cmos5l_fill_1
X_4075_ _4077_/B _4068_/Y _4074_/Y _4045_/Y VPWR VGND sg13cmos5l_a21oi_1
X_3026_ _3026_/Y _5696_/Q _5062_/B VPWR VGND sg13cmos5l_nand2_1
XFILLER_34_17 VPWR VGND sg13cmos5l_fill_2
X_6716_ Tile_X0Y1_E6BEG[9] Tile_X0Y1_E6END[11] VPWR VGND sg13cmos5l_buf_1
X_4977_ _4977_/Y _5701_/Q _4976_/Y _2767_/Y VPWR VGND sg13cmos5l_a21oi_1
XFILLER_11_229 VPWR VGND sg13cmos5l_fill_1
XFILLER_11_207 VPWR VGND sg13cmos5l_fill_2
X_3928_ _3928_/Y Tile_X0Y0_S2END[5] _5682_/Q _5681_/Q VPWR VGND sg13cmos5l_o21ai_1
X_6647_ Tile_X0Y0_W2BEG[4] Tile_X0Y0_W2END[4] VPWR VGND sg13cmos5l_buf_1
X_3859_ _3859_/Y _6030_/Q Tile_X0Y1_N4END[0] VPWR VGND sg13cmos5l_nor2b_1
X_6578_ Tile_X0Y0_FrameStrobe_O[12] Tile_X0Y1_FrameStrobe[12] VPWR VGND sg13cmos5l_buf_1
X_5529_ _5529_/X Tile_X0Y1_N2MID[6] Tile_X0Y1_E2MID[6] Tile_X0Y1_E2MID[0] _6779_/A
+ _6271_/Q _6272_/Q VPWR VGND sg13cmos5l_mux4_1
XFILLER_105_334 VPWR VGND sg13cmos5l_decap_8
XFILLER_1_7 VPWR VGND sg13cmos5l_decap_8
XANTENNA__6585__X Tile_X0Y0_FrameStrobe_O[19] VPWR VGND sg13cmos5l_antennanp
XFILLER_6_211 VPWR VGND sg13cmos5l_fill_1
XANTENNA__6495__X Tile_X0Y0_E2BEG[5] VPWR VGND sg13cmos5l_antennanp
XFILLER_111_348 VPWR VGND sg13cmos5l_fill_2
XFILLER_1_21 VPWR VGND sg13cmos5l_decap_8
X_5880_ _5880_/Q Tile_X0Y0_FrameData[10] Tile_X0Y1_FrameStrobe[9] VPWR VGND sg13cmos5l_dlhq_1
X_4900_ _6011_/D _4900_/A VPWR VGND sg13cmos5l_inv_1
X_4831_ _4831_/Y Tile_X0Y0_E2END[6] _5614_/Q _4830_/Y VPWR VGND sg13cmos5l_a21oi_1
XFILLER_33_343 VPWR VGND sg13cmos5l_fill_1
XANTENNA_180 Tile_X0Y1_W2END[0] VPWR VGND sg13cmos5l_antennanp
XANTENNA_191 Tile_X0Y1_W2MID[3] VPWR VGND sg13cmos5l_antennanp
XFILLER_60_151 VPWR VGND sg13cmos5l_fill_1
X_4762_ _4762_/Y _5674_/Q _4759_/X _5673_/Q VPWR VGND sg13cmos5l_o21ai_1
X_6501_ Tile_X0Y0_E2BEGb[3] Tile_X0Y0_E2MID[3] VPWR VGND sg13cmos5l_buf_1
X_4693_ _4696_/B _4715_/A _4693_/B VPWR VGND sg13cmos5l_nand2_1
X_3713_ _5468_/B _6263_/Q _3709_/X _3712_/Y VPWR VGND sg13cmos5l_o21ai_1
X_6432_ _6432_/L_HI VPWR VGND sg13cmos5l_tiehi
X_3644_ _3644_/Y _3637_/Y _3639_/Y _3641_/B _3641_/A _6298_/Q VPWR VGND sg13cmos5l_a221oi_1
X_6363_ _6363_/Q Tile_X0Y1_FrameData[1] Tile_X0Y1_FrameStrobe[10] VPWR VGND sg13cmos5l_dlhq_1
X_3575_ _3575_/Y _6308_/Q _3575_/B VPWR VGND sg13cmos5l_nand2_1
X_6294_ _6294_/Q Tile_X0Y1_FrameData[6] Tile_X0Y1_FrameStrobe[8] VPWR VGND sg13cmos5l_dlhq_1
X_5314_ _5314_/Y _5314_/A VPWR VGND sg13cmos5l_inv_1
X_5245_ _5245_/X _5872_/Q _5245_/B VPWR VGND sg13cmos5l_or2_1
X_5176_ _5177_/B _5898_/Q _2886_/Y _5175_/Y VPWR VGND sg13cmos5l_a21oi_1
X_4127_ _4127_/Y _4127_/A VPWR VGND sg13cmos5l_inv_1
X_4058_ _4058_/Y _5716_/Q _5062_/B VPWR VGND sg13cmos5l_nand2_1
X_3009_ _6599_/A _6165_/Q _2999_/Y _3001_/Y _3008_/Y VPWR VGND sg13cmos5l_a22oi_1
XFILLER_101_88 VPWR VGND sg13cmos5l_fill_1
XFILLER_105_153 VPWR VGND sg13cmos5l_fill_2
XFILLER_105_164 VPWR VGND sg13cmos5l_fill_1
XFILLER_86_67 VPWR VGND sg13cmos5l_fill_2
XFILLER_59_284 VPWR VGND sg13cmos5l_fill_1
XFILLER_15_332 VPWR VGND sg13cmos5l_fill_2
XFILLER_42_173 VPWR VGND sg13cmos5l_fill_1
XFILLER_30_379 VPWR VGND sg13cmos5l_fill_2
X_3360_ _6604_/A _4796_/B VPWR VGND sg13cmos5l_inv_1
X_5030_ _6587_/A _5973_/Q _5029_/Y _5027_/X VPWR VGND sg13cmos5l_o21ai_1
X_3291_ _3291_/Y _6152_/Q _4409_/B _3290_/Y VPWR VGND sg13cmos5l_o21ai_1
XFILLER_97_379 VPWR VGND sg13cmos5l_fill_2
X_5932_ _5932_/Q Tile_X0Y0_FrameData[22] Tile_X0Y1_FrameStrobe[11] VPWR VGND sg13cmos5l_dlhq_1
X_5863_ _5863_/Q Tile_X0Y0_FrameData[27] Tile_X0Y1_FrameStrobe[9] VPWR VGND sg13cmos5l_dlhq_1
X_5794_ _5794_/Q Tile_X0Y0_FrameData[0] Tile_X0Y1_FrameStrobe[6] VPWR VGND sg13cmos5l_dlhq_1
X_4814_ _4817_/B _5770_/Q _6605_/A _4813_/Y VPWR VGND sg13cmos5l_o21ai_1
X_4745_ _4746_/C _5836_/Q _4745_/B VPWR VGND sg13cmos5l_nor2_1
X_4676_ _6006_/D _4676_/A _4676_/B VPWR VGND sg13cmos5l_or2_1
X_6415_ _6415_/Q Tile_X0Y1_FrameData[13] Tile_X0Y1_FrameStrobe[12] VPWR VGND sg13cmos5l_dlhq_1
X_3627_ _3627_/Y _2826_/Y _6228_/Q _6227_/Q VPWR VGND sg13cmos5l_a21oi_1
X_6346_ _6346_/Q Tile_X0Y1_FrameData[18] Tile_X0Y1_FrameStrobe[10] VPWR VGND sg13cmos5l_dlhq_1
X_3558_ _3558_/Y _6126_/Q _3555_/X _6127_/Q VPWR VGND sg13cmos5l_a21oi_1
X_6277_ _6277_/Q Tile_X0Y1_FrameData[23] Tile_X0Y1_FrameStrobe[8] VPWR VGND sg13cmos5l_dlhq_1
X_3489_ _3489_/X _3488_/X _3031_/X _6310_/Q VPWR VGND sg13cmos5l_mux2_1
XFILLER_88_335 VPWR VGND sg13cmos5l_fill_2
XFILLER_0_239 VPWR VGND sg13cmos5l_fill_1
X_5228_ _6685_/A _5218_/Y _5221_/Y _5227_/Y VPWR VGND sg13cmos5l_a21oi_1
XFILLER_88_379 VPWR VGND sg13cmos5l_fill_2
X_5159_ _5159_/Y _5902_/Q _5159_/B VPWR VGND sg13cmos5l_nor2_1
XANTENNA__6863__X Tile_X0Y1_WW4BEG[11] VPWR VGND sg13cmos5l_antennanp
XFILLER_16_107 VPWR VGND sg13cmos5l_fill_1
XFILLER_72_36 VPWR VGND sg13cmos5l_fill_2
XFILLER_24_173 VPWR VGND sg13cmos5l_fill_2
XFILLER_12_379 VPWR VGND sg13cmos5l_fill_2
XANTENNA_80 Tile_X0Y0_E2MID[6] VPWR VGND sg13cmos5l_antennanp
XANTENNA_91 Tile_X0Y0_SS4END[2] VPWR VGND sg13cmos5l_antennanp
XFILLER_108_0 VPWR VGND sg13cmos5l_decap_8
XFILLER_97_55 VPWR VGND sg13cmos5l_fill_1
XANTENNA__6773__X Tile_X0Y1_S2BEG[2] VPWR VGND sg13cmos5l_antennanp
XFILLER_47_243 VPWR VGND sg13cmos5l_fill_2
X_2860_ _2860_/Y _6001_/Q VPWR VGND sg13cmos5l_inv_1
XFILLER_30_121 VPWR VGND sg13cmos5l_fill_2
X_2791_ _2791_/Y _6386_/Q VPWR VGND sg13cmos5l_inv_1
X_4530_ _4531_/C _5676_/Q _4530_/B VPWR VGND sg13cmos5l_nand2_1
X_4461_ _4496_/B _6426_/Q _6003_/D _4460_/Y VPWR VGND sg13cmos5l_o21ai_1
X_6200_ _6200_/Q Tile_X0Y1_FrameData[4] Tile_X0Y1_FrameStrobe[5] VPWR VGND sg13cmos5l_dlhq_1
X_3412_ _3412_/Y _6060_/Q _2891_/Y _6058_/Q VPWR VGND sg13cmos5l_a21oi_1
X_6131_ _6131_/Q Tile_X0Y1_FrameData[9] Tile_X0Y1_FrameStrobe[3] VPWR VGND sg13cmos5l_dlhq_1
X_4392_ _4519_/B _4392_/A _4392_/B VPWR VGND sg13cmos5l_xor2_1
X_3343_ _3344_/A _4503_/Y _5262_/X _3916_/Y _5422_/B _6050_/Q _6052_/Q VPWR VGND sg13cmos5l_mux4_1
XFILLER_97_143 VPWR VGND sg13cmos5l_fill_1
X_6062_ _6062_/Q Tile_X0Y1_FrameData[14] Tile_X0Y1_FrameStrobe[1] VPWR VGND sg13cmos5l_dlhq_1
X_3274_ _6601_/A _3271_/Y _3273_/Y _3266_/Y VPWR VGND sg13cmos5l_o21ai_1
XFILLER_23_0 VPWR VGND sg13cmos5l_fill_2
X_5013_ _5013_/X Tile_X0Y0_E2END[1] Tile_X0Y0_E6END[1] Tile_X0Y0_W2END[1] Tile_X0Y0_W6END[1]
+ _5634_/Q _5632_/Q VPWR VGND sg13cmos5l_mux4_1
XANTENNA__6683__X Tile_X0Y0_WW4BEG[12] VPWR VGND sg13cmos5l_antennanp
X_5915_ _5915_/Q Tile_X0Y0_FrameData[7] Tile_X0Y1_FrameStrobe[10] VPWR VGND sg13cmos5l_dlhq_1
X_5846_ _5846_/Q Tile_X0Y0_FrameData[12] Tile_X0Y1_FrameStrobe[8] VPWR VGND sg13cmos5l_dlhq_1
XFILLER_42_17 VPWR VGND sg13cmos5l_fill_2
X_5777_ _5777_/Q Tile_X0Y0_FrameData[17] Tile_X0Y1_FrameStrobe[6] VPWR VGND sg13cmos5l_dlhq_1
X_2989_ _2989_/Y _5620_/Q _4909_/X _2988_/Y VPWR VGND sg13cmos5l_a21oi_1
X_4728_ _5006_/A _6424_/Q _4875_/A VPWR VGND sg13cmos5l_and2_1
X_4659_ _4938_/A _4659_/A _4659_/B VPWR VGND sg13cmos5l_xnor2_1
XANTENNA__6858__X Tile_X0Y1_WW4BEG[6] VPWR VGND sg13cmos5l_antennanp
XFILLER_107_21 VPWR VGND sg13cmos5l_decap_8
X_6329_ _6329_/Q Tile_X0Y1_FrameData[3] Tile_X0Y1_FrameStrobe[9] VPWR VGND sg13cmos5l_dlhq_1
XFILLER_67_14 VPWR VGND sg13cmos5l_fill_1
XFILLER_76_338 VPWR VGND sg13cmos5l_fill_2
XANTENNA__6593__X Tile_X0Y0_N2BEG[3] VPWR VGND sg13cmos5l_antennanp
XANTENNA__6768__X Tile_X0Y1_S1BEG[1] VPWR VGND sg13cmos5l_antennanp
XFILLER_4_353 VPWR VGND sg13cmos5l_decap_4
XFILLER_67_305 VPWR VGND sg13cmos5l_decap_8
XFILLER_57_80 VPWR VGND sg13cmos5l_fill_1
X_3961_ _3961_/Y _5720_/Q _5009_/Y VPWR VGND sg13cmos5l_nand2_1
X_5700_ _5700_/Q Tile_X0Y0_FrameData[30] Tile_X0Y1_FrameStrobe[4] VPWR VGND sg13cmos5l_dlhq_1
X_2912_ _2913_/A _5661_/Q _2912_/B VPWR VGND sg13cmos5l_nor2_1
X_6680_ Tile_X0Y0_WW4BEG[9] Tile_X0Y0_WW4END[13] VPWR VGND sg13cmos5l_buf_1
X_3892_ _3893_/C _6072_/Q _3890_/X _3891_/Y VPWR VGND sg13cmos5l_a21oi_1
X_5631_ _5631_/Q Tile_X0Y0_FrameData[3] Tile_X0Y1_FrameStrobe[1] VPWR VGND sg13cmos5l_dlhq_1
X_2843_ _2843_/Y Tile_X0Y1_E2MID[1] VPWR VGND sg13cmos5l_inv_1
X_5562_ _5562_/Q Tile_X0Y1_UserCLK _5562_/D _6470_/L_HI VPWR VGND sg13cmos5l_dfrbpq_1
X_2774_ _2774_/Y _5957_/Q VPWR VGND sg13cmos5l_inv_1
X_4513_ _5532_/B _4513_/A _4513_/B VPWR VGND sg13cmos5l_xor2_1
XANTENNA__6678__X Tile_X0Y0_WW4BEG[7] VPWR VGND sg13cmos5l_antennanp
X_5493_ _5493_/Y _6321_/Q _5493_/B VPWR VGND sg13cmos5l_nand2_1
X_4444_ _4444_/Y _4443_/Y _6109_/Q _4444_/C VPWR VGND sg13cmos5l_nand3b_1
X_4375_ _4375_/Y _6286_/Q _4375_/B VPWR VGND sg13cmos5l_nor2_1
X_6114_ _6114_/Q Tile_X0Y1_FrameData[26] Tile_X0Y1_FrameStrobe[3] VPWR VGND sg13cmos5l_dlhq_1
X_3326_ _3326_/X _3217_/A _3325_/A _2750_/Y _2789_/Y _6116_/Q _6115_/Q VPWR VGND sg13cmos5l_mux4_1
X_6045_ _6045_/Q Tile_X0Y1_FrameData[31] Tile_X0Y1_FrameStrobe[1] VPWR VGND sg13cmos5l_dlhq_1
X_3257_ _3258_/A _3251_/Y _3256_/Y _3245_/Y VPWR VGND sg13cmos5l_a21oi_1
X_3188_ _3189_/B _4940_/Y _4934_/Y _5011_/X _4937_/Y _5686_/Q _5684_/Q VPWR VGND sg13cmos5l_mux4_1
XFILLER_85_179 VPWR VGND sg13cmos5l_fill_2
X_5829_ _5829_/Q Tile_X0Y0_FrameData[29] Tile_X0Y1_FrameStrobe[8] VPWR VGND sg13cmos5l_dlhq_1
XANTENNA__6588__X Tile_X0Y0_N1BEG[2] VPWR VGND sg13cmos5l_antennanp
XFILLER_1_345 VPWR VGND sg13cmos5l_decap_4
XFILLER_49_327 VPWR VGND sg13cmos5l_fill_2
XANTENNA__6498__X Tile_X0Y0_E2BEGb[0] VPWR VGND sg13cmos5l_antennanp
XFILLER_4_194 VPWR VGND sg13cmos5l_decap_8
X_4160_ _4160_/Y _4155_/Y _4158_/Y _4159_/Y VPWR VGND sg13cmos5l_o21ai_1
X_3111_ _3112_/B _5690_/Q _3111_/B _3111_/C VPWR VGND sg13cmos5l_nand3_1
X_4091_ _4091_/X Tile_X0Y1_N2MID[4] Tile_X0Y0_S2END[4] Tile_X0Y0_EE4END[0] Tile_X0Y0_W2END[4]
+ _5757_/Q _5758_/Q VPWR VGND sg13cmos5l_mux4_1
X_3042_ _3042_/Y _6066_/Q _2888_/Y _3041_/Y VPWR VGND sg13cmos5l_o21ai_1
X_6801_ Tile_X0Y1_S4BEG[14] _6801_/A VPWR VGND sg13cmos5l_buf_1
X_4993_ _4993_/Y Tile_X0Y0_S1END[0] _5670_/Q _4992_/Y VPWR VGND sg13cmos5l_o21ai_1
X_6732_ Tile_X0Y1_EE4BEG[13] _6732_/A VPWR VGND sg13cmos5l_buf_1
X_3944_ _3945_/B Tile_X0Y1_N2MID[2] Tile_X0Y0_S2END[2] Tile_X0Y0_E2END[2] Tile_X0Y0_WW4END[2]
+ _5751_/Q _5752_/Q VPWR VGND sg13cmos5l_mux4_1
XFILLER_90_193 VPWR VGND sg13cmos5l_fill_1
XFILLER_90_0 VPWR VGND sg13cmos5l_fill_1
X_6663_ Tile_X0Y0_W6BEG[4] Tile_X0Y0_W6END[6] VPWR VGND sg13cmos5l_buf_1
X_3875_ _3906_/A _3680_/Y _4007_/A _3874_/Y VPWR VGND sg13cmos5l_a21o_1
X_5614_ _5614_/Q Tile_X0Y0_FrameData[20] Tile_X0Y1_FrameStrobe[1] VPWR VGND sg13cmos5l_dlhq_1
X_2826_ _2826_/Y Tile_X0Y1_E2MID[7] VPWR VGND sg13cmos5l_inv_1
X_6594_ Tile_X0Y0_N2BEG[4] _6594_/A VPWR VGND sg13cmos5l_buf_1
X_5545_ _5565_/D _5551_/A _4910_/Y VPWR VGND sg13cmos5l_nor2b_1
X_2757_ _2757_/Y Tile_X0Y0_E2MID[4] VPWR VGND sg13cmos5l_inv_1
X_5476_ _5477_/B _6325_/Q _5476_/B _5476_/C VPWR VGND sg13cmos5l_nor3_1
X_4427_ _4427_/X Tile_X0Y1_N1END[0] Tile_X0Y1_N2END[0] Tile_X0Y1_E1END[0] Tile_X0Y1_E2END[0]
+ _6080_/Q _6079_/Q VPWR VGND sg13cmos5l_mux4_1
X_4358_ _4358_/Y _6244_/Q _4796_/B _4357_/Y VPWR VGND sg13cmos5l_a21oi_1
X_4289_ _4293_/B _6238_/Q _3349_/A _4288_/Y VPWR VGND sg13cmos5l_a21oi_1
X_3309_ _3310_/B _5724_/Q _2886_/Y _3308_/Y VPWR VGND sg13cmos5l_o21ai_1
XFILLER_100_232 VPWR VGND sg13cmos5l_fill_2
X_6028_ _6028_/Q Tile_X0Y1_FrameData[16] Tile_X0Y1_FrameStrobe[0] VPWR VGND sg13cmos5l_dlhq_1
XFILLER_104_33 VPWR VGND sg13cmos5l_decap_4
XFILLER_54_341 VPWR VGND sg13cmos5l_fill_2
XFILLER_45_330 VPWR VGND sg13cmos5l_fill_1
XANTENNA__6781__X Tile_X0Y1_S2BEGb[2] VPWR VGND sg13cmos5l_antennanp
XFILLER_72_171 VPWR VGND sg13cmos5l_fill_1
X_3660_ _3660_/Y _2870_/Y _3659_/X _6099_/Q VPWR VGND sg13cmos5l_a21oi_1
X_3591_ _3591_/X Tile_X0Y1_W2END[3] Tile_X0Y1_WW4END[1] _6164_/Q VPWR VGND sg13cmos5l_mux2_1
X_5330_ _5330_/Y _2795_/Y _5329_/X _6378_/Q VPWR VGND sg13cmos5l_a21oi_1
X_5261_ _5261_/X _5261_/A _5261_/B VPWR VGND sg13cmos5l_xor2_1
X_4212_ _4212_/Y _4213_/B _4213_/A VPWR VGND sg13cmos5l_nor2b_1
X_5192_ _5192_/Y _5890_/Q _4937_/Y _5191_/Y VPWR VGND sg13cmos5l_o21ai_1
X_4143_ _4145_/B _4143_/A _4143_/B VPWR VGND sg13cmos5l_xor2_1
X_4074_ _4074_/Y _4070_/Y _4073_/Y _5863_/Q VPWR VGND sg13cmos5l_a21oi_1
X_3025_ _3025_/Y _5696_/Q _4911_/X _3024_/Y VPWR VGND sg13cmos5l_o21ai_1
XFILLER_55_127 VPWR VGND sg13cmos5l_fill_1
XANTENNA__6691__X Tile_X0Y1_E2BEG[0] VPWR VGND sg13cmos5l_antennanp
XFILLER_51_355 VPWR VGND sg13cmos5l_fill_1
XFILLER_51_344 VPWR VGND sg13cmos5l_fill_2
X_6715_ Tile_X0Y1_E6BEG[8] Tile_X0Y1_E6END[10] VPWR VGND sg13cmos5l_buf_1
X_4976_ _4976_/Y _2725_/Y _5702_/Q _4975_/Y VPWR VGND sg13cmos5l_o21ai_1
X_3927_ _3927_/Y Tile_X0Y0_S1END[1] _5682_/Q _3926_/Y VPWR VGND sg13cmos5l_o21ai_1
X_6646_ Tile_X0Y0_W2BEG[3] Tile_X0Y0_W2END[3] VPWR VGND sg13cmos5l_buf_1
X_3858_ _3858_/X Tile_X0Y1_W6END[0] _6826_/A _6030_/Q VPWR VGND sg13cmos5l_mux2_1
X_6577_ Tile_X0Y0_FrameStrobe_O[11] Tile_X0Y1_FrameStrobe[11] VPWR VGND sg13cmos5l_buf_1
X_3789_ _4507_/A _3789_/A VPWR VGND sg13cmos5l_inv_1
X_2809_ _3888_/A Tile_X0Y1_E2END[2] VPWR VGND sg13cmos5l_inv_1
X_5528_ _5528_/Y _6270_/Q _5528_/B VPWR VGND sg13cmos5l_nand2_1
X_5459_ _5459_/Y _5455_/Y _5456_/Y _5458_/Y _6329_/Q _6328_/Q VPWR VGND sg13cmos5l_a221oi_1
XANTENNA__6866__X Tile_X0Y1_WW4BEG[14] VPWR VGND sg13cmos5l_antennanp
XFILLER_91_13 VPWR VGND sg13cmos5l_fill_2
XANTENNA__6776__X Tile_X0Y1_S2BEG[5] VPWR VGND sg13cmos5l_antennanp
XFILLER_111_327 VPWR VGND sg13cmos5l_decap_8
XFILLER_1_66 VPWR VGND sg13cmos5l_fill_2
XANTENNA_170 Tile_X0Y1_NN4END[7] VPWR VGND sg13cmos5l_antennanp
X_4830_ _4830_/Y _5614_/Q Tile_X0Y0_E1END[2] VPWR VGND sg13cmos5l_nor2b_1
XANTENNA_181 Tile_X0Y1_W2MID[3] VPWR VGND sg13cmos5l_antennanp
XANTENNA_192 Tile_X0Y1_W2MID[3] VPWR VGND sg13cmos5l_antennanp
X_4761_ _4761_/Y Tile_X0Y0_W1END[3] _5672_/Q _4760_/Y VPWR VGND sg13cmos5l_a21oi_1
X_6500_ Tile_X0Y0_E2BEGb[2] Tile_X0Y0_E2MID[2] VPWR VGND sg13cmos5l_buf_1
X_4692_ _4693_/B _4692_/A _4692_/B _4692_/C VPWR VGND sg13cmos5l_or3_1
X_3712_ _3712_/Y _6263_/Q _3712_/B VPWR VGND sg13cmos5l_nand2_1
X_6431_ _6431_/L_HI VPWR VGND sg13cmos5l_tiehi
X_3643_ _3643_/Y _3643_/A VPWR VGND sg13cmos5l_inv_1
X_6362_ _6362_/Q Tile_X0Y1_FrameData[2] Tile_X0Y1_FrameStrobe[10] VPWR VGND sg13cmos5l_dlhq_1
X_5313_ _5314_/A _6385_/Q _5310_/Y _6384_/Q VPWR VGND sg13cmos5l_o21ai_1
X_3574_ _3574_/Y _3574_/A VPWR VGND sg13cmos5l_inv_1
XFILLER_53_0 VPWR VGND sg13cmos5l_fill_1
X_6293_ _6293_/Q Tile_X0Y1_FrameData[7] Tile_X0Y1_FrameStrobe[8] VPWR VGND sg13cmos5l_dlhq_1
XANTENNA__6686__X Tile_X0Y0_WW4BEG[15] VPWR VGND sg13cmos5l_antennanp
X_5244_ _5244_/Y _5872_/Q _5180_/B _5243_/Y VPWR VGND sg13cmos5l_a21oi_1
X_5175_ _5175_/Y Tile_X0Y0_W1END[0] _5898_/Q _5897_/Q VPWR VGND sg13cmos5l_o21ai_1
X_4126_ _4127_/A _4121_/X _4122_/Y _4125_/X VPWR VGND sg13cmos5l_a21o_1
XFILLER_68_296 VPWR VGND sg13cmos5l_fill_1
X_4057_ _4064_/B _5718_/Q _4055_/Y _4056_/Y VPWR VGND sg13cmos5l_o21ai_1
XFILLER_83_255 VPWR VGND sg13cmos5l_fill_2
X_3008_ _3008_/Y _6165_/Q _3008_/B VPWR VGND sg13cmos5l_nor2_1
X_4959_ _4959_/Y _5604_/Q _4707_/Y VPWR VGND sg13cmos5l_nor2b_1
XFILLER_51_174 VPWR VGND sg13cmos5l_fill_2
X_6629_ Tile_X0Y0_NN4BEG[7] Tile_X0Y1_NN4END[15] VPWR VGND sg13cmos5l_buf_1
XANTENNA__6596__X Tile_X0Y0_N2BEG[6] VPWR VGND sg13cmos5l_antennanp
XFILLER_59_274 VPWR VGND sg13cmos5l_fill_2
XFILLER_19_116 VPWR VGND sg13cmos5l_fill_1
XFILLER_15_366 VPWR VGND sg13cmos5l_fill_2
X_3290_ _3290_/Y _6152_/Q _3916_/Y VPWR VGND sg13cmos5l_nand2_1
X_5931_ _5931_/Q Tile_X0Y0_FrameData[23] Tile_X0Y1_FrameStrobe[11] VPWR VGND sg13cmos5l_dlhq_1
XFILLER_80_236 VPWR VGND sg13cmos5l_fill_1
X_5862_ _5862_/Q Tile_X0Y0_FrameData[28] Tile_X0Y1_FrameStrobe[9] VPWR VGND sg13cmos5l_dlhq_1
X_5793_ _5793_/Q Tile_X0Y0_FrameData[1] Tile_X0Y1_FrameStrobe[6] VPWR VGND sg13cmos5l_dlhq_1
X_4813_ _4813_/Y _5770_/Q _2749_/Y _5769_/Q VPWR VGND sg13cmos5l_a21oi_1
X_4744_ _4744_/Y _4745_/B VPWR VGND sg13cmos5l_inv_1
X_4675_ _4676_/B _4674_/A _5229_/B _4671_/Y _4674_/Y _5843_/Q VPWR VGND sg13cmos5l_a221oi_1
X_6414_ _6414_/Q Tile_X0Y1_FrameData[14] Tile_X0Y1_FrameStrobe[12] VPWR VGND sg13cmos5l_dlhq_1
X_3626_ _3626_/Y _3626_/A _3626_/B VPWR VGND sg13cmos5l_nand2_1
X_6345_ _6345_/Q Tile_X0Y1_FrameData[19] Tile_X0Y1_FrameStrobe[10] VPWR VGND sg13cmos5l_dlhq_1
X_3557_ _3557_/Y _2825_/Y Tile_X0Y1_N2END[4] _3556_/Y VPWR VGND sg13cmos5l_o21ai_1
X_6276_ _6276_/Q Tile_X0Y1_FrameData[24] Tile_X0Y1_FrameStrobe[8] VPWR VGND sg13cmos5l_dlhq_1
XFILLER_0_207 VPWR VGND sg13cmos5l_fill_1
X_5227_ _5227_/Y _5227_/A _5227_/B VPWR VGND sg13cmos5l_nor2_1
X_3488_ _3488_/X Tile_X0Y1_N2END[6] Tile_X0Y1_E2END[6] Tile_X0Y0_SS4END[7] Tile_X0Y1_W2END[6]
+ _6204_/Q _6203_/Q VPWR VGND sg13cmos5l_mux4_1
XFILLER_102_179 VPWR VGND sg13cmos5l_fill_1
X_5158_ _5159_/B _4944_/X Tile_X0Y0_W1END[2] Tile_X0Y0_E1END[2] _4707_/Y _5903_/Q
+ _5904_/Q VPWR VGND sg13cmos5l_mux4_1
X_5089_ _5090_/B _5730_/Q _5085_/X _5088_/Y VPWR VGND sg13cmos5l_a21oi_1
X_4109_ _4111_/B _4570_/A _4471_/A VPWR VGND sg13cmos5l_and2_1
XFILLER_56_266 VPWR VGND sg13cmos5l_decap_4
XANTENNA_70 Tile_X0Y0_E2MID[4] VPWR VGND sg13cmos5l_antennanp
XANTENNA_81 Tile_X0Y0_E2MID[6] VPWR VGND sg13cmos5l_antennanp
XANTENNA_92 Tile_X0Y0_SS4END[3] VPWR VGND sg13cmos5l_antennanp
XFILLER_87_380 VPWR VGND sg13cmos5l_fill_1
X_2790_ _2790_/Y Tile_X0Y1_W1END[1] VPWR VGND sg13cmos5l_inv_1
X_4460_ _4460_/Y _6426_/Q _2720_/Y _6425_/Q VPWR VGND sg13cmos5l_a21oi_1
X_4391_ _4519_/A _5261_/A _5261_/B _4306_/Y VPWR VGND sg13cmos5l_o21ai_1
X_3411_ _3411_/Y _6058_/Q _3410_/X _6059_/Q VPWR VGND sg13cmos5l_a21oi_1
X_6130_ _6130_/Q Tile_X0Y1_FrameData[10] Tile_X0Y1_FrameStrobe[3] VPWR VGND sg13cmos5l_dlhq_1
X_3342_ _3348_/A _6050_/Q _3339_/X _3341_/Y VPWR VGND sg13cmos5l_a21oi_1
X_6061_ _6061_/Q Tile_X0Y1_FrameData[15] Tile_X0Y1_FrameStrobe[1] VPWR VGND sg13cmos5l_dlhq_1
X_3273_ _3273_/Y _6159_/Q _3272_/X _6157_/Q VPWR VGND sg13cmos5l_o21ai_1
X_5012_ _6586_/A _4707_/Y _2993_/Y _3206_/X _3187_/X _5975_/Q _5976_/Q VPWR VGND sg13cmos5l_mux4_1
XFILLER_97_199 VPWR VGND sg13cmos5l_fill_1
XFILLER_16_0 VPWR VGND sg13cmos5l_fill_2
X_5914_ _5914_/Q Tile_X0Y0_FrameData[8] Tile_X0Y1_FrameStrobe[10] VPWR VGND sg13cmos5l_dlhq_1
X_5845_ _5845_/Q Tile_X0Y0_FrameData[13] Tile_X0Y1_FrameStrobe[8] VPWR VGND sg13cmos5l_dlhq_1
X_5776_ _5776_/Q Tile_X0Y0_FrameData[18] Tile_X0Y1_FrameStrobe[6] VPWR VGND sg13cmos5l_dlhq_1
X_2988_ _2988_/Y _5620_/Q _4707_/Y VPWR VGND sg13cmos5l_nor2b_1
XFILLER_21_155 VPWR VGND sg13cmos5l_decap_4
X_4727_ _4875_/A _4727_/A _4727_/B _4727_/C VPWR VGND sg13cmos5l_nand3_1
X_4658_ _4658_/Y _4659_/B _4659_/A VPWR VGND sg13cmos5l_nor2b_1
X_3609_ _3609_/Y _6036_/Q Tile_X0Y1_E2END[3] VPWR VGND sg13cmos5l_nor2b_1
X_4589_ _4616_/A _4590_/A _4590_/B VPWR VGND sg13cmos5l_and2_1
X_6328_ _6328_/Q Tile_X0Y1_FrameData[4] Tile_X0Y1_FrameStrobe[9] VPWR VGND sg13cmos5l_dlhq_1
X_6259_ _6259_/Q Tile_X0Y1_FrameData[9] Tile_X0Y1_FrameStrobe[7] VPWR VGND sg13cmos5l_dlhq_1
XFILLER_107_77 VPWR VGND sg13cmos5l_decap_4
XFILLER_76_328 VPWR VGND sg13cmos5l_fill_2
XFILLER_69_380 VPWR VGND sg13cmos5l_fill_1
XFILLER_29_299 VPWR VGND sg13cmos5l_fill_2
XFILLER_32_84 VPWR VGND sg13cmos5l_fill_1
XFILLER_4_332 VPWR VGND sg13cmos5l_decap_8
XANTENNA__6784__X Tile_X0Y1_S2BEGb[5] VPWR VGND sg13cmos5l_antennanp
XFILLER_67_317 VPWR VGND sg13cmos5l_fill_1
X_3960_ _3960_/X _4940_/Y _4934_/Y _5011_/X _4937_/Y _5722_/Q _5720_/Q VPWR VGND sg13cmos5l_mux4_1
X_2911_ _2912_/B _4940_/Y _4707_/Y _5011_/X _4937_/Y _5662_/Q _5660_/Q VPWR VGND sg13cmos5l_mux4_1
X_3891_ _3891_/Y _6072_/Q _3889_/Y _6071_/Q VPWR VGND sg13cmos5l_o21ai_1
X_5630_ _5630_/Q Tile_X0Y0_FrameData[4] Tile_X0Y1_FrameStrobe[1] VPWR VGND sg13cmos5l_dlhq_1
X_2842_ _2842_/Y Tile_X0Y1_W2MID[1] VPWR VGND sg13cmos5l_inv_1
X_5561_ _5561_/Q Tile_X0Y1_UserCLK _5561_/D _6471_/L_HI VPWR VGND sg13cmos5l_dfrbpq_1
X_2773_ _5044_/A _5959_/Q VPWR VGND sg13cmos5l_inv_1
X_5492_ _5492_/X _5420_/B _3707_/X _6321_/Q VPWR VGND sg13cmos5l_mux2_1
X_4512_ _5390_/B _6423_/Q _5537_/B _4511_/Y VPWR VGND sg13cmos5l_o21ai_1
X_4443_ _4443_/Y _4443_/A _4439_/Y VPWR VGND sg13cmos5l_nor2b_1
X_4374_ _4375_/B Tile_X0Y1_N2END[7] Tile_X0Y1_E2END[7] Tile_X0Y0_S2MID[7] Tile_X0Y1_WW4END[0]
+ _6180_/Q _6179_/Q VPWR VGND sg13cmos5l_mux4_1
X_6113_ _6113_/Q Tile_X0Y1_FrameData[27] Tile_X0Y1_FrameStrobe[3] VPWR VGND sg13cmos5l_dlhq_1
X_3325_ _3325_/Y _3325_/A VPWR VGND sg13cmos5l_inv_1
XANTENNA__6694__X Tile_X0Y1_E2BEG[3] VPWR VGND sg13cmos5l_antennanp
X_6044_ _6044_/Q Tile_X0Y1_FrameData[0] Tile_X0Y1_FrameStrobe[0] VPWR VGND sg13cmos5l_dlhq_1
X_3256_ _3256_/Y _3253_/Y _3255_/Y _5691_/Q VPWR VGND sg13cmos5l_a21oi_1
X_3187_ _3187_/X Tile_X0Y1_N4END[6] Tile_X0Y0_E2END[2] Tile_X0Y0_W2END[7] _6492_/A
+ _5592_/Q _5591_/Q VPWR VGND sg13cmos5l_mux4_1
XFILLER_81_331 VPWR VGND sg13cmos5l_fill_2
X_5828_ _5828_/Q Tile_X0Y0_FrameData[30] Tile_X0Y1_FrameStrobe[8] VPWR VGND sg13cmos5l_dlhq_1
X_5759_ _5759_/Q Tile_X0Y0_FrameData[3] Tile_X0Y1_FrameStrobe[5] VPWR VGND sg13cmos5l_dlhq_1
XFILLER_1_324 VPWR VGND sg13cmos5l_decap_8
XFILLER_1_357 VPWR VGND sg13cmos5l_fill_1
XFILLER_103_263 VPWR VGND sg13cmos5l_fill_2
XANTENNA__6779__X Tile_X0Y1_S2BEGb[0] VPWR VGND sg13cmos5l_antennanp
XFILLER_4_151 VPWR VGND sg13cmos5l_fill_1
XFILLER_4_173 VPWR VGND sg13cmos5l_fill_2
X_3110_ _3111_/C _5688_/Q _3110_/B VPWR VGND sg13cmos5l_nand2_1
X_4090_ _4090_/Y _4090_/A _4090_/B VPWR VGND sg13cmos5l_nor2_1
X_3041_ _3041_/Y _6066_/Q _5422_/B VPWR VGND sg13cmos5l_nand2_1
X_6800_ Tile_X0Y1_S4BEG[13] _6800_/A VPWR VGND sg13cmos5l_buf_1
XFILLER_90_150 VPWR VGND sg13cmos5l_fill_1
X_4992_ _4992_/Y _2727_/Y _5670_/Q _5669_/Q VPWR VGND sg13cmos5l_a21oi_1
X_6731_ Tile_X0Y1_EE4BEG[12] _6731_/A VPWR VGND sg13cmos5l_buf_1
X_3943_ _3943_/Y _5854_/Q _3942_/Y _3940_/Y VPWR VGND sg13cmos5l_a21oi_1
X_6662_ Tile_X0Y0_W6BEG[3] Tile_X0Y0_W6END[5] VPWR VGND sg13cmos5l_buf_1
X_3874_ _3874_/Y _4137_/A _4477_/A _4570_/A _4138_/A VPWR VGND sg13cmos5l_a22oi_1
X_5613_ _5613_/Q Tile_X0Y0_FrameData[21] Tile_X0Y1_FrameStrobe[1] VPWR VGND sg13cmos5l_dlhq_1
X_2825_ _2825_/Y _6128_/Q VPWR VGND sg13cmos5l_inv_1
XFILLER_83_0 VPWR VGND sg13cmos5l_fill_1
XANTENNA__6689__X Tile_X0Y1_E1BEG[2] VPWR VGND sg13cmos5l_antennanp
X_6593_ Tile_X0Y0_N2BEG[3] _6593_/A VPWR VGND sg13cmos5l_buf_1
X_5544_ _5564_/D _5551_/A _5544_/B VPWR VGND sg13cmos5l_nor2_1
X_2756_ _2756_/Y Tile_X0Y0_S2END[5] VPWR VGND sg13cmos5l_inv_1
X_5475_ _5476_/C _6327_/Q _2891_/Y _5474_/Y VPWR VGND sg13cmos5l_a21oi_1
X_4426_ _4426_/Y _4426_/A VPWR VGND sg13cmos5l_inv_1
X_4357_ _4357_/Y _6244_/Q _6785_/A _6243_/Q VPWR VGND sg13cmos5l_o21ai_1
XFILLER_48_17 VPWR VGND sg13cmos5l_fill_1
X_4288_ _4288_/Y Tile_X0Y1_W2MID[0] _6238_/Q _6237_/Q VPWR VGND sg13cmos5l_o21ai_1
X_3308_ _3308_/Y _5724_/Q _5062_/B VPWR VGND sg13cmos5l_nand2_1
X_6027_ _6027_/Q Tile_X0Y1_FrameData[17] Tile_X0Y1_FrameStrobe[0] VPWR VGND sg13cmos5l_dlhq_1
X_3239_ _3245_/A _5693_/Q _3239_/B VPWR VGND sg13cmos5l_nor2_1
XANTENNA__6599__X Tile_X0Y0_N2BEGb[1] VPWR VGND sg13cmos5l_antennanp
XFILLER_108_377 VPWR VGND sg13cmos5l_decap_4
XFILLER_108_366 VPWR VGND sg13cmos5l_fill_2
XFILLER_108_355 VPWR VGND sg13cmos5l_decap_8
XFILLER_1_143 VPWR VGND sg13cmos5l_fill_1
X_3590_ _3596_/B _6163_/Q _3590_/B VPWR VGND sg13cmos5l_nor2_1
XFILLER_70_92 VPWR VGND sg13cmos5l_fill_1
X_5260_ _6670_/A _5865_/Q _5255_/Y _5259_/X VPWR VGND sg13cmos5l_o21ai_1
X_4211_ _4213_/B _4211_/A _4211_/B VPWR VGND sg13cmos5l_xnor2_1
X_5191_ _5191_/Y _5890_/Q _5191_/B VPWR VGND sg13cmos5l_nand2_1
X_4142_ _4201_/A _4143_/A _4143_/B VPWR VGND sg13cmos5l_nor2_1
X_4073_ _4073_/Y _4073_/A _5864_/Q VPWR VGND sg13cmos5l_nor2b_1
XFILLER_95_264 VPWR VGND sg13cmos5l_fill_1
X_3024_ _3024_/Y _5696_/Q _2890_/Y _5698_/Q VPWR VGND sg13cmos5l_a21oi_1
XFILLER_63_161 VPWR VGND sg13cmos5l_fill_1
X_4975_ _4975_/Y Tile_X0Y0_W1END[2] _5702_/Q VPWR VGND sg13cmos5l_nand2_1
X_6714_ Tile_X0Y1_E6BEG[7] Tile_X0Y1_E6END[9] VPWR VGND sg13cmos5l_buf_1
X_3926_ _3926_/Y _2748_/Y _5682_/Q _5681_/Q VPWR VGND sg13cmos5l_a21oi_1
XFILLER_11_209 VPWR VGND sg13cmos5l_fill_1
X_6645_ Tile_X0Y0_W2BEG[2] _6645_/A VPWR VGND sg13cmos5l_buf_1
X_3857_ _3857_/Y _6296_/Q _2916_/X _6295_/Q VPWR VGND sg13cmos5l_a21oi_1
X_6576_ Tile_X0Y0_FrameStrobe_O[10] Tile_X0Y1_FrameStrobe[10] VPWR VGND sg13cmos5l_buf_1
X_3788_ _3789_/A _4513_/A _4513_/B VPWR VGND sg13cmos5l_nor2b_1
X_2808_ _5524_/A _6270_/Q VPWR VGND sg13cmos5l_inv_1
X_5527_ _5528_/B Tile_X0Y1_W2MID[0] _6601_/A _6600_/A _6693_/A _6271_/Q _6272_/Q VPWR
+ VGND sg13cmos5l_mux4_1
X_2739_ _2739_/Y Tile_X0Y0_S2MID[4] VPWR VGND sg13cmos5l_inv_1
X_5458_ _5458_/Y _6330_/Q _4409_/B _5457_/Y VPWR VGND sg13cmos5l_a21oi_1
X_5389_ _5389_/Y _6364_/Q _3162_/Y _5388_/Y VPWR VGND sg13cmos5l_a21oi_1
X_4409_ _4409_/Y _6046_/Q _4409_/B VPWR VGND sg13cmos5l_nor2_1
XANTENNA__6792__X Tile_X0Y1_S4BEG[5] VPWR VGND sg13cmos5l_antennanp
XANTENNA_160 Tile_X0Y1_E2MID[7] VPWR VGND sg13cmos5l_antennanp
XANTENNA_171 Tile_X0Y1_NN4END[7] VPWR VGND sg13cmos5l_antennanp
XANTENNA_182 Tile_X0Y1_W2MID[3] VPWR VGND sg13cmos5l_antennanp
XANTENNA_193 Tile_X0Y1_W2MID[3] VPWR VGND sg13cmos5l_antennanp
X_4760_ _4760_/Y _5672_/Q Tile_X0Y0_E2END[7] VPWR VGND sg13cmos5l_nor2b_1
X_4691_ _4715_/A _4692_/A _4692_/B _4692_/C VPWR VGND sg13cmos5l_o21ai_1
X_3711_ _3712_/B _6264_/Q _6774_/A _3710_/Y VPWR VGND sg13cmos5l_a21oi_1
X_6430_ _6430_/L_HI VPWR VGND sg13cmos5l_tiehi
X_3642_ _3643_/A _3637_/Y _3639_/Y _3641_/X VPWR VGND sg13cmos5l_a21o_1
X_6361_ _6361_/Q Tile_X0Y1_FrameData[3] Tile_X0Y1_FrameStrobe[10] VPWR VGND sg13cmos5l_dlhq_1
X_5312_ _5312_/X _2791_/Y _3481_/Y _5311_/Y VPWR VGND sg13cmos5l_a21o_1
X_3573_ _3574_/A Tile_X0Y1_NN4END[0] Tile_X0Y1_E2END[2] Tile_X0Y0_S2MID[2] Tile_X0Y1_W2END[2]
+ _6202_/Q _6201_/Q VPWR VGND sg13cmos5l_mux4_1
X_6292_ _6292_/Q Tile_X0Y1_FrameData[8] Tile_X0Y1_FrameStrobe[8] VPWR VGND sg13cmos5l_dlhq_1
XFILLER_46_0 VPWR VGND sg13cmos5l_fill_2
X_5243_ _5243_/Y _5872_/Q _5243_/B VPWR VGND sg13cmos5l_nor2_1
X_5174_ _5174_/Y _5898_/Q _5058_/B _5173_/Y VPWR VGND sg13cmos5l_o21ai_1
X_4125_ _4125_/X _4125_/A _4125_/B VPWR VGND sg13cmos5l_and2_1
X_4056_ _4056_/Y _5718_/Q _4053_/X _5717_/Q VPWR VGND sg13cmos5l_a21oi_1
XFILLER_45_18 VPWR VGND sg13cmos5l_fill_1
X_3007_ _3008_/B _6166_/Q _3003_/Y _3006_/Y VPWR VGND sg13cmos5l_a21oi_1
XFILLER_83_289 VPWR VGND sg13cmos5l_fill_2
X_4958_ _4958_/Y _5604_/Q _2889_/Y _4957_/Y VPWR VGND sg13cmos5l_o21ai_1
XFILLER_61_17 VPWR VGND sg13cmos5l_fill_2
X_4889_ _4889_/Y _5610_/Q _4886_/X _5609_/Q VPWR VGND sg13cmos5l_o21ai_1
X_3909_ _3910_/B _3909_/A _3909_/B VPWR VGND sg13cmos5l_xnor2_1
X_6628_ Tile_X0Y0_NN4BEG[6] Tile_X0Y1_NN4END[14] VPWR VGND sg13cmos5l_buf_1
X_6559_ Tile_X0Y0_FrameData_O[25] Tile_X0Y0_FrameData[25] VPWR VGND sg13cmos5l_buf_1
XFILLER_3_227 VPWR VGND sg13cmos5l_fill_2
XFILLER_105_122 VPWR VGND sg13cmos5l_decap_4
XFILLER_59_264 VPWR VGND sg13cmos5l_fill_2
XFILLER_19_41 VPWR VGND sg13cmos5l_fill_2
XFILLER_15_345 VPWR VGND sg13cmos5l_decap_8
XANTENNA__6787__X Tile_X0Y1_S4BEG[0] VPWR VGND sg13cmos5l_antennanp
XFILLER_97_304 VPWR VGND sg13cmos5l_fill_1
XFILLER_111_103 VPWR VGND sg13cmos5l_fill_2
X_5930_ _5930_/Q Tile_X0Y0_FrameData[24] Tile_X0Y1_FrameStrobe[11] VPWR VGND sg13cmos5l_dlhq_1
XFILLER_65_278 VPWR VGND sg13cmos5l_decap_8
X_5861_ _5861_/Q Tile_X0Y0_FrameData[29] Tile_X0Y1_FrameStrobe[9] VPWR VGND sg13cmos5l_dlhq_1
X_5792_ _5792_/Q Tile_X0Y0_FrameData[2] Tile_X0Y1_FrameStrobe[6] VPWR VGND sg13cmos5l_dlhq_1
X_4812_ _4819_/B _4796_/Y _4797_/Y _4811_/X _5801_/Q _5840_/Q VPWR VGND sg13cmos5l_a221oi_1
X_4743_ _4745_/B Tile_X0Y0_E2MID[4] Tile_X0Y0_S2MID[4] Tile_X0Y0_W2MID[4] _6785_/A
+ _5798_/Q _5797_/Q VPWR VGND sg13cmos5l_mux4_1
X_6413_ _6413_/Q Tile_X0Y1_FrameData[15] Tile_X0Y1_FrameStrobe[12] VPWR VGND sg13cmos5l_dlhq_1
X_4674_ _4674_/Y _4674_/A _4674_/B VPWR VGND sg13cmos5l_nor2_1
X_3625_ _3625_/X _3626_/B _3138_/A _3624_/Y VPWR VGND sg13cmos5l_a21o_1
XANTENNA__6697__X Tile_X0Y1_E2BEG[6] VPWR VGND sg13cmos5l_antennanp
X_6344_ _6344_/Q Tile_X0Y1_FrameData[20] Tile_X0Y1_FrameStrobe[10] VPWR VGND sg13cmos5l_dlhq_1
X_3556_ _3556_/Y _2787_/Y _2825_/Y _6126_/Q VPWR VGND sg13cmos5l_a21oi_1
X_6275_ _6275_/Q Tile_X0Y1_FrameData[25] Tile_X0Y1_FrameStrobe[8] VPWR VGND sg13cmos5l_dlhq_1
X_5226_ _5227_/B _2783_/Y _5225_/Y _5876_/Q VPWR VGND sg13cmos5l_o21ai_1
X_3487_ _4205_/A _3484_/A _2850_/Y _6427_/Q VPWR VGND sg13cmos5l_mux2_1
XFILLER_88_326 VPWR VGND sg13cmos5l_decap_4
X_5157_ _6798_/A Tile_X0Y0_S2END[1] Tile_X0Y0_W6END[0] Tile_X0Y0_S4END[0] _4911_/X
+ _5905_/Q _5906_/Q VPWR VGND sg13cmos5l_mux4_1
XFILLER_96_370 VPWR VGND sg13cmos5l_fill_1
X_5088_ _5088_/Y _5730_/Q _5087_/Y _5727_/Q VPWR VGND sg13cmos5l_o21ai_1
X_4108_ _4197_/A _4471_/A _4571_/A VPWR VGND sg13cmos5l_nand2_1
XFILLER_56_234 VPWR VGND sg13cmos5l_decap_8
X_4039_ _4215_/A _4477_/A _4253_/A VPWR VGND sg13cmos5l_nand2_1
XFILLER_72_38 VPWR VGND sg13cmos5l_fill_1
XFILLER_24_175 VPWR VGND sg13cmos5l_fill_1
XFILLER_12_359 VPWR VGND sg13cmos5l_fill_2
XFILLER_12_348 VPWR VGND sg13cmos5l_decap_8
XANTENNA_60 Tile_X0Y0_E2MID[2] VPWR VGND sg13cmos5l_antennanp
XANTENNA_71 Tile_X0Y0_E2MID[4] VPWR VGND sg13cmos5l_antennanp
XANTENNA_82 Tile_X0Y0_E2MID[6] VPWR VGND sg13cmos5l_antennanp
XANTENNA_93 Tile_X0Y0_SS4END[3] VPWR VGND sg13cmos5l_antennanp
XFILLER_79_359 VPWR VGND sg13cmos5l_fill_1
XFILLER_47_278 VPWR VGND sg13cmos5l_fill_2
XFILLER_62_237 VPWR VGND sg13cmos5l_fill_2
XFILLER_62_226 VPWR VGND sg13cmos5l_fill_1
XFILLER_62_71 VPWR VGND sg13cmos5l_fill_2
XFILLER_30_145 VPWR VGND sg13cmos5l_fill_2
X_4390_ _5261_/B _4390_/A _4390_/B VPWR VGND sg13cmos5l_xor2_1
X_3410_ _3410_/X _5390_/B _5374_/B _6060_/Q VPWR VGND sg13cmos5l_mux2_1
X_3341_ _3341_/Y _6050_/Q _3340_/X _2858_/Y VPWR VGND sg13cmos5l_o21ai_1
X_6060_ _6060_/Q Tile_X0Y1_FrameData[16] Tile_X0Y1_FrameStrobe[1] VPWR VGND sg13cmos5l_dlhq_1
X_3272_ _3272_/X _4515_/Y _4509_/Y _5390_/B _5374_/B _6160_/Q _6158_/Q VPWR VGND sg13cmos5l_mux4_1
X_5011_ _5011_/X _5010_/Y _5567_/Q _6423_/Q VPWR VGND sg13cmos5l_mux2_1
X_5913_ _5913_/Q Tile_X0Y0_FrameData[9] Tile_X0Y1_FrameStrobe[10] VPWR VGND sg13cmos5l_dlhq_1
X_5844_ _5844_/Q Tile_X0Y0_FrameData[14] Tile_X0Y1_FrameStrobe[8] VPWR VGND sg13cmos5l_dlhq_1
X_5775_ _5775_/Q Tile_X0Y0_FrameData[19] Tile_X0Y1_FrameStrobe[6] VPWR VGND sg13cmos5l_dlhq_1
X_2987_ _2987_/Y _5620_/Q _2886_/Y _2986_/Y VPWR VGND sg13cmos5l_o21ai_1
X_4726_ _4727_/C _4719_/A _4708_/Y _4724_/A _4724_/B VPWR VGND sg13cmos5l_a22oi_1
X_4657_ _4659_/B _4657_/A _4657_/B VPWR VGND sg13cmos5l_xnor2_1
X_3608_ _3612_/A _6036_/Q _4769_/B _3607_/Y VPWR VGND sg13cmos5l_a21oi_1
X_6327_ _6327_/Q Tile_X0Y1_FrameData[5] Tile_X0Y1_FrameStrobe[9] VPWR VGND sg13cmos5l_dlhq_1
X_4588_ _4590_/B _4588_/A _4588_/B VPWR VGND sg13cmos5l_xor2_1
X_3539_ _3539_/Y _5656_/Q _4943_/Y VPWR VGND sg13cmos5l_nor2_1
XFILLER_107_56 VPWR VGND sg13cmos5l_decap_4
X_6258_ _6258_/Q Tile_X0Y1_FrameData[10] Tile_X0Y1_FrameStrobe[7] VPWR VGND sg13cmos5l_dlhq_1
XFILLER_88_134 VPWR VGND sg13cmos5l_fill_2
X_6189_ _6189_/Q Tile_X0Y1_FrameData[15] Tile_X0Y1_FrameStrobe[5] VPWR VGND sg13cmos5l_dlhq_1
X_5209_ _5209_/Y _5881_/Q _5209_/B VPWR VGND sg13cmos5l_nand2_1
XFILLER_8_116 VPWR VGND sg13cmos5l_fill_1
XFILLER_32_74 VPWR VGND sg13cmos5l_fill_2
XFILLER_57_71 VPWR VGND sg13cmos5l_decap_8
X_2910_ _2910_/Y _5662_/Q _2907_/X _2909_/Y VPWR VGND sg13cmos5l_o21ai_1
X_3890_ _3890_/X Tile_X0Y1_E6END[0] Tile_X0Y1_W6END[0] _6070_/Q VPWR VGND sg13cmos5l_mux2_1
X_2841_ _2905_/B _5661_/Q VPWR VGND sg13cmos5l_inv_1
X_5560_ _5560_/Q Tile_X0Y1_UserCLK _5560_/D _6472_/L_HI VPWR VGND sg13cmos5l_dfrbpq_1
X_2772_ _3195_/A Tile_X0Y0_W6END[0] VPWR VGND sg13cmos5l_inv_1
X_5491_ _5497_/A _6319_/Q _5491_/B VPWR VGND sg13cmos5l_nor2_1
X_4511_ _4511_/Y _6423_/Q _5557_/Q VPWR VGND sg13cmos5l_nand2_1
X_4442_ _4443_/A _4440_/Y _4441_/Y _6111_/Q VPWR VGND sg13cmos5l_o21ai_1
X_4373_ _4373_/Y _6019_/Q _4372_/Y _6286_/Q VPWR VGND sg13cmos5l_o21ai_1
X_6112_ _6112_/Q Tile_X0Y1_FrameData[28] Tile_X0Y1_FrameStrobe[3] VPWR VGND sg13cmos5l_dlhq_1
X_3324_ _3325_/A _2890_/Y _3185_/A _5197_/B _3323_/Y _5913_/Q _5914_/Q VPWR VGND sg13cmos5l_mux4_1
X_6043_ _6043_/Q Tile_X0Y1_FrameData[1] Tile_X0Y1_FrameStrobe[0] VPWR VGND sg13cmos5l_dlhq_1
X_3255_ _3255_/Y _5693_/Q _3254_/X _2833_/Y VPWR VGND sg13cmos5l_a21oi_1
XFILLER_58_318 VPWR VGND sg13cmos5l_fill_2
X_3186_ _3186_/X _4776_/B _4551_/A _2722_/Y _3185_/A _5592_/Q _5591_/Q VPWR VGND sg13cmos5l_mux4_1
X_5827_ _5827_/Q Tile_X0Y0_FrameData[31] Tile_X0Y1_FrameStrobe[8] VPWR VGND sg13cmos5l_dlhq_1
X_5758_ _5758_/Q Tile_X0Y0_FrameData[4] Tile_X0Y1_FrameStrobe[5] VPWR VGND sg13cmos5l_dlhq_1
X_4709_ _4710_/B _4709_/A _4709_/B VPWR VGND sg13cmos5l_nand2_1
X_5689_ _5689_/Q Tile_X0Y0_FrameData[9] Tile_X0Y1_FrameStrobe[3] VPWR VGND sg13cmos5l_dlhq_1
XFILLER_94_69 VPWR VGND sg13cmos5l_fill_2
XANTENNA__6795__X Tile_X0Y1_S4BEG[8] VPWR VGND sg13cmos5l_antennanp
X_3040_ _3040_/X _4515_/Y _4509_/Y _5390_/B _5374_/B _6068_/Q _6066_/Q VPWR VGND sg13cmos5l_mux4_1
X_6730_ Tile_X0Y1_EE4BEG[11] Tile_X0Y1_EE4END[15] VPWR VGND sg13cmos5l_buf_1
X_4991_ _4991_/X _5058_/B Tile_X0Y0_E1END[0] Tile_X0Y1_N2MID[0] Tile_X0Y0_E2END[0]
+ _5669_/Q _5670_/Q VPWR VGND sg13cmos5l_mux4_1
X_3942_ _3942_/Y _5204_/B VPWR VGND sg13cmos5l_inv_1
X_6661_ Tile_X0Y0_W6BEG[2] Tile_X0Y0_W6END[4] VPWR VGND sg13cmos5l_buf_1
X_3873_ _4218_/A _4138_/A _4137_/A _4477_/A _4570_/A VPWR VGND sg13cmos5l_nand4_1
X_5612_ _5612_/Q Tile_X0Y0_FrameData[22] Tile_X0Y1_FrameStrobe[1] VPWR VGND sg13cmos5l_dlhq_1
X_6592_ Tile_X0Y0_N2BEG[2] _6592_/A VPWR VGND sg13cmos5l_buf_1
X_2824_ _3189_/A _5685_/Q VPWR VGND sg13cmos5l_inv_1
X_5543_ _5563_/D _5551_/A _5543_/B VPWR VGND sg13cmos5l_nor2_1
XFILLER_76_0 VPWR VGND sg13cmos5l_fill_1
X_2755_ _2755_/Y Tile_X0Y0_E6END[1] VPWR VGND sg13cmos5l_inv_1
X_5474_ _5474_/Y Tile_X0Y1_W1END[3] _6327_/Q _6326_/Q VPWR VGND sg13cmos5l_o21ai_1
X_4425_ _4426_/A _3208_/Y Tile_X0Y1_W1END[0] Tile_X0Y0_S2MID[0] Tile_X0Y1_W1END[2]
+ _6079_/Q _6080_/Q VPWR VGND sg13cmos5l_mux4_1
X_4356_ _4380_/A _6425_/Q _5556_/Q VPWR VGND sg13cmos5l_nand2_1
X_3307_ _3311_/B _5724_/Q _4911_/X _3306_/Y VPWR VGND sg13cmos5l_o21ai_1
X_4287_ _4301_/A _6280_/Q _4284_/A _4286_/Y VPWR VGND sg13cmos5l_a21oi_1
X_6026_ _6026_/Q Tile_X0Y1_FrameData[18] Tile_X0Y1_FrameStrobe[0] VPWR VGND sg13cmos5l_dlhq_1
X_3238_ _3239_/B _4940_/Y _4707_/Y _5011_/X _4937_/Y _5694_/Q _5692_/Q VPWR VGND sg13cmos5l_mux4_1
X_3169_ _3169_/Y _6420_/Q _3168_/A _6419_/Q VPWR VGND sg13cmos5l_o21ai_1
XFILLER_54_310 VPWR VGND sg13cmos5l_fill_2
X_6859_ Tile_X0Y1_WW4BEG[7] Tile_X0Y1_WW4END[11] VPWR VGND sg13cmos5l_buf_1
XFILLER_13_10 VPWR VGND sg13cmos5l_fill_2
XFILLER_108_334 VPWR VGND sg13cmos5l_decap_8
XFILLER_38_84 VPWR VGND sg13cmos5l_fill_2
XFILLER_60_324 VPWR VGND sg13cmos5l_fill_2
XFILLER_60_379 VPWR VGND sg13cmos5l_fill_2
X_4210_ _4211_/B _4210_/A _4210_/B VPWR VGND sg13cmos5l_xnor2_1
X_5190_ _5190_/X _5890_/Q _3099_/Y _5189_/Y VPWR VGND sg13cmos5l_a21o_1
X_4141_ _4143_/B _4192_/A _4141_/B VPWR VGND sg13cmos5l_or2_1
X_4072_ _4073_/A _2751_/Y _5794_/Q _4071_/Y VPWR VGND sg13cmos5l_a21oi_1
XFILLER_95_254 VPWR VGND sg13cmos5l_decap_4
X_3023_ _3023_/X _4934_/Y _4707_/Y _5011_/X _4937_/Y _5698_/Q _5696_/Q VPWR VGND sg13cmos5l_mux4_1
X_4974_ _4974_/Y Tile_X0Y0_S1END[0] _5702_/Q _4973_/Y VPWR VGND sg13cmos5l_o21ai_1
XFILLER_51_346 VPWR VGND sg13cmos5l_fill_1
X_6713_ Tile_X0Y1_E6BEG[6] Tile_X0Y1_E6END[8] VPWR VGND sg13cmos5l_buf_1
X_3925_ _3925_/X _3172_/Y Tile_X0Y0_E1END[1] Tile_X0Y1_N2MID[5] Tile_X0Y0_E2END[5]
+ _5681_/Q _5682_/Q VPWR VGND sg13cmos5l_mux4_1
XFILLER_51_379 VPWR VGND sg13cmos5l_fill_2
X_6644_ Tile_X0Y0_W2BEG[1] _6644_/A VPWR VGND sg13cmos5l_buf_1
X_3856_ _3856_/Y _3852_/Y _3853_/Y _3855_/Y VPWR VGND sg13cmos5l_o21ai_1
X_6575_ Tile_X0Y0_FrameStrobe_O[9] Tile_X0Y1_FrameStrobe[9] VPWR VGND sg13cmos5l_buf_1
X_3787_ _4513_/B _3787_/A _3787_/B VPWR VGND sg13cmos5l_nand2_1
X_2807_ _5522_/B _6271_/Q VPWR VGND sg13cmos5l_inv_1
X_5526_ _5526_/Y _5522_/Y _5524_/Y _5525_/X _5524_/A VPWR VGND sg13cmos5l_a22oi_1
X_2738_ _2738_/Y Tile_X0Y0_W2MID[4] VPWR VGND sg13cmos5l_inv_1
X_5457_ _5457_/Y Tile_X0Y1_W1END[2] _6330_/Q VPWR VGND sg13cmos5l_nor2_1
X_4408_ _4408_/Y _6046_/Q _2891_/Y _4407_/Y VPWR VGND sg13cmos5l_o21ai_1
XFILLER_105_348 VPWR VGND sg13cmos5l_decap_8
X_5388_ _5388_/Y _6364_/Q _6691_/A _6363_/Q VPWR VGND sg13cmos5l_o21ai_1
X_4339_ _4340_/B _4339_/A _5342_/B VPWR VGND sg13cmos5l_nor2_1
X_6009_ _6009_/Q Tile_X0Y1_UserCLK _6009_/D _6463_/L_HI VPWR VGND sg13cmos5l_dfrbpq_1
XFILLER_42_379 VPWR VGND sg13cmos5l_fill_2
XFILLER_42_357 VPWR VGND sg13cmos5l_fill_1
XFILLER_1_35 VPWR VGND sg13cmos5l_decap_8
XFILLER_1_68 VPWR VGND sg13cmos5l_fill_1
XANTENNA_150 Tile_X0Y1_E2MID[3] VPWR VGND sg13cmos5l_antennanp
XANTENNA_161 Tile_X0Y1_N4END[3] VPWR VGND sg13cmos5l_antennanp
XANTENNA_172 Tile_X0Y1_W2END[0] VPWR VGND sg13cmos5l_antennanp
XANTENNA_183 Tile_X0Y1_W2MID[3] VPWR VGND sg13cmos5l_antennanp
XANTENNA_194 Tile_X0Y1_W2MID[3] VPWR VGND sg13cmos5l_antennanp
XFILLER_33_379 VPWR VGND sg13cmos5l_fill_2
X_3710_ _3710_/Y _6264_/Q Tile_X0Y1_W2MID[4] VPWR VGND sg13cmos5l_nor2b_1
X_4690_ _4692_/C _4714_/A _4690_/B VPWR VGND sg13cmos5l_and2_1
X_3641_ _3641_/X _3641_/A _3641_/B VPWR VGND sg13cmos5l_and2_1
X_6360_ _6360_/Q Tile_X0Y1_FrameData[4] Tile_X0Y1_FrameStrobe[10] VPWR VGND sg13cmos5l_dlhq_1
X_3572_ _6694_/A _6125_/Q _3571_/X _3564_/Y VPWR VGND sg13cmos5l_a21o_1
X_5311_ _5311_/Y _2791_/Y _4375_/B _6385_/Q VPWR VGND sg13cmos5l_o21ai_1
X_6291_ _6291_/Q Tile_X0Y1_FrameData[9] Tile_X0Y1_FrameStrobe[8] VPWR VGND sg13cmos5l_dlhq_1
X_5242_ _5242_/Y _5871_/Q _5238_/X _5241_/Y VPWR VGND sg13cmos5l_o21ai_1
X_5173_ _5173_/Y _2764_/Y _5898_/Q _5897_/Q VPWR VGND sg13cmos5l_a21oi_1
XFILLER_39_0 VPWR VGND sg13cmos5l_fill_1
X_4124_ _4125_/B _2757_/Y _5814_/Q _5813_/Q VPWR VGND sg13cmos5l_a21oi_1
X_4055_ _4055_/Y _5716_/Q _5011_/X _4054_/Y VPWR VGND sg13cmos5l_a21oi_1
XFILLER_83_257 VPWR VGND sg13cmos5l_fill_1
X_3006_ _3006_/Y _6166_/Q _3005_/Y _6167_/Q VPWR VGND sg13cmos5l_o21ai_1
XFILLER_51_110 VPWR VGND sg13cmos5l_fill_1
XFILLER_51_132 VPWR VGND sg13cmos5l_fill_2
X_4957_ _4957_/Y _5604_/Q _5009_/Y VPWR VGND sg13cmos5l_nand2_1
X_4888_ _4888_/Y Tile_X0Y0_W1END[3] _5608_/Q _4887_/Y VPWR VGND sg13cmos5l_a21oi_1
X_3908_ _3908_/Y _3909_/A _3909_/B VPWR VGND sg13cmos5l_nor2b_1
X_6627_ Tile_X0Y0_NN4BEG[5] Tile_X0Y1_NN4END[13] VPWR VGND sg13cmos5l_buf_1
X_3839_ _3839_/Y _2883_/Y _3838_/X _6288_/Q VPWR VGND sg13cmos5l_a21oi_1
X_6558_ Tile_X0Y0_FrameData_O[24] Tile_X0Y0_FrameData[24] VPWR VGND sg13cmos5l_buf_1
X_5509_ _5509_/Y _6317_/Q _5508_/Y _6315_/Q VPWR VGND sg13cmos5l_a21oi_1
X_6489_ Tile_X0Y0_E1BEG[3] _6489_/A VPWR VGND sg13cmos5l_buf_1
XFILLER_59_221 VPWR VGND sg13cmos5l_decap_8
XFILLER_59_232 VPWR VGND sg13cmos5l_fill_2
XFILLER_19_53 VPWR VGND sg13cmos5l_fill_1
XFILLER_101_362 VPWR VGND sg13cmos5l_decap_4
XFILLER_76_70 VPWR VGND sg13cmos5l_fill_2
X_5860_ _5860_/Q Tile_X0Y0_FrameData[30] Tile_X0Y1_FrameStrobe[9] VPWR VGND sg13cmos5l_dlhq_1
X_4811_ _4811_/X Tile_X0Y0_S2MID[6] _6596_/A _5802_/Q VPWR VGND sg13cmos5l_mux2_1
X_5791_ _5791_/Q Tile_X0Y0_FrameData[3] Tile_X0Y1_FrameStrobe[6] VPWR VGND sg13cmos5l_dlhq_1
X_4742_ _4746_/B _4737_/Y _4738_/Y _4741_/Y VPWR VGND sg13cmos5l_a21oi_1
X_4673_ _4674_/B _5774_/Q _2742_/Y _4672_/Y VPWR VGND sg13cmos5l_a21oi_1
X_6412_ _6412_/Q Tile_X0Y1_FrameData[16] Tile_X0Y1_FrameStrobe[12] VPWR VGND sg13cmos5l_dlhq_1
X_3624_ _3624_/Y _3626_/B Tile_X0Y1_W2MID[7] _6227_/Q VPWR VGND sg13cmos5l_o21ai_1
X_6343_ _6343_/Q Tile_X0Y1_FrameData[21] Tile_X0Y1_FrameStrobe[10] VPWR VGND sg13cmos5l_dlhq_1
X_3555_ _3555_/X Tile_X0Y1_E6END[0] Tile_X0Y0_S2MID[4] _6128_/Q VPWR VGND sg13cmos5l_mux2_1
X_6274_ _6274_/Q Tile_X0Y1_FrameData[26] Tile_X0Y1_FrameStrobe[8] VPWR VGND sg13cmos5l_dlhq_1
X_3486_ _4247_/A _6427_/Q _3484_/A _3485_/Y VPWR VGND sg13cmos5l_o21ai_1
X_5225_ _5225_/Y _5878_/Q _5180_/B _5224_/Y VPWR VGND sg13cmos5l_o21ai_1
X_5156_ _6797_/A Tile_X0Y0_S2END[0] Tile_X0Y0_S4END[3] Tile_X0Y0_W6END[1] _4707_/Y
+ _5908_/Q _5907_/Q VPWR VGND sg13cmos5l_mux4_1
X_5087_ _5087_/Y _5728_/Q _5011_/X _5086_/Y VPWR VGND sg13cmos5l_a21oi_1
X_4107_ _4112_/A _4261_/A _4602_/A VPWR VGND sg13cmos5l_nor2_1
XFILLER_56_246 VPWR VGND sg13cmos5l_fill_1
X_4038_ _4038_/Y _4138_/A _4570_/A _4038_/C VPWR VGND sg13cmos5l_nand3_1
X_5989_ _5989_/Q Tile_X0Y1_UserCLK _5989_/D _6443_/L_HI VPWR VGND sg13cmos5l_dfrbpq_1
XANTENNA_50 Tile_X0Y0_E2MID[2] VPWR VGND sg13cmos5l_antennanp
XANTENNA_61 Tile_X0Y0_E2MID[2] VPWR VGND sg13cmos5l_antennanp
XANTENNA_72 Tile_X0Y0_E2MID[4] VPWR VGND sg13cmos5l_antennanp
XANTENNA_83 Tile_X0Y0_E2MID[6] VPWR VGND sg13cmos5l_antennanp
XANTENNA_94 Tile_X0Y0_SS4END[3] VPWR VGND sg13cmos5l_antennanp
XFILLER_30_168 VPWR VGND sg13cmos5l_decap_4
XFILLER_7_342 VPWR VGND sg13cmos5l_decap_8
XANTENNA__6798__X Tile_X0Y1_S4BEG[11] VPWR VGND sg13cmos5l_antennanp
XFILLER_7_375 VPWR VGND sg13cmos5l_decap_4
X_3340_ _3340_/X Tile_X0Y1_N1END[3] Tile_X0Y1_E1END[3] Tile_X0Y1_N2END[7] Tile_X0Y1_E2END[7]
+ _6051_/Q _6052_/Q VPWR VGND sg13cmos5l_mux4_1
X_5010_ _5010_/Y _5010_/A _5010_/B VPWR VGND sg13cmos5l_xnor2_1
X_3271_ _3271_/Y _6160_/Q _3269_/Y _3270_/Y VPWR VGND sg13cmos5l_a21oi_1
XFILLER_85_308 VPWR VGND sg13cmos5l_fill_2
XFILLER_87_91 VPWR VGND sg13cmos5l_fill_1
X_5912_ _5912_/Q Tile_X0Y0_FrameData[10] Tile_X0Y1_FrameStrobe[10] VPWR VGND sg13cmos5l_dlhq_1
X_5843_ _5843_/Q Tile_X0Y0_FrameData[15] Tile_X0Y1_FrameStrobe[8] VPWR VGND sg13cmos5l_dlhq_1
X_5774_ _5774_/Q Tile_X0Y0_FrameData[20] Tile_X0Y1_FrameStrobe[6] VPWR VGND sg13cmos5l_dlhq_1
X_2986_ _2986_/Y _5620_/Q _5009_/Y VPWR VGND sg13cmos5l_nand2_1
X_4725_ _4727_/B _4824_/A _4824_/B VPWR VGND sg13cmos5l_or2_1
X_4656_ _4659_/A _4656_/A _4656_/B VPWR VGND sg13cmos5l_nand2_1
XANTENNA__6501__X Tile_X0Y0_E2BEGb[3] VPWR VGND sg13cmos5l_antennanp
X_4587_ _4588_/B _4587_/A _4587_/B VPWR VGND sg13cmos5l_xnor2_1
X_3607_ _3607_/Y Tile_X0Y1_WW4END[2] _6036_/Q _6035_/Q VPWR VGND sg13cmos5l_o21ai_1
X_6326_ _6326_/Q Tile_X0Y1_FrameData[6] Tile_X0Y1_FrameStrobe[9] VPWR VGND sg13cmos5l_dlhq_1
X_3538_ _3538_/Y _5656_/Q _2890_/Y _3537_/Y VPWR VGND sg13cmos5l_a21oi_1
XFILLER_107_35 VPWR VGND sg13cmos5l_decap_8
X_6257_ _6257_/Q Tile_X0Y1_FrameData[11] Tile_X0Y1_FrameStrobe[7] VPWR VGND sg13cmos5l_dlhq_1
X_3469_ _3470_/B _6426_/Q _5996_/D _3468_/Y VPWR VGND sg13cmos5l_o21ai_1
X_6188_ _6188_/Q Tile_X0Y1_FrameData[16] Tile_X0Y1_FrameStrobe[5] VPWR VGND sg13cmos5l_dlhq_1
X_5208_ _6683_/A _5208_/A _5208_/B VPWR VGND sg13cmos5l_nor2_1
X_5139_ _5139_/Y _5927_/Q _5137_/X _5138_/Y VPWR VGND sg13cmos5l_a21oi_1
XFILLER_8_139 VPWR VGND sg13cmos5l_fill_1
XFILLER_106_0 VPWR VGND sg13cmos5l_fill_1
XFILLER_90_300 VPWR VGND sg13cmos5l_fill_1
X_2840_ _2926_/B _6129_/Q VPWR VGND sg13cmos5l_inv_1
X_2771_ _2771_/Y Tile_X0Y0_W6END[1] VPWR VGND sg13cmos5l_inv_1
X_5490_ _5491_/B Tile_X0Y1_N1END[1] Tile_X0Y1_W1END[1] _3217_/Y _5390_/B _6320_/Q
+ _6321_/Q VPWR VGND sg13cmos5l_mux4_1
X_4510_ _5537_/B _4510_/A _4510_/B VPWR VGND sg13cmos5l_xnor2_1
X_4441_ _4441_/Y _6112_/Q _5374_/B _6110_/Q VPWR VGND sg13cmos5l_o21ai_1
X_6111_ _6111_/Q Tile_X0Y1_FrameData[29] Tile_X0Y1_FrameStrobe[3] VPWR VGND sg13cmos5l_dlhq_1
X_4372_ _4372_/Y Tile_X0Y1_EE4END[0] _6020_/Q _4371_/Y VPWR VGND sg13cmos5l_a21oi_1
X_3323_ _3323_/Y _5601_/Q _3319_/X _3322_/Y VPWR VGND sg13cmos5l_o21ai_1
X_6042_ _6042_/Q Tile_X0Y1_FrameData[2] Tile_X0Y1_FrameStrobe[0] VPWR VGND sg13cmos5l_dlhq_1
X_3254_ _3254_/X Tile_X0Y0_W2END[2] Tile_X0Y0_WW4END[3] _5694_/Q VPWR VGND sg13cmos5l_mux2_1
X_3185_ _6492_/A _3185_/A VPWR VGND sg13cmos5l_inv_1
X_5826_ _5826_/Q Tile_X0Y0_FrameData[0] Tile_X0Y1_FrameStrobe[7] VPWR VGND sg13cmos5l_dlhq_1
X_5757_ _5757_/Q Tile_X0Y0_FrameData[5] Tile_X0Y1_FrameStrobe[5] VPWR VGND sg13cmos5l_dlhq_1
X_2969_ _2971_/B _6170_/Q _2967_/X _2968_/Y VPWR VGND sg13cmos5l_a21oi_1
X_4708_ _4708_/Y _4708_/A _4709_/B VPWR VGND sg13cmos5l_nor2b_1
X_5688_ _5688_/Q Tile_X0Y0_FrameData[10] Tile_X0Y1_FrameStrobe[3] VPWR VGND sg13cmos5l_dlhq_1
X_4639_ _4639_/Y _5709_/Q _4639_/B VPWR VGND sg13cmos5l_nand2b_1
X_6309_ _6309_/Q Tile_X0Y1_FrameData[23] Tile_X0Y1_FrameStrobe[9] VPWR VGND sg13cmos5l_dlhq_1
XFILLER_49_308 VPWR VGND sg13cmos5l_decap_8
XFILLER_48_352 VPWR VGND sg13cmos5l_fill_2
X_4990_ _4990_/Y _4988_/Y _4989_/Y _5667_/Q VPWR VGND sg13cmos5l_o21ai_1
X_3941_ _5204_/B _6601_/A Tile_X0Y0_S2MID[3] Tile_X0Y0_E2MID[3] Tile_X0Y0_W2MID[3]
+ _5783_/Q _5784_/Q VPWR VGND sg13cmos5l_mux4_1
X_6660_ Tile_X0Y0_W6BEG[1] Tile_X0Y0_W6END[3] VPWR VGND sg13cmos5l_buf_1
X_3872_ _4007_/A _4137_/A _4570_/A VPWR VGND sg13cmos5l_and2_1
X_5611_ _5611_/Q Tile_X0Y0_FrameData[23] Tile_X0Y1_FrameStrobe[1] VPWR VGND sg13cmos5l_dlhq_1
X_6591_ Tile_X0Y0_N2BEG[1] _6591_/A VPWR VGND sg13cmos5l_buf_1
X_2823_ _3195_/B _5684_/Q VPWR VGND sg13cmos5l_inv_1
X_5542_ _5562_/D _5551_/A _5542_/B VPWR VGND sg13cmos5l_nor2_1
X_2754_ _2754_/Y _6009_/Q VPWR VGND sg13cmos5l_inv_1
XFILLER_69_0 VPWR VGND sg13cmos5l_fill_1
X_5473_ _5476_/B _6327_/Q _3325_/A _5472_/Y VPWR VGND sg13cmos5l_a21oi_1
X_4424_ _4424_/Y _4424_/A _4424_/B VPWR VGND sg13cmos5l_nor2_1
X_4355_ _4355_/Y _4386_/A _4386_/B VPWR VGND sg13cmos5l_nand2_1
X_3306_ _3306_/Y _5724_/Q _2890_/Y _5726_/Q VPWR VGND sg13cmos5l_a21oi_1
X_4286_ _4286_/Y _6280_/Q _4285_/X _6279_/Q VPWR VGND sg13cmos5l_o21ai_1
X_6025_ _6025_/Q Tile_X0Y1_FrameData[19] Tile_X0Y1_FrameStrobe[0] VPWR VGND sg13cmos5l_dlhq_1
X_3237_ _3237_/Y _3233_/Y _3237_/B VPWR VGND sg13cmos5l_nand2b_1
X_3168_ _3168_/Y _3168_/A VPWR VGND sg13cmos5l_inv_1
XFILLER_104_58 VPWR VGND sg13cmos5l_fill_2
X_3099_ _3099_/Y _3099_/A _3099_/B VPWR VGND sg13cmos5l_nor2_1
XFILLER_54_366 VPWR VGND sg13cmos5l_fill_2
X_6858_ Tile_X0Y1_WW4BEG[6] Tile_X0Y1_WW4END[10] VPWR VGND sg13cmos5l_buf_1
X_5809_ _5809_/Q Tile_X0Y0_FrameData[17] Tile_X0Y1_FrameStrobe[7] VPWR VGND sg13cmos5l_dlhq_1
XFILLER_13_33 VPWR VGND sg13cmos5l_fill_2
X_6789_ Tile_X0Y1_S4BEG[2] Tile_X0Y0_S4END[10] VPWR VGND sg13cmos5l_buf_1
XFILLER_13_66 VPWR VGND sg13cmos5l_fill_2
XFILLER_89_296 VPWR VGND sg13cmos5l_fill_1
XFILLER_45_300 VPWR VGND sg13cmos5l_fill_1
X_4140_ _4141_/B _4137_/A _4681_/A _4189_/A VPWR VGND sg13cmos5l_a21oi_1
X_4071_ _4071_/Y Tile_X0Y0_S2MID[7] _5794_/Q _5793_/Q VPWR VGND sg13cmos5l_o21ai_1
X_3022_ _5985_/D _3019_/Y _3021_/Y _3013_/Y VPWR VGND sg13cmos5l_o21ai_1
XFILLER_55_119 VPWR VGND sg13cmos5l_fill_1
XFILLER_55_108 VPWR VGND sg13cmos5l_decap_8
X_4973_ _4973_/Y _2709_/Y _5702_/Q _5701_/Q VPWR VGND sg13cmos5l_a21oi_1
X_6712_ Tile_X0Y1_E6BEG[5] Tile_X0Y1_E6END[7] VPWR VGND sg13cmos5l_buf_1
X_3924_ _3933_/A _3924_/A _3924_/B VPWR VGND sg13cmos5l_nor2_1
X_6643_ Tile_X0Y0_W2BEG[0] Tile_X0Y0_W2END[0] VPWR VGND sg13cmos5l_buf_1
X_3855_ _3855_/Y _2873_/Y _3854_/X _6296_/Q VPWR VGND sg13cmos5l_a21oi_1
X_6574_ Tile_X0Y0_FrameStrobe_O[8] Tile_X0Y1_FrameStrobe[8] VPWR VGND sg13cmos5l_buf_1
X_3786_ _3787_/B _6426_/Q _5994_/D _3785_/Y VPWR VGND sg13cmos5l_o21ai_1
X_2806_ _5518_/A _6312_/Q VPWR VGND sg13cmos5l_inv_1
X_5525_ _5525_/X _6774_/A _6694_/A _6826_/A _6773_/A _5522_/B _6272_/Q VPWR VGND sg13cmos5l_mux4_1
X_2737_ _4320_/A Tile_X0Y1_N2MID[5] VPWR VGND sg13cmos5l_inv_1
X_5456_ _5456_/Y _2787_/Y _2802_/Y _6329_/Q VPWR VGND sg13cmos5l_a21oi_1
X_4407_ _4407_/Y _6046_/Q _5440_/B VPWR VGND sg13cmos5l_nand2_1
X_5387_ _6691_/A _5387_/A _5387_/B VPWR VGND sg13cmos5l_nand2_1
X_4338_ _5342_/B Tile_X0Y1_N2MID[3] Tile_X0Y1_E2MID[3] _6782_/A Tile_X0Y1_W2MID[3]
+ _6210_/Q _6209_/Q VPWR VGND sg13cmos5l_mux4_1
X_4269_ _4269_/Y _4270_/A _4270_/B VPWR VGND sg13cmos5l_nand2b_1
X_6008_ _6008_/Q Tile_X0Y1_UserCLK _6008_/D _6462_/L_HI VPWR VGND sg13cmos5l_dfrbpq_1
XFILLER_27_333 VPWR VGND sg13cmos5l_fill_2
XFILLER_42_336 VPWR VGND sg13cmos5l_fill_2
XFILLER_42_314 VPWR VGND sg13cmos5l_decap_4
XFILLER_1_14 VPWR VGND sg13cmos5l_decap_8
XANTENNA_140 Tile_X0Y0_WW4END[2] VPWR VGND sg13cmos5l_antennanp
XANTENNA_151 Tile_X0Y1_E2MID[3] VPWR VGND sg13cmos5l_antennanp
XANTENNA_162 Tile_X0Y1_N4END[3] VPWR VGND sg13cmos5l_antennanp
XANTENNA_173 Tile_X0Y1_W2END[0] VPWR VGND sg13cmos5l_antennanp
XANTENNA_184 Tile_X0Y1_W2MID[3] VPWR VGND sg13cmos5l_antennanp
XANTENNA_195 Tile_X0Y1_W2MID[3] VPWR VGND sg13cmos5l_antennanp
X_3640_ _3641_/B Tile_X0Y1_N2MID[4] Tile_X0Y1_E2MID[4] _6256_/Q VPWR VGND sg13cmos5l_mux2_1
X_3571_ _3571_/X _3570_/X _3569_/X _3566_/Y _3568_/Y _6128_/Q _6127_/Q VPWR VGND sg13cmos5l_mux4_1
X_6290_ _6290_/Q Tile_X0Y1_FrameData[10] Tile_X0Y1_FrameStrobe[8] VPWR VGND sg13cmos5l_dlhq_1
X_5310_ _5310_/Y _6386_/Q _5374_/B _5309_/Y VPWR VGND sg13cmos5l_o21ai_1
X_5241_ _5241_/Y _5871_/Q _5240_/Y _5869_/Q VPWR VGND sg13cmos5l_a21oi_1
X_5172_ _6812_/A _5171_/X _5170_/Y _5899_/Q VPWR VGND sg13cmos5l_mux2_1
X_4123_ _4125_/A _5814_/Q _4123_/B _4123_/C VPWR VGND sg13cmos5l_nand3b_1
XFILLER_110_341 VPWR VGND sg13cmos5l_fill_1
XFILLER_110_330 VPWR VGND sg13cmos5l_fill_1
X_4054_ _4054_/Y _5716_/Q _4940_/Y VPWR VGND sg13cmos5l_nor2b_1
XFILLER_83_203 VPWR VGND sg13cmos5l_fill_2
XFILLER_68_266 VPWR VGND sg13cmos5l_fill_1
X_3005_ _3005_/Y _3888_/A _6168_/Q _3004_/Y VPWR VGND sg13cmos5l_a21oi_1
XFILLER_36_163 VPWR VGND sg13cmos5l_fill_2
XANTENNA__6504__X Tile_X0Y0_E2BEGb[6] VPWR VGND sg13cmos5l_antennanp
X_4956_ _4956_/X _4940_/Y _4934_/Y _4943_/Y _5011_/X _5606_/Q _5604_/Q VPWR VGND sg13cmos5l_mux4_1
XFILLER_51_166 VPWR VGND sg13cmos5l_fill_2
X_4887_ _4887_/Y _5608_/Q Tile_X0Y0_E2END[7] VPWR VGND sg13cmos5l_nor2b_1
X_3907_ _3909_/B _3725_/A _3725_/B _3723_/Y VPWR VGND sg13cmos5l_o21ai_1
X_6626_ Tile_X0Y0_NN4BEG[4] Tile_X0Y1_NN4END[12] VPWR VGND sg13cmos5l_buf_1
X_3838_ _3838_/X Tile_X0Y1_E2MID[0] _6779_/A _6246_/Q VPWR VGND sg13cmos5l_mux2_1
X_6557_ Tile_X0Y0_FrameData_O[23] Tile_X0Y0_FrameData[23] VPWR VGND sg13cmos5l_buf_1
X_5508_ _5508_/Y _5508_/A VPWR VGND sg13cmos5l_inv_1
X_3769_ _3787_/A _6425_/Q _5552_/Q VPWR VGND sg13cmos5l_nand2_1
X_6488_ Tile_X0Y0_E1BEG[2] _6488_/A VPWR VGND sg13cmos5l_buf_1
X_5439_ _5439_/X _2891_/Y _2892_/Y _6106_/Q VPWR VGND sg13cmos5l_mux2_1
XFILLER_59_266 VPWR VGND sg13cmos5l_fill_1
XFILLER_101_374 VPWR VGND sg13cmos5l_decap_8
XFILLER_59_299 VPWR VGND sg13cmos5l_fill_1
XFILLER_19_87 VPWR VGND sg13cmos5l_fill_2
XFILLER_27_152 VPWR VGND sg13cmos5l_fill_2
XFILLER_15_325 VPWR VGND sg13cmos5l_decap_8
XFILLER_30_317 VPWR VGND sg13cmos5l_fill_1
XFILLER_23_380 VPWR VGND sg13cmos5l_fill_1
XFILLER_51_85 VPWR VGND sg13cmos5l_fill_1
XFILLER_111_105 VPWR VGND sg13cmos5l_fill_1
XFILLER_73_280 VPWR VGND sg13cmos5l_fill_1
X_4810_ _6596_/A _5703_/Q _4801_/Y _4803_/Y _4809_/Y VPWR VGND sg13cmos5l_a22oi_1
X_5790_ _5790_/Q Tile_X0Y0_FrameData[4] Tile_X0Y1_FrameStrobe[6] VPWR VGND sg13cmos5l_dlhq_1
X_4741_ _4741_/Y _4739_/Y _4740_/Y _5836_/Q VPWR VGND sg13cmos5l_o21ai_1
XFILLER_14_380 VPWR VGND sg13cmos5l_fill_1
X_4672_ _4672_/Y _5774_/Q Tile_X0Y0_S2MID[5] _5773_/Q VPWR VGND sg13cmos5l_o21ai_1
X_6411_ _6411_/Q Tile_X0Y1_FrameData[17] Tile_X0Y1_FrameStrobe[12] VPWR VGND sg13cmos5l_dlhq_1
X_3623_ _3623_/X _3617_/Y _3619_/Y _3622_/Y VPWR VGND sg13cmos5l_a21o_1
X_6342_ _6342_/Q Tile_X0Y1_FrameData[22] Tile_X0Y1_FrameStrobe[10] VPWR VGND sg13cmos5l_dlhq_1
X_3554_ _6781_/A _3553_/Y _3545_/X _5655_/Q VPWR VGND sg13cmos5l_mux2_1
XFILLER_51_0 VPWR VGND sg13cmos5l_fill_2
X_6273_ _6273_/Q Tile_X0Y1_FrameData[27] Tile_X0Y1_FrameStrobe[8] VPWR VGND sg13cmos5l_dlhq_1
X_3485_ _3485_/Y _6427_/Q _5987_/Q VPWR VGND sg13cmos5l_nand2_1
X_5224_ _5224_/Y _4118_/X _5878_/Q VPWR VGND sg13cmos5l_nand2b_1
XFILLER_102_116 VPWR VGND sg13cmos5l_decap_4
X_5155_ _6796_/A Tile_X0Y0_E6END[0] Tile_X0Y0_S4END[2] Tile_X0Y0_S2END[3] _4934_/Y
+ _5909_/Q _5910_/Q VPWR VGND sg13cmos5l_mux4_1
X_5086_ _5086_/Y _5728_/Q _4934_/Y VPWR VGND sg13cmos5l_nor2b_1
X_4106_ _4146_/A _4106_/A _4106_/B VPWR VGND sg13cmos5l_xor2_1
X_4037_ _4041_/A _4138_/A _4570_/A _4038_/C VPWR VGND sg13cmos5l_and3_1
X_5988_ _5988_/Q Tile_X0Y1_UserCLK _5988_/D _6442_/L_HI VPWR VGND sg13cmos5l_dfrbpq_1
X_4939_ _4939_/Y _5562_/Q _6423_/Q VPWR VGND sg13cmos5l_nand2_1
XANTENNA_40 Tile_X0Y0_E2MID[0] VPWR VGND sg13cmos5l_antennanp
XANTENNA_51 Tile_X0Y0_E2MID[2] VPWR VGND sg13cmos5l_antennanp
XANTENNA_62 Tile_X0Y0_E2MID[3] VPWR VGND sg13cmos5l_antennanp
XANTENNA_73 Tile_X0Y0_E2MID[4] VPWR VGND sg13cmos5l_antennanp
X_6609_ Tile_X0Y0_N4BEG[3] Tile_X0Y1_N4END[11] VPWR VGND sg13cmos5l_buf_1
XANTENNA_84 Tile_X0Y0_E2MID[6] VPWR VGND sg13cmos5l_antennanp
XANTENNA_95 Tile_X0Y0_SS4END[3] VPWR VGND sg13cmos5l_antennanp
XFILLER_70_283 VPWR VGND sg13cmos5l_fill_1
XFILLER_11_350 VPWR VGND sg13cmos5l_decap_8
X_3270_ _3270_/Y _6160_/Q _3267_/X _6159_/Q VPWR VGND sg13cmos5l_o21ai_1
X_5911_ _5911_/Q Tile_X0Y0_FrameData[11] Tile_X0Y1_FrameStrobe[10] VPWR VGND sg13cmos5l_dlhq_1
XFILLER_93_375 VPWR VGND sg13cmos5l_decap_4
XFILLER_53_206 VPWR VGND sg13cmos5l_fill_2
X_5842_ _5842_/Q Tile_X0Y0_FrameData[16] Tile_X0Y1_FrameStrobe[8] VPWR VGND sg13cmos5l_dlhq_1
X_5773_ _5773_/Q Tile_X0Y0_FrameData[21] Tile_X0Y1_FrameStrobe[6] VPWR VGND sg13cmos5l_dlhq_1
XFILLER_99_0 VPWR VGND sg13cmos5l_fill_1
XFILLER_21_125 VPWR VGND sg13cmos5l_fill_2
X_4724_ _4824_/B _4724_/A _4724_/B VPWR VGND sg13cmos5l_xnor2_1
X_2985_ _2985_/X _4940_/Y _4934_/Y _5011_/X _4937_/Y _5622_/Q _5620_/Q VPWR VGND sg13cmos5l_mux4_1
X_4655_ _4656_/B _6426_/Q _6004_/D _4654_/Y VPWR VGND sg13cmos5l_o21ai_1
X_4586_ _4586_/Y _4587_/B _4587_/A VPWR VGND sg13cmos5l_nor2b_1
X_3606_ _6600_/A _4769_/B VPWR VGND sg13cmos5l_inv_1
X_6325_ _6325_/Q Tile_X0Y1_FrameData[7] Tile_X0Y1_FrameStrobe[9] VPWR VGND sg13cmos5l_dlhq_1
X_3537_ _3537_/Y _5656_/Q _4911_/X VPWR VGND sg13cmos5l_nor2_1
XFILLER_107_14 VPWR VGND sg13cmos5l_decap_8
X_6256_ _6256_/Q Tile_X0Y1_FrameData[12] Tile_X0Y1_FrameStrobe[7] VPWR VGND sg13cmos5l_dlhq_1
X_3468_ _3468_/Y _6426_/Q _2855_/Y _6425_/Q VPWR VGND sg13cmos5l_a21oi_1
X_6187_ _6187_/Q Tile_X0Y1_FrameData[17] Tile_X0Y1_FrameStrobe[5] VPWR VGND sg13cmos5l_dlhq_1
X_5207_ _5208_/B _5207_/A _5207_/B VPWR VGND sg13cmos5l_nor2_1
X_3399_ _3399_/Y _5422_/B _6124_/Q VPWR VGND sg13cmos5l_nor2b_1
X_5138_ _5138_/Y _5927_/Q _5136_/X VPWR VGND sg13cmos5l_nor2b_1
X_5069_ _5070_/A _2775_/Y _4744_/Y _5068_/Y VPWR VGND sg13cmos5l_a21oi_1
XFILLER_84_375 VPWR VGND sg13cmos5l_fill_2
XFILLER_4_346 VPWR VGND sg13cmos5l_decap_8
XFILLER_57_40 VPWR VGND sg13cmos5l_fill_1
XFILLER_50_209 VPWR VGND sg13cmos5l_fill_2
X_2770_ _2770_/Y _6013_/Q VPWR VGND sg13cmos5l_inv_1
XANTENNA__6602__X Tile_X0Y0_N2BEGb[4] VPWR VGND sg13cmos5l_antennanp
X_4440_ _4440_/Y _4447_/A _5440_/B VPWR VGND sg13cmos5l_nor2_1
X_6110_ _6110_/Q Tile_X0Y1_FrameData[30] Tile_X0Y1_FrameStrobe[3] VPWR VGND sg13cmos5l_dlhq_1
X_4371_ _4371_/Y _6020_/Q Tile_X0Y1_N4END[3] VPWR VGND sg13cmos5l_nor2b_1
X_3322_ _3322_/Y _5601_/Q _3322_/B VPWR VGND sg13cmos5l_nand2_1
X_6041_ _6041_/Q Tile_X0Y1_FrameData[3] Tile_X0Y1_FrameStrobe[0] VPWR VGND sg13cmos5l_dlhq_1
X_3253_ _3253_/Y Tile_X0Y0_E6END[0] _5694_/Q _3252_/Y VPWR VGND sg13cmos5l_o21ai_1
X_3184_ _3185_/A _3177_/Y _3183_/Y _3113_/Y VPWR VGND sg13cmos5l_a21oi_1
XFILLER_66_353 VPWR VGND sg13cmos5l_fill_1
X_5825_ _5825_/Q Tile_X0Y0_FrameData[1] Tile_X0Y1_FrameStrobe[7] VPWR VGND sg13cmos5l_dlhq_1
X_5756_ _5756_/Q Tile_X0Y0_FrameData[6] Tile_X0Y1_FrameStrobe[5] VPWR VGND sg13cmos5l_dlhq_1
X_2968_ _2968_/Y _6170_/Q _2966_/Y _6171_/Q VPWR VGND sg13cmos5l_o21ai_1
XANTENNA__6512__X Tile_X0Y0_E6BEG[6] VPWR VGND sg13cmos5l_antennanp
X_5687_ _5687_/Q Tile_X0Y0_FrameData[11] Tile_X0Y1_FrameStrobe[3] VPWR VGND sg13cmos5l_dlhq_1
X_4707_ _4707_/Y _6423_/Q _5544_/B _4706_/Y VPWR VGND sg13cmos5l_o21ai_1
X_4638_ _4639_/B _4944_/X Tile_X0Y0_S1END[2] Tile_X0Y1_N2MID[6] Tile_X0Y0_S2END[6]
+ _5708_/Q _5710_/Q VPWR VGND sg13cmos5l_mux4_1
X_2899_ _2899_/Y _2707_/Y _2898_/X _5627_/Q VPWR VGND sg13cmos5l_o21ai_1
X_4569_ _4587_/A _4483_/A _4482_/Y _4475_/Y VPWR VGND sg13cmos5l_o21ai_1
X_6308_ _6308_/Q Tile_X0Y1_FrameData[24] Tile_X0Y1_FrameStrobe[9] VPWR VGND sg13cmos5l_dlhq_1
XFILLER_1_338 VPWR VGND sg13cmos5l_decap_8
X_6239_ _6239_/Q Tile_X0Y1_FrameData[29] Tile_X0Y1_FrameStrobe[7] VPWR VGND sg13cmos5l_dlhq_1
XFILLER_27_32 VPWR VGND sg13cmos5l_fill_1
X_3940_ _3940_/Y _5854_/Q _3940_/B _3940_/C VPWR VGND sg13cmos5l_nor3_1
X_3871_ _4478_/A _4570_/A VPWR VGND sg13cmos5l_inv_1
X_5610_ _5610_/Q Tile_X0Y0_FrameData[24] Tile_X0Y1_FrameStrobe[1] VPWR VGND sg13cmos5l_dlhq_1
X_6590_ Tile_X0Y0_N2BEG[0] _6590_/A VPWR VGND sg13cmos5l_buf_1
X_2822_ _2822_/Y _6141_/Q VPWR VGND sg13cmos5l_inv_1
X_5541_ _5561_/D _5551_/A _5541_/B VPWR VGND sg13cmos5l_nor2_1
X_2753_ _4776_/B Tile_X0Y1_N4END[6] VPWR VGND sg13cmos5l_inv_1
X_5472_ _5472_/Y Tile_X0Y1_N1END[3] _6327_/Q _2804_/Y VPWR VGND sg13cmos5l_o21ai_1
X_4423_ _4424_/B _6080_/Q _4421_/Y _4422_/Y VPWR VGND sg13cmos5l_a21oi_1
X_4354_ _4386_/B _4354_/A _4354_/B VPWR VGND sg13cmos5l_xnor2_1
X_3305_ _3305_/Y _5725_/Q _3304_/X _2852_/Y VPWR VGND sg13cmos5l_o21ai_1
X_6024_ _6024_/Q Tile_X0Y1_FrameData[20] Tile_X0Y1_FrameStrobe[0] VPWR VGND sg13cmos5l_dlhq_1
X_4285_ _4285_/X Tile_X0Y1_N2END[1] Tile_X0Y1_EE4END[3] Tile_X0Y0_S2MID[1] Tile_X0Y1_W2END[1]
+ _6174_/Q _6173_/Q VPWR VGND sg13cmos5l_mux4_1
XFILLER_100_214 VPWR VGND sg13cmos5l_fill_1
X_3236_ _3236_/X _2831_/Y _2832_/Y _3016_/B _3231_/Y _5977_/Q _5572_/Q VPWR VGND sg13cmos5l_mux4_1
XFILLER_104_26 VPWR VGND sg13cmos5l_decap_8
X_3167_ _3168_/A _3166_/X _3165_/X _3163_/X _3164_/X _6075_/Q _6073_/Q VPWR VGND sg13cmos5l_mux4_1
XFILLER_54_312 VPWR VGND sg13cmos5l_fill_1
XFILLER_100_269 VPWR VGND sg13cmos5l_fill_2
XANTENNA__6507__X Tile_X0Y0_E6BEG[1] VPWR VGND sg13cmos5l_antennanp
X_3098_ _3099_/B _5581_/Q _3098_/B _3098_/C VPWR VGND sg13cmos5l_nor3_1
XFILLER_81_131 VPWR VGND sg13cmos5l_fill_1
X_6857_ Tile_X0Y1_WW4BEG[5] Tile_X0Y1_WW4END[9] VPWR VGND sg13cmos5l_buf_1
XFILLER_80_18 VPWR VGND sg13cmos5l_fill_1
X_5808_ _5808_/Q Tile_X0Y0_FrameData[18] Tile_X0Y1_FrameStrobe[7] VPWR VGND sg13cmos5l_dlhq_1
X_6788_ Tile_X0Y1_S4BEG[1] Tile_X0Y0_S4END[9] VPWR VGND sg13cmos5l_buf_1
X_5739_ _5739_/Q Tile_X0Y0_FrameData[23] Tile_X0Y1_FrameStrobe[5] VPWR VGND sg13cmos5l_dlhq_1
XFILLER_60_315 VPWR VGND sg13cmos5l_fill_1
XFILLER_70_51 VPWR VGND sg13cmos5l_fill_1
XFILLER_107_380 VPWR VGND sg13cmos5l_fill_1
X_4070_ _4070_/Y _5794_/Q _6605_/A _4069_/Y VPWR VGND sg13cmos5l_o21ai_1
X_3021_ _3021_/Y _5858_/Q _3020_/X _5857_/Q VPWR VGND sg13cmos5l_o21ai_1
XFILLER_36_301 VPWR VGND sg13cmos5l_fill_1
X_4972_ _4972_/X _5058_/B Tile_X0Y0_E1END[0] Tile_X0Y1_N2MID[0] Tile_X0Y0_EE4END[0]
+ _5701_/Q _5702_/Q VPWR VGND sg13cmos5l_mux4_1
XFILLER_51_337 VPWR VGND sg13cmos5l_decap_8
XFILLER_51_326 VPWR VGND sg13cmos5l_decap_4
X_6711_ Tile_X0Y1_E6BEG[4] Tile_X0Y1_E6END[6] VPWR VGND sg13cmos5l_buf_1
X_3923_ _3924_/B _2869_/Y _3922_/X _5679_/Q VPWR VGND sg13cmos5l_o21ai_1
X_6642_ Tile_X0Y0_W1BEG[3] _6642_/A VPWR VGND sg13cmos5l_buf_1
X_3854_ _3854_/X Tile_X0Y1_N2MID[0] _6779_/A _6254_/Q VPWR VGND sg13cmos5l_mux2_1
X_2805_ _2805_/Y _6323_/Q VPWR VGND sg13cmos5l_inv_1
XFILLER_81_0 VPWR VGND sg13cmos5l_fill_2
X_6573_ Tile_X0Y0_FrameStrobe_O[7] Tile_X0Y1_FrameStrobe[7] VPWR VGND sg13cmos5l_buf_1
X_3785_ _3785_/Y _6426_/Q _2839_/Y _6425_/Q VPWR VGND sg13cmos5l_a21oi_1
X_5524_ _5524_/Y _5524_/A _5524_/B VPWR VGND sg13cmos5l_nor2_1
X_2736_ _4674_/A _5844_/Q VPWR VGND sg13cmos5l_inv_1
X_5455_ _5455_/Y _6330_/Q _5455_/B VPWR VGND sg13cmos5l_nand2_1
X_4406_ _4413_/B _6048_/Q _4403_/X _4404_/X _4405_/Y _6047_/Q VPWR VGND sg13cmos5l_a221oi_1
X_5386_ _5387_/B _6137_/Q _5386_/B _5386_/C VPWR VGND sg13cmos5l_nand3_1
X_4337_ _4337_/Y _6241_/Q _4336_/Y _4339_/A VPWR VGND sg13cmos5l_o21ai_1
X_4268_ _4270_/B _4268_/A _4268_/B VPWR VGND sg13cmos5l_xor2_1
X_6007_ _6007_/Q Tile_X0Y1_UserCLK _6007_/D _6461_/L_HI VPWR VGND sg13cmos5l_dfrbpq_1
X_3219_ _3219_/X Tile_X0Y0_E1END[1] Tile_X0Y0_E2END[5] _5618_/Q VPWR VGND sg13cmos5l_mux2_1
X_4199_ _4199_/Y _4200_/A _4200_/B VPWR VGND sg13cmos5l_nor2_1
XFILLER_6_238 VPWR VGND sg13cmos5l_fill_1
XFILLER_40_43 VPWR VGND sg13cmos5l_fill_1
XANTENNA__6700__X Tile_X0Y1_E2BEGb[1] VPWR VGND sg13cmos5l_antennanp
XFILLER_40_87 VPWR VGND sg13cmos5l_fill_2
XFILLER_104_350 VPWR VGND sg13cmos5l_decap_8
XANTENNA_130 Tile_X0Y0_WW4END[0] VPWR VGND sg13cmos5l_antennanp
XANTENNA_141 Tile_X0Y1_E2MID[2] VPWR VGND sg13cmos5l_antennanp
XANTENNA_152 Tile_X0Y1_E2MID[5] VPWR VGND sg13cmos5l_antennanp
XFILLER_33_337 VPWR VGND sg13cmos5l_fill_1
XANTENNA_163 Tile_X0Y1_N4END[3] VPWR VGND sg13cmos5l_antennanp
XANTENNA_174 Tile_X0Y1_W2END[0] VPWR VGND sg13cmos5l_antennanp
XANTENNA_185 Tile_X0Y1_W2MID[3] VPWR VGND sg13cmos5l_antennanp
XANTENNA_196 Tile_X0Y1_W2MID[3] VPWR VGND sg13cmos5l_antennanp
XFILLER_81_61 VPWR VGND sg13cmos5l_fill_2
X_3570_ _3570_/X _4515_/Y _5390_/B _6126_/Q VPWR VGND sg13cmos5l_mux2_1
XANTENNA__6610__X Tile_X0Y0_N4BEG[4] VPWR VGND sg13cmos5l_antennanp
X_5240_ _5240_/Y _5240_/A VPWR VGND sg13cmos5l_inv_1
X_5171_ _5171_/X _3063_/X Tile_X0Y0_W1END[3] Tile_X0Y0_E1END[3] _4911_/X _5900_/Q
+ _5901_/Q VPWR VGND sg13cmos5l_mux4_1
X_4122_ _4122_/Y _5814_/Q _3446_/Y _2865_/Y VPWR VGND sg13cmos5l_a21oi_1
X_4053_ _4053_/X _4934_/Y _4937_/Y _5716_/Q VPWR VGND sg13cmos5l_mux2_1
X_3004_ _3004_/Y Tile_X0Y1_E1END[0] _6168_/Q VPWR VGND sg13cmos5l_nor2_1
X_4955_ _4965_/B _5604_/Q _4948_/X _4954_/Y VPWR VGND sg13cmos5l_o21ai_1
X_3906_ _3909_/A _3906_/A _3906_/B VPWR VGND sg13cmos5l_xnor2_1
X_4886_ _4886_/X Tile_X0Y0_E1END[3] Tile_X0Y0_S2END[7] _5608_/Q VPWR VGND sg13cmos5l_mux2_1
X_6625_ Tile_X0Y0_NN4BEG[3] Tile_X0Y1_NN4END[11] VPWR VGND sg13cmos5l_buf_1
X_3837_ _6779_/A _3835_/Y _3836_/Y _3829_/Y VPWR VGND sg13cmos5l_o21ai_1
X_6556_ Tile_X0Y0_FrameData_O[22] Tile_X0Y0_FrameData[22] VPWR VGND sg13cmos5l_buf_1
X_3768_ _3768_/Y _3790_/B _3790_/A VPWR VGND sg13cmos5l_nand2b_1
XANTENNA__6520__X Tile_X0Y0_EE4BEG[2] VPWR VGND sg13cmos5l_antennanp
X_5507_ _5508_/A _4515_/Y _4509_/Y _4518_/Y _5390_/B _6318_/Q _6316_/Q VPWR VGND sg13cmos5l_mux4_1
X_2719_ _2719_/Y _6109_/Q VPWR VGND sg13cmos5l_inv_1
X_6487_ Tile_X0Y0_E1BEG[1] _6487_/A VPWR VGND sg13cmos5l_buf_1
X_3699_ _3699_/Y _6103_/Q _3693_/X _6101_/Q VPWR VGND sg13cmos5l_o21ai_1
X_5438_ _5438_/Y _6105_/Q _5438_/B _5438_/C VPWR VGND sg13cmos5l_nor3_1
X_5369_ _5369_/Y _6140_/Q Tile_X0Y1_EE4END[1] _5368_/Y VPWR VGND sg13cmos5l_a21oi_1
XFILLER_86_39 VPWR VGND sg13cmos5l_fill_1
XFILLER_59_289 VPWR VGND sg13cmos5l_fill_1
XFILLER_59_256 VPWR VGND sg13cmos5l_decap_4
XFILLER_15_359 VPWR VGND sg13cmos5l_decap_8
XFILLER_15_337 VPWR VGND sg13cmos5l_fill_2
XFILLER_76_72 VPWR VGND sg13cmos5l_fill_1
XFILLER_65_248 VPWR VGND sg13cmos5l_fill_2
XFILLER_80_229 VPWR VGND sg13cmos5l_fill_2
XANTENNA__6605__X Tile_X0Y0_N2BEGb[7] VPWR VGND sg13cmos5l_antennanp
X_4740_ _4740_/Y Tile_X0Y0_S2MID[5] _5766_/Q _5765_/Q VPWR VGND sg13cmos5l_o21ai_1
X_4671_ _4671_/Y _5774_/Q _6603_/A _4670_/Y VPWR VGND sg13cmos5l_o21ai_1
X_6410_ _6410_/Q Tile_X0Y1_FrameData[18] Tile_X0Y1_FrameStrobe[12] VPWR VGND sg13cmos5l_dlhq_1
X_3622_ _3622_/Y _6259_/Q _3621_/Y _2816_/Y VPWR VGND sg13cmos5l_o21ai_1
X_6341_ _6341_/Q Tile_X0Y1_FrameData[23] Tile_X0Y1_FrameStrobe[10] VPWR VGND sg13cmos5l_dlhq_1
X_3553_ _3553_/Y _3551_/Y _3552_/Y _3547_/Y VPWR VGND sg13cmos5l_o21ai_1
X_6272_ _6272_/Q Tile_X0Y1_FrameData[28] Tile_X0Y1_FrameStrobe[8] VPWR VGND sg13cmos5l_dlhq_1
X_3484_ _5987_/D _3484_/A VPWR VGND sg13cmos5l_inv_1
XFILLER_44_0 VPWR VGND sg13cmos5l_fill_2
X_5223_ _5227_/A _5878_/Q _5243_/B _5222_/Y VPWR VGND sg13cmos5l_a21oi_1
X_5154_ _6795_/A Tile_X0Y0_E6END[1] Tile_X0Y0_S4END[1] Tile_X0Y0_S2END[2] _4940_/Y
+ _5911_/Q _5912_/Q VPWR VGND sg13cmos5l_mux4_1
X_4105_ _4106_/B _4105_/A _4105_/B VPWR VGND sg13cmos5l_xnor2_1
X_5085_ _5085_/X _4707_/Y _4937_/Y _5728_/Q VPWR VGND sg13cmos5l_mux2_1
X_4036_ _4083_/A _4216_/A _4600_/A VPWR VGND sg13cmos5l_nor2_1
XFILLER_56_259 VPWR VGND sg13cmos5l_decap_8
XANTENNA__6515__X Tile_X0Y0_E6BEG[9] VPWR VGND sg13cmos5l_antennanp
X_5987_ _5987_/Q Tile_X0Y1_UserCLK _5987_/D _6441_/L_HI VPWR VGND sg13cmos5l_dfrbpq_1
X_4938_ _5542_/B _4938_/A _4938_/B VPWR VGND sg13cmos5l_xnor2_1
XANTENNA_30 Tile_X0Y0_E2MID[0] VPWR VGND sg13cmos5l_antennanp
XANTENNA_41 Tile_X0Y0_E2MID[0] VPWR VGND sg13cmos5l_antennanp
X_4869_ _4869_/Y _4870_/A _4870_/B VPWR VGND sg13cmos5l_nor2_1
XANTENNA_52 Tile_X0Y0_E2MID[2] VPWR VGND sg13cmos5l_antennanp
XANTENNA_63 Tile_X0Y0_E2MID[3] VPWR VGND sg13cmos5l_antennanp
XANTENNA_74 Tile_X0Y0_E2MID[4] VPWR VGND sg13cmos5l_antennanp
X_6608_ Tile_X0Y0_N4BEG[2] Tile_X0Y1_N4END[10] VPWR VGND sg13cmos5l_buf_1
XANTENNA_96 Tile_X0Y0_SS4END[4] VPWR VGND sg13cmos5l_antennanp
XANTENNA_85 Tile_X0Y0_E2MID[6] VPWR VGND sg13cmos5l_antennanp
X_6539_ Tile_X0Y0_FrameData_O[5] Tile_X0Y0_FrameData[5] VPWR VGND sg13cmos5l_buf_1
XFILLER_55_281 VPWR VGND sg13cmos5l_decap_8
XFILLER_109_283 VPWR VGND sg13cmos5l_fill_2
X_5910_ _5910_/Q Tile_X0Y0_FrameData[12] Tile_X0Y1_FrameStrobe[10] VPWR VGND sg13cmos5l_dlhq_1
X_5841_ _5841_/Q Tile_X0Y0_FrameData[17] Tile_X0Y1_FrameStrobe[8] VPWR VGND sg13cmos5l_dlhq_1
X_5772_ _5772_/Q Tile_X0Y0_FrameData[22] Tile_X0Y1_FrameStrobe[6] VPWR VGND sg13cmos5l_dlhq_1
X_2984_ _2984_/Y _5619_/Q _2984_/B VPWR VGND sg13cmos5l_nand2b_1
X_4723_ _4724_/B _4714_/A _4714_/B _4722_/Y VPWR VGND sg13cmos5l_o21ai_1
X_4654_ _4654_/Y _6426_/Q _2728_/Y _6425_/Q VPWR VGND sg13cmos5l_a21oi_1
X_4585_ _4587_/B _4585_/A _4585_/B VPWR VGND sg13cmos5l_xor2_1
X_3605_ _4769_/B _3605_/A _3605_/B VPWR VGND sg13cmos5l_nor2_1
X_6324_ _6324_/Q Tile_X0Y1_FrameData[8] Tile_X0Y1_FrameStrobe[9] VPWR VGND sg13cmos5l_dlhq_1
X_3536_ _6692_/A _6133_/Q _3535_/Y _3531_/Y VPWR VGND sg13cmos5l_o21ai_1
X_6255_ _6255_/Q Tile_X0Y1_FrameData[13] Tile_X0Y1_FrameStrobe[7] VPWR VGND sg13cmos5l_dlhq_1
X_5206_ _5207_/B _5204_/Y _5205_/Y _5882_/Q VPWR VGND sg13cmos5l_o21ai_1
X_3467_ _5996_/D _3432_/Y _3467_/B VPWR VGND sg13cmos5l_nand2b_1
X_6186_ _6186_/Q Tile_X0Y1_FrameData[18] Tile_X0Y1_FrameStrobe[5] VPWR VGND sg13cmos5l_dlhq_1
X_3398_ _3398_/Y _6124_/Q _4503_/Y _3397_/Y VPWR VGND sg13cmos5l_o21ai_1
X_5137_ _5137_/X _4940_/Y _4934_/Y _4943_/Y _5011_/X _5928_/Q _5926_/Q VPWR VGND sg13cmos5l_mux4_1
XFILLER_96_170 VPWR VGND sg13cmos5l_decap_8
X_5068_ _5068_/Y _2775_/Y _4028_/X _5950_/Q VPWR VGND sg13cmos5l_o21ai_1
X_4019_ _4020_/B Tile_X0Y0_E2MID[2] Tile_X0Y0_W2MID[2] Tile_X0Y0_S2MID[2] _6493_/A
+ _5823_/Q _5824_/Q VPWR VGND sg13cmos5l_mux4_1
XFILLER_16_23 VPWR VGND sg13cmos5l_fill_1
XFILLER_52_262 VPWR VGND sg13cmos5l_fill_2
XFILLER_52_273 VPWR VGND sg13cmos5l_fill_1
XFILLER_79_104 VPWR VGND sg13cmos5l_fill_1
XFILLER_90_379 VPWR VGND sg13cmos5l_fill_2
X_4370_ _4370_/Y _6020_/Q _3383_/Y _4369_/Y VPWR VGND sg13cmos5l_a21oi_1
XFILLER_7_196 VPWR VGND sg13cmos5l_fill_2
X_3321_ _3322_/B _5602_/Q _6591_/A _3320_/Y VPWR VGND sg13cmos5l_a21oi_1
X_6040_ _6040_/Q Tile_X0Y1_FrameData[4] Tile_X0Y1_FrameStrobe[0] VPWR VGND sg13cmos5l_dlhq_1
X_3252_ _3252_/Y _2778_/Y _5694_/Q _5693_/Q VPWR VGND sg13cmos5l_a21oi_1
X_3183_ _3183_/Y _3179_/Y _3182_/Y _5687_/Q VPWR VGND sg13cmos5l_a21oi_1
XFILLER_78_170 VPWR VGND sg13cmos5l_fill_2
XFILLER_93_184 VPWR VGND sg13cmos5l_decap_8
X_5824_ _5824_/Q Tile_X0Y0_FrameData[2] Tile_X0Y1_FrameStrobe[7] VPWR VGND sg13cmos5l_dlhq_1
X_5755_ _5755_/Q Tile_X0Y0_FrameData[7] Tile_X0Y1_FrameStrobe[5] VPWR VGND sg13cmos5l_dlhq_1
X_2967_ _2967_/X Tile_X0Y1_W2END[1] Tile_X0Y1_W6END[1] _6172_/Q VPWR VGND sg13cmos5l_mux2_1
X_5686_ _5686_/Q Tile_X0Y0_FrameData[12] Tile_X0Y1_FrameStrobe[3] VPWR VGND sg13cmos5l_dlhq_1
X_4706_ _4706_/Y _5564_/Q _6423_/Q VPWR VGND sg13cmos5l_nand2_1
X_2898_ _2898_/X _4911_/X _4909_/X _4943_/Y _5009_/Y _5628_/Q _5630_/Q VPWR VGND sg13cmos5l_mux4_1
X_4637_ _4637_/X _4633_/Y _4635_/Y _4631_/Y _4636_/X _5709_/Q _5710_/Q VPWR VGND sg13cmos5l_mux4_1
X_4568_ _4588_/A _4481_/A _4481_/B _4479_/Y VPWR VGND sg13cmos5l_o21ai_1
X_6307_ _6307_/Q Tile_X0Y1_FrameData[25] Tile_X0Y1_FrameStrobe[9] VPWR VGND sg13cmos5l_dlhq_1
X_4499_ _4499_/Y _5561_/Q _6423_/Q VPWR VGND sg13cmos5l_nand2_1
X_3519_ _3575_/B _5500_/B VPWR VGND sg13cmos5l_inv_1
X_6238_ _6238_/Q Tile_X0Y1_FrameData[30] Tile_X0Y1_FrameStrobe[7] VPWR VGND sg13cmos5l_dlhq_1
X_6169_ _6169_/Q Tile_X0Y1_FrameData[3] Tile_X0Y1_FrameStrobe[4] VPWR VGND sg13cmos5l_dlhq_1
XFILLER_94_17 VPWR VGND sg13cmos5l_fill_1
XANTENNA__6703__X Tile_X0Y1_E2BEGb[4] VPWR VGND sg13cmos5l_antennanp
XFILLER_111_0 VPWR VGND sg13cmos5l_decap_8
XFILLER_68_84 VPWR VGND sg13cmos5l_fill_1
XFILLER_16_240 VPWR VGND sg13cmos5l_fill_2
X_3870_ _4570_/A _6427_/Q _3868_/A _3869_/Y VPWR VGND sg13cmos5l_o21ai_1
XANTENNA__6613__X Tile_X0Y0_N4BEG[7] VPWR VGND sg13cmos5l_antennanp
X_2821_ _3206_/S _5779_/Q VPWR VGND sg13cmos5l_inv_1
X_5540_ _5560_/D _5551_/A _4519_/X VPWR VGND sg13cmos5l_nor2b_1
X_2752_ _2752_/Y _6008_/Q VPWR VGND sg13cmos5l_inv_1
X_5471_ _5477_/A _5471_/A _5471_/B VPWR VGND sg13cmos5l_nor2_1
X_4422_ _4422_/Y _6080_/Q _4419_/Y _6079_/Q VPWR VGND sg13cmos5l_o21ai_1
X_4353_ _4386_/A _4353_/A _4353_/B VPWR VGND sg13cmos5l_nand2_1
X_4284_ _4284_/Y _4284_/A VPWR VGND sg13cmos5l_inv_1
X_3304_ _3304_/X Tile_X0Y1_N2MID[2] Tile_X0Y1_N4END[6] Tile_X0Y0_E6END[0] Tile_X0Y0_S2END[2]
+ _5726_/Q _5724_/Q VPWR VGND sg13cmos5l_mux4_1
XFILLER_98_254 VPWR VGND sg13cmos5l_fill_1
X_6023_ _6023_/Q Tile_X0Y1_FrameData[21] Tile_X0Y1_FrameStrobe[0] VPWR VGND sg13cmos5l_dlhq_1
X_3235_ _3237_/B Tile_X0Y1_NN4END[4] _5572_/Q _3234_/Y VPWR VGND sg13cmos5l_o21ai_1
XFILLER_58_107 VPWR VGND sg13cmos5l_decap_4
X_3166_ _3166_/X Tile_X0Y1_N1END[3] Tile_X0Y1_N2END[1] Tile_X0Y0_S2MID[1] Tile_X0Y0_S4END[5]
+ _6076_/Q _6074_/Q VPWR VGND sg13cmos5l_mux4_1
X_3097_ _3098_/C Tile_X0Y1_N4END[5] _5582_/Q VPWR VGND sg13cmos5l_nor2_1
XFILLER_54_335 VPWR VGND sg13cmos5l_fill_1
XFILLER_54_379 VPWR VGND sg13cmos5l_fill_2
X_6856_ Tile_X0Y1_WW4BEG[4] Tile_X0Y1_WW4END[8] VPWR VGND sg13cmos5l_buf_1
XANTENNA__6523__X Tile_X0Y0_EE4BEG[5] VPWR VGND sg13cmos5l_antennanp
X_5807_ _5807_/Q Tile_X0Y0_FrameData[19] Tile_X0Y1_FrameStrobe[7] VPWR VGND sg13cmos5l_dlhq_1
X_6787_ Tile_X0Y1_S4BEG[0] Tile_X0Y0_S4END[8] VPWR VGND sg13cmos5l_buf_1
X_3999_ _4000_/A _3980_/Y _3998_/Y _3975_/Y VPWR VGND sg13cmos5l_a21oi_1
X_5738_ _5738_/Q Tile_X0Y0_FrameData[24] Tile_X0Y1_FrameStrobe[5] VPWR VGND sg13cmos5l_dlhq_1
X_5669_ _5669_/Q Tile_X0Y0_FrameData[29] Tile_X0Y1_FrameStrobe[3] VPWR VGND sg13cmos5l_dlhq_1
XFILLER_108_348 VPWR VGND sg13cmos5l_decap_4
XFILLER_45_313 VPWR VGND sg13cmos5l_decap_4
XFILLER_45_379 VPWR VGND sg13cmos5l_fill_2
XANTENNA__6608__X Tile_X0Y0_N4BEG[2] VPWR VGND sg13cmos5l_antennanp
X_3020_ _3020_/X Tile_X0Y1_N2MID[0] Tile_X0Y0_E2END[0] Tile_X0Y0_S2END[0] Tile_X0Y0_WW4END[3]
+ _5756_/Q _5755_/Q VPWR VGND sg13cmos5l_mux4_1
X_4971_ _4971_/Y _2768_/Y _4970_/X _5699_/Q VPWR VGND sg13cmos5l_o21ai_1
X_6710_ Tile_X0Y1_E6BEG[3] Tile_X0Y1_E6END[5] VPWR VGND sg13cmos5l_buf_1
X_3922_ _3922_/X _4707_/Y _4909_/X _4911_/X _5062_/B _5680_/Q _5682_/Q VPWR VGND sg13cmos5l_mux4_1
X_6641_ Tile_X0Y0_W1BEG[2] _6641_/A VPWR VGND sg13cmos5l_buf_1
X_3853_ _3853_/Y Tile_X0Y1_W2MID[0] _6254_/Q _6253_/Q VPWR VGND sg13cmos5l_o21ai_1
X_2804_ _2804_/Y _6326_/Q VPWR VGND sg13cmos5l_inv_1
X_6572_ Tile_X0Y0_FrameStrobe_O[6] Tile_X0Y1_FrameStrobe[6] VPWR VGND sg13cmos5l_buf_1
X_3784_ _5994_/D _3774_/Y _3776_/Y _3783_/Y VPWR VGND sg13cmos5l_o21ai_1
X_5523_ _5524_/B _5522_/B _2952_/A _6272_/Q VPWR VGND sg13cmos5l_a21oi_1
X_2735_ _2735_/Y _6005_/Q VPWR VGND sg13cmos5l_inv_1
X_5454_ _6823_/A _4515_/Y _3715_/B _6773_/A _3031_/X _6332_/Q _6331_/Q VPWR VGND sg13cmos5l_mux4_1
X_5385_ _5386_/C _6139_/Q _5385_/B _5385_/C VPWR VGND sg13cmos5l_nand3_1
X_4405_ _4405_/Y _6046_/Q _2888_/Y _6048_/Q VPWR VGND sg13cmos5l_a21oi_1
X_4336_ _4336_/Y _6242_/Q _6781_/A _4335_/Y VPWR VGND sg13cmos5l_a21oi_1
X_4267_ _4268_/B _4267_/A _4267_/B VPWR VGND sg13cmos5l_xor2_1
XANTENNA__6518__X Tile_X0Y0_EE4BEG[0] VPWR VGND sg13cmos5l_antennanp
X_6006_ _6006_/Q Tile_X0Y1_UserCLK _6006_/D _6460_/L_HI VPWR VGND sg13cmos5l_dfrbpq_1
X_4198_ _4200_/B _4198_/A _4198_/B VPWR VGND sg13cmos5l_xnor2_1
X_3218_ _3218_/X _3171_/X _4320_/A _5618_/Q VPWR VGND sg13cmos5l_mux2_1
X_3149_ _3149_/Y _6095_/Q _3142_/X _3148_/Y VPWR VGND sg13cmos5l_o21ai_1
XFILLER_27_357 VPWR VGND sg13cmos5l_fill_1
X_6839_ Tile_X0Y1_W2BEGb[7] Tile_X0Y1_W2MID[7] VPWR VGND sg13cmos5l_buf_1
XFILLER_24_45 VPWR VGND sg13cmos5l_fill_1
XFILLER_108_189 VPWR VGND sg13cmos5l_fill_1
XFILLER_65_52 VPWR VGND sg13cmos5l_fill_2
XANTENNA_120 Tile_X0Y0_W2MID[7] VPWR VGND sg13cmos5l_antennanp
XANTENNA_131 Tile_X0Y0_WW4END[0] VPWR VGND sg13cmos5l_antennanp
XANTENNA_142 Tile_X0Y1_E2MID[2] VPWR VGND sg13cmos5l_antennanp
XANTENNA_153 Tile_X0Y1_E2MID[5] VPWR VGND sg13cmos5l_antennanp
XANTENNA_164 Tile_X0Y1_N4END[3] VPWR VGND sg13cmos5l_antennanp
XANTENNA_175 Tile_X0Y1_W2END[0] VPWR VGND sg13cmos5l_antennanp
XANTENNA_186 Tile_X0Y1_W2MID[3] VPWR VGND sg13cmos5l_antennanp
XANTENNA_197 Tile_X0Y1_W2MID[6] VPWR VGND sg13cmos5l_antennanp
XFILLER_41_360 VPWR VGND sg13cmos5l_fill_2
XFILLER_5_294 VPWR VGND sg13cmos5l_fill_2
X_5170_ _5170_/Y _5900_/Q _5167_/Y _5169_/Y VPWR VGND sg13cmos5l_o21ai_1
X_4121_ _4121_/X Tile_X0Y0_S2MID[4] _5814_/Q VPWR VGND sg13cmos5l_or2_1
XFILLER_110_321 VPWR VGND sg13cmos5l_decap_8
X_4052_ _4052_/Y _5717_/Q _4050_/X _4051_/Y VPWR VGND sg13cmos5l_a21oi_1
X_3003_ _3003_/Y Tile_X0Y1_W6END[0] _6168_/Q _3002_/Y VPWR VGND sg13cmos5l_a21oi_1
X_4954_ _4954_/Y _4950_/Y _4953_/Y _5603_/Q VPWR VGND sg13cmos5l_a21oi_1
X_3905_ _3905_/Y _4229_/A VPWR VGND sg13cmos5l_inv_1
X_4885_ _4885_/Y _5609_/Q _4885_/B VPWR VGND sg13cmos5l_nand2b_1
X_6624_ Tile_X0Y0_NN4BEG[2] Tile_X0Y1_NN4END[10] VPWR VGND sg13cmos5l_buf_1
X_3836_ _3836_/Y _5665_/Q _3830_/X _5663_/Q VPWR VGND sg13cmos5l_o21ai_1
XANTENNA__6801__X Tile_X0Y1_S4BEG[14] VPWR VGND sg13cmos5l_antennanp
X_6555_ Tile_X0Y0_FrameData_O[21] Tile_X0Y0_FrameData[21] VPWR VGND sg13cmos5l_buf_1
X_3767_ _3790_/B _3767_/A _3767_/B VPWR VGND sg13cmos5l_xor2_1
X_5506_ _5506_/X Tile_X0Y1_E1END[3] Tile_X0Y1_W1END[3] _4503_/Y _3916_/Y _6318_/Q
+ _6316_/Q VPWR VGND sg13cmos5l_mux4_1
X_2718_ _4447_/A _6112_/Q VPWR VGND sg13cmos5l_inv_1
X_6486_ Tile_X0Y0_E1BEG[0] _6486_/A VPWR VGND sg13cmos5l_buf_1
X_3698_ _3698_/Y _6104_/Q _3695_/Y _3697_/Y VPWR VGND sg13cmos5l_a21oi_1
X_5437_ _5438_/C _6106_/Q _5433_/X _5436_/Y VPWR VGND sg13cmos5l_a21oi_1
X_5368_ _5368_/Y _6140_/Q Tile_X0Y1_N4END[1] VPWR VGND sg13cmos5l_nor2b_1
X_5299_ _5299_/Y _6392_/Q _5450_/B VPWR VGND sg13cmos5l_nand2_1
X_4319_ _4319_/Y _6208_/Q _3061_/A _4318_/Y VPWR VGND sg13cmos5l_o21ai_1
XFILLER_74_227 VPWR VGND sg13cmos5l_fill_2
XFILLER_27_154 VPWR VGND sg13cmos5l_fill_1
XANTENNA__6711__X Tile_X0Y1_E6BEG[4] VPWR VGND sg13cmos5l_antennanp
XFILLER_2_275 VPWR VGND sg13cmos5l_fill_1
XFILLER_14_360 VPWR VGND sg13cmos5l_decap_4
X_4670_ _4670_/Y _5774_/Q _2740_/Y _5773_/Q VPWR VGND sg13cmos5l_a21oi_1
XANTENNA__6621__X Tile_X0Y0_N4BEG[15] VPWR VGND sg13cmos5l_antennanp
X_3621_ _3621_/Y Tile_X0Y1_E2MID[6] _6260_/Q _3620_/Y VPWR VGND sg13cmos5l_o21ai_1
X_6340_ _6340_/Q Tile_X0Y1_FrameData[24] Tile_X0Y1_FrameStrobe[10] VPWR VGND sg13cmos5l_dlhq_1
X_3552_ _3552_/Y _5658_/Q _3549_/Y _5657_/Q VPWR VGND sg13cmos5l_o21ai_1
X_6271_ _6271_/Q Tile_X0Y1_FrameData[29] Tile_X0Y1_FrameStrobe[8] VPWR VGND sg13cmos5l_dlhq_1
X_3483_ _3484_/A _6299_/Q _3474_/Y _3479_/Y _3482_/Y VPWR VGND sg13cmos5l_a22oi_1
X_5222_ _5222_/Y _5878_/Q _5062_/B _2783_/Y VPWR VGND sg13cmos5l_o21ai_1
X_5153_ _6517_/A _5921_/Q _5148_/Y _5152_/X VPWR VGND sg13cmos5l_o21ai_1
X_4104_ _4104_/Y _4105_/A _4105_/B VPWR VGND sg13cmos5l_nand2_1
XFILLER_96_363 VPWR VGND sg13cmos5l_fill_2
X_5084_ _5084_/X Tile_X0Y1_N2MID[1] Tile_X0Y1_N4END[5] Tile_X0Y0_E6END[1] Tile_X0Y0_SS4END[1]
+ _5730_/Q _5728_/Q VPWR VGND sg13cmos5l_mux4_1
X_4035_ _4601_/A _4600_/A VPWR VGND sg13cmos5l_inv_1
XFILLER_2_81 VPWR VGND sg13cmos5l_decap_4
X_5986_ _5986_/Q Tile_X0Y1_UserCLK _5986_/D _6440_/L_HI VPWR VGND sg13cmos5l_dfrbpq_1
X_4937_ _4937_/Y _6423_/Q _5548_/B _4936_/Y VPWR VGND sg13cmos5l_o21ai_1
XANTENNA_20 Tile_X0Y0_E2END[7] VPWR VGND sg13cmos5l_antennanp
XANTENNA_31 Tile_X0Y0_E2MID[0] VPWR VGND sg13cmos5l_antennanp
X_4868_ _4910_/A _4705_/A _4705_/B _4703_/X VPWR VGND sg13cmos5l_a21oi_1
XANTENNA__6531__X Tile_X0Y0_EE4BEG[13] VPWR VGND sg13cmos5l_antennanp
XANTENNA_42 Tile_X0Y0_E2MID[0] VPWR VGND sg13cmos5l_antennanp
XANTENNA_53 Tile_X0Y0_E2MID[2] VPWR VGND sg13cmos5l_antennanp
XANTENNA_64 Tile_X0Y0_E2MID[3] VPWR VGND sg13cmos5l_antennanp
XANTENNA_75 Tile_X0Y0_E2MID[4] VPWR VGND sg13cmos5l_antennanp
X_6607_ Tile_X0Y0_N4BEG[1] Tile_X0Y1_N4END[9] VPWR VGND sg13cmos5l_buf_1
X_3819_ _6829_/A _5522_/C VPWR VGND sg13cmos5l_inv_1
XFILLER_20_374 VPWR VGND sg13cmos5l_decap_8
X_4799_ _4799_/Y _5705_/Q _4798_/X VPWR VGND sg13cmos5l_nor2b_1
XANTENNA_97 Tile_X0Y0_SS4END[4] VPWR VGND sg13cmos5l_antennanp
XANTENNA_86 Tile_X0Y0_SS4END[2] VPWR VGND sg13cmos5l_antennanp
X_6538_ Tile_X0Y0_FrameData_O[4] Tile_X0Y0_FrameData[4] VPWR VGND sg13cmos5l_buf_1
X_6469_ _6469_/L_HI VPWR VGND sg13cmos5l_tiehi
XFILLER_87_330 VPWR VGND sg13cmos5l_fill_1
XANTENNA__6706__X Tile_X0Y1_E2BEGb[7] VPWR VGND sg13cmos5l_antennanp
XFILLER_55_293 VPWR VGND sg13cmos5l_decap_4
XFILLER_102_93 VPWR VGND sg13cmos5l_decap_4
XFILLER_7_356 VPWR VGND sg13cmos5l_decap_4
XFILLER_97_105 VPWR VGND sg13cmos5l_fill_1
XANTENNA__6616__X Tile_X0Y0_N4BEG[10] VPWR VGND sg13cmos5l_antennanp
XFILLER_46_293 VPWR VGND sg13cmos5l_fill_1
XFILLER_46_271 VPWR VGND sg13cmos5l_decap_8
X_5840_ _5840_/Q Tile_X0Y0_FrameData[18] Tile_X0Y1_FrameStrobe[8] VPWR VGND sg13cmos5l_dlhq_1
X_5771_ _5771_/Q Tile_X0Y0_FrameData[23] Tile_X0Y1_FrameStrobe[6] VPWR VGND sg13cmos5l_dlhq_1
X_2983_ _2984_/B _2981_/X _2982_/X _5621_/Q VPWR VGND sg13cmos5l_mux2_1
XFILLER_61_274 VPWR VGND sg13cmos5l_fill_2
X_4722_ _4722_/Y _4715_/A _4722_/B VPWR VGND sg13cmos5l_nand2b_1
X_4653_ _6004_/D _4653_/A _4653_/B VPWR VGND sg13cmos5l_or2_1
X_4584_ _4585_/B _4584_/A _4584_/B VPWR VGND sg13cmos5l_xnor2_1
X_3604_ _3605_/B _3604_/A _3604_/B VPWR VGND sg13cmos5l_nor2_1
X_6323_ _6323_/Q Tile_X0Y1_FrameData[9] Tile_X0Y1_FrameStrobe[9] VPWR VGND sg13cmos5l_dlhq_1
X_3535_ _3535_/Y _6135_/Q _3533_/X _3534_/Y VPWR VGND sg13cmos5l_a21oi_1
X_6254_ _6254_/Q Tile_X0Y1_FrameData[14] Tile_X0Y1_FrameStrobe[7] VPWR VGND sg13cmos5l_dlhq_1
X_3466_ _3467_/B _6290_/Q _3458_/A _3465_/Y VPWR VGND sg13cmos5l_o21ai_1
X_5205_ _5205_/Y _2782_/Y _4735_/B _5883_/Q VPWR VGND sg13cmos5l_o21ai_1
XFILLER_107_49 VPWR VGND sg13cmos5l_decap_8
X_6185_ _6185_/Q Tile_X0Y1_FrameData[19] Tile_X0Y1_FrameStrobe[5] VPWR VGND sg13cmos5l_dlhq_1
X_3397_ _3397_/Y _6124_/Q _2891_/Y _6122_/Q VPWR VGND sg13cmos5l_a21oi_1
X_5136_ _5136_/X Tile_X0Y0_E1END[3] Tile_X0Y0_W1END[3] _4707_/Y _4911_/X _5928_/Q
+ _5926_/Q VPWR VGND sg13cmos5l_mux4_1
X_5067_ _5067_/Y _5951_/Q _5009_/Y _5066_/Y VPWR VGND sg13cmos5l_o21ai_1
XANTENNA__6526__X Tile_X0Y0_EE4BEG[8] VPWR VGND sg13cmos5l_antennanp
X_4018_ _4018_/Y _5245_/B VPWR VGND sg13cmos5l_inv_1
XFILLER_84_377 VPWR VGND sg13cmos5l_fill_1
XFILLER_52_230 VPWR VGND sg13cmos5l_fill_1
X_5969_ _5969_/Q Tile_X0Y0_FrameData[17] Tile_X0Y1_FrameStrobe[12] VPWR VGND sg13cmos5l_dlhq_1
X_3320_ _3320_/Y _5602_/Q Tile_X0Y0_WW4END[0] VPWR VGND sg13cmos5l_nor2b_1
X_3251_ _3251_/Y _5693_/Q _3247_/Y _3250_/Y VPWR VGND sg13cmos5l_o21ai_1
X_3182_ _3182_/Y _3182_/A _5688_/Q VPWR VGND sg13cmos5l_nor2b_1
X_5823_ _5823_/Q Tile_X0Y0_FrameData[3] Tile_X0Y1_FrameStrobe[7] VPWR VGND sg13cmos5l_dlhq_1
X_5754_ _5754_/Q Tile_X0Y0_FrameData[8] Tile_X0Y1_FrameStrobe[5] VPWR VGND sg13cmos5l_dlhq_1
X_2966_ _2966_/Y Tile_X0Y1_E2END[1] _6172_/Q _2965_/Y VPWR VGND sg13cmos5l_a21oi_1
X_5685_ _5685_/Q Tile_X0Y0_FrameData[13] Tile_X0Y1_FrameStrobe[3] VPWR VGND sg13cmos5l_dlhq_1
X_4705_ _5544_/B _4705_/A _4705_/B VPWR VGND sg13cmos5l_xnor2_1
X_2897_ _2897_/Y _5629_/Q _2897_/B VPWR VGND sg13cmos5l_nor2_1
X_4636_ _4636_/X _4911_/X _5062_/B _5708_/Q VPWR VGND sg13cmos5l_mux2_1
X_6306_ _6306_/Q Tile_X0Y1_FrameData[26] Tile_X0Y1_FrameStrobe[9] VPWR VGND sg13cmos5l_dlhq_1
X_4567_ _4590_/A _4466_/Y _4486_/B _4484_/Y VPWR VGND sg13cmos5l_o21ai_1
X_4498_ _5541_/B _4498_/A _4498_/B VPWR VGND sg13cmos5l_xor2_1
X_3518_ _5500_/B _2734_/Y _2814_/Y _3093_/Y _2813_/Y _6234_/Q _6233_/Q VPWR VGND sg13cmos5l_mux4_1
XFILLER_103_202 VPWR VGND sg13cmos5l_fill_1
X_6237_ _6237_/Q Tile_X0Y1_FrameData[31] Tile_X0Y1_FrameStrobe[7] VPWR VGND sg13cmos5l_dlhq_1
X_3449_ _3449_/X _4503_/Y _5262_/X _3916_/Y _5422_/B _6086_/Q _6088_/Q VPWR VGND sg13cmos5l_mux4_1
XFILLER_103_246 VPWR VGND sg13cmos5l_decap_4
X_6168_ _6168_/Q Tile_X0Y1_FrameData[4] Tile_X0Y1_FrameStrobe[4] VPWR VGND sg13cmos5l_dlhq_1
X_5119_ _5119_/Y _5932_/Q _5119_/B VPWR VGND sg13cmos5l_nor2_1
XFILLER_84_130 VPWR VGND sg13cmos5l_fill_1
X_6099_ _6099_/Q Tile_X0Y1_FrameData[9] Tile_X0Y1_FrameStrobe[2] VPWR VGND sg13cmos5l_dlhq_1
XFILLER_4_16 VPWR VGND sg13cmos5l_fill_1
XFILLER_104_0 VPWR VGND sg13cmos5l_fill_1
XFILLER_4_27 VPWR VGND sg13cmos5l_decap_4
XFILLER_0_373 VPWR VGND sg13cmos5l_fill_2
XFILLER_0_351 VPWR VGND sg13cmos5l_decap_8
XFILLER_75_174 VPWR VGND sg13cmos5l_fill_2
XFILLER_90_166 VPWR VGND sg13cmos5l_fill_2
X_2820_ _2820_/Y _5697_/Q VPWR VGND sg13cmos5l_inv_1
X_2751_ _2751_/Y Tile_X0Y0_W2MID[7] VPWR VGND sg13cmos5l_inv_1
X_5470_ _5471_/B _6326_/Q _5469_/Y _6325_/Q VPWR VGND sg13cmos5l_o21ai_1
X_4421_ _4421_/Y _6078_/Q _2891_/Y _4420_/Y VPWR VGND sg13cmos5l_o21ai_1
X_4352_ _4353_/B _6426_/Q _5999_/D _4351_/Y VPWR VGND sg13cmos5l_o21ai_1
X_4283_ _4284_/A _2859_/Y _4280_/X _4282_/Y VPWR VGND sg13cmos5l_a21oi_1
X_3303_ _3303_/Y _5724_/Q _3301_/X _3302_/Y VPWR VGND sg13cmos5l_a21oi_1
X_6022_ _6022_/Q Tile_X0Y1_FrameData[22] Tile_X0Y1_FrameStrobe[0] VPWR VGND sg13cmos5l_dlhq_1
X_3234_ _3234_/Y _3016_/B _5572_/Q _5977_/Q VPWR VGND sg13cmos5l_a21oi_1
X_3165_ _3165_/X Tile_X0Y1_E2END[1] Tile_X0Y1_W2END[1] Tile_X0Y1_E6END[1] Tile_X0Y1_W6END[1]
+ _6074_/Q _6076_/Q VPWR VGND sg13cmos5l_mux4_1
X_3096_ _3098_/B Tile_X0Y0_SS4END[1] _5582_/Q VPWR VGND sg13cmos5l_nor2b_1
XANTENNA__6804__X Tile_X0Y1_SS4BEG[1] VPWR VGND sg13cmos5l_antennanp
X_6855_ Tile_X0Y1_WW4BEG[3] Tile_X0Y1_WW4END[7] VPWR VGND sg13cmos5l_buf_1
X_5806_ _5806_/Q Tile_X0Y0_FrameData[20] Tile_X0Y1_FrameStrobe[7] VPWR VGND sg13cmos5l_dlhq_1
X_6786_ Tile_X0Y1_S2BEGb[7] _6786_/A VPWR VGND sg13cmos5l_buf_1
X_3998_ _3998_/Y _5855_/Q _3998_/B VPWR VGND sg13cmos5l_nor2_1
X_5737_ _5737_/Q Tile_X0Y0_FrameData[25] Tile_X0Y1_FrameStrobe[5] VPWR VGND sg13cmos5l_dlhq_1
X_2949_ _2949_/Y _2739_/Y _6062_/Q _2948_/Y VPWR VGND sg13cmos5l_a21oi_1
X_5668_ _5668_/Q Tile_X0Y0_FrameData[30] Tile_X0Y1_FrameStrobe[3] VPWR VGND sg13cmos5l_dlhq_1
XFILLER_108_327 VPWR VGND sg13cmos5l_decap_8
X_5599_ _5599_/Q Tile_X0Y0_FrameData[3] Tile_X0Y1_FrameStrobe[0] VPWR VGND sg13cmos5l_dlhq_1
X_4619_ _4656_/A _6425_/Q _5562_/Q VPWR VGND sg13cmos5l_nand2_1
XFILLER_89_222 VPWR VGND sg13cmos5l_fill_2
XANTENNA__6714__X Tile_X0Y1_E6BEG[7] VPWR VGND sg13cmos5l_antennanp
XFILLER_53_380 VPWR VGND sg13cmos5l_fill_1
XFILLER_95_258 VPWR VGND sg13cmos5l_fill_1
XFILLER_48_174 VPWR VGND sg13cmos5l_fill_1
XANTENNA__6624__X Tile_X0Y0_NN4BEG[2] VPWR VGND sg13cmos5l_antennanp
X_4970_ _4970_/X _4707_/Y _4911_/X _4937_/Y _5062_/B _5702_/Q _5700_/Q VPWR VGND sg13cmos5l_mux4_1
XFILLER_51_306 VPWR VGND sg13cmos5l_fill_2
X_3921_ _3924_/A _5681_/Q _3921_/B VPWR VGND sg13cmos5l_nor2_1
X_6640_ Tile_X0Y0_W1BEG[1] _6640_/A VPWR VGND sg13cmos5l_buf_1
X_3852_ _3852_/Y _3852_/A _3852_/B _3852_/C VPWR VGND sg13cmos5l_nor3_1
X_6571_ Tile_X0Y0_FrameStrobe_O[5] Tile_X0Y1_FrameStrobe[5] VPWR VGND sg13cmos5l_buf_1
X_2803_ _2803_/Y _6327_/Q VPWR VGND sg13cmos5l_inv_1
X_5522_ _5522_/Y _6272_/Q _5522_/B _5522_/C VPWR VGND sg13cmos5l_nand3_1
X_3783_ _3783_/Y _3778_/Y _3781_/Y _3782_/Y VPWR VGND sg13cmos5l_o21ai_1
X_2734_ _2734_/Y Tile_X0Y1_N2MID[3] VPWR VGND sg13cmos5l_inv_1
XFILLER_67_0 VPWR VGND sg13cmos5l_fill_2
X_5453_ _6822_/A _5262_/X _6772_/A _5342_/B _4284_/Y _6333_/Q _6334_/Q VPWR VGND sg13cmos5l_mux4_1
X_5384_ _5385_/C _6138_/Q _3916_/Y _5383_/Y VPWR VGND sg13cmos5l_o21ai_1
X_4404_ _4404_/X _6046_/Q _4515_/Y VPWR VGND sg13cmos5l_or2_1
X_4335_ _4335_/Y _6242_/Q Tile_X0Y1_N2MID[2] VPWR VGND sg13cmos5l_nor2b_1
X_4266_ _4267_/B _4266_/A _4266_/B VPWR VGND sg13cmos5l_xnor2_1
X_6005_ _6005_/Q Tile_X0Y1_UserCLK _6005_/D _6459_/L_HI VPWR VGND sg13cmos5l_dfrbpq_1
X_4197_ _4198_/B _4197_/A _4265_/A VPWR VGND sg13cmos5l_xnor2_1
X_3217_ _3217_/Y _3217_/A VPWR VGND sg13cmos5l_inv_1
X_3148_ _3148_/Y _6093_/Q _3148_/B VPWR VGND sg13cmos5l_nor2_1
X_3079_ _3079_/Y _5652_/Q _4707_/Y VPWR VGND sg13cmos5l_nor2_1
XANTENNA__6534__X Tile_X0Y0_FrameData_O[0] VPWR VGND sg13cmos5l_antennanp
X_6838_ Tile_X0Y1_W2BEGb[6] Tile_X0Y1_W2MID[6] VPWR VGND sg13cmos5l_buf_1
XFILLER_24_68 VPWR VGND sg13cmos5l_fill_1
X_6769_ Tile_X0Y1_S1BEG[2] _6769_/A VPWR VGND sg13cmos5l_buf_1
XFILLER_10_236 VPWR VGND sg13cmos5l_fill_2
XFILLER_108_113 VPWR VGND sg13cmos5l_fill_2
XFILLER_104_374 VPWR VGND sg13cmos5l_decap_8
XANTENNA__6709__X Tile_X0Y1_E6BEG[2] VPWR VGND sg13cmos5l_antennanp
XFILLER_1_28 VPWR VGND sg13cmos5l_decap_8
XFILLER_92_217 VPWR VGND sg13cmos5l_decap_4
XFILLER_18_314 VPWR VGND sg13cmos5l_fill_2
XFILLER_105_93 VPWR VGND sg13cmos5l_fill_2
XFILLER_18_347 VPWR VGND sg13cmos5l_decap_4
XANTENNA_110 Tile_X0Y0_W2MID[3] VPWR VGND sg13cmos5l_antennanp
XANTENNA_121 Tile_X0Y0_W2MID[7] VPWR VGND sg13cmos5l_antennanp
XANTENNA_132 Tile_X0Y0_WW4END[2] VPWR VGND sg13cmos5l_antennanp
XANTENNA_143 Tile_X0Y1_E2MID[2] VPWR VGND sg13cmos5l_antennanp
XANTENNA_154 Tile_X0Y1_E2MID[5] VPWR VGND sg13cmos5l_antennanp
XANTENNA_165 Tile_X0Y1_N4END[3] VPWR VGND sg13cmos5l_antennanp
XANTENNA_176 Tile_X0Y1_W2END[0] VPWR VGND sg13cmos5l_antennanp
XFILLER_45_188 VPWR VGND sg13cmos5l_decap_8
XANTENNA_187 Tile_X0Y1_W2MID[3] VPWR VGND sg13cmos5l_antennanp
XANTENNA_198 Tile_X0Y1_W2MID[6] VPWR VGND sg13cmos5l_antennanp
XFILLER_60_169 VPWR VGND sg13cmos5l_fill_2
XFILLER_81_74 VPWR VGND sg13cmos5l_fill_2
XFILLER_68_203 VPWR VGND sg13cmos5l_fill_1
XANTENNA__6619__X Tile_X0Y0_N4BEG[13] VPWR VGND sg13cmos5l_antennanp
X_4120_ _4120_/X _4120_/A _4120_/B VPWR VGND sg13cmos5l_or2_1
X_4051_ _4051_/Y _5717_/Q _4049_/X VPWR VGND sg13cmos5l_nor2b_1
X_3002_ _3002_/Y _6168_/Q Tile_X0Y1_W2END[2] VPWR VGND sg13cmos5l_nor2b_1
XFILLER_51_103 VPWR VGND sg13cmos5l_decap_8
X_4953_ _4953_/Y _4953_/A _5604_/Q VPWR VGND sg13cmos5l_nor2b_1
X_3904_ _4229_/A _3906_/A _3906_/B VPWR VGND sg13cmos5l_nor2_1
X_6623_ Tile_X0Y0_NN4BEG[1] Tile_X0Y1_NN4END[9] VPWR VGND sg13cmos5l_buf_1
X_4884_ _4885_/B _3063_/X Tile_X0Y0_S1END[1] Tile_X0Y1_N2MID[7] Tile_X0Y0_S1END[3]
+ _5608_/Q _5610_/Q VPWR VGND sg13cmos5l_mux4_1
X_3835_ _3835_/Y _5666_/Q _3832_/Y _3834_/Y VPWR VGND sg13cmos5l_a21oi_1
X_6554_ Tile_X0Y0_FrameData_O[20] Tile_X0Y0_FrameData[20] VPWR VGND sg13cmos5l_buf_1
X_3766_ _3790_/A _3766_/A _3766_/B VPWR VGND sg13cmos5l_nand2_1
X_5505_ _5505_/Y _6316_/Q _5504_/X _6315_/Q VPWR VGND sg13cmos5l_o21ai_1
X_6485_ _6485_/L_HI VPWR VGND sg13cmos5l_tiehi
X_2717_ _4413_/A _6045_/Q VPWR VGND sg13cmos5l_inv_1
X_5436_ _5436_/Y _6106_/Q _5435_/Y _2801_/Y VPWR VGND sg13cmos5l_o21ai_1
X_3697_ _3697_/Y _6104_/Q _3696_/X _6103_/Q VPWR VGND sg13cmos5l_o21ai_1
X_5367_ _5367_/X Tile_X0Y1_W2END[1] Tile_X0Y1_W6END[1] _6140_/Q VPWR VGND sg13cmos5l_mux2_1
XANTENNA__6529__X Tile_X0Y0_EE4BEG[11] VPWR VGND sg13cmos5l_antennanp
X_5298_ _5298_/X _6392_/Q _3162_/Y _5297_/Y VPWR VGND sg13cmos5l_a21o_1
X_4318_ _4318_/Y Tile_X0Y1_W2MID[5] _6208_/Q VPWR VGND sg13cmos5l_nand2_1
X_4249_ _4271_/A _4249_/A _4249_/B VPWR VGND sg13cmos5l_xor2_1
XFILLER_101_366 VPWR VGND sg13cmos5l_fill_2
XFILLER_27_177 VPWR VGND sg13cmos5l_fill_2
XFILLER_15_339 VPWR VGND sg13cmos5l_fill_1
XFILLER_50_180 VPWR VGND sg13cmos5l_fill_2
X_3620_ _3620_/Y _6260_/Q _3620_/B VPWR VGND sg13cmos5l_nand2_1
X_3551_ _3551_/Y Tile_X0Y0_W6END[1] _5656_/Q _3550_/Y VPWR VGND sg13cmos5l_a21oi_1
X_6270_ _6270_/Q Tile_X0Y1_FrameData[30] Tile_X0Y1_FrameStrobe[8] VPWR VGND sg13cmos5l_dlhq_1
X_3482_ _3482_/Y _6300_/Q _3481_/Y _6299_/Q VPWR VGND sg13cmos5l_a21oi_1
X_5221_ _5221_/Y _5876_/Q _5221_/B VPWR VGND sg13cmos5l_nor2_1
X_5152_ _5152_/X _5922_/Q _5149_/X _5151_/Y VPWR VGND sg13cmos5l_a21o_1
X_4103_ _4105_/B _4205_/A _4600_/A VPWR VGND sg13cmos5l_nor2_1
X_5083_ _5083_/Y _5081_/Y _5082_/Y _5729_/Q VPWR VGND sg13cmos5l_o21ai_1
XFILLER_2_60 VPWR VGND sg13cmos5l_fill_2
X_4034_ _4600_/A _6428_/Q _5983_/Q _4033_/Y VPWR VGND sg13cmos5l_a21oi_1
X_5985_ _5985_/Q Tile_X0Y1_UserCLK _5985_/D _6439_/L_HI VPWR VGND sg13cmos5l_dfrbpq_1
X_4936_ _4936_/Y _5568_/Q _6423_/Q VPWR VGND sg13cmos5l_nand2_1
XANTENNA__6812__X Tile_X0Y1_SS4BEG[9] VPWR VGND sg13cmos5l_antennanp
XANTENNA_10 Tile_X0Y0_E2END[7] VPWR VGND sg13cmos5l_antennanp
XANTENNA_21 Tile_X0Y0_E2END[7] VPWR VGND sg13cmos5l_antennanp
XANTENNA_32 Tile_X0Y0_E2MID[0] VPWR VGND sg13cmos5l_antennanp
X_4867_ _4867_/Y _4870_/A _4870_/B VPWR VGND sg13cmos5l_nand2_1
XFILLER_32_180 VPWR VGND sg13cmos5l_fill_2
XANTENNA_43 Tile_X0Y0_E2MID[0] VPWR VGND sg13cmos5l_antennanp
XANTENNA_54 Tile_X0Y0_E2MID[2] VPWR VGND sg13cmos5l_antennanp
XANTENNA_65 Tile_X0Y0_E2MID[3] VPWR VGND sg13cmos5l_antennanp
X_6606_ Tile_X0Y0_N4BEG[0] Tile_X0Y1_N4END[8] VPWR VGND sg13cmos5l_buf_1
X_3818_ _5522_/C _3802_/X _3808_/X _3814_/Y _3817_/Y VPWR VGND sg13cmos5l_a22oi_1
XANTENNA_76 Tile_X0Y0_E2MID[4] VPWR VGND sg13cmos5l_antennanp
X_6537_ Tile_X0Y0_FrameData_O[3] Tile_X0Y0_FrameData[3] VPWR VGND sg13cmos5l_buf_1
X_4798_ _4798_/X _4940_/Y _4934_/Y _4943_/Y _5011_/X _5706_/Q _5704_/Q VPWR VGND sg13cmos5l_mux4_1
XANTENNA_98 Tile_X0Y0_SS4END[4] VPWR VGND sg13cmos5l_antennanp
XANTENNA_87 Tile_X0Y0_SS4END[2] VPWR VGND sg13cmos5l_antennanp
X_3749_ _3749_/Y _6250_/Q _3747_/A _3748_/Y VPWR VGND sg13cmos5l_a21oi_1
X_6468_ _6468_/L_HI VPWR VGND sg13cmos5l_tiehi
XFILLER_108_7 VPWR VGND sg13cmos5l_decap_8
X_5419_ _5426_/A _6339_/Q _5419_/B VPWR VGND sg13cmos5l_nor2_1
X_6399_ _6399_/Q Tile_X0Y1_FrameData[29] Tile_X0Y1_FrameStrobe[12] VPWR VGND sg13cmos5l_dlhq_1
XFILLER_46_77 VPWR VGND sg13cmos5l_fill_1
XFILLER_55_272 VPWR VGND sg13cmos5l_fill_1
XANTENNA__6722__X Tile_X0Y1_EE4BEG[3] VPWR VGND sg13cmos5l_antennanp
XFILLER_11_320 VPWR VGND sg13cmos5l_fill_1
XFILLER_11_364 VPWR VGND sg13cmos5l_fill_1
XFILLER_7_379 VPWR VGND sg13cmos5l_fill_2
XFILLER_61_253 VPWR VGND sg13cmos5l_fill_2
X_5770_ _5770_/Q Tile_X0Y0_FrameData[24] Tile_X0Y1_FrameStrobe[6] VPWR VGND sg13cmos5l_dlhq_1
X_2982_ _2982_/X Tile_X0Y0_E2END[4] Tile_X0Y0_W2END[4] Tile_X0Y0_E6END[0] Tile_X0Y0_W6END[0]
+ _5620_/Q _5622_/Q VPWR VGND sg13cmos5l_mux4_1
XANTENNA__6632__X Tile_X0Y0_NN4BEG[10] VPWR VGND sg13cmos5l_antennanp
X_4721_ _4724_/A _4721_/A _4721_/B VPWR VGND sg13cmos5l_xnor2_1
X_4652_ _4653_/B _5848_/Q _5191_/B _4629_/Y _4651_/Y _5847_/Q VPWR VGND sg13cmos5l_a221oi_1
X_3603_ _3604_/B _6163_/Q _3597_/X _6161_/Q VPWR VGND sg13cmos5l_o21ai_1
X_4583_ _4583_/Y _4584_/A _4584_/B VPWR VGND sg13cmos5l_nand2_1
X_6322_ _6322_/Q Tile_X0Y1_FrameData[10] Tile_X0Y1_FrameStrobe[9] VPWR VGND sg13cmos5l_dlhq_1
X_3534_ _3534_/Y _6135_/Q _3532_/X VPWR VGND sg13cmos5l_nor2b_1
X_6253_ _6253_/Q Tile_X0Y1_FrameData[15] Tile_X0Y1_FrameStrobe[7] VPWR VGND sg13cmos5l_dlhq_1
X_3465_ _3465_/Y _6289_/Q _3465_/B VPWR VGND sg13cmos5l_nor2_1
XFILLER_107_28 VPWR VGND sg13cmos5l_decap_8
X_5204_ _5204_/Y _5884_/Q _5204_/B VPWR VGND sg13cmos5l_nor2_1
X_6184_ _6184_/Q Tile_X0Y1_FrameData[20] Tile_X0Y1_FrameStrobe[5] VPWR VGND sg13cmos5l_dlhq_1
X_3396_ _3475_/B _6122_/Q _3393_/X _3395_/Y VPWR VGND sg13cmos5l_a21oi_1
X_5135_ _6533_/A _5135_/A VPWR VGND sg13cmos5l_inv_1
XFILLER_69_364 VPWR VGND sg13cmos5l_fill_2
XANTENNA__6807__X Tile_X0Y1_SS4BEG[4] VPWR VGND sg13cmos5l_antennanp
X_5066_ _5066_/Y _5951_/Q _5229_/B VPWR VGND sg13cmos5l_nand2_1
XFILLER_84_334 VPWR VGND sg13cmos5l_fill_2
X_4017_ _5245_/B _5791_/Q _4016_/X _4015_/Y VPWR VGND sg13cmos5l_o21ai_1
XFILLER_52_242 VPWR VGND sg13cmos5l_fill_1
X_5968_ _5968_/Q Tile_X0Y0_FrameData[18] Tile_X0Y1_FrameStrobe[12] VPWR VGND sg13cmos5l_dlhq_1
XFILLER_52_286 VPWR VGND sg13cmos5l_decap_4
XANTENNA__6542__X Tile_X0Y0_FrameData_O[8] VPWR VGND sg13cmos5l_antennanp
X_4919_ _4919_/Y _2761_/Y _3995_/A _5831_/Q VPWR VGND sg13cmos5l_a21oi_1
X_5899_ _5899_/Q Tile_X0Y0_FrameData[23] Tile_X0Y1_FrameStrobe[10] VPWR VGND sg13cmos5l_dlhq_1
XFILLER_106_4 VPWR VGND sg13cmos5l_decap_8
XFILLER_106_299 VPWR VGND sg13cmos5l_fill_2
XANTENNA__6717__X Tile_X0Y1_E6BEG[10] VPWR VGND sg13cmos5l_antennanp
X_3250_ _3250_/Y _5692_/Q _3250_/B VPWR VGND sg13cmos5l_nor2_1
X_3181_ _3182_/A _2771_/Y _5690_/Q _3180_/Y VPWR VGND sg13cmos5l_a21oi_1
XANTENNA__6627__X Tile_X0Y0_NN4BEG[5] VPWR VGND sg13cmos5l_antennanp
XFILLER_93_120 VPWR VGND sg13cmos5l_fill_2
XFILLER_19_261 VPWR VGND sg13cmos5l_fill_1
X_5822_ _5822_/Q Tile_X0Y0_FrameData[4] Tile_X0Y1_FrameStrobe[7] VPWR VGND sg13cmos5l_dlhq_1
X_5753_ _5753_/Q Tile_X0Y0_FrameData[9] Tile_X0Y1_FrameStrobe[5] VPWR VGND sg13cmos5l_dlhq_1
XFILLER_97_0 VPWR VGND sg13cmos5l_fill_1
X_4704_ _4705_/B _4704_/A _4704_/B VPWR VGND sg13cmos5l_xor2_1
X_2965_ _2965_/Y _6172_/Q Tile_X0Y1_E1END[3] VPWR VGND sg13cmos5l_nor2b_1
X_5684_ _5684_/Q Tile_X0Y0_FrameData[14] Tile_X0Y1_FrameStrobe[3] VPWR VGND sg13cmos5l_dlhq_1
X_2896_ _2897_/B _4940_/Y _4707_/Y _5011_/X _4937_/Y _5630_/Q _5628_/Q VPWR VGND sg13cmos5l_mux4_1
X_4635_ _4635_/Y _5708_/Q _2890_/Y _4634_/Y VPWR VGND sg13cmos5l_a21oi_1
X_4566_ _4662_/A _4566_/A _4566_/B VPWR VGND sg13cmos5l_nand2_1
X_6305_ _6305_/Q Tile_X0Y1_FrameData[27] Tile_X0Y1_FrameStrobe[9] VPWR VGND sg13cmos5l_dlhq_1
X_3517_ _3767_/A _4247_/A _4138_/A VPWR VGND sg13cmos5l_nand2_1
X_4497_ _4498_/B _4497_/A _4497_/B VPWR VGND sg13cmos5l_nor2_1
X_6236_ _6236_/Q Tile_X0Y1_FrameData[0] Tile_X0Y1_FrameStrobe[6] VPWR VGND sg13cmos5l_dlhq_1
X_3448_ _3448_/Y _6087_/Q _3448_/B VPWR VGND sg13cmos5l_nor2_1
X_6167_ _6167_/Q Tile_X0Y1_FrameData[5] Tile_X0Y1_FrameStrobe[4] VPWR VGND sg13cmos5l_dlhq_1
X_3379_ _3379_/X Tile_X0Y1_N1END[1] Tile_X0Y1_E1END[1] Tile_X0Y1_N2END[5] Tile_X0Y1_E2END[5]
+ _6155_/Q _6156_/Q VPWR VGND sg13cmos5l_mux4_1
XANTENNA__6537__X Tile_X0Y0_FrameData_O[3] VPWR VGND sg13cmos5l_antennanp
X_5118_ _5119_/B _5934_/Q _2886_/Y _5117_/Y VPWR VGND sg13cmos5l_a21oi_1
XFILLER_111_280 VPWR VGND sg13cmos5l_decap_8
X_6098_ _6098_/Q Tile_X0Y1_FrameData[10] Tile_X0Y1_FrameStrobe[2] VPWR VGND sg13cmos5l_dlhq_1
X_5049_ _6634_/A _5045_/Y _5048_/Y _5042_/Y VPWR VGND sg13cmos5l_a21oi_1
XFILLER_72_315 VPWR VGND sg13cmos5l_fill_2
XFILLER_0_330 VPWR VGND sg13cmos5l_decap_8
X_2750_ _2750_/Y Tile_X0Y0_S2MID[7] VPWR VGND sg13cmos5l_inv_1
X_4420_ _4420_/Y _6078_/Q _5422_/B VPWR VGND sg13cmos5l_nand2_1
X_4351_ _4351_/Y _6426_/Q _2868_/Y _6425_/Q VPWR VGND sg13cmos5l_a21oi_1
X_4282_ _4282_/Y _6014_/Q _3421_/Y _4281_/Y VPWR VGND sg13cmos5l_a21oi_1
X_3302_ _3302_/Y _5724_/Q _3300_/X _5725_/Q VPWR VGND sg13cmos5l_o21ai_1
X_6021_ _6021_/Q Tile_X0Y1_FrameData[23] Tile_X0Y1_FrameStrobe[0] VPWR VGND sg13cmos5l_dlhq_1
X_3233_ _3233_/Y _5572_/Q _3231_/Y _3232_/Y VPWR VGND sg13cmos5l_a21oi_1
XFILLER_66_120 VPWR VGND sg13cmos5l_fill_2
X_3164_ _3164_/X _3916_/Y _5262_/X _4518_/Y _5422_/B _6074_/Q _6076_/Q VPWR VGND sg13cmos5l_mux4_1
XFILLER_12_0 VPWR VGND sg13cmos5l_fill_2
X_3095_ _3099_/A _5582_/Q _3093_/Y _3094_/Y VPWR VGND sg13cmos5l_a21oi_1
XFILLER_54_326 VPWR VGND sg13cmos5l_fill_1
X_6854_ Tile_X0Y1_WW4BEG[2] Tile_X0Y1_WW4END[6] VPWR VGND sg13cmos5l_buf_1
X_5805_ _5805_/Q Tile_X0Y0_FrameData[21] Tile_X0Y1_FrameStrobe[7] VPWR VGND sg13cmos5l_dlhq_1
X_6785_ Tile_X0Y1_S2BEGb[6] _6785_/A VPWR VGND sg13cmos5l_buf_1
X_3997_ _3998_/B _5856_/Q _3997_/B VPWR VGND sg13cmos5l_nor2_1
X_5736_ _5736_/Q Tile_X0Y0_FrameData[26] Tile_X0Y1_FrameStrobe[5] VPWR VGND sg13cmos5l_dlhq_1
X_2948_ _2948_/Y Tile_X0Y1_N1END[2] _6062_/Q VPWR VGND sg13cmos5l_nor2_1
XANTENNA__6820__X Tile_X0Y1_W1BEG[0] VPWR VGND sg13cmos5l_antennanp
X_5667_ _5667_/Q Tile_X0Y0_FrameData[31] Tile_X0Y1_FrameStrobe[3] VPWR VGND sg13cmos5l_dlhq_1
X_4618_ _4618_/Y _4662_/A _4662_/B VPWR VGND sg13cmos5l_nand2_1
X_2879_ _2879_/Y _6211_/Q VPWR VGND sg13cmos5l_inv_1
X_5598_ _5598_/Q Tile_X0Y0_FrameData[4] Tile_X0Y1_FrameStrobe[0] VPWR VGND sg13cmos5l_dlhq_1
X_4549_ _4549_/Y _5584_/Q Tile_X0Y0_S4END[2] _5583_/Q VPWR VGND sg13cmos5l_o21ai_1
X_6219_ _6219_/Q Tile_X0Y1_FrameData[17] Tile_X0Y1_FrameStrobe[6] VPWR VGND sg13cmos5l_dlhq_1
XFILLER_54_11 VPWR VGND sg13cmos5l_fill_2
XANTENNA__6730__X Tile_X0Y1_EE4BEG[11] VPWR VGND sg13cmos5l_antennanp
XFILLER_95_204 VPWR VGND sg13cmos5l_fill_1
XFILLER_95_62 VPWR VGND sg13cmos5l_fill_1
XFILLER_36_315 VPWR VGND sg13cmos5l_fill_2
XFILLER_63_145 VPWR VGND sg13cmos5l_fill_1
X_3920_ _3921_/B _4940_/Y _4934_/Y _5011_/X _4937_/Y _5682_/Q _5680_/Q VPWR VGND sg13cmos5l_mux4_1
XFILLER_51_318 VPWR VGND sg13cmos5l_fill_2
X_3851_ _3913_/A _6425_/Q _5555_/Q _3849_/X _3850_/Y VPWR VGND sg13cmos5l_a22oi_1
X_6570_ Tile_X0Y0_FrameStrobe_O[4] Tile_X0Y1_FrameStrobe[4] VPWR VGND sg13cmos5l_buf_1
X_3782_ _3782_/Y _6294_/Q _5450_/B _6293_/Q VPWR VGND sg13cmos5l_a21oi_1
X_2802_ _2802_/Y _6330_/Q VPWR VGND sg13cmos5l_inv_1
XANTENNA__6640__X Tile_X0Y0_W1BEG[1] VPWR VGND sg13cmos5l_antennanp
X_5521_ _6851_/A _5518_/Y _5520_/Y _5516_/Y VPWR VGND sg13cmos5l_o21ai_1
X_2733_ _2733_/Y Tile_X0Y0_S2END[3] VPWR VGND sg13cmos5l_inv_1
X_5452_ _6821_/A _6335_/Q _5451_/Y _5449_/X VPWR VGND sg13cmos5l_o21ai_1
X_5383_ _5383_/Y _6138_/Q _2892_/Y _6140_/Q VPWR VGND sg13cmos5l_a21oi_1
X_4403_ _4403_/X _4509_/Y _5390_/B _6046_/Q VPWR VGND sg13cmos5l_mux2_1
X_4334_ _4334_/Y _6242_/Q _3338_/A _4333_/Y VPWR VGND sg13cmos5l_a21oi_1
X_6004_ _6004_/Q Tile_X0Y1_UserCLK _6004_/D _6458_/L_HI VPWR VGND sg13cmos5l_dfrbpq_1
X_4265_ _4265_/Y _4265_/A _4480_/A VPWR VGND sg13cmos5l_nand2_1
X_4196_ _4196_/Y _4478_/A _4602_/A _4197_/A VPWR VGND sg13cmos5l_nor3_1
X_3216_ _3217_/A _2885_/Y _3075_/A _5191_/B _3099_/Y _5917_/Q _5918_/Q VPWR VGND sg13cmos5l_mux4_1
X_3147_ _3148_/B _6094_/Q _3143_/X _3146_/Y VPWR VGND sg13cmos5l_a21oi_1
XANTENNA__6815__X Tile_X0Y1_SS4BEG[12] VPWR VGND sg13cmos5l_antennanp
X_3078_ _3078_/Y _5652_/Q _4943_/Y _3077_/Y VPWR VGND sg13cmos5l_o21ai_1
XFILLER_42_318 VPWR VGND sg13cmos5l_fill_1
XFILLER_42_307 VPWR VGND sg13cmos5l_decap_8
X_6837_ Tile_X0Y1_W2BEGb[5] Tile_X0Y1_W2MID[5] VPWR VGND sg13cmos5l_buf_1
XFILLER_10_215 VPWR VGND sg13cmos5l_fill_1
XANTENNA__6550__X Tile_X0Y0_FrameData_O[16] VPWR VGND sg13cmos5l_antennanp
X_6768_ Tile_X0Y1_S1BEG[1] _6768_/A VPWR VGND sg13cmos5l_buf_1
X_5719_ _5719_/Q Tile_X0Y0_FrameData[11] Tile_X0Y1_FrameStrobe[4] VPWR VGND sg13cmos5l_dlhq_1
X_6699_ Tile_X0Y1_E2BEGb[0] Tile_X0Y1_E2MID[0] VPWR VGND sg13cmos5l_buf_1
XFILLER_104_320 VPWR VGND sg13cmos5l_fill_1
XFILLER_104_342 VPWR VGND sg13cmos5l_decap_4
XFILLER_65_10 VPWR VGND sg13cmos5l_decap_4
XANTENNA__6725__X Tile_X0Y1_EE4BEG[6] VPWR VGND sg13cmos5l_antennanp
XANTENNA_100 Tile_X0Y0_SS4END[5] VPWR VGND sg13cmos5l_antennanp
XANTENNA_111 Tile_X0Y0_W2MID[3] VPWR VGND sg13cmos5l_antennanp
XANTENNA_122 Tile_X0Y0_W2MID[7] VPWR VGND sg13cmos5l_antennanp
XANTENNA_133 Tile_X0Y0_WW4END[2] VPWR VGND sg13cmos5l_antennanp
XANTENNA_144 Tile_X0Y1_E2MID[2] VPWR VGND sg13cmos5l_antennanp
XANTENNA_155 Tile_X0Y1_E2MID[5] VPWR VGND sg13cmos5l_antennanp
XANTENNA_166 Tile_X0Y1_NN4END[6] VPWR VGND sg13cmos5l_antennanp
XANTENNA_177 Tile_X0Y1_W2END[0] VPWR VGND sg13cmos5l_antennanp
XANTENNA_188 Tile_X0Y1_W2MID[3] VPWR VGND sg13cmos5l_antennanp
XANTENNA_199 Tile_X0Y1_W2MID[6] VPWR VGND sg13cmos5l_antennanp
XFILLER_107_180 VPWR VGND sg13cmos5l_fill_2
XFILLER_39_5 VPWR VGND sg13cmos5l_fill_1
X_4050_ _4050_/X Tile_X0Y0_E1END[2] Tile_X0Y0_E2END[4] Tile_X0Y0_W2END[4] Tile_X0Y0_W6END[0]
+ _5718_/Q _5716_/Q VPWR VGND sg13cmos5l_mux4_1
XFILLER_110_356 VPWR VGND sg13cmos5l_fill_2
X_3001_ _3001_/Y _6167_/Q _3001_/B VPWR VGND sg13cmos5l_nand2b_1
XANTENNA__6635__X Tile_X0Y0_NN4BEG[13] VPWR VGND sg13cmos5l_antennanp
XFILLER_36_145 VPWR VGND sg13cmos5l_fill_1
X_4952_ _4953_/A _2725_/Y _5606_/Q _4951_/Y VPWR VGND sg13cmos5l_a21oi_1
X_4883_ _4883_/Y _5609_/Q _4882_/X _4881_/Y VPWR VGND sg13cmos5l_a21oi_1
X_3903_ _3906_/B _4235_/A _3903_/B VPWR VGND sg13cmos5l_nand2_1
X_6622_ Tile_X0Y0_NN4BEG[0] Tile_X0Y1_NN4END[8] VPWR VGND sg13cmos5l_buf_1
X_3834_ _3834_/Y _5666_/Q _3833_/X _5665_/Q VPWR VGND sg13cmos5l_o21ai_1
X_6553_ Tile_X0Y0_FrameData_O[19] Tile_X0Y0_FrameData[19] VPWR VGND sg13cmos5l_buf_1
X_3765_ _3766_/B _6426_/Q _5995_/D _3764_/Y VPWR VGND sg13cmos5l_o21ai_1
X_5504_ _5504_/X _5374_/B _5262_/X _5440_/B _5422_/B _6318_/Q _6317_/Q VPWR VGND sg13cmos5l_mux4_1
X_6484_ _6484_/L_HI VPWR VGND sg13cmos5l_tiehi
X_3696_ _3696_/X _2891_/Y _2892_/Y _6102_/Q VPWR VGND sg13cmos5l_mux2_1
X_2716_ _4454_/A _6275_/Q VPWR VGND sg13cmos5l_inv_1
X_5435_ _5435_/Y Tile_X0Y1_E1END[3] _6108_/Q _5434_/Y VPWR VGND sg13cmos5l_a21oi_1
X_5366_ _5366_/X Tile_X0Y1_N1END[3] Tile_X0Y1_N2END[1] Tile_X0Y1_E6END[1] Tile_X0Y0_S2MID[1]
+ _6140_/Q _6138_/Q VPWR VGND sg13cmos5l_mux4_1
X_5297_ _5297_/Y _6392_/Q _6598_/A _6391_/Q VPWR VGND sg13cmos5l_o21ai_1
X_4317_ _5420_/B Tile_X0Y1_E2MID[4] Tile_X0Y1_W2MID[4] _6783_/A _6777_/A _6239_/Q
+ _6240_/Q VPWR VGND sg13cmos5l_mux4_1
X_4248_ _4490_/A _4249_/B _4249_/A VPWR VGND sg13cmos5l_nand2b_1
XFILLER_19_14 VPWR VGND sg13cmos5l_fill_2
XANTENNA__6545__X Tile_X0Y0_FrameData_O[11] VPWR VGND sg13cmos5l_antennanp
X_4179_ _4180_/B _5587_/Q _4178_/Y _5850_/Q VPWR VGND sg13cmos5l_o21ai_1
XFILLER_104_161 VPWR VGND sg13cmos5l_decap_8
XFILLER_76_64 VPWR VGND sg13cmos5l_fill_1
XFILLER_58_270 VPWR VGND sg13cmos5l_fill_2
XFILLER_14_340 VPWR VGND sg13cmos5l_fill_2
X_3550_ _3550_/Y _2755_/Y _5656_/Q _5658_/Q VPWR VGND sg13cmos5l_o21ai_1
X_5220_ _5221_/B _5878_/Q _2886_/Y _5219_/Y VPWR VGND sg13cmos5l_a21oi_1
X_3481_ _3481_/Y _3481_/A VPWR VGND sg13cmos5l_inv_1
X_5151_ _5151_/Y _5922_/Q _5150_/X _5921_/Q VPWR VGND sg13cmos5l_o21ai_1
X_5082_ _5082_/Y _5727_/Q _5082_/B VPWR VGND sg13cmos5l_nand2_1
X_4102_ _4105_/A _4009_/A _4005_/Y _4007_/Y VPWR VGND sg13cmos5l_o21ai_1
X_4033_ _4033_/Y _6428_/Q _4033_/B VPWR VGND sg13cmos5l_nor2_1
XFILLER_96_365 VPWR VGND sg13cmos5l_fill_1
X_5984_ _5984_/Q Tile_X0Y1_UserCLK _5984_/D _6438_/L_HI VPWR VGND sg13cmos5l_dfrbpq_1
X_4935_ _5548_/B _4935_/A _4935_/B VPWR VGND sg13cmos5l_xnor2_1
XANTENNA_11 Tile_X0Y0_E2END[7] VPWR VGND sg13cmos5l_antennanp
XANTENNA_22 Tile_X0Y0_E2END[7] VPWR VGND sg13cmos5l_antennanp
X_4866_ _4870_/B _4866_/A _4865_/Y VPWR VGND sg13cmos5l_nor2b_1
XANTENNA_33 Tile_X0Y0_E2MID[0] VPWR VGND sg13cmos5l_antennanp
XANTENNA_44 Tile_X0Y0_E2MID[0] VPWR VGND sg13cmos5l_antennanp
XANTENNA_55 Tile_X0Y0_E2MID[2] VPWR VGND sg13cmos5l_antennanp
XANTENNA_66 Tile_X0Y0_E2MID[3] VPWR VGND sg13cmos5l_antennanp
X_6605_ Tile_X0Y0_N2BEGb[7] _6605_/A VPWR VGND sg13cmos5l_buf_1
X_4797_ _4797_/Y _2724_/Y _5802_/Q _5801_/Q VPWR VGND sg13cmos5l_a21oi_1
X_3817_ _3817_/Y _6053_/Q _3817_/B VPWR VGND sg13cmos5l_nor2_1
XANTENNA_77 Tile_X0Y0_E2MID[6] VPWR VGND sg13cmos5l_antennanp
X_6536_ Tile_X0Y0_FrameData_O[2] Tile_X0Y0_FrameData[2] VPWR VGND sg13cmos5l_buf_1
X_3748_ _3748_/Y _6250_/Q _6781_/A _6249_/Q VPWR VGND sg13cmos5l_o21ai_1
XANTENNA_99 Tile_X0Y0_SS4END[4] VPWR VGND sg13cmos5l_antennanp
XANTENNA_88 Tile_X0Y0_SS4END[2] VPWR VGND sg13cmos5l_antennanp
X_6467_ _6467_/L_HI VPWR VGND sg13cmos5l_tiehi
X_3679_ _4261_/A _6427_/Q _5988_/D _3677_/Y VPWR VGND sg13cmos5l_o21ai_1
X_5418_ _5419_/B Tile_X0Y1_N1END[1] Tile_X0Y1_E1END[1] Tile_X0Y1_W1END[1] _5390_/B
+ _6341_/Q _6340_/Q VPWR VGND sg13cmos5l_mux4_1
X_6398_ _6398_/Q Tile_X0Y1_FrameData[30] Tile_X0Y1_FrameStrobe[12] VPWR VGND sg13cmos5l_dlhq_1
X_5349_ _5349_/X _4515_/Y _4509_/Y _4518_/Y _5390_/B _6374_/Q _6372_/Q VPWR VGND sg13cmos5l_mux4_1
XFILLER_70_265 VPWR VGND sg13cmos5l_fill_1
XFILLER_62_55 VPWR VGND sg13cmos5l_fill_1
XFILLER_11_343 VPWR VGND sg13cmos5l_decap_8
XFILLER_7_39 VPWR VGND sg13cmos5l_fill_2
XFILLER_93_379 VPWR VGND sg13cmos5l_fill_2
X_2981_ _2981_/X _4944_/X Tile_X0Y0_S2END[4] Tile_X0Y1_N2MID[4] Tile_X0Y0_S4END[0]
+ _5620_/Q _5622_/Q VPWR VGND sg13cmos5l_mux4_1
XFILLER_99_4 VPWR VGND sg13cmos5l_fill_2
X_4720_ _4727_/A _4721_/A _4721_/B VPWR VGND sg13cmos5l_nand2b_1
X_4651_ _4651_/Y _5848_/Q _4651_/B VPWR VGND sg13cmos5l_nor2_1
X_3602_ _3604_/A _6164_/Q _3599_/Y _3601_/Y VPWR VGND sg13cmos5l_a21oi_1
X_4582_ _4584_/B _4582_/A _4582_/B VPWR VGND sg13cmos5l_xor2_1
X_6321_ _6321_/Q Tile_X0Y1_FrameData[11] Tile_X0Y1_FrameStrobe[9] VPWR VGND sg13cmos5l_dlhq_1
X_3533_ _3533_/X Tile_X0Y1_N4END[2] Tile_X0Y1_W2END[2] Tile_X0Y1_E2END[2] Tile_X0Y1_WW4END[3]
+ _6134_/Q _6136_/Q VPWR VGND sg13cmos5l_mux4_1
X_6252_ _6252_/Q Tile_X0Y1_FrameData[16] Tile_X0Y1_FrameStrobe[7] VPWR VGND sg13cmos5l_dlhq_1
X_3464_ _3465_/B _6215_/Q _3460_/Y _3463_/Y VPWR VGND sg13cmos5l_a21oi_1
X_6183_ _6183_/Q Tile_X0Y1_FrameData[21] Tile_X0Y1_FrameStrobe[5] VPWR VGND sg13cmos5l_dlhq_1
X_5203_ _5207_/A _5884_/Q _5245_/B _5202_/X VPWR VGND sg13cmos5l_a21oi_1
X_5134_ _5135_/A _5929_/Q _5133_/X _5132_/Y VPWR VGND sg13cmos5l_o21ai_1
X_3395_ _3395_/Y _6122_/Q _3394_/X _2851_/Y VPWR VGND sg13cmos5l_o21ai_1
XFILLER_69_354 VPWR VGND sg13cmos5l_fill_1
X_5065_ _6636_/A _5059_/Y _5061_/Y _5063_/Y _5064_/X _5953_/Q _5952_/Q VPWR VGND sg13cmos5l_mux4_1
X_4016_ _4016_/X _6601_/A Tile_X0Y0_E2MID[3] _5792_/Q VPWR VGND sg13cmos5l_mux2_1
XANTENNA__6823__X Tile_X0Y1_W1BEG[3] VPWR VGND sg13cmos5l_antennanp
X_5967_ _5967_/Q Tile_X0Y0_FrameData[19] Tile_X0Y1_FrameStrobe[12] VPWR VGND sg13cmos5l_dlhq_1
X_4918_ _4921_/B _2761_/Y _3934_/A _4917_/Y VPWR VGND sg13cmos5l_a21oi_1
X_5898_ _5898_/Q Tile_X0Y0_FrameData[24] Tile_X0Y1_FrameStrobe[10] VPWR VGND sg13cmos5l_dlhq_1
X_4849_ _6648_/A _4849_/A VPWR VGND sg13cmos5l_inv_1
XFILLER_20_151 VPWR VGND sg13cmos5l_fill_1
X_6519_ Tile_X0Y0_EE4BEG[1] Tile_X0Y0_EE4END[5] VPWR VGND sg13cmos5l_buf_1
XFILLER_4_339 VPWR VGND sg13cmos5l_decap_8
XANTENNA__6733__X Tile_X0Y1_EE4BEG[14] VPWR VGND sg13cmos5l_antennanp
XFILLER_43_254 VPWR VGND sg13cmos5l_fill_1
XFILLER_98_40 VPWR VGND sg13cmos5l_fill_1
XFILLER_98_95 VPWR VGND sg13cmos5l_fill_1
XFILLER_3_361 VPWR VGND sg13cmos5l_fill_1
X_3180_ _3180_/Y Tile_X0Y0_W2END[3] _5690_/Q _5689_/Q VPWR VGND sg13cmos5l_o21ai_1
XFILLER_81_349 VPWR VGND sg13cmos5l_fill_2
XANTENNA__6643__X Tile_X0Y0_W2BEG[0] VPWR VGND sg13cmos5l_antennanp
X_5821_ _5821_/Q Tile_X0Y0_FrameData[5] Tile_X0Y1_FrameStrobe[7] VPWR VGND sg13cmos5l_dlhq_1
X_5752_ _5752_/Q Tile_X0Y0_FrameData[10] Tile_X0Y1_FrameStrobe[5] VPWR VGND sg13cmos5l_dlhq_1
X_2964_ _2964_/Y _6644_/A VPWR VGND sg13cmos5l_inv_1
X_4703_ _4703_/X _4704_/A _4704_/B VPWR VGND sg13cmos5l_and2_1
X_5683_ _5683_/Q Tile_X0Y0_FrameData[15] Tile_X0Y1_FrameStrobe[3] VPWR VGND sg13cmos5l_dlhq_1
X_2895_ _2895_/Y _5440_/B VPWR VGND sg13cmos5l_inv_1
X_4634_ _4634_/Y _5708_/Q _4707_/Y VPWR VGND sg13cmos5l_nor2_1
X_4565_ _4566_/B _6426_/Q _6005_/D _4564_/Y VPWR VGND sg13cmos5l_o21ai_1
X_6304_ _6304_/Q Tile_X0Y1_FrameData[28] Tile_X0Y1_FrameStrobe[9] VPWR VGND sg13cmos5l_dlhq_1
X_3516_ _4186_/A _4138_/A VPWR VGND sg13cmos5l_inv_1
X_4496_ _4497_/B _4496_/A _4496_/B _4496_/C VPWR VGND sg13cmos5l_and3_1
XFILLER_1_309 VPWR VGND sg13cmos5l_fill_2
X_6235_ _6235_/Q Tile_X0Y1_FrameData[1] Tile_X0Y1_FrameStrobe[6] VPWR VGND sg13cmos5l_dlhq_1
X_3447_ _3448_/B _4515_/Y _4509_/Y _4518_/Y _5374_/B _6088_/Q _6086_/Q VPWR VGND sg13cmos5l_mux4_1
XANTENNA__6818__X Tile_X0Y1_SS4BEG[15] VPWR VGND sg13cmos5l_antennanp
X_6166_ _6166_/Q Tile_X0Y1_FrameData[6] Tile_X0Y1_FrameStrobe[4] VPWR VGND sg13cmos5l_dlhq_1
X_3378_ _3378_/X _3217_/A _2790_/Y _2741_/Y _2789_/Y _6155_/Q _6156_/Q VPWR VGND sg13cmos5l_mux4_1
X_6097_ _6097_/Q Tile_X0Y1_FrameData[11] Tile_X0Y1_FrameStrobe[2] VPWR VGND sg13cmos5l_dlhq_1
X_5117_ _5117_/Y Tile_X0Y0_S1END[0] _5934_/Q _5933_/Q VPWR VGND sg13cmos5l_o21ai_1
X_5048_ _5048_/Y _5048_/A _5958_/Q VPWR VGND sg13cmos5l_nor2b_1
XFILLER_27_69 VPWR VGND sg13cmos5l_fill_2
XANTENNA__6553__X Tile_X0Y0_FrameData_O[19] VPWR VGND sg13cmos5l_antennanp
XFILLER_4_103 VPWR VGND sg13cmos5l_fill_2
XANTENNA__6728__X Tile_X0Y1_EE4BEG[9] VPWR VGND sg13cmos5l_antennanp
XFILLER_75_176 VPWR VGND sg13cmos5l_fill_1
XFILLER_75_165 VPWR VGND sg13cmos5l_fill_1
XFILLER_75_198 VPWR VGND sg13cmos5l_fill_1
XFILLER_31_213 VPWR VGND sg13cmos5l_fill_2
X_4350_ _5999_/D _4347_/Y _4349_/Y _4341_/Y VPWR VGND sg13cmos5l_o21ai_1
X_3301_ _3301_/X Tile_X0Y0_W2END[2] Tile_X0Y0_W6END[0] _5726_/Q VPWR VGND sg13cmos5l_mux2_1
X_4281_ _4281_/Y _6014_/Q Tile_X0Y1_W2END[0] _6429_/Q VPWR VGND sg13cmos5l_o21ai_1
XANTENNA__6638__X Tile_X0Y0_UserCLKo VPWR VGND sg13cmos5l_antennanp
X_6020_ _6020_/Q Tile_X0Y1_FrameData[24] Tile_X0Y1_FrameStrobe[0] VPWR VGND sg13cmos5l_dlhq_1
X_3232_ _3232_/Y _5572_/Q Tile_X0Y0_W2END[0] _5977_/Q VPWR VGND sg13cmos5l_o21ai_1
X_3163_ _3163_/X _4509_/Y _4503_/Y _5390_/B _5374_/B _6076_/Q _6074_/Q VPWR VGND sg13cmos5l_mux4_1
XFILLER_104_19 VPWR VGND sg13cmos5l_decap_8
X_3094_ _3094_/Y Tile_X0Y0_W2END[4] _5582_/Q _5581_/Q VPWR VGND sg13cmos5l_o21ai_1
X_6853_ Tile_X0Y1_WW4BEG[1] Tile_X0Y1_WW4END[5] VPWR VGND sg13cmos5l_buf_1
X_5804_ _5804_/Q Tile_X0Y0_FrameData[22] Tile_X0Y1_FrameStrobe[7] VPWR VGND sg13cmos5l_dlhq_1
X_6784_ Tile_X0Y1_S2BEGb[5] _6784_/A VPWR VGND sg13cmos5l_buf_1
X_3996_ _3997_/B Tile_X0Y0_E2MID[6] Tile_X0Y0_W2MID[6] Tile_X0Y0_S2MID[6] _6594_/A
+ _5817_/Q _5818_/Q VPWR VGND sg13cmos5l_mux4_1
X_5735_ _5735_/Q Tile_X0Y0_FrameData[27] Tile_X0Y1_FrameStrobe[5] VPWR VGND sg13cmos5l_dlhq_1
X_2947_ _2947_/Y _2797_/Y _6062_/Q _2946_/Y VPWR VGND sg13cmos5l_a21oi_1
X_5666_ _5666_/Q Tile_X0Y0_FrameData[0] Tile_X0Y1_FrameStrobe[2] VPWR VGND sg13cmos5l_dlhq_1
X_4617_ _4662_/B _4617_/A _4617_/B VPWR VGND sg13cmos5l_xnor2_1
X_2878_ _2878_/Y _6286_/Q VPWR VGND sg13cmos5l_inv_1
X_5597_ _5597_/Q Tile_X0Y0_FrameData[5] Tile_X0Y1_FrameStrobe[0] VPWR VGND sg13cmos5l_dlhq_1
X_4548_ _6495_/A _4548_/A VPWR VGND sg13cmos5l_inv_1
X_4479_ _4479_/Y _4480_/A _4572_/A VPWR VGND sg13cmos5l_nand2_1
XANTENNA__6548__X Tile_X0Y0_FrameData_O[14] VPWR VGND sg13cmos5l_antennanp
X_6218_ _6218_/Q Tile_X0Y1_FrameData[18] Tile_X0Y1_FrameStrobe[6] VPWR VGND sg13cmos5l_dlhq_1
X_6149_ _6149_/Q Tile_X0Y1_FrameData[23] Tile_X0Y1_FrameStrobe[4] VPWR VGND sg13cmos5l_dlhq_1
XFILLER_53_360 VPWR VGND sg13cmos5l_fill_2
XFILLER_107_351 VPWR VGND sg13cmos5l_fill_1
XFILLER_51_308 VPWR VGND sg13cmos5l_fill_1
X_3850_ _3850_/Y _6426_/Q _2882_/Y _6425_/Q VPWR VGND sg13cmos5l_a21oi_1
X_3781_ _3781_/Y _6251_/Q _3780_/Y _2838_/Y VPWR VGND sg13cmos5l_o21ai_1
X_2801_ _2801_/Y _6107_/Q VPWR VGND sg13cmos5l_inv_1
X_5520_ _5520_/Y _6312_/Q _5519_/X _6311_/Q VPWR VGND sg13cmos5l_o21ai_1
X_2732_ _4024_/A Tile_X0Y0_S4END[2] VPWR VGND sg13cmos5l_inv_1
XFILLER_12_290 VPWR VGND sg13cmos5l_fill_1
X_5451_ _5451_/Y _6336_/Q _5374_/B _5450_/Y VPWR VGND sg13cmos5l_o21ai_1
X_5382_ _5385_/B _6140_/Q _5382_/B VPWR VGND sg13cmos5l_nand2_1
X_4402_ _4414_/B _4396_/Y _4399_/Y _4401_/Y VPWR VGND sg13cmos5l_a21oi_1
X_4333_ _4333_/Y Tile_X0Y1_W2MID[2] _6242_/Q _6241_/Q VPWR VGND sg13cmos5l_o21ai_1
X_4264_ _4266_/B _4478_/A _4600_/A VPWR VGND sg13cmos5l_nor2_1
X_6003_ _6003_/Q Tile_X0Y1_UserCLK _6003_/D _6457_/L_HI VPWR VGND sg13cmos5l_dfrbpq_1
X_3215_ _5191_/B _3214_/A _2750_/Y _2749_/Y _2751_/Y _5777_/Q _5778_/Q VPWR VGND sg13cmos5l_mux4_1
X_4195_ _4265_/A _4478_/A _4602_/A VPWR VGND sg13cmos5l_nor2_1
XFILLER_39_121 VPWR VGND sg13cmos5l_fill_1
X_3146_ _3146_/Y _6094_/Q _3145_/Y _6095_/Q VPWR VGND sg13cmos5l_o21ai_1
X_3077_ _3077_/Y _5062_/B _5652_/Q VPWR VGND sg13cmos5l_nand2b_1
X_6836_ Tile_X0Y1_W2BEGb[4] Tile_X0Y1_W2MID[4] VPWR VGND sg13cmos5l_buf_1
XANTENNA__6831__X Tile_X0Y1_W2BEG[7] VPWR VGND sg13cmos5l_antennanp
X_6767_ Tile_X0Y1_S1BEG[0] _6767_/A VPWR VGND sg13cmos5l_buf_1
X_5718_ _5718_/Q Tile_X0Y0_FrameData[12] Tile_X0Y1_FrameStrobe[4] VPWR VGND sg13cmos5l_dlhq_1
X_3979_ _3979_/Y _2751_/Y _5786_/Q _3978_/Y VPWR VGND sg13cmos5l_a21oi_1
X_6698_ Tile_X0Y1_E2BEG[7] _6698_/A VPWR VGND sg13cmos5l_buf_1
XFILLER_108_115 VPWR VGND sg13cmos5l_fill_1
XFILLER_108_104 VPWR VGND sg13cmos5l_decap_4
X_5649_ _5649_/Q Tile_X0Y0_FrameData[17] Tile_X0Y1_FrameStrobe[2] VPWR VGND sg13cmos5l_dlhq_1
XFILLER_108_148 VPWR VGND sg13cmos5l_fill_1
XFILLER_105_95 VPWR VGND sg13cmos5l_fill_1
XANTENNA_101 Tile_X0Y0_SS4END[5] VPWR VGND sg13cmos5l_antennanp
XANTENNA_112 Tile_X0Y0_W2MID[3] VPWR VGND sg13cmos5l_antennanp
XANTENNA_123 Tile_X0Y0_WW4END[0] VPWR VGND sg13cmos5l_antennanp
XANTENNA_134 Tile_X0Y0_WW4END[2] VPWR VGND sg13cmos5l_antennanp
XFILLER_65_77 VPWR VGND sg13cmos5l_fill_2
XANTENNA_145 Tile_X0Y1_E2MID[3] VPWR VGND sg13cmos5l_antennanp
XANTENNA_156 Tile_X0Y1_E2MID[5] VPWR VGND sg13cmos5l_antennanp
XANTENNA_167 Tile_X0Y1_NN4END[6] VPWR VGND sg13cmos5l_antennanp
XANTENNA_178 Tile_X0Y1_W2END[0] VPWR VGND sg13cmos5l_antennanp
XANTENNA_189 Tile_X0Y1_W2MID[3] VPWR VGND sg13cmos5l_antennanp
XANTENNA__6741__X Tile_X0Y1_FrameData_O[6] VPWR VGND sg13cmos5l_antennanp
X_3000_ _3001_/B Tile_X0Y1_N2END[2] Tile_X0Y1_E6END[0] Tile_X0Y1_N4END[2] Tile_X0Y0_S2MID[2]
+ _6166_/Q _6168_/Q VPWR VGND sg13cmos5l_mux4_1
X_4951_ _4951_/Y Tile_X0Y0_S2END[0] _5606_/Q _5605_/Q VPWR VGND sg13cmos5l_o21ai_1
X_4882_ _4882_/X _4707_/Y _4909_/X _4911_/X _5062_/B _5608_/Q _5610_/Q VPWR VGND sg13cmos5l_mux4_1
X_3902_ _3903_/B _4216_/A _4470_/A _3721_/Y VPWR VGND sg13cmos5l_o21ai_1
XANTENNA__6651__X Tile_X0Y0_W2BEGb[0] VPWR VGND sg13cmos5l_antennanp
X_6621_ Tile_X0Y0_N4BEG[15] _6621_/A VPWR VGND sg13cmos5l_buf_1
X_3833_ _3833_/X _2889_/Y _2890_/Y _5664_/Q VPWR VGND sg13cmos5l_mux2_1
X_6552_ Tile_X0Y0_FrameData_O[18] Tile_X0Y0_FrameData[18] VPWR VGND sg13cmos5l_buf_1
X_3764_ _3764_/Y _6426_/Q _2815_/Y _6425_/Q VPWR VGND sg13cmos5l_a21oi_1
XFILLER_72_0 VPWR VGND sg13cmos5l_fill_1
X_5503_ _5503_/Y _5503_/A _6316_/Q VPWR VGND sg13cmos5l_nor2b_1
X_6483_ _6483_/L_HI VPWR VGND sg13cmos5l_tiehi
X_3695_ _3695_/Y _6102_/Q _2888_/Y _3694_/Y VPWR VGND sg13cmos5l_o21ai_1
X_2715_ _2715_/Y Tile_X0Y1_W1END[2] VPWR VGND sg13cmos5l_inv_1
X_5434_ _5434_/Y _6108_/Q Tile_X0Y1_NN4END[1] VPWR VGND sg13cmos5l_nor2b_1
X_5365_ _6767_/A _4518_/Y _2917_/X _6694_/A _2935_/X _6366_/Q _6365_/Q VPWR VGND sg13cmos5l_mux4_1
X_5296_ _6687_/A _3916_/Y _2917_/X _6601_/A _2935_/X _6394_/Q _6393_/Q VPWR VGND sg13cmos5l_mux4_1
X_4316_ _4316_/Y _4310_/Y _4313_/Y _6281_/Q VPWR VGND sg13cmos5l_o21ai_1
XFILLER_99_374 VPWR VGND sg13cmos5l_decap_8
X_4247_ _4249_/B _4247_/A _4709_/B VPWR VGND sg13cmos5l_nand2_1
XFILLER_59_249 VPWR VGND sg13cmos5l_decap_8
XANTENNA__6826__X Tile_X0Y1_W2BEG[2] VPWR VGND sg13cmos5l_antennanp
X_4178_ _4178_/Y Tile_X0Y0_SS4END[0] _5588_/Q _4177_/Y VPWR VGND sg13cmos5l_a21oi_1
X_3129_ _3136_/B _5637_/Q _3129_/B _3129_/C VPWR VGND sg13cmos5l_nand3_1
XFILLER_27_179 VPWR VGND sg13cmos5l_fill_1
XANTENNA__6561__X Tile_X0Y0_FrameData_O[27] VPWR VGND sg13cmos5l_antennanp
X_6819_ Tile_X0Y1_UserCLKo Tile_X0Y1_UserCLK VPWR VGND sg13cmos5l_buf_1
XFILLER_50_182 VPWR VGND sg13cmos5l_fill_1
XFILLER_50_171 VPWR VGND sg13cmos5l_fill_1
XFILLER_2_256 VPWR VGND sg13cmos5l_fill_2
XFILLER_104_140 VPWR VGND sg13cmos5l_fill_2
XANTENNA__6736__X Tile_X0Y1_FrameData_O[1] VPWR VGND sg13cmos5l_antennanp
X_3480_ _3481_/A Tile_X0Y1_N2MID[3] Tile_X0Y1_E2MID[3] _6782_/A Tile_X0Y1_W2MID[3]
+ _6226_/Q _6225_/Q VPWR VGND sg13cmos5l_mux4_1
X_5150_ _5150_/X _4937_/Y _4909_/X _5062_/B _5009_/Y _5924_/Q _5923_/Q VPWR VGND sg13cmos5l_mux4_1
X_5081_ _5081_/Y _5728_/Q _2894_/Y _5080_/Y VPWR VGND sg13cmos5l_a21oi_1
X_4101_ _4101_/Y _4106_/A VPWR VGND sg13cmos5l_inv_1
XANTENNA__6646__X Tile_X0Y0_W2BEG[3] VPWR VGND sg13cmos5l_antennanp
X_4032_ _5983_/D _4033_/B VPWR VGND sg13cmos5l_inv_1
XFILLER_49_282 VPWR VGND sg13cmos5l_fill_2
X_5983_ _5983_/Q Tile_X0Y1_UserCLK _5983_/D _6437_/L_HI VPWR VGND sg13cmos5l_dfrbpq_1
X_4934_ _4934_/Y _6423_/Q _5543_/B _4933_/Y VPWR VGND sg13cmos5l_o21ai_1
XANTENNA_12 Tile_X0Y0_E2END[7] VPWR VGND sg13cmos5l_antennanp
XANTENNA_23 Tile_X0Y0_E2END[7] VPWR VGND sg13cmos5l_antennanp
X_4865_ _4865_/Y _4865_/A _4865_/B _4865_/C VPWR VGND sg13cmos5l_nand3_1
XANTENNA_34 Tile_X0Y0_E2MID[0] VPWR VGND sg13cmos5l_antennanp
XANTENNA_45 Tile_X0Y0_E2MID[0] VPWR VGND sg13cmos5l_antennanp
XANTENNA_56 Tile_X0Y0_E2MID[2] VPWR VGND sg13cmos5l_antennanp
X_6604_ Tile_X0Y0_N2BEGb[6] _6604_/A VPWR VGND sg13cmos5l_buf_1
X_4796_ _4796_/Y _5802_/Q _4796_/B VPWR VGND sg13cmos5l_nand2b_1
X_3816_ _3817_/B _6054_/Q _3816_/B VPWR VGND sg13cmos5l_nor2_1
XANTENNA_67 Tile_X0Y0_E2MID[3] VPWR VGND sg13cmos5l_antennanp
XANTENNA_78 Tile_X0Y0_E2MID[6] VPWR VGND sg13cmos5l_antennanp
X_6535_ Tile_X0Y0_FrameData_O[1] Tile_X0Y0_FrameData[1] VPWR VGND sg13cmos5l_buf_1
X_3747_ _6696_/A _3747_/A VPWR VGND sg13cmos5l_inv_1
XANTENNA_89 Tile_X0Y0_SS4END[2] VPWR VGND sg13cmos5l_antennanp
X_6466_ _6466_/L_HI VPWR VGND sg13cmos5l_tiehi
X_3678_ _4477_/A _5988_/D _5988_/Q _6427_/Q VPWR VGND sg13cmos5l_mux2_1
X_5417_ _6817_/A _5413_/Y _5416_/Y _5411_/Y VPWR VGND sg13cmos5l_a21oi_1
X_6397_ _6397_/Q Tile_X0Y1_FrameData[31] Tile_X0Y1_FrameStrobe[12] VPWR VGND sg13cmos5l_dlhq_1
X_5348_ _5348_/X Tile_X0Y1_E1END[3] Tile_X0Y1_W1END[3] _4503_/Y _3916_/Y _6374_/Q
+ _6372_/Q VPWR VGND sg13cmos5l_mux4_1
XANTENNA__6556__X Tile_X0Y0_FrameData_O[22] VPWR VGND sg13cmos5l_antennanp
X_5279_ _5280_/B Tile_X0Y1_N1END[0] Tile_X0Y1_E1END[0] Tile_X0Y1_W1END[0] _4518_/Y
+ _6400_/Q _6399_/Q VPWR VGND sg13cmos5l_mux4_1
XFILLER_23_182 VPWR VGND sg13cmos5l_fill_2
XFILLER_11_377 VPWR VGND sg13cmos5l_decap_4
XFILLER_2_0 VPWR VGND sg13cmos5l_decap_8
XFILLER_78_377 VPWR VGND sg13cmos5l_fill_1
X_2980_ _6598_/A _2978_/Y _2979_/Y _2972_/Y VPWR VGND sg13cmos5l_o21ai_1
X_4650_ _4651_/B _5810_/Q _4648_/A _4649_/Y VPWR VGND sg13cmos5l_a21oi_1
X_3601_ _3601_/Y _6164_/Q _3600_/X _6163_/Q VPWR VGND sg13cmos5l_o21ai_1
X_6320_ _6320_/Q Tile_X0Y1_FrameData[12] Tile_X0Y1_FrameStrobe[9] VPWR VGND sg13cmos5l_dlhq_1
X_4581_ _4582_/B _4581_/A _4581_/B VPWR VGND sg13cmos5l_xnor2_1
X_3532_ _3532_/X Tile_X0Y1_N1END[0] Tile_X0Y1_N2END[2] Tile_X0Y1_E6END[0] Tile_X0Y0_S2MID[2]
+ _6136_/Q _6134_/Q VPWR VGND sg13cmos5l_mux4_1
X_6251_ _6251_/Q Tile_X0Y1_FrameData[17] Tile_X0Y1_FrameStrobe[7] VPWR VGND sg13cmos5l_dlhq_1
X_3463_ _3463_/Y _6215_/Q _3462_/Y _6290_/Q VPWR VGND sg13cmos5l_o21ai_1
X_6182_ _6182_/Q Tile_X0Y1_FrameData[22] Tile_X0Y1_FrameStrobe[5] VPWR VGND sg13cmos5l_dlhq_1
X_5202_ _5202_/X _2782_/Y _2887_/Y _5883_/Q VPWR VGND sg13cmos5l_a21o_1
XFILLER_88_108 VPWR VGND sg13cmos5l_fill_1
X_5133_ _5133_/X _3172_/Y Tile_X0Y0_E1END[1] Tile_X0Y0_S1END[1] _5011_/X _5931_/Q
+ _5930_/Q VPWR VGND sg13cmos5l_mux4_1
X_3394_ _3394_/X Tile_X0Y1_N1END[1] Tile_X0Y1_E1END[1] Tile_X0Y1_N2END[5] Tile_X0Y1_E2END[5]
+ _6123_/Q _6124_/Q VPWR VGND sg13cmos5l_mux4_1
X_5064_ _5064_/X _5180_/B _3945_/B _5954_/Q VPWR VGND sg13cmos5l_mux2_1
XFILLER_84_314 VPWR VGND sg13cmos5l_fill_2
X_4015_ _4015_/Y _5791_/Q _4015_/B _4015_/C VPWR VGND sg13cmos5l_nand3_1
XFILLER_52_200 VPWR VGND sg13cmos5l_fill_2
X_5966_ _5966_/Q Tile_X0Y0_FrameData[20] Tile_X0Y1_FrameStrobe[12] VPWR VGND sg13cmos5l_dlhq_1
X_5897_ _5897_/Q Tile_X0Y0_FrameData[25] Tile_X0Y1_FrameStrobe[10] VPWR VGND sg13cmos5l_dlhq_1
X_4917_ _4917_/Y _2761_/Y _6496_/A _5831_/Q VPWR VGND sg13cmos5l_o21ai_1
X_4848_ _4849_/A _4840_/Y _4847_/Y _4834_/Y VPWR VGND sg13cmos5l_a21oi_1
X_4779_ _4779_/Y _4779_/A _4779_/B VPWR VGND sg13cmos5l_nor2_1
X_6518_ Tile_X0Y0_EE4BEG[0] Tile_X0Y0_EE4END[4] VPWR VGND sg13cmos5l_buf_1
XFILLER_106_213 VPWR VGND sg13cmos5l_fill_1
X_6449_ _6449_/L_HI VPWR VGND sg13cmos5l_tiehi
XFILLER_57_78 VPWR VGND sg13cmos5l_fill_2
XFILLER_75_369 VPWR VGND sg13cmos5l_fill_2
XFILLER_28_285 VPWR VGND sg13cmos5l_fill_2
XFILLER_43_299 VPWR VGND sg13cmos5l_fill_2
XFILLER_3_340 VPWR VGND sg13cmos5l_decap_8
XFILLER_78_152 VPWR VGND sg13cmos5l_fill_1
X_5820_ _5820_/Q Tile_X0Y0_FrameData[6] Tile_X0Y1_FrameStrobe[7] VPWR VGND sg13cmos5l_dlhq_1
X_5751_ _5751_/Q Tile_X0Y0_FrameData[11] Tile_X0Y1_FrameStrobe[5] VPWR VGND sg13cmos5l_dlhq_1
X_2963_ _6644_/A _2897_/Y _2899_/Y _2962_/Y VPWR VGND sg13cmos5l_o21ai_1
X_4702_ _4704_/B _4702_/A _4865_/B VPWR VGND sg13cmos5l_and2_1
X_5682_ _5682_/Q Tile_X0Y0_FrameData[16] Tile_X0Y1_FrameStrobe[3] VPWR VGND sg13cmos5l_dlhq_1
X_2894_ _2894_/Y _5009_/Y VPWR VGND sg13cmos5l_inv_1
X_4633_ _4633_/Y _5708_/Q _2886_/Y _4632_/Y VPWR VGND sg13cmos5l_a21oi_1
X_4564_ _4564_/Y _6426_/Q _2735_/Y _6425_/Q VPWR VGND sg13cmos5l_a21oi_1
X_6303_ _6303_/Q Tile_X0Y1_FrameData[29] Tile_X0Y1_FrameStrobe[9] VPWR VGND sg13cmos5l_dlhq_1
X_3515_ _4138_/A _6428_/Q _3513_/A _3514_/Y VPWR VGND sg13cmos5l_o21ai_1
X_6234_ _6234_/Q Tile_X0Y1_FrameData[2] Tile_X0Y1_FrameStrobe[6] VPWR VGND sg13cmos5l_dlhq_1
X_4495_ _4497_/A _4495_/A VPWR VGND sg13cmos5l_inv_1
X_3446_ _3446_/Y _6783_/A VPWR VGND sg13cmos5l_inv_1
X_6165_ _6165_/Q Tile_X0Y1_FrameData[7] Tile_X0Y1_FrameStrobe[4] VPWR VGND sg13cmos5l_dlhq_1
X_3377_ _4123_/B _3377_/A VPWR VGND sg13cmos5l_inv_1
X_6096_ _6096_/Q Tile_X0Y1_FrameData[12] Tile_X0Y1_FrameStrobe[2] VPWR VGND sg13cmos5l_dlhq_1
X_5116_ _5116_/Y _5934_/Q _5058_/B _5115_/Y VPWR VGND sg13cmos5l_o21ai_1
X_5047_ _5048_/A _5960_/Q _5245_/B _5046_/Y VPWR VGND sg13cmos5l_a21oi_1
XANTENNA__6834__X Tile_X0Y1_W2BEGb[2] VPWR VGND sg13cmos5l_antennanp
X_5949_ _5949_/Q Tile_X0Y0_FrameData[5] Tile_X0Y1_FrameStrobe[11] VPWR VGND sg13cmos5l_dlhq_1
XFILLER_25_288 VPWR VGND sg13cmos5l_fill_2
XFILLER_108_40 VPWR VGND sg13cmos5l_decap_4
XFILLER_75_133 VPWR VGND sg13cmos5l_fill_1
XFILLER_48_336 VPWR VGND sg13cmos5l_fill_2
XANTENNA__6744__X Tile_X0Y1_FrameData_O[9] VPWR VGND sg13cmos5l_antennanp
XFILLER_63_317 VPWR VGND sg13cmos5l_fill_2
XFILLER_63_306 VPWR VGND sg13cmos5l_fill_2
X_3300_ _3300_/X _2764_/Y _4551_/A _5726_/Q VPWR VGND sg13cmos5l_mux2_1
X_4280_ _4280_/X Tile_X0Y1_NN4END[0] Tile_X0Y1_E6END[0] _6014_/Q VPWR VGND sg13cmos5l_mux2_1
X_3231_ _3231_/Y _3221_/Y _3227_/Y _3230_/X _5615_/Q VPWR VGND sg13cmos5l_a22oi_1
X_3162_ _3162_/Y _6023_/Q _3158_/X _3161_/Y VPWR VGND sg13cmos5l_o21ai_1
X_3093_ _3093_/Y _6782_/A VPWR VGND sg13cmos5l_inv_1
XANTENNA__6654__X Tile_X0Y0_W2BEGb[3] VPWR VGND sg13cmos5l_antennanp
XFILLER_47_380 VPWR VGND sg13cmos5l_fill_1
X_6852_ Tile_X0Y1_WW4BEG[0] Tile_X0Y1_WW4END[4] VPWR VGND sg13cmos5l_buf_1
X_5803_ _5803_/Q Tile_X0Y0_FrameData[23] Tile_X0Y1_FrameStrobe[7] VPWR VGND sg13cmos5l_dlhq_1
X_6783_ Tile_X0Y1_S2BEGb[4] _6783_/A VPWR VGND sg13cmos5l_buf_1
X_3995_ _6594_/A _3995_/A VPWR VGND sg13cmos5l_inv_1
X_5734_ _5734_/Q Tile_X0Y0_FrameData[28] Tile_X0Y1_FrameStrobe[5] VPWR VGND sg13cmos5l_dlhq_1
X_2946_ _2946_/Y Tile_X0Y1_N2END[4] _6062_/Q VPWR VGND sg13cmos5l_nor2_1
X_5665_ _5665_/Q Tile_X0Y0_FrameData[1] Tile_X0Y1_FrameStrobe[2] VPWR VGND sg13cmos5l_dlhq_1
X_2877_ _2877_/Y _6147_/Q VPWR VGND sg13cmos5l_inv_1
X_4616_ _4617_/B _4616_/A _4616_/B VPWR VGND sg13cmos5l_xor2_1
X_5596_ _5596_/Q Tile_X0Y0_FrameData[6] Tile_X0Y1_FrameStrobe[0] VPWR VGND sg13cmos5l_dlhq_1
X_4547_ _4548_/A _4531_/Y _4537_/Y _4546_/Y _5675_/Q VPWR VGND sg13cmos5l_a22oi_1
XFILLER_1_107 VPWR VGND sg13cmos5l_fill_1
XANTENNA__6829__X Tile_X0Y1_W2BEG[5] VPWR VGND sg13cmos5l_antennanp
X_4478_ _4572_/A _4478_/A _4683_/A VPWR VGND sg13cmos5l_nor2_1
X_6217_ _6217_/Q Tile_X0Y1_FrameData[19] Tile_X0Y1_FrameStrobe[6] VPWR VGND sg13cmos5l_dlhq_1
X_3429_ _3470_/A _6425_/Q _5554_/Q VPWR VGND sg13cmos5l_nand2_1
X_6148_ _6148_/Q Tile_X0Y1_FrameData[24] Tile_X0Y1_FrameStrobe[4] VPWR VGND sg13cmos5l_dlhq_1
X_6079_ _6079_/Q Tile_X0Y1_FrameData[29] Tile_X0Y1_FrameStrobe[2] VPWR VGND sg13cmos5l_dlhq_1
XANTENNA__6564__X Tile_X0Y0_FrameData_O[30] VPWR VGND sg13cmos5l_antennanp
XFILLER_38_380 VPWR VGND sg13cmos5l_fill_1
XFILLER_107_330 VPWR VGND sg13cmos5l_decap_8
XFILLER_102_0 VPWR VGND sg13cmos5l_fill_1
XANTENNA__6739__X Tile_X0Y1_FrameData_O[4] VPWR VGND sg13cmos5l_antennanp
XFILLER_29_380 VPWR VGND sg13cmos5l_fill_1
X_3780_ _3780_/Y Tile_X0Y1_N2MID[6] _6252_/Q _3779_/Y VPWR VGND sg13cmos5l_o21ai_1
X_2800_ _2800_/Y _6341_/Q VPWR VGND sg13cmos5l_inv_1
X_2731_ _4551_/A Tile_X0Y0_E2END[2] VPWR VGND sg13cmos5l_inv_1
X_5450_ _5450_/Y _6336_/Q _5450_/B VPWR VGND sg13cmos5l_nand2_1
XFILLER_8_262 VPWR VGND sg13cmos5l_fill_1
X_4401_ _4401_/Y _6046_/Q _4400_/X _4413_/A VPWR VGND sg13cmos5l_o21ai_1
X_5381_ _5382_/B _6138_/Q _2888_/Y _5380_/Y VPWR VGND sg13cmos5l_o21ai_1
XANTENNA__6649__X Tile_X0Y0_W2BEG[6] VPWR VGND sg13cmos5l_antennanp
X_4332_ _4353_/A _6425_/Q _5557_/Q VPWR VGND sg13cmos5l_nand2_1
X_4263_ _4480_/A _4263_/A _4600_/A VPWR VGND sg13cmos5l_nor2_1
X_6002_ _6002_/Q Tile_X0Y1_UserCLK _6002_/D _6456_/L_HI VPWR VGND sg13cmos5l_dfrbpq_1
X_3214_ _6605_/A _3214_/A VPWR VGND sg13cmos5l_inv_1
X_4194_ _4266_/A _4263_/A _4602_/A VPWR VGND sg13cmos5l_nor2_1
X_3145_ _3145_/Y Tile_X0Y1_E6END[0] _6096_/Q _3144_/Y VPWR VGND sg13cmos5l_a21oi_1
X_3076_ _3076_/X _4940_/Y _4934_/Y _5011_/X _4937_/Y _5654_/Q _5652_/Q VPWR VGND sg13cmos5l_mux4_1
X_6835_ Tile_X0Y1_W2BEGb[3] Tile_X0Y1_W2MID[3] VPWR VGND sg13cmos5l_buf_1
X_6766_ Tile_X0Y1_FrameData_O[31] Tile_X0Y1_FrameData[31] VPWR VGND sg13cmos5l_buf_1
X_3978_ _3978_/Y Tile_X0Y0_S2MID[7] _5786_/Q _5785_/Q VPWR VGND sg13cmos5l_o21ai_1
X_5717_ _5717_/Q Tile_X0Y0_FrameData[13] Tile_X0Y1_FrameStrobe[4] VPWR VGND sg13cmos5l_dlhq_1
X_2929_ _2929_/Y _6132_/Q _2929_/B VPWR VGND sg13cmos5l_nand2b_1
X_6697_ Tile_X0Y1_E2BEG[6] _6697_/A VPWR VGND sg13cmos5l_buf_1
X_5648_ _5648_/Q Tile_X0Y0_FrameData[18] Tile_X0Y1_FrameStrobe[2] VPWR VGND sg13cmos5l_dlhq_1
X_5579_ _5579_/Q Tile_X0Y0_FrameData[23] Tile_X0Y1_FrameStrobe[0] VPWR VGND sg13cmos5l_dlhq_1
XANTENNA__6559__X Tile_X0Y0_FrameData_O[25] VPWR VGND sg13cmos5l_antennanp
XFILLER_45_103 VPWR VGND sg13cmos5l_fill_2
XANTENNA_102 Tile_X0Y0_SS4END[5] VPWR VGND sg13cmos5l_antennanp
XANTENNA_113 Tile_X0Y0_W2MID[3] VPWR VGND sg13cmos5l_antennanp
XANTENNA_124 Tile_X0Y0_WW4END[0] VPWR VGND sg13cmos5l_antennanp
XFILLER_33_309 VPWR VGND sg13cmos5l_fill_1
XANTENNA_135 Tile_X0Y0_WW4END[2] VPWR VGND sg13cmos5l_antennanp
XANTENNA_146 Tile_X0Y1_E2MID[3] VPWR VGND sg13cmos5l_antennanp
XANTENNA_157 Tile_X0Y1_E2MID[7] VPWR VGND sg13cmos5l_antennanp
XANTENNA_168 Tile_X0Y1_NN4END[6] VPWR VGND sg13cmos5l_antennanp
XANTENNA_179 Tile_X0Y1_W2END[0] VPWR VGND sg13cmos5l_antennanp
XFILLER_107_182 VPWR VGND sg13cmos5l_fill_1
X_4950_ _4950_/Y Tile_X0Y0_S1END[0] _5606_/Q _4949_/Y VPWR VGND sg13cmos5l_o21ai_1
X_4881_ _4881_/Y _5609_/Q _4880_/X VPWR VGND sg13cmos5l_nor2b_1
X_3901_ _4235_/A _3901_/A _4218_/B VPWR VGND sg13cmos5l_nand2_1
X_6620_ Tile_X0Y0_N4BEG[14] _6620_/A VPWR VGND sg13cmos5l_buf_1
X_3832_ _3832_/Y _5664_/Q _2886_/Y _3831_/Y VPWR VGND sg13cmos5l_o21ai_1
X_6551_ Tile_X0Y0_FrameData_O[17] Tile_X0Y0_FrameData[17] VPWR VGND sg13cmos5l_buf_1
X_5502_ _5503_/A _6317_/Q _5499_/Y _5500_/X _5501_/Y VPWR VGND sg13cmos5l_a22oi_1
X_3763_ _5995_/D _3760_/Y _3762_/Y _3755_/Y VPWR VGND sg13cmos5l_o21ai_1
X_6482_ _6482_/L_HI VPWR VGND sg13cmos5l_tiehi
X_3694_ _3694_/Y _6102_/Q _5422_/B VPWR VGND sg13cmos5l_nand2_1
X_2714_ _2714_/Y Tile_X0Y1_W1END[0] VPWR VGND sg13cmos5l_inv_1
XFILLER_65_0 VPWR VGND sg13cmos5l_fill_2
X_5433_ _5433_/X Tile_X0Y0_S2MID[1] Tile_X0Y0_S4END[5] _6108_/Q VPWR VGND sg13cmos5l_mux2_1
X_5364_ _6718_/A _6367_/Q _5356_/Y _5363_/X VPWR VGND sg13cmos5l_o21ai_1
X_4315_ _4315_/Y _6282_/Q _4315_/B VPWR VGND sg13cmos5l_nor2_1
X_5295_ _6633_/A _5295_/A _5295_/B VPWR VGND sg13cmos5l_nor2_1
XFILLER_59_228 VPWR VGND sg13cmos5l_decap_4
X_4246_ _4249_/A _4198_/A _4198_/B _4196_/Y VPWR VGND sg13cmos5l_a21o_1
X_4177_ _4177_/Y _5588_/Q Tile_X0Y1_N4END[4] VPWR VGND sg13cmos5l_nor2b_1
X_3128_ _3129_/C _3118_/S _2887_/Y _3127_/Y VPWR VGND sg13cmos5l_a21o_1
XFILLER_27_114 VPWR VGND sg13cmos5l_fill_1
X_3059_ _3059_/Y _5645_/Q _3058_/X _3057_/Y VPWR VGND sg13cmos5l_a21oi_1
XANTENNA__6842__X Tile_X0Y1_W6BEG[2] VPWR VGND sg13cmos5l_antennanp
XFILLER_35_59 VPWR VGND sg13cmos5l_fill_1
X_6818_ Tile_X0Y1_SS4BEG[15] _6818_/A VPWR VGND sg13cmos5l_buf_1
X_6749_ Tile_X0Y1_FrameData_O[14] Tile_X0Y1_FrameData[14] VPWR VGND sg13cmos5l_buf_1
XFILLER_100_380 VPWR VGND sg13cmos5l_fill_1
XANTENNA__6752__X Tile_X0Y1_FrameData_O[17] VPWR VGND sg13cmos5l_antennanp
XFILLER_14_364 VPWR VGND sg13cmos5l_fill_1
XFILLER_14_353 VPWR VGND sg13cmos5l_decap_8
XFILLER_14_342 VPWR VGND sg13cmos5l_fill_1
X_5080_ _5080_/Y _5728_/Q _4943_/Y _5730_/Q VPWR VGND sg13cmos5l_o21ai_1
X_4100_ _4106_/A _4216_/A _4683_/A VPWR VGND sg13cmos5l_nor2_1
X_4031_ _4033_/B _4020_/X _4021_/Y _4030_/Y VPWR VGND sg13cmos5l_a21oi_1
XFILLER_49_261 VPWR VGND sg13cmos5l_fill_2
XFILLER_2_85 VPWR VGND sg13cmos5l_fill_1
XFILLER_2_74 VPWR VGND sg13cmos5l_decap_8
X_5982_ _5982_/Q Tile_X0Y1_UserCLK _5982_/D _6436_/L_HI VPWR VGND sg13cmos5l_dfrbpq_1
XANTENNA__6662__X Tile_X0Y0_W6BEG[3] VPWR VGND sg13cmos5l_antennanp
X_4933_ _4933_/Y _5563_/Q _6423_/Q VPWR VGND sg13cmos5l_nand2_1
XANTENNA_13 Tile_X0Y0_E2END[7] VPWR VGND sg13cmos5l_antennanp
X_4864_ _4870_/A _4864_/A _4864_/B VPWR VGND sg13cmos5l_nand2_1
XANTENNA_24 Tile_X0Y0_E2END[7] VPWR VGND sg13cmos5l_antennanp
XANTENNA_35 Tile_X0Y0_E2MID[0] VPWR VGND sg13cmos5l_antennanp
XANTENNA_46 Tile_X0Y0_E2MID[2] VPWR VGND sg13cmos5l_antennanp
XANTENNA_57 Tile_X0Y0_E2MID[2] VPWR VGND sg13cmos5l_antennanp
X_6603_ Tile_X0Y0_N2BEGb[5] _6603_/A VPWR VGND sg13cmos5l_buf_1
X_4795_ _4795_/Y _4789_/Y _4792_/Y _5839_/Q VPWR VGND sg13cmos5l_o21ai_1
X_3815_ _3816_/B Tile_X0Y1_N1END[2] Tile_X0Y1_E1END[2] Tile_X0Y1_N2END[6] Tile_X0Y1_E2END[6]
+ _6055_/Q _6056_/Q VPWR VGND sg13cmos5l_mux4_1
XANTENNA_68 Tile_X0Y0_E2MID[4] VPWR VGND sg13cmos5l_antennanp
XANTENNA_79 Tile_X0Y0_E2MID[6] VPWR VGND sg13cmos5l_antennanp
X_6534_ Tile_X0Y0_FrameData_O[0] Tile_X0Y0_FrameData[0] VPWR VGND sg13cmos5l_buf_1
X_3746_ _3747_/A _3746_/A _3746_/B VPWR VGND sg13cmos5l_nor2_1
XFILLER_20_367 VPWR VGND sg13cmos5l_decap_8
X_6465_ _6465_/L_HI VPWR VGND sg13cmos5l_tiehi
X_5416_ _5416_/Y _5416_/A _6342_/Q VPWR VGND sg13cmos5l_nor2b_1
X_3677_ _3677_/Y _5988_/Q _6427_/Q VPWR VGND sg13cmos5l_nand2b_1
X_6396_ _6396_/Q Tile_X0Y1_FrameData[0] Tile_X0Y1_FrameStrobe[11] VPWR VGND sg13cmos5l_dlhq_1
X_5347_ _5347_/X _6372_/Q _5344_/Y _5346_/Y VPWR VGND sg13cmos5l_a21o_1
XFILLER_99_150 VPWR VGND sg13cmos5l_fill_1
XANTENNA__6837__X Tile_X0Y1_W2BEGb[5] VPWR VGND sg13cmos5l_antennanp
X_5278_ _6631_/A _5273_/X _5277_/Y _5271_/Y VPWR VGND sg13cmos5l_a21oi_1
X_4229_ _4235_/B _4229_/A _4229_/B VPWR VGND sg13cmos5l_xnor2_1
XANTENNA__6572__X Tile_X0Y0_FrameStrobe_O[6] VPWR VGND sg13cmos5l_antennanp
XFILLER_102_97 VPWR VGND sg13cmos5l_fill_2
XFILLER_11_301 VPWR VGND sg13cmos5l_fill_2
XFILLER_7_349 VPWR VGND sg13cmos5l_decap_8
XFILLER_109_277 VPWR VGND sg13cmos5l_fill_2
XANTENNA__6747__X Tile_X0Y1_FrameData_O[12] VPWR VGND sg13cmos5l_antennanp
X_4580_ _4580_/Y _4581_/A _4581_/B VPWR VGND sg13cmos5l_nand2_1
X_3600_ _3600_/X _2891_/Y _2892_/Y _6162_/Q VPWR VGND sg13cmos5l_mux2_1
X_3531_ _3531_/Y _6133_/Q _3531_/B _3531_/C VPWR VGND sg13cmos5l_nand3_1
XFILLER_6_360 VPWR VGND sg13cmos5l_fill_1
X_6250_ _6250_/Q Tile_X0Y1_FrameData[18] Tile_X0Y1_FrameStrobe[7] VPWR VGND sg13cmos5l_dlhq_1
X_3462_ _3462_/Y Tile_X0Y1_E2MID[5] _6216_/Q _3461_/Y VPWR VGND sg13cmos5l_a21oi_1
X_6181_ _6181_/Q Tile_X0Y1_FrameData[23] Tile_X0Y1_FrameStrobe[5] VPWR VGND sg13cmos5l_dlhq_1
X_5201_ _5208_/A _5882_/Q _5201_/B VPWR VGND sg13cmos5l_nor2_1
X_3393_ _3393_/X _3217_/A _3325_/A _2741_/Y _2790_/Y _6124_/Q _6123_/Q VPWR VGND sg13cmos5l_mux4_1
XANTENNA__6657__X Tile_X0Y0_W2BEGb[6] VPWR VGND sg13cmos5l_antennanp
X_5132_ _5132_/Y _5930_/Q _5128_/Y _5131_/Y VPWR VGND sg13cmos5l_o21ai_1
XFILLER_69_312 VPWR VGND sg13cmos5l_fill_1
X_5063_ _5063_/Y _5954_/Q _5243_/B _5062_/Y VPWR VGND sg13cmos5l_a21oi_1
X_4014_ _4015_/C _5792_/Q Tile_X0Y0_S2MID[3] VPWR VGND sg13cmos5l_nand2b_1
XFILLER_52_234 VPWR VGND sg13cmos5l_decap_4
XFILLER_52_223 VPWR VGND sg13cmos5l_decap_8
X_5965_ _5965_/Q Tile_X0Y0_FrameData[21] Tile_X0Y1_FrameStrobe[12] VPWR VGND sg13cmos5l_dlhq_1
X_5896_ _5896_/Q Tile_X0Y0_FrameData[26] Tile_X0Y1_FrameStrobe[10] VPWR VGND sg13cmos5l_dlhq_1
X_4916_ _4916_/Y _4916_/A _5830_/Q VPWR VGND sg13cmos5l_nor2b_1
X_4847_ _4847_/Y _4847_/A _5611_/Q VPWR VGND sg13cmos5l_nor2b_1
X_4778_ _4779_/B _5575_/Q _4777_/Y _5838_/Q VPWR VGND sg13cmos5l_o21ai_1
X_6517_ Tile_X0Y0_E6BEG[11] _6517_/A VPWR VGND sg13cmos5l_buf_1
X_3729_ _3729_/Y _6120_/Q _3729_/B VPWR VGND sg13cmos5l_nand2b_1
X_6448_ _6448_/L_HI VPWR VGND sg13cmos5l_tiehi
XFILLER_106_236 VPWR VGND sg13cmos5l_fill_1
X_6379_ _6379_/Q Tile_X0Y1_FrameData[17] Tile_X0Y1_FrameStrobe[11] VPWR VGND sg13cmos5l_dlhq_1
XANTENNA__6567__X Tile_X0Y0_FrameStrobe_O[1] VPWR VGND sg13cmos5l_antennanp
XFILLER_75_359 VPWR VGND sg13cmos5l_fill_2
XFILLER_90_318 VPWR VGND sg13cmos5l_decap_4
XFILLER_73_56 VPWR VGND sg13cmos5l_fill_1
XFILLER_7_157 VPWR VGND sg13cmos5l_fill_2
XFILLER_93_145 VPWR VGND sg13cmos5l_fill_2
XFILLER_19_242 VPWR VGND sg13cmos5l_fill_2
XFILLER_34_234 VPWR VGND sg13cmos5l_decap_8
X_5750_ _5750_/Q Tile_X0Y0_FrameData[12] Tile_X0Y1_FrameStrobe[5] VPWR VGND sg13cmos5l_dlhq_1
X_2962_ _2962_/Y _5628_/Q _2955_/X _2961_/Y VPWR VGND sg13cmos5l_o21ai_1
X_5681_ _5681_/Q Tile_X0Y0_FrameData[17] Tile_X0Y1_FrameStrobe[3] VPWR VGND sg13cmos5l_dlhq_1
X_4701_ _4865_/B _4701_/A _4701_/B _4701_/C VPWR VGND sg13cmos5l_or3_1
X_4632_ _4632_/Y _5708_/Q _4940_/Y VPWR VGND sg13cmos5l_nor2_1
X_2893_ _4409_/B _4503_/Y VPWR VGND sg13cmos5l_inv_1
X_4563_ _6005_/D _5846_/Q _4556_/Y _4562_/Y VPWR VGND sg13cmos5l_a21oi_1
X_6302_ _6302_/Q Tile_X0Y1_FrameData[30] Tile_X0Y1_FrameStrobe[9] VPWR VGND sg13cmos5l_dlhq_1
X_4494_ _4495_/A _4496_/A _4496_/B _4496_/C VPWR VGND sg13cmos5l_a21o_1
X_3514_ _3514_/Y _6428_/Q _5978_/Q VPWR VGND sg13cmos5l_nand2_1
X_6233_ _6233_/Q Tile_X0Y1_FrameData[3] Tile_X0Y1_FrameStrobe[6] VPWR VGND sg13cmos5l_dlhq_1
X_3445_ _6783_/A _3434_/Y _3436_/Y _3444_/Y VPWR VGND sg13cmos5l_o21ai_1
X_6164_ _6164_/Q Tile_X0Y1_FrameData[8] Tile_X0Y1_FrameStrobe[4] VPWR VGND sg13cmos5l_dlhq_1
X_3376_ _3377_/A _3376_/A _3376_/B VPWR VGND sg13cmos5l_nor2_1
X_6095_ _6095_/Q Tile_X0Y1_FrameData[13] Tile_X0Y1_FrameStrobe[2] VPWR VGND sg13cmos5l_dlhq_1
X_5115_ _5115_/Y _2764_/Y _5934_/Q _5933_/Q VPWR VGND sg13cmos5l_a21oi_1
XFILLER_57_315 VPWR VGND sg13cmos5l_fill_1
X_5046_ _5046_/Y _5960_/Q _4937_/Y _5044_/A VPWR VGND sg13cmos5l_o21ai_1
XFILLER_111_294 VPWR VGND sg13cmos5l_fill_1
X_5948_ _5948_/Q Tile_X0Y0_FrameData[6] Tile_X0Y1_FrameStrobe[11] VPWR VGND sg13cmos5l_dlhq_1
XANTENNA__6850__X Tile_X0Y1_W6BEG[10] VPWR VGND sg13cmos5l_antennanp
X_5879_ _5879_/Q Tile_X0Y0_FrameData[11] Tile_X0Y1_FrameStrobe[9] VPWR VGND sg13cmos5l_dlhq_1
XFILLER_0_344 VPWR VGND sg13cmos5l_decap_8
XFILLER_56_370 VPWR VGND sg13cmos5l_fill_1
XANTENNA__6760__X Tile_X0Y1_FrameData_O[25] VPWR VGND sg13cmos5l_antennanp
XFILLER_3_160 VPWR VGND sg13cmos5l_fill_2
X_3230_ _3230_/X _3228_/X _3229_/X _5617_/Q VPWR VGND sg13cmos5l_mux2_1
X_3161_ _3161_/Y _6023_/Q _3161_/B _3161_/C VPWR VGND sg13cmos5l_nand3_1
XFILLER_66_101 VPWR VGND sg13cmos5l_fill_2
X_3092_ _6782_/A _5651_/Q _3083_/Y _3085_/Y _3091_/Y VPWR VGND sg13cmos5l_a22oi_1
XFILLER_47_370 VPWR VGND sg13cmos5l_fill_1
X_6851_ Tile_X0Y1_W6BEG[11] _6851_/A VPWR VGND sg13cmos5l_buf_1
X_5802_ _5802_/Q Tile_X0Y0_FrameData[24] Tile_X0Y1_FrameStrobe[7] VPWR VGND sg13cmos5l_dlhq_1
XANTENNA__6670__X Tile_X0Y0_W6BEG[11] VPWR VGND sg13cmos5l_antennanp
X_6782_ Tile_X0Y1_S2BEGb[3] _6782_/A VPWR VGND sg13cmos5l_buf_1
X_3994_ _3995_/A _3994_/A _3993_/Y VPWR VGND sg13cmos5l_nor2b_1
XFILLER_22_248 VPWR VGND sg13cmos5l_fill_2
X_5733_ _5733_/Q Tile_X0Y0_FrameData[29] Tile_X0Y1_FrameStrobe[5] VPWR VGND sg13cmos5l_dlhq_1
X_2945_ _2945_/Y _2786_/Y _6062_/Q _2944_/Y VPWR VGND sg13cmos5l_a21oi_1
X_5664_ _5664_/Q Tile_X0Y0_FrameData[2] Tile_X0Y1_FrameStrobe[2] VPWR VGND sg13cmos5l_dlhq_1
X_2876_ _2876_/Y _6145_/Q VPWR VGND sg13cmos5l_inv_1
X_5595_ _5595_/Q Tile_X0Y0_FrameData[7] Tile_X0Y1_FrameStrobe[0] VPWR VGND sg13cmos5l_dlhq_1
X_4615_ _4701_/A _4616_/A _4616_/B VPWR VGND sg13cmos5l_nor2_1
X_4546_ _4546_/Y _4546_/A _4546_/B VPWR VGND sg13cmos5l_nor2_1
X_4477_ _4481_/A _4477_/A _4709_/B VPWR VGND sg13cmos5l_nand2_1
X_6216_ _6216_/Q Tile_X0Y1_FrameData[20] Tile_X0Y1_FrameStrobe[6] VPWR VGND sg13cmos5l_dlhq_1
X_3428_ _6002_/D _6277_/Q _3422_/X _3426_/Y _3427_/Y VPWR VGND sg13cmos5l_a22oi_1
X_6147_ _6147_/Q Tile_X0Y1_FrameData[25] Tile_X0Y1_FrameStrobe[4] VPWR VGND sg13cmos5l_dlhq_1
X_3359_ _4796_/B _4046_/B _4046_/C VPWR VGND sg13cmos5l_nor2_1
XANTENNA__6845__X Tile_X0Y1_W6BEG[5] VPWR VGND sg13cmos5l_antennanp
X_6078_ _6078_/Q Tile_X0Y1_FrameData[30] Tile_X0Y1_FrameStrobe[2] VPWR VGND sg13cmos5l_dlhq_1
X_5029_ _5029_/Y _5974_/Q _4911_/X _5028_/Y VPWR VGND sg13cmos5l_o21ai_1
XFILLER_72_137 VPWR VGND sg13cmos5l_fill_2
XANTENNA__6580__X Tile_X0Y0_FrameStrobe_O[14] VPWR VGND sg13cmos5l_antennanp
XFILLER_110_31 VPWR VGND sg13cmos5l_fill_2
XFILLER_21_270 VPWR VGND sg13cmos5l_fill_1
XANTENNA__6755__X Tile_X0Y1_FrameData_O[20] VPWR VGND sg13cmos5l_antennanp
XFILLER_88_292 VPWR VGND sg13cmos5l_fill_1
XANTENNA__6490__X Tile_X0Y0_E2BEG[0] VPWR VGND sg13cmos5l_antennanp
X_2730_ _2730_/Y Tile_X0Y0_S2MID[2] VPWR VGND sg13cmos5l_inv_1
XFILLER_8_241 VPWR VGND sg13cmos5l_fill_1
X_4400_ _4400_/X Tile_X0Y1_N1END[0] Tile_X0Y1_N2END[0] Tile_X0Y1_E1END[0] Tile_X0Y1_E2END[0]
+ _6048_/Q _6047_/Q VPWR VGND sg13cmos5l_mux4_1
X_5380_ _5380_/Y _6138_/Q _5422_/B VPWR VGND sg13cmos5l_nand2_1
X_4331_ _4331_/Y _4388_/B _4388_/A VPWR VGND sg13cmos5l_nor2b_1
X_4262_ _4262_/Y _4267_/A VPWR VGND sg13cmos5l_inv_1
X_6001_ _6001_/Q Tile_X0Y1_UserCLK _6001_/D _6455_/L_HI VPWR VGND sg13cmos5l_dfrbpq_1
X_3213_ _3214_/A _3213_/A _3213_/B VPWR VGND sg13cmos5l_and2_1
XANTENNA__6665__X Tile_X0Y0_W6BEG[6] VPWR VGND sg13cmos5l_antennanp
X_4193_ _4198_/A _4261_/A _4600_/A VPWR VGND sg13cmos5l_nor2_1
X_3144_ _3144_/Y _6096_/Q Tile_X0Y1_E2END[4] VPWR VGND sg13cmos5l_nor2b_1
X_3075_ _6490_/A _3075_/A VPWR VGND sg13cmos5l_inv_1
XFILLER_39_189 VPWR VGND sg13cmos5l_fill_1
XFILLER_54_159 VPWR VGND sg13cmos5l_fill_1
XFILLER_54_137 VPWR VGND sg13cmos5l_fill_2
XFILLER_35_340 VPWR VGND sg13cmos5l_fill_1
X_6834_ Tile_X0Y1_W2BEGb[2] Tile_X0Y1_W2MID[2] VPWR VGND sg13cmos5l_buf_1
XFILLER_50_343 VPWR VGND sg13cmos5l_fill_1
X_6765_ Tile_X0Y1_FrameData_O[30] Tile_X0Y1_FrameData[30] VPWR VGND sg13cmos5l_buf_1
X_3977_ _3980_/C _5786_/Q _6605_/A _3976_/Y VPWR VGND sg13cmos5l_o21ai_1
X_5716_ _5716_/Q Tile_X0Y0_FrameData[14] Tile_X0Y1_FrameStrobe[4] VPWR VGND sg13cmos5l_dlhq_1
X_2928_ _2929_/B _4515_/Y _5390_/B _6130_/Q VPWR VGND sg13cmos5l_mux2_1
X_6696_ Tile_X0Y1_E2BEG[5] _6696_/A VPWR VGND sg13cmos5l_buf_1
X_5647_ _5647_/Q Tile_X0Y0_FrameData[19] Tile_X0Y1_FrameStrobe[2] VPWR VGND sg13cmos5l_dlhq_1
X_2859_ _2859_/Y _6429_/Q VPWR VGND sg13cmos5l_inv_1
X_5578_ _5578_/Q Tile_X0Y0_FrameData[24] Tile_X0Y1_FrameStrobe[0] VPWR VGND sg13cmos5l_dlhq_1
X_4529_ _4530_/B Tile_X0Y0_S2END[6] Tile_X0Y0_W1END[2] _5678_/Q VPWR VGND sg13cmos5l_mux2_1
XFILLER_105_31 VPWR VGND sg13cmos5l_decap_8
XANTENNA__6575__X Tile_X0Y0_FrameStrobe_O[9] VPWR VGND sg13cmos5l_antennanp
XANTENNA_103 Tile_X0Y0_SS4END[5] VPWR VGND sg13cmos5l_antennanp
XANTENNA_114 Tile_X0Y0_W2MID[3] VPWR VGND sg13cmos5l_antennanp
XANTENNA_125 Tile_X0Y0_WW4END[0] VPWR VGND sg13cmos5l_antennanp
XANTENNA_136 Tile_X0Y0_WW4END[2] VPWR VGND sg13cmos5l_antennanp
XANTENNA_147 Tile_X0Y1_E2MID[3] VPWR VGND sg13cmos5l_antennanp
XANTENNA_158 Tile_X0Y1_E2MID[7] VPWR VGND sg13cmos5l_antennanp
XANTENNA_169 Tile_X0Y1_NN4END[7] VPWR VGND sg13cmos5l_antennanp
XFILLER_41_343 VPWR VGND sg13cmos5l_fill_1
XFILLER_36_126 VPWR VGND sg13cmos5l_fill_2
X_4880_ _4880_/X _4940_/Y _4934_/Y _4943_/Y _5011_/X _5610_/Q _5608_/Q VPWR VGND sg13cmos5l_mux4_1
X_3900_ _4218_/B _4205_/A _4470_/A VPWR VGND sg13cmos5l_nor2_1
X_3831_ _3831_/Y _5664_/Q _5009_/Y VPWR VGND sg13cmos5l_nand2_1
X_6550_ Tile_X0Y0_FrameData_O[16] Tile_X0Y0_FrameData[16] VPWR VGND sg13cmos5l_buf_1
X_3762_ _3762_/Y _6292_/Q _3761_/X _6291_/Q VPWR VGND sg13cmos5l_o21ai_1
X_5501_ _5501_/Y _6318_/Q _3481_/A _6317_/Q VPWR VGND sg13cmos5l_a21oi_1
X_6481_ _6481_/L_HI VPWR VGND sg13cmos5l_tiehi
X_3693_ _3693_/X _4515_/Y _4503_/Y _5390_/B _5374_/B _6104_/Q _6102_/Q VPWR VGND sg13cmos5l_mux4_1
X_2713_ _2713_/Y Tile_X0Y0_S2MID[0] VPWR VGND sg13cmos5l_inv_1
X_5432_ _5438_/B _6106_/Q _5430_/X _5431_/Y VPWR VGND sg13cmos5l_a21oi_1
X_5363_ _5363_/X _6368_/Q _5360_/Y _5362_/Y VPWR VGND sg13cmos5l_a21o_1
XFILLER_58_0 VPWR VGND sg13cmos5l_fill_1
X_4314_ _4315_/B Tile_X0Y1_NN4END[1] Tile_X0Y1_E2END[5] Tile_X0Y0_S2MID[5] Tile_X0Y1_W2END[5]
+ _6176_/Q _6175_/Q VPWR VGND sg13cmos5l_mux4_1
X_5294_ _5295_/B _5294_/A _5294_/B VPWR VGND sg13cmos5l_nor2_1
X_4245_ _4273_/A _4201_/A _4201_/B _4209_/Y VPWR VGND sg13cmos5l_a21oi_1
X_4176_ _4180_/A _5588_/Q _4174_/Y _4175_/Y VPWR VGND sg13cmos5l_a21oi_1
X_3127_ _3127_/Y _3118_/S _5062_/B _5636_/Q VPWR VGND sg13cmos5l_o21ai_1
X_3058_ _3058_/X Tile_X0Y0_E1END[2] Tile_X0Y0_W1END[0] Tile_X0Y0_E2END[6] Tile_X0Y0_W1END[2]
+ _5644_/Q _5646_/Q VPWR VGND sg13cmos5l_mux4_1
X_6817_ Tile_X0Y1_SS4BEG[14] _6817_/A VPWR VGND sg13cmos5l_buf_1
X_6748_ Tile_X0Y1_FrameData_O[13] Tile_X0Y1_FrameData[13] VPWR VGND sg13cmos5l_buf_1
X_6679_ Tile_X0Y0_WW4BEG[8] Tile_X0Y0_WW4END[12] VPWR VGND sg13cmos5l_buf_1
XFILLER_73_232 VPWR VGND sg13cmos5l_fill_1
XFILLER_73_254 VPWR VGND sg13cmos5l_fill_2
XFILLER_25_71 VPWR VGND sg13cmos5l_fill_2
XFILLER_14_376 VPWR VGND sg13cmos5l_decap_4
X_4030_ _4030_/Y _4030_/A _4030_/B VPWR VGND sg13cmos5l_nor2_1
XFILLER_96_379 VPWR VGND sg13cmos5l_fill_2
XFILLER_2_53 VPWR VGND sg13cmos5l_decap_8
XFILLER_49_284 VPWR VGND sg13cmos5l_fill_1
XFILLER_49_273 VPWR VGND sg13cmos5l_fill_1
X_5981_ _5981_/Q Tile_X0Y1_UserCLK _5981_/D _6435_/L_HI VPWR VGND sg13cmos5l_dfrbpq_1
X_4932_ _5543_/B _4932_/A _4932_/B VPWR VGND sg13cmos5l_xnor2_1
XANTENNA_14 Tile_X0Y0_E2END[7] VPWR VGND sg13cmos5l_antennanp
X_6602_ Tile_X0Y0_N2BEGb[4] _6602_/A VPWR VGND sg13cmos5l_buf_1
X_4863_ _4864_/B _6426_/Q _6007_/D _4862_/Y VPWR VGND sg13cmos5l_o21ai_1
XANTENNA_25 Tile_X0Y0_E2END[7] VPWR VGND sg13cmos5l_antennanp
XANTENNA_36 Tile_X0Y0_E2MID[0] VPWR VGND sg13cmos5l_antennanp
XANTENNA_47 Tile_X0Y0_E2MID[2] VPWR VGND sg13cmos5l_antennanp
X_4794_ _4794_/Y _5840_/Q _4794_/B VPWR VGND sg13cmos5l_nor2_1
X_3814_ _3814_/Y _6055_/Q _3810_/Y _3813_/Y VPWR VGND sg13cmos5l_o21ai_1
XANTENNA_58 Tile_X0Y0_E2MID[2] VPWR VGND sg13cmos5l_antennanp
XANTENNA_69 Tile_X0Y0_E2MID[4] VPWR VGND sg13cmos5l_antennanp
X_6533_ Tile_X0Y0_EE4BEG[15] _6533_/A VPWR VGND sg13cmos5l_buf_1
X_3745_ _3746_/B _3745_/A _3745_/B VPWR VGND sg13cmos5l_nor2_1
X_6464_ _6464_/L_HI VPWR VGND sg13cmos5l_tiehi
X_5415_ _5416_/A _6344_/Q _3864_/Y _5414_/Y VPWR VGND sg13cmos5l_a21oi_1
X_3676_ _5988_/D _3644_/Y _3651_/X _3675_/X VPWR VGND sg13cmos5l_o21ai_1
X_6395_ _6395_/Q Tile_X0Y1_FrameData[1] Tile_X0Y1_FrameStrobe[11] VPWR VGND sg13cmos5l_dlhq_1
X_5346_ _5346_/Y _6372_/Q _5345_/X _6371_/Q VPWR VGND sg13cmos5l_o21ai_1
X_5277_ _5277_/Y _5277_/A VPWR VGND sg13cmos5l_inv_1
X_4228_ _4229_/B _4228_/A _4228_/B VPWR VGND sg13cmos5l_xnor2_1
XFILLER_87_357 VPWR VGND sg13cmos5l_fill_2
X_4159_ _4159_/Y _5850_/Q _3205_/Y _5849_/Q VPWR VGND sg13cmos5l_a21oi_1
XFILLER_55_221 VPWR VGND sg13cmos5l_fill_1
XANTENNA__6853__X Tile_X0Y1_WW4BEG[1] VPWR VGND sg13cmos5l_antennanp
XFILLER_70_213 VPWR VGND sg13cmos5l_fill_2
XFILLER_23_184 VPWR VGND sg13cmos5l_fill_1
XFILLER_11_357 VPWR VGND sg13cmos5l_decap_8
XANTENNA__6763__X Tile_X0Y1_FrameData_O[28] VPWR VGND sg13cmos5l_antennanp
X_3530_ _3531_/C _6136_/Q _3528_/Y _3529_/Y VPWR VGND sg13cmos5l_o21ai_1
X_3461_ _3461_/Y _4320_/A _6216_/Q VPWR VGND sg13cmos5l_nor2_1
X_6180_ _6180_/Q Tile_X0Y1_FrameData[24] Tile_X0Y1_FrameStrobe[5] VPWR VGND sg13cmos5l_dlhq_1
X_5200_ _5201_/B _4944_/X Tile_X0Y0_S1END[2] Tile_X0Y0_W1END[2] _4707_/Y _5884_/Q
+ _5883_/Q VPWR VGND sg13cmos5l_mux4_1
X_3392_ _6775_/A _4308_/B _4308_/C VPWR VGND sg13cmos5l_nand2_1
X_5131_ _5131_/Y _5930_/Q _5130_/Y _2777_/Y VPWR VGND sg13cmos5l_a21oi_1
X_5062_ _5062_/Y _5954_/Q _5062_/B VPWR VGND sg13cmos5l_nor2_1
X_4013_ _4015_/B Tile_X0Y0_W2MID[3] _5792_/Q VPWR VGND sg13cmos5l_nand2_1
XFILLER_84_316 VPWR VGND sg13cmos5l_fill_1
XFILLER_96_198 VPWR VGND sg13cmos5l_fill_1
XANTENNA__6673__X Tile_X0Y0_WW4BEG[2] VPWR VGND sg13cmos5l_antennanp
X_5964_ _5964_/Q Tile_X0Y0_FrameData[22] Tile_X0Y1_FrameStrobe[12] VPWR VGND sg13cmos5l_dlhq_1
X_5895_ _5895_/Q Tile_X0Y0_FrameData[27] Tile_X0Y1_FrameStrobe[10] VPWR VGND sg13cmos5l_dlhq_1
X_4915_ _4916_/A _2761_/Y _3231_/Y _4914_/Y VPWR VGND sg13cmos5l_a21oi_1
XFILLER_52_279 VPWR VGND sg13cmos5l_decap_8
X_4846_ _4847_/A _5614_/Q _4842_/Y _4845_/Y VPWR VGND sg13cmos5l_a21oi_1
X_6516_ Tile_X0Y0_E6BEG[10] _6516_/A VPWR VGND sg13cmos5l_buf_1
X_4777_ _4777_/Y _5576_/Q Tile_X0Y0_SS4END[2] _4776_/Y VPWR VGND sg13cmos5l_a21oi_1
XFILLER_20_176 VPWR VGND sg13cmos5l_fill_2
X_3728_ _3766_/A _6425_/Q _5553_/Q VPWR VGND sg13cmos5l_nand2_1
X_6447_ _6447_/L_HI VPWR VGND sg13cmos5l_tiehi
X_3659_ _3659_/X _4515_/Y _5390_/B _6098_/Q VPWR VGND sg13cmos5l_mux2_1
XANTENNA__6848__X Tile_X0Y1_W6BEG[8] VPWR VGND sg13cmos5l_antennanp
X_6378_ _6378_/Q Tile_X0Y1_FrameData[18] Tile_X0Y1_FrameStrobe[11] VPWR VGND sg13cmos5l_dlhq_1
X_5329_ _5329_/X Tile_X0Y1_N1END[0] Tile_X0Y1_E1END[0] _6380_/Q VPWR VGND sg13cmos5l_mux2_1
XANTENNA__6583__X Tile_X0Y0_FrameStrobe_O[17] VPWR VGND sg13cmos5l_antennanp
XFILLER_22_83 VPWR VGND sg13cmos5l_fill_2
XANTENNA__6758__X Tile_X0Y1_FrameData_O[23] VPWR VGND sg13cmos5l_antennanp
XANTENNA__6493__X Tile_X0Y0_E2BEG[3] VPWR VGND sg13cmos5l_antennanp
XFILLER_93_157 VPWR VGND sg13cmos5l_fill_1
X_2961_ _2961_/Y _2957_/Y _2960_/Y _5627_/Q VPWR VGND sg13cmos5l_a21oi_1
X_5680_ _5680_/Q Tile_X0Y0_FrameData[18] Tile_X0Y1_FrameStrobe[3] VPWR VGND sg13cmos5l_dlhq_1
X_4700_ _4702_/A _4701_/A _4701_/C _4701_/B VPWR VGND sg13cmos5l_o21ai_1
XFILLER_97_4 VPWR VGND sg13cmos5l_fill_1
X_4631_ _4631_/Y _5708_/Q _2887_/Y _4630_/Y VPWR VGND sg13cmos5l_a21oi_1
X_2892_ _2892_/Y _5262_/X VPWR VGND sg13cmos5l_inv_1
X_4562_ _4562_/Y _5845_/Q _4553_/X _4558_/Y _4561_/Y _5846_/Q VPWR VGND sg13cmos5l_a221oi_1
X_6301_ _6301_/Q Tile_X0Y1_FrameData[31] Tile_X0Y1_FrameStrobe[9] VPWR VGND sg13cmos5l_dlhq_1
X_4493_ _4496_/C _4493_/A _4493_/B VPWR VGND sg13cmos5l_xnor2_1
X_3513_ _5978_/D _3513_/A VPWR VGND sg13cmos5l_inv_1
XANTENNA__6668__X Tile_X0Y0_W6BEG[9] VPWR VGND sg13cmos5l_antennanp
X_6232_ _6232_/Q Tile_X0Y1_FrameData[4] Tile_X0Y1_FrameStrobe[6] VPWR VGND sg13cmos5l_dlhq_1
X_3444_ _3444_/Y _5648_/Q _3437_/X _3443_/Y VPWR VGND sg13cmos5l_o21ai_1
XFILLER_6_191 VPWR VGND sg13cmos5l_fill_2
XFILLER_40_0 VPWR VGND sg13cmos5l_fill_2
X_6163_ _6163_/Q Tile_X0Y1_FrameData[9] Tile_X0Y1_FrameStrobe[4] VPWR VGND sg13cmos5l_dlhq_1
X_3375_ _3376_/B _2818_/Y _3374_/X _6153_/Q VPWR VGND sg13cmos5l_o21ai_1
X_6094_ _6094_/Q Tile_X0Y1_FrameData[14] Tile_X0Y1_FrameStrobe[2] VPWR VGND sg13cmos5l_dlhq_1
X_5114_ _6531_/A _5114_/A _5114_/B VPWR VGND sg13cmos5l_nor2_1
XFILLER_111_273 VPWR VGND sg13cmos5l_decap_8
XFILLER_111_240 VPWR VGND sg13cmos5l_decap_4
X_5045_ _5045_/Y _5960_/Q _5204_/B _5044_/Y VPWR VGND sg13cmos5l_o21ai_1
XFILLER_69_198 VPWR VGND sg13cmos5l_fill_2
XFILLER_25_202 VPWR VGND sg13cmos5l_fill_1
X_5947_ _5947_/Q Tile_X0Y0_FrameData[7] Tile_X0Y1_FrameStrobe[11] VPWR VGND sg13cmos5l_dlhq_1
XFILLER_40_205 VPWR VGND sg13cmos5l_fill_2
X_5878_ _5878_/Q Tile_X0Y0_FrameData[12] Tile_X0Y1_FrameStrobe[9] VPWR VGND sg13cmos5l_dlhq_1
X_4829_ _4829_/X Tile_X0Y0_S2END[6] Tile_X0Y0_W1END[2] _5614_/Q VPWR VGND sg13cmos5l_mux2_1
XANTENNA__6578__X Tile_X0Y0_FrameStrobe_O[12] VPWR VGND sg13cmos5l_antennanp
XFILLER_48_338 VPWR VGND sg13cmos5l_fill_1
XFILLER_63_308 VPWR VGND sg13cmos5l_fill_1
XFILLER_84_78 VPWR VGND sg13cmos5l_fill_1
XFILLER_17_72 VPWR VGND sg13cmos5l_fill_1
XFILLER_31_249 VPWR VGND sg13cmos5l_decap_4
XANTENNA__6488__X Tile_X0Y0_E1BEG[2] VPWR VGND sg13cmos5l_antennanp
X_3160_ _3161_/C _6024_/Q Tile_X0Y1_W2END[4] VPWR VGND sg13cmos5l_nand2b_1
X_3091_ _3091_/Y _5651_/Q _3091_/B VPWR VGND sg13cmos5l_nor2_1
X_6850_ Tile_X0Y1_W6BEG[10] _6850_/A VPWR VGND sg13cmos5l_buf_1
X_5801_ _5801_/Q Tile_X0Y0_FrameData[25] Tile_X0Y1_FrameStrobe[7] VPWR VGND sg13cmos5l_dlhq_1
X_6781_ Tile_X0Y1_S2BEGb[2] _6781_/A VPWR VGND sg13cmos5l_buf_1
X_5732_ _5732_/Q Tile_X0Y0_FrameData[30] Tile_X0Y1_FrameStrobe[5] VPWR VGND sg13cmos5l_dlhq_1
X_3993_ _3993_/Y _5712_/Q _3986_/X _3992_/Y VPWR VGND sg13cmos5l_o21ai_1
X_2944_ _2944_/Y Tile_X0Y1_E6END[0] _6062_/Q VPWR VGND sg13cmos5l_nor2_1
X_5663_ _5663_/Q Tile_X0Y0_FrameData[3] Tile_X0Y1_FrameStrobe[2] VPWR VGND sg13cmos5l_dlhq_1
X_2875_ _2875_/Y _6057_/Q VPWR VGND sg13cmos5l_inv_1
X_5594_ _5594_/Q Tile_X0Y0_FrameData[8] Tile_X0Y1_FrameStrobe[0] VPWR VGND sg13cmos5l_dlhq_1
X_4614_ _4616_/B _4614_/A _4614_/B VPWR VGND sg13cmos5l_xnor2_1
X_4545_ _4546_/B _5678_/Q _4541_/Y _4544_/Y VPWR VGND sg13cmos5l_a21oi_1
X_4476_ _4483_/A _4476_/A _4476_/B VPWR VGND sg13cmos5l_xor2_1
X_6215_ _6215_/Q Tile_X0Y1_FrameData[21] Tile_X0Y1_FrameStrobe[6] VPWR VGND sg13cmos5l_dlhq_1
X_3427_ _3427_/Y _2710_/Y _3424_/Y _6277_/Q VPWR VGND sg13cmos5l_a21oi_1
X_6146_ _6146_/Q Tile_X0Y1_FrameData[26] Tile_X0Y1_FrameStrobe[4] VPWR VGND sg13cmos5l_dlhq_1
X_3358_ _4046_/C _6146_/Q _3355_/X _3357_/Y VPWR VGND sg13cmos5l_a21oi_1
X_6077_ _6077_/Q Tile_X0Y1_FrameData[31] Tile_X0Y1_FrameStrobe[2] VPWR VGND sg13cmos5l_dlhq_1
X_3289_ _3296_/A _6151_/Q _3289_/B VPWR VGND sg13cmos5l_nor2_1
X_5028_ _5028_/Y _5974_/Q _5191_/B VPWR VGND sg13cmos5l_nand2_1
XFILLER_65_190 VPWR VGND sg13cmos5l_fill_1
XANTENNA__6861__X Tile_X0Y1_WW4BEG[9] VPWR VGND sg13cmos5l_antennanp
XFILLER_95_22 VPWR VGND sg13cmos5l_fill_2
XFILLER_0_142 VPWR VGND sg13cmos5l_fill_2
XFILLER_48_135 VPWR VGND sg13cmos5l_fill_1
XFILLER_63_127 VPWR VGND sg13cmos5l_fill_1
XANTENNA__6771__X Tile_X0Y1_S2BEG[0] VPWR VGND sg13cmos5l_antennanp
X_4330_ _4388_/B _4330_/A _4330_/B VPWR VGND sg13cmos5l_xnor2_1
XFILLER_5_53 VPWR VGND sg13cmos5l_fill_2
X_4261_ _4267_/A _4261_/A _4683_/A VPWR VGND sg13cmos5l_nor2_1
X_6000_ _6000_/Q Tile_X0Y1_UserCLK _6000_/D _6454_/L_HI VPWR VGND sg13cmos5l_dfrbpq_1
X_3212_ _3213_/B _6142_/Q _3209_/X _3211_/Y VPWR VGND sg13cmos5l_a21o_1
X_4192_ _4200_/A _4192_/A _4192_/B VPWR VGND sg13cmos5l_xnor2_1
X_3143_ _3143_/X Tile_X0Y1_W2END[4] Tile_X0Y1_WW4END[2] _6096_/Q VPWR VGND sg13cmos5l_mux2_1
X_3074_ _3075_/A _3074_/A _3074_/B VPWR VGND sg13cmos5l_nor2_1
XFILLER_94_296 VPWR VGND sg13cmos5l_fill_1
XANTENNA__6681__X Tile_X0Y0_WW4BEG[10] VPWR VGND sg13cmos5l_antennanp
X_6833_ Tile_X0Y1_W2BEGb[1] Tile_X0Y1_W2MID[1] VPWR VGND sg13cmos5l_buf_1
X_6764_ Tile_X0Y1_FrameData_O[29] Tile_X0Y1_FrameData[29] VPWR VGND sg13cmos5l_buf_1
X_3976_ _3976_/Y _2749_/Y _5786_/Q _5785_/Q VPWR VGND sg13cmos5l_a21oi_1
X_5715_ _5715_/Q Tile_X0Y0_FrameData[15] Tile_X0Y1_FrameStrobe[4] VPWR VGND sg13cmos5l_dlhq_1
X_6695_ Tile_X0Y1_E2BEG[4] _6695_/A VPWR VGND sg13cmos5l_buf_1
X_2927_ _2927_/X _4509_/Y _5374_/B _6130_/Q VPWR VGND sg13cmos5l_mux2_1
X_5646_ _5646_/Q Tile_X0Y0_FrameData[20] Tile_X0Y1_FrameStrobe[2] VPWR VGND sg13cmos5l_dlhq_1
X_2858_ _2858_/Y _6049_/Q VPWR VGND sg13cmos5l_inv_1
X_5577_ _5577_/Q Tile_X0Y0_FrameData[25] Tile_X0Y1_FrameStrobe[0] VPWR VGND sg13cmos5l_dlhq_1
X_2789_ _2789_/Y Tile_X0Y1_W1END[3] VPWR VGND sg13cmos5l_inv_1
X_4528_ _4531_/B Tile_X0Y0_E1END[2] _5678_/Q _4527_/Y VPWR VGND sg13cmos5l_o21ai_1
X_4459_ _6003_/D _4455_/Y _4456_/Y _4457_/X _4458_/Y _6273_/Q _6274_/Q VPWR VGND sg13cmos5l_mux4_1
XANTENNA__6856__X Tile_X0Y1_WW4BEG[4] VPWR VGND sg13cmos5l_antennanp
XFILLER_104_357 VPWR VGND sg13cmos5l_fill_2
XFILLER_105_10 VPWR VGND sg13cmos5l_decap_8
X_6129_ _6129_/Q Tile_X0Y1_FrameData[11] Tile_X0Y1_FrameStrobe[3] VPWR VGND sg13cmos5l_dlhq_1
XFILLER_45_105 VPWR VGND sg13cmos5l_fill_1
XANTENNA_104 Tile_X0Y0_SS4END[5] VPWR VGND sg13cmos5l_antennanp
XANTENNA_115 Tile_X0Y0_W2MID[3] VPWR VGND sg13cmos5l_antennanp
XANTENNA__6591__X Tile_X0Y0_N2BEG[1] VPWR VGND sg13cmos5l_antennanp
XANTENNA_126 Tile_X0Y0_WW4END[0] VPWR VGND sg13cmos5l_antennanp
XANTENNA_137 Tile_X0Y0_WW4END[2] VPWR VGND sg13cmos5l_antennanp
XANTENNA_148 Tile_X0Y1_E2MID[3] VPWR VGND sg13cmos5l_antennanp
XANTENNA_159 Tile_X0Y1_E2MID[7] VPWR VGND sg13cmos5l_antennanp
XFILLER_41_311 VPWR VGND sg13cmos5l_fill_1
XFILLER_81_68 VPWR VGND sg13cmos5l_fill_1
XFILLER_5_256 VPWR VGND sg13cmos5l_fill_2
XANTENNA__6766__X Tile_X0Y1_FrameData_O[31] VPWR VGND sg13cmos5l_antennanp
X_3830_ _3830_/X _4934_/Y _4707_/Y _5011_/X _4937_/Y _5666_/Q _5664_/Q VPWR VGND sg13cmos5l_mux4_1
X_3761_ _3761_/X Tile_X0Y1_N2END[3] Tile_X0Y1_E2END[3] Tile_X0Y0_S2MID[3] Tile_X0Y1_WW4END[1]
+ _6186_/Q _6185_/Q VPWR VGND sg13cmos5l_mux4_1
X_5500_ _5500_/X _6318_/Q _5500_/B VPWR VGND sg13cmos5l_or2_1
X_2712_ _4424_/A _6077_/Q VPWR VGND sg13cmos5l_inv_1
X_6480_ _6480_/L_HI VPWR VGND sg13cmos5l_tiehi
X_3692_ _3692_/Y _3687_/Y _3690_/Y _3691_/Y VPWR VGND sg13cmos5l_o21ai_1
X_5431_ _5431_/Y _6106_/Q _5429_/Y _6107_/Q VPWR VGND sg13cmos5l_o21ai_1
X_5362_ _5362_/Y _6368_/Q _5361_/X _6367_/Q VPWR VGND sg13cmos5l_o21ai_1
X_4313_ _4313_/Y _6015_/Q _4312_/Y _6282_/Q VPWR VGND sg13cmos5l_o21ai_1
XANTENNA__6676__X Tile_X0Y0_WW4BEG[5] VPWR VGND sg13cmos5l_antennanp
X_5293_ _5294_/B _6396_/Q _5292_/Y _6395_/Q VPWR VGND sg13cmos5l_o21ai_1
X_4244_ _4274_/A _4206_/A _4206_/B _4207_/Y VPWR VGND sg13cmos5l_o21ai_1
X_4175_ _4175_/Y Tile_X0Y0_W6END[0] _5588_/Q _5587_/Q VPWR VGND sg13cmos5l_o21ai_1
X_3126_ _3129_/B _5638_/Q _4707_/Y _3125_/Y VPWR VGND sg13cmos5l_o21ai_1
X_3057_ _3057_/Y _5644_/Q _3054_/Y _3055_/Y _3056_/Y _5645_/Q VPWR VGND sg13cmos5l_a221oi_1
XFILLER_82_255 VPWR VGND sg13cmos5l_fill_2
XFILLER_35_39 VPWR VGND sg13cmos5l_fill_2
XFILLER_35_17 VPWR VGND sg13cmos5l_fill_1
X_6816_ Tile_X0Y1_SS4BEG[13] _6816_/A VPWR VGND sg13cmos5l_buf_1
X_6747_ Tile_X0Y1_FrameData_O[12] Tile_X0Y1_FrameData[12] VPWR VGND sg13cmos5l_buf_1
X_3959_ _3959_/Y _5721_/Q _3952_/X _3958_/Y VPWR VGND sg13cmos5l_o21ai_1
X_6678_ Tile_X0Y0_WW4BEG[7] Tile_X0Y0_WW4END[11] VPWR VGND sg13cmos5l_buf_1
X_5629_ _5629_/Q Tile_X0Y0_FrameData[5] Tile_X0Y1_FrameStrobe[1] VPWR VGND sg13cmos5l_dlhq_1
XANTENNA__6586__X Tile_X0Y0_N1BEG[0] VPWR VGND sg13cmos5l_antennanp
XFILLER_58_241 VPWR VGND sg13cmos5l_fill_1
XFILLER_58_296 VPWR VGND sg13cmos5l_decap_8
XFILLER_26_160 VPWR VGND sg13cmos5l_fill_2
XFILLER_14_333 VPWR VGND sg13cmos5l_decap_8
XANTENNA__6496__X Tile_X0Y0_E2BEG[6] VPWR VGND sg13cmos5l_antennanp
X_5980_ _5980_/Q Tile_X0Y1_UserCLK _5980_/D _6434_/L_HI VPWR VGND sg13cmos5l_dfrbpq_1
X_4931_ _5062_/B _6423_/Q _5550_/B _4930_/Y VPWR VGND sg13cmos5l_o21ai_1
XFILLER_64_288 VPWR VGND sg13cmos5l_fill_2
X_4862_ _4862_/Y _6426_/Q _2744_/Y _6425_/Q VPWR VGND sg13cmos5l_a21oi_1
X_6601_ Tile_X0Y0_N2BEGb[3] _6601_/A VPWR VGND sg13cmos5l_buf_1
X_3813_ _3813_/Y _3813_/A _6054_/Q VPWR VGND sg13cmos5l_nor2b_1
XANTENNA_15 Tile_X0Y0_E2END[7] VPWR VGND sg13cmos5l_antennanp
XANTENNA_26 Tile_X0Y0_E2END[7] VPWR VGND sg13cmos5l_antennanp
XANTENNA_37 Tile_X0Y0_E2MID[0] VPWR VGND sg13cmos5l_antennanp
XANTENNA_48 Tile_X0Y0_E2MID[2] VPWR VGND sg13cmos5l_antennanp
X_4793_ _4794_/B Tile_X0Y1_N2MID[7] Tile_X0Y0_E2END[7] Tile_X0Y0_S2END[7] Tile_X0Y0_WW4END[0]
+ _5738_/Q _5737_/Q VPWR VGND sg13cmos5l_mux4_1
XANTENNA_59 Tile_X0Y0_E2MID[2] VPWR VGND sg13cmos5l_antennanp
X_6532_ Tile_X0Y0_EE4BEG[14] _6532_/A VPWR VGND sg13cmos5l_buf_1
X_3744_ _3745_/B _6119_/Q _3743_/X _6117_/Q VPWR VGND sg13cmos5l_o21ai_1
X_6463_ _6463_/L_HI VPWR VGND sg13cmos5l_tiehi
X_3675_ _3675_/X _3675_/A _3675_/B VPWR VGND sg13cmos5l_or2_1
X_5414_ _5414_/Y _6344_/Q _5342_/B _6343_/Q VPWR VGND sg13cmos5l_o21ai_1
X_6394_ _6394_/Q Tile_X0Y1_FrameData[2] Tile_X0Y1_FrameStrobe[11] VPWR VGND sg13cmos5l_dlhq_1
X_5345_ _5345_/X _5374_/B _5262_/X _5440_/B _5422_/B _6374_/Q _6373_/Q VPWR VGND sg13cmos5l_mux4_1
X_5276_ _5277_/A _6402_/Q _5275_/Y _6401_/Q VPWR VGND sg13cmos5l_o21ai_1
X_4227_ _4227_/X _4239_/A _4239_/B VPWR VGND sg13cmos5l_and2_1
X_4158_ _4158_/Y _5850_/Q _4158_/B VPWR VGND sg13cmos5l_nand2b_1
XFILLER_95_380 VPWR VGND sg13cmos5l_fill_1
X_4089_ _4090_/B _5860_/Q _4089_/B VPWR VGND sg13cmos5l_nand2_1
X_3109_ _3110_/B _5689_/Q _2887_/Y _3108_/Y VPWR VGND sg13cmos5l_o21ai_1
XFILLER_11_336 VPWR VGND sg13cmos5l_decap_8
XFILLER_93_317 VPWR VGND sg13cmos5l_decap_4
XFILLER_46_200 VPWR VGND sg13cmos5l_fill_1
XFILLER_46_222 VPWR VGND sg13cmos5l_fill_2
XFILLER_46_288 VPWR VGND sg13cmos5l_fill_1
XFILLER_10_380 VPWR VGND sg13cmos5l_fill_1
X_3460_ _3460_/Y _6216_/Q _3061_/A _3459_/Y VPWR VGND sg13cmos5l_o21ai_1
X_3391_ _4308_/C _6090_/Q _3388_/X _3390_/Y VPWR VGND sg13cmos5l_a21o_1
X_5130_ _5130_/Y _5931_/Q _4744_/Y _5129_/Y VPWR VGND sg13cmos5l_o21ai_1
X_5061_ _5061_/Y _5954_/Q _2886_/Y _5060_/Y VPWR VGND sg13cmos5l_a21oi_1
X_4012_ _4084_/A _4221_/A VPWR VGND sg13cmos5l_inv_1
XFILLER_96_177 VPWR VGND sg13cmos5l_decap_4
XFILLER_37_222 VPWR VGND sg13cmos5l_fill_2
X_5963_ _5963_/Q Tile_X0Y0_FrameData[23] Tile_X0Y1_FrameStrobe[12] VPWR VGND sg13cmos5l_dlhq_1
X_4914_ _4914_/Y _2761_/Y _6649_/A _5831_/Q VPWR VGND sg13cmos5l_o21ai_1
X_5894_ _5894_/Q Tile_X0Y0_FrameData[28] Tile_X0Y1_FrameStrobe[10] VPWR VGND sg13cmos5l_dlhq_1
X_4845_ _4845_/Y _5614_/Q _4844_/Y _5613_/Q VPWR VGND sg13cmos5l_o21ai_1
X_4776_ _4776_/Y _5576_/Q _4776_/B VPWR VGND sg13cmos5l_nor2_1
X_6515_ Tile_X0Y0_E6BEG[9] Tile_X0Y0_E6END[11] VPWR VGND sg13cmos5l_buf_1
X_3727_ _3792_/B _3727_/A _3727_/B VPWR VGND sg13cmos5l_xor2_1
X_6446_ _6446_/L_HI VPWR VGND sg13cmos5l_tiehi
X_3658_ _3658_/Y _6098_/Q _5374_/B _3657_/Y VPWR VGND sg13cmos5l_a21oi_1
X_6377_ _6377_/Q Tile_X0Y1_FrameData[19] Tile_X0Y1_FrameStrobe[11] VPWR VGND sg13cmos5l_dlhq_1
X_3589_ _3590_/B Tile_X0Y1_N2END[3] Tile_X0Y1_N4END[3] Tile_X0Y1_E6END[1] Tile_X0Y0_S2MID[3]
+ _6164_/Q _6162_/Q VPWR VGND sg13cmos5l_mux4_1
X_5328_ _5328_/Y _6380_/Q _3208_/Y _5327_/Y VPWR VGND sg13cmos5l_o21ai_1
X_5259_ _5259_/X _5866_/Q _5256_/X _5258_/Y VPWR VGND sg13cmos5l_a21o_1
XANTENNA__6864__X Tile_X0Y1_WW4BEG[12] VPWR VGND sg13cmos5l_antennanp
XFILLER_7_159 VPWR VGND sg13cmos5l_fill_1
XFILLER_3_354 VPWR VGND sg13cmos5l_decap_8
XFILLER_0_0 VPWR VGND sg13cmos5l_decap_8
XFILLER_93_103 VPWR VGND sg13cmos5l_fill_2
XANTENNA__6774__X Tile_X0Y1_S2BEG[3] VPWR VGND sg13cmos5l_antennanp
X_2960_ _2960_/Y _2960_/A _5628_/Q VPWR VGND sg13cmos5l_nor2b_1
X_2891_ _2891_/Y _3916_/Y VPWR VGND sg13cmos5l_inv_1
X_4630_ _4630_/Y _5708_/Q _4934_/Y VPWR VGND sg13cmos5l_nor2_1
X_6300_ _6300_/Q Tile_X0Y1_FrameData[0] Tile_X0Y1_FrameStrobe[8] VPWR VGND sg13cmos5l_dlhq_1
X_4561_ _4561_/Y _5845_/Q _4561_/B VPWR VGND sg13cmos5l_nor2_1
X_4492_ _4493_/B _4492_/A _4492_/B VPWR VGND sg13cmos5l_xor2_1
X_3512_ _3513_/A _6309_/Q _3489_/X _3511_/Y VPWR VGND sg13cmos5l_a21oi_1
X_6231_ _6231_/Q Tile_X0Y1_FrameData[5] Tile_X0Y1_FrameStrobe[6] VPWR VGND sg13cmos5l_dlhq_1
X_3443_ _3443_/Y _3439_/Y _3442_/Y _5647_/Q VPWR VGND sg13cmos5l_a21oi_1
X_6162_ _6162_/Q Tile_X0Y1_FrameData[10] Tile_X0Y1_FrameStrobe[4] VPWR VGND sg13cmos5l_dlhq_1
X_5113_ _5114_/B _5936_/Q _5111_/X _5112_/Y VPWR VGND sg13cmos5l_a21oi_1
X_3374_ _3374_/X _4503_/Y _5262_/X _3916_/Y _5440_/B _6154_/Q _6156_/Q VPWR VGND sg13cmos5l_mux4_1
XFILLER_33_0 VPWR VGND sg13cmos5l_fill_1
X_6093_ _6093_/Q Tile_X0Y1_FrameData[15] Tile_X0Y1_FrameStrobe[2] VPWR VGND sg13cmos5l_dlhq_1
XANTENNA__6684__X Tile_X0Y0_WW4BEG[13] VPWR VGND sg13cmos5l_antennanp
X_5044_ _5044_/Y _5044_/A _5044_/B VPWR VGND sg13cmos5l_nor2_1
XFILLER_84_158 VPWR VGND sg13cmos5l_fill_1
X_5946_ _5946_/Q Tile_X0Y0_FrameData[8] Tile_X0Y1_FrameStrobe[11] VPWR VGND sg13cmos5l_dlhq_1
X_5877_ _5877_/Q Tile_X0Y0_FrameData[13] Tile_X0Y1_FrameStrobe[9] VPWR VGND sg13cmos5l_dlhq_1
X_4828_ _4834_/B _5613_/Q _4828_/B VPWR VGND sg13cmos5l_nor2_1
X_4759_ _4759_/X Tile_X0Y0_E1END[3] Tile_X0Y0_S2END[7] _5672_/Q VPWR VGND sg13cmos5l_mux2_1
XANTENNA__6859__X Tile_X0Y1_WW4BEG[7] VPWR VGND sg13cmos5l_antennanp
XFILLER_111_7 VPWR VGND sg13cmos5l_fill_2
X_6429_ _6429_/Q Tile_X0Y1_FrameData[31] Tile_X0Y1_FrameStrobe[0] VPWR VGND sg13cmos5l_dlhq_1
XFILLER_108_21 VPWR VGND sg13cmos5l_fill_2
XANTENNA__6594__X Tile_X0Y0_N2BEG[4] VPWR VGND sg13cmos5l_antennanp
XFILLER_102_285 VPWR VGND sg13cmos5l_fill_2
XANTENNA__6769__X Tile_X0Y1_S1BEG[2] VPWR VGND sg13cmos5l_antennanp
X_3090_ _3091_/B _3090_/A _3090_/B VPWR VGND sg13cmos5l_nor2_1
XFILLER_47_361 VPWR VGND sg13cmos5l_fill_1
X_5800_ _5800_/Q Tile_X0Y0_FrameData[26] Tile_X0Y1_FrameStrobe[7] VPWR VGND sg13cmos5l_dlhq_1
X_6780_ Tile_X0Y1_S2BEGb[1] _6780_/A VPWR VGND sg13cmos5l_buf_1
X_3992_ _3992_/Y _3988_/Y _3991_/Y _5711_/Q VPWR VGND sg13cmos5l_a21oi_1
X_5731_ _5731_/Q Tile_X0Y0_FrameData[31] Tile_X0Y1_FrameStrobe[5] VPWR VGND sg13cmos5l_dlhq_1
X_2943_ _2943_/X Tile_X0Y1_E2END[4] Tile_X0Y1_W2END[4] _6062_/Q VPWR VGND sg13cmos5l_mux2_1
X_5662_ _5662_/Q Tile_X0Y0_FrameData[4] Tile_X0Y1_FrameStrobe[2] VPWR VGND sg13cmos5l_dlhq_1
X_2874_ _3852_/A _6254_/Q VPWR VGND sg13cmos5l_inv_1
X_5593_ _5593_/Q Tile_X0Y0_FrameData[9] Tile_X0Y1_FrameStrobe[0] VPWR VGND sg13cmos5l_dlhq_1
X_4613_ _4698_/A _4614_/B _4614_/A VPWR VGND sg13cmos5l_nand2b_1
XANTENNA__6679__X Tile_X0Y0_WW4BEG[8] VPWR VGND sg13cmos5l_antennanp
X_4544_ _4544_/Y _5678_/Q _4543_/Y _5677_/Q VPWR VGND sg13cmos5l_o21ai_1
X_6214_ _6214_/Q Tile_X0Y1_FrameData[22] Tile_X0Y1_FrameStrobe[6] VPWR VGND sg13cmos5l_dlhq_1
X_4475_ _4475_/Y _4476_/B _4476_/A VPWR VGND sg13cmos5l_nand2b_1
X_3426_ _3426_/Y _6276_/Q _6604_/A _3425_/Y VPWR VGND sg13cmos5l_o21ai_1
X_6145_ _6145_/Q Tile_X0Y1_FrameData[27] Tile_X0Y1_FrameStrobe[4] VPWR VGND sg13cmos5l_dlhq_1
X_3357_ _3357_/Y _6146_/Q _3356_/X _2876_/Y VPWR VGND sg13cmos5l_o21ai_1
X_6076_ _6076_/Q Tile_X0Y1_FrameData[0] Tile_X0Y1_FrameStrobe[1] VPWR VGND sg13cmos5l_dlhq_1
X_5027_ _5027_/X _5974_/Q _3099_/Y _5026_/Y VPWR VGND sg13cmos5l_a21o_1
X_3288_ _3289_/B _4515_/Y _4509_/Y _4518_/Y _5374_/B _6152_/Q _6150_/Q VPWR VGND sg13cmos5l_mux4_1
X_5929_ _5929_/Q Tile_X0Y0_FrameData[25] Tile_X0Y1_FrameStrobe[11] VPWR VGND sg13cmos5l_dlhq_1
XANTENNA__6589__X Tile_X0Y0_N1BEG[3] VPWR VGND sg13cmos5l_antennanp
XFILLER_107_311 VPWR VGND sg13cmos5l_decap_8
XFILLER_107_344 VPWR VGND sg13cmos5l_decap_8
XFILLER_0_187 VPWR VGND sg13cmos5l_fill_2
XFILLER_63_106 VPWR VGND sg13cmos5l_fill_2
XANTENNA__6499__X Tile_X0Y0_E2BEGb[1] VPWR VGND sg13cmos5l_antennanp
X_4260_ _4268_/A _4260_/A _4260_/B VPWR VGND sg13cmos5l_xnor2_1
X_4191_ _4192_/B _4191_/A _4191_/B VPWR VGND sg13cmos5l_xnor2_1
X_3211_ _3211_/Y _6142_/Q _3210_/X _2822_/Y VPWR VGND sg13cmos5l_o21ai_1
X_3142_ _3142_/X Tile_X0Y1_N2END[4] Tile_X0Y1_E1END[2] Tile_X0Y0_S2MID[4] Tile_X0Y0_S4END[4]
+ _6096_/Q _6094_/Q VPWR VGND sg13cmos5l_mux4_1
X_3073_ _3074_/B _3065_/Y _3067_/Y _3069_/Y _3072_/Y _5695_/Q VPWR VGND sg13cmos5l_a221oi_1
X_6832_ Tile_X0Y1_W2BEGb[0] Tile_X0Y1_W2MID[0] VPWR VGND sg13cmos5l_buf_1
X_6763_ Tile_X0Y1_FrameData_O[28] Tile_X0Y1_FrameData[28] VPWR VGND sg13cmos5l_buf_1
X_3975_ _3975_/Y _3975_/A _3975_/B VPWR VGND sg13cmos5l_nor2_1
X_5714_ _5714_/Q Tile_X0Y0_FrameData[16] Tile_X0Y1_FrameStrobe[4] VPWR VGND sg13cmos5l_dlhq_1
X_6694_ Tile_X0Y1_E2BEG[3] _6694_/A VPWR VGND sg13cmos5l_buf_1
X_2926_ _2926_/Y _2925_/X _2926_/B VPWR VGND sg13cmos5l_nand2b_1
X_5645_ _5645_/Q Tile_X0Y0_FrameData[21] Tile_X0Y1_FrameStrobe[2] VPWR VGND sg13cmos5l_dlhq_1
X_2857_ _2857_/Y _6087_/Q VPWR VGND sg13cmos5l_inv_1
XFILLER_108_108 VPWR VGND sg13cmos5l_fill_1
X_5576_ _5576_/Q Tile_X0Y0_FrameData[26] Tile_X0Y1_FrameStrobe[0] VPWR VGND sg13cmos5l_dlhq_1
X_2788_ _2788_/Y _6403_/Q VPWR VGND sg13cmos5l_inv_1
X_4527_ _4527_/Y _4640_/B _5678_/Q _5676_/Q VPWR VGND sg13cmos5l_a21oi_1
X_4458_ _4458_/Y _4454_/A _5522_/C _4414_/Y VPWR VGND sg13cmos5l_a21oi_1
X_3409_ _3409_/Y _6058_/Q _3409_/B VPWR VGND sg13cmos5l_nand2b_1
X_6128_ _6128_/Q Tile_X0Y1_FrameData[12] Tile_X0Y1_FrameStrobe[3] VPWR VGND sg13cmos5l_dlhq_1
X_4389_ _5261_/A _4504_/A _4504_/B _4331_/Y VPWR VGND sg13cmos5l_a21oi_1
XFILLER_85_231 VPWR VGND sg13cmos5l_fill_1
X_6059_ _6059_/Q Tile_X0Y1_FrameData[17] Tile_X0Y1_FrameStrobe[1] VPWR VGND sg13cmos5l_dlhq_1
XANTENNA_105 Tile_X0Y0_SS4END[5] VPWR VGND sg13cmos5l_antennanp
XANTENNA_116 Tile_X0Y0_W2MID[5] VPWR VGND sg13cmos5l_antennanp
XANTENNA_127 Tile_X0Y0_WW4END[0] VPWR VGND sg13cmos5l_antennanp
XANTENNA_138 Tile_X0Y0_WW4END[2] VPWR VGND sg13cmos5l_antennanp
XANTENNA_149 Tile_X0Y1_E2MID[3] VPWR VGND sg13cmos5l_antennanp
XFILLER_26_342 VPWR VGND sg13cmos5l_fill_2
XFILLER_53_183 VPWR VGND sg13cmos5l_fill_1
XFILLER_107_141 VPWR VGND sg13cmos5l_fill_1
XFILLER_100_0 VPWR VGND sg13cmos5l_fill_1
XFILLER_110_328 VPWR VGND sg13cmos5l_fill_2
XANTENNA__6782__X Tile_X0Y1_S2BEGb[3] VPWR VGND sg13cmos5l_antennanp
X_3760_ _3760_/Y _6025_/Q _3756_/X _3759_/Y VPWR VGND sg13cmos5l_a21oi_1
X_2711_ _2711_/Y _6002_/Q VPWR VGND sg13cmos5l_inv_1
XFILLER_71_91 VPWR VGND sg13cmos5l_fill_1
X_5430_ _5430_/X Tile_X0Y1_W2END[1] Tile_X0Y1_W6END[1] _6108_/Q VPWR VGND sg13cmos5l_mux2_1
X_3691_ _3691_/Y _3684_/Y _3685_/Y _6101_/Q VPWR VGND sg13cmos5l_a21oi_1
X_5361_ _5361_/X _5374_/B _5262_/X _5440_/B _5422_/B _6370_/Q _6369_/Q VPWR VGND sg13cmos5l_mux4_1
X_5292_ _5292_/Y _6397_/Q _5422_/B _5291_/Y VPWR VGND sg13cmos5l_o21ai_1
X_4312_ _4312_/Y Tile_X0Y0_S4END[5] _6016_/Q _4311_/Y VPWR VGND sg13cmos5l_a21oi_1
X_4243_ _4276_/A _4211_/A _4211_/B _4212_/Y VPWR VGND sg13cmos5l_a21oi_1
X_4174_ _4174_/Y _6645_/A VPWR VGND sg13cmos5l_inv_1
X_3125_ _3125_/Y _5638_/Q _2889_/Y _5636_/Q VPWR VGND sg13cmos5l_a21oi_1
XANTENNA__6692__X Tile_X0Y1_E2BEG[1] VPWR VGND sg13cmos5l_antennanp
X_3056_ _3056_/Y _2856_/Y _4944_/X _5644_/Q VPWR VGND sg13cmos5l_a21oi_1
XFILLER_35_172 VPWR VGND sg13cmos5l_fill_2
X_6815_ Tile_X0Y1_SS4BEG[12] _6815_/A VPWR VGND sg13cmos5l_buf_1
XFILLER_50_131 VPWR VGND sg13cmos5l_decap_8
X_6746_ Tile_X0Y1_FrameData_O[11] Tile_X0Y1_FrameData[11] VPWR VGND sg13cmos5l_buf_1
X_3958_ _3958_/Y _5719_/Q _3958_/B VPWR VGND sg13cmos5l_nor2_1
X_6677_ Tile_X0Y0_WW4BEG[6] Tile_X0Y0_WW4END[10] VPWR VGND sg13cmos5l_buf_1
X_3889_ _3889_/Y Tile_X0Y1_W2END[2] _6070_/Q _3888_/Y VPWR VGND sg13cmos5l_a21oi_1
X_2909_ _2909_/Y _5662_/Q _2908_/X _2905_/B VPWR VGND sg13cmos5l_a21oi_1
X_5628_ _5628_/Q Tile_X0Y0_FrameData[6] Tile_X0Y1_FrameStrobe[1] VPWR VGND sg13cmos5l_dlhq_1
X_5559_ _5559_/Q Tile_X0Y1_UserCLK _5559_/D _6473_/L_HI VPWR VGND sg13cmos5l_dfrbpq_1
XANTENNA__6867__X Tile_X0Y1_WW4BEG[15] VPWR VGND sg13cmos5l_antennanp
XFILLER_104_122 VPWR VGND sg13cmos5l_fill_1
XFILLER_58_220 VPWR VGND sg13cmos5l_fill_2
XFILLER_73_278 VPWR VGND sg13cmos5l_fill_2
XFILLER_73_256 VPWR VGND sg13cmos5l_fill_1
XANTENNA__6777__X Tile_X0Y1_S2BEG[6] VPWR VGND sg13cmos5l_antennanp
XFILLER_49_242 VPWR VGND sg13cmos5l_fill_1
XFILLER_1_271 VPWR VGND sg13cmos5l_fill_2
X_4930_ _4930_/Y _5570_/Q _6423_/Q VPWR VGND sg13cmos5l_nand2_1
X_4861_ _6007_/D _5842_/Q _4858_/Y _4859_/Y _4860_/Y VPWR VGND sg13cmos5l_a22oi_1
X_6600_ Tile_X0Y0_N2BEGb[2] _6600_/A VPWR VGND sg13cmos5l_buf_1
X_3812_ _3813_/A _2715_/Y _6056_/Q _3811_/Y VPWR VGND sg13cmos5l_a21oi_1
XANTENNA_16 Tile_X0Y0_E2END[7] VPWR VGND sg13cmos5l_antennanp
XANTENNA_27 Tile_X0Y0_E2END[7] VPWR VGND sg13cmos5l_antennanp
XANTENNA_38 Tile_X0Y0_E2MID[0] VPWR VGND sg13cmos5l_antennanp
X_4792_ _4792_/Y _5577_/Q _4791_/Y _5840_/Q VPWR VGND sg13cmos5l_o21ai_1
XANTENNA_49 Tile_X0Y0_E2MID[2] VPWR VGND sg13cmos5l_antennanp
X_6531_ Tile_X0Y0_EE4BEG[13] _6531_/A VPWR VGND sg13cmos5l_buf_1
X_3743_ _3743_/X _4515_/Y _4509_/Y _4518_/Y _5374_/B _6120_/Q _6118_/Q VPWR VGND sg13cmos5l_mux4_1
X_6462_ _6462_/L_HI VPWR VGND sg13cmos5l_tiehi
X_3674_ _3675_/B _6298_/Q _3673_/X _6297_/Q VPWR VGND sg13cmos5l_o21ai_1
X_5413_ _5413_/Y _6344_/Q _5440_/B _5412_/Y VPWR VGND sg13cmos5l_o21ai_1
X_6393_ _6393_/Q Tile_X0Y1_FrameData[3] Tile_X0Y1_FrameStrobe[11] VPWR VGND sg13cmos5l_dlhq_1
XANTENNA__6687__X Tile_X0Y1_E1BEG[0] VPWR VGND sg13cmos5l_antennanp
X_5344_ _5344_/Y _5342_/X _5343_/Y _5341_/Y VPWR VGND sg13cmos5l_o21ai_1
XFILLER_99_131 VPWR VGND sg13cmos5l_fill_2
X_5275_ _5275_/Y _6403_/Q _5262_/X _5274_/Y VPWR VGND sg13cmos5l_o21ai_1
XFILLER_99_164 VPWR VGND sg13cmos5l_fill_2
X_4226_ _4239_/B _4226_/A _4226_/B VPWR VGND sg13cmos5l_xnor2_1
X_4157_ _4158_/B _5812_/Q _6598_/A _4156_/Y VPWR VGND sg13cmos5l_o21ai_1
X_3108_ _3108_/Y _5689_/Q _5062_/B VPWR VGND sg13cmos5l_nand2_1
XFILLER_55_234 VPWR VGND sg13cmos5l_fill_2
X_4088_ _4089_/B Tile_X0Y1_N4END[5] _5598_/Q _4087_/Y VPWR VGND sg13cmos5l_o21ai_1
XFILLER_55_256 VPWR VGND sg13cmos5l_fill_2
X_3039_ _3039_/Y _6067_/Q _3032_/X _3038_/Y VPWR VGND sg13cmos5l_o21ai_1
XFILLER_102_23 VPWR VGND sg13cmos5l_fill_1
X_6729_ Tile_X0Y1_EE4BEG[10] Tile_X0Y1_EE4END[14] VPWR VGND sg13cmos5l_buf_1
XANTENNA__6597__X Tile_X0Y0_N2BEG[7] VPWR VGND sg13cmos5l_antennanp
XFILLER_87_68 VPWR VGND sg13cmos5l_fill_1
XFILLER_46_278 VPWR VGND sg13cmos5l_fill_2
X_3390_ _3390_/Y _6090_/Q _3389_/X _2854_/Y VPWR VGND sg13cmos5l_o21ai_1
X_5060_ _5060_/Y Tile_X0Y0_W1END[0] _5954_/Q VPWR VGND sg13cmos5l_nor2_1
X_4011_ _4221_/A _4139_/A _4011_/B VPWR VGND sg13cmos5l_xnor2_1
XFILLER_92_340 VPWR VGND sg13cmos5l_decap_4
X_5962_ _5962_/Q Tile_X0Y0_FrameData[24] Tile_X0Y1_FrameStrobe[12] VPWR VGND sg13cmos5l_dlhq_1
XFILLER_92_362 VPWR VGND sg13cmos5l_decap_4
XFILLER_52_215 VPWR VGND sg13cmos5l_fill_2
X_4913_ _4913_/Y _5832_/Q _6783_/A _4912_/Y VPWR VGND sg13cmos5l_o21ai_1
X_5893_ _5893_/Q Tile_X0Y0_FrameData[29] Tile_X0Y1_FrameStrobe[10] VPWR VGND sg13cmos5l_dlhq_1
X_4844_ _4844_/Y _5612_/Q _4909_/X _4843_/Y VPWR VGND sg13cmos5l_a21oi_1
XFILLER_60_270 VPWR VGND sg13cmos5l_fill_1
X_4775_ _4779_/A _5576_/Q _3934_/A _4774_/Y VPWR VGND sg13cmos5l_a21oi_1
X_6514_ Tile_X0Y0_E6BEG[8] Tile_X0Y0_E6END[10] VPWR VGND sg13cmos5l_buf_1
X_3726_ _3910_/A _3727_/A _3727_/B VPWR VGND sg13cmos5l_nor2_1
X_6445_ _6445_/L_HI VPWR VGND sg13cmos5l_tiehi
X_3657_ _3657_/Y _6098_/Q _4509_/Y VPWR VGND sg13cmos5l_nor2b_1
X_6376_ _6376_/Q Tile_X0Y1_FrameData[20] Tile_X0Y1_FrameStrobe[11] VPWR VGND sg13cmos5l_dlhq_1
X_3588_ _4188_/A _4137_/A VPWR VGND sg13cmos5l_inv_1
X_5327_ _5327_/Y _6380_/Q _2888_/Y _2795_/Y VPWR VGND sg13cmos5l_a21oi_1
X_5258_ _5258_/Y _5866_/Q _5257_/X _5865_/Q VPWR VGND sg13cmos5l_o21ai_1
X_5189_ _5189_/Y _5890_/Q _6779_/A _5889_/Q VPWR VGND sg13cmos5l_o21ai_1
X_4209_ _4209_/Y _4210_/A _4210_/B VPWR VGND sg13cmos5l_nor2b_1
XFILLER_87_189 VPWR VGND sg13cmos5l_fill_1
XFILLER_11_189 VPWR VGND sg13cmos5l_decap_4
XFILLER_3_300 VPWR VGND sg13cmos5l_fill_1
XFILLER_3_333 VPWR VGND sg13cmos5l_decap_8
XFILLER_3_377 VPWR VGND sg13cmos5l_fill_1
XFILLER_47_82 VPWR VGND sg13cmos5l_fill_1
XANTENNA__6790__X Tile_X0Y1_S4BEG[3] VPWR VGND sg13cmos5l_antennanp
X_2890_ _2890_/Y _4909_/X VPWR VGND sg13cmos5l_inv_1
XFILLER_8_10 VPWR VGND sg13cmos5l_fill_1
X_4560_ _4561_/B _5808_/Q _6495_/A _4559_/Y VPWR VGND sg13cmos5l_a21oi_1
X_4491_ _4491_/Y _4492_/B _4492_/A VPWR VGND sg13cmos5l_nand2b_1
X_3511_ _3511_/Y _6309_/Q _3511_/B VPWR VGND sg13cmos5l_nor2_1
X_6230_ _6230_/Q Tile_X0Y1_FrameData[6] Tile_X0Y1_FrameStrobe[6] VPWR VGND sg13cmos5l_dlhq_1
X_3442_ _3442_/Y _3442_/A _5648_/Q VPWR VGND sg13cmos5l_nor2b_1
XFILLER_6_193 VPWR VGND sg13cmos5l_fill_1
X_6161_ _6161_/Q Tile_X0Y1_FrameData[11] Tile_X0Y1_FrameStrobe[4] VPWR VGND sg13cmos5l_dlhq_1
X_3373_ _3376_/A _6155_/Q _3373_/B VPWR VGND sg13cmos5l_nor2_1
X_5112_ _5112_/Y _5936_/Q _5110_/Y _5935_/Q VPWR VGND sg13cmos5l_o21ai_1
X_6092_ _6092_/Q Tile_X0Y1_FrameData[16] Tile_X0Y1_FrameStrobe[2] VPWR VGND sg13cmos5l_dlhq_1
XFILLER_69_167 VPWR VGND sg13cmos5l_decap_4
XFILLER_26_0 VPWR VGND sg13cmos5l_fill_1
X_5043_ _5044_/B _5043_/A _5960_/Q VPWR VGND sg13cmos5l_nor2b_1
XFILLER_57_329 VPWR VGND sg13cmos5l_decap_8
XFILLER_65_362 VPWR VGND sg13cmos5l_fill_2
XFILLER_80_343 VPWR VGND sg13cmos5l_fill_2
X_5945_ _5945_/Q Tile_X0Y0_FrameData[9] Tile_X0Y1_FrameStrobe[11] VPWR VGND sg13cmos5l_dlhq_1
XFILLER_25_259 VPWR VGND sg13cmos5l_fill_2
X_5876_ _5876_/Q Tile_X0Y0_FrameData[14] Tile_X0Y1_FrameStrobe[9] VPWR VGND sg13cmos5l_dlhq_1
X_4827_ _4828_/B _4944_/X Tile_X0Y0_S1END[0] Tile_X0Y1_N2MID[6] Tile_X0Y0_S1END[2]
+ _5612_/Q _5614_/Q VPWR VGND sg13cmos5l_mux4_1
X_4758_ _4758_/Y _5673_/Q _4758_/B VPWR VGND sg13cmos5l_nand2b_1
X_4689_ _4690_/B _4689_/A _4689_/B _4689_/C VPWR VGND sg13cmos5l_or3_1
X_3709_ _3709_/X Tile_X0Y1_N2MID[4] Tile_X0Y1_E2MID[4] _6264_/Q VPWR VGND sg13cmos5l_mux2_1
X_6428_ _6428_/Q Tile_X0Y1_FrameData[0] Tile_X0Y1_FrameStrobe[12] VPWR VGND sg13cmos5l_dlhq_1
XFILLER_108_33 VPWR VGND sg13cmos5l_fill_2
X_6359_ _6359_/Q Tile_X0Y1_FrameData[5] Tile_X0Y1_FrameStrobe[10] VPWR VGND sg13cmos5l_dlhq_1
XFILLER_0_358 VPWR VGND sg13cmos5l_fill_2
XFILLER_48_318 VPWR VGND sg13cmos5l_fill_2
XFILLER_56_340 VPWR VGND sg13cmos5l_fill_1
XANTENNA__6785__X Tile_X0Y1_S2BEGb[6] VPWR VGND sg13cmos5l_antennanp
X_3991_ _3991_/Y _3991_/A _5712_/Q VPWR VGND sg13cmos5l_nor2b_1
X_5730_ _5730_/Q Tile_X0Y0_FrameData[0] Tile_X0Y1_FrameStrobe[4] VPWR VGND sg13cmos5l_dlhq_1
X_2942_ _2942_/X _2941_/X _2940_/X _2939_/Y _2937_/Y _6064_/Q _6063_/Q VPWR VGND sg13cmos5l_mux4_1
XFILLER_95_3 VPWR VGND sg13cmos5l_fill_2
X_5661_ _5661_/Q Tile_X0Y0_FrameData[5] Tile_X0Y1_FrameStrobe[2] VPWR VGND sg13cmos5l_dlhq_1
X_2873_ _2873_/Y _6253_/Q VPWR VGND sg13cmos5l_inv_1
X_5592_ _5592_/Q Tile_X0Y0_FrameData[10] Tile_X0Y1_FrameStrobe[0] VPWR VGND sg13cmos5l_dlhq_1
X_4612_ _4614_/B _4612_/A _4612_/B VPWR VGND sg13cmos5l_xnor2_1
X_4543_ _4543_/Y _5676_/Q _4909_/X _4542_/Y VPWR VGND sg13cmos5l_a21oi_1
X_6213_ _6213_/Q Tile_X0Y1_FrameData[23] Tile_X0Y1_FrameStrobe[6] VPWR VGND sg13cmos5l_dlhq_1
X_4474_ _4476_/B _4474_/A _4474_/B VPWR VGND sg13cmos5l_xor2_1
XFILLER_89_218 VPWR VGND sg13cmos5l_decap_4
X_3425_ _3425_/Y _6276_/Q _3371_/A _2710_/Y VPWR VGND sg13cmos5l_a21oi_1
XANTENNA__6695__X Tile_X0Y1_E2BEG[4] VPWR VGND sg13cmos5l_antennanp
X_6144_ _6144_/Q Tile_X0Y1_FrameData[28] Tile_X0Y1_FrameStrobe[4] VPWR VGND sg13cmos5l_dlhq_1
X_3356_ _3356_/X Tile_X0Y1_N1END[3] Tile_X0Y1_E1END[3] Tile_X0Y1_N2END[7] Tile_X0Y1_E2END[7]
+ _6147_/Q _6148_/Q VPWR VGND sg13cmos5l_mux4_1
X_6075_ _6075_/Q Tile_X0Y1_FrameData[1] Tile_X0Y1_FrameStrobe[1] VPWR VGND sg13cmos5l_dlhq_1
X_3287_ _3287_/Y _6149_/Q _3287_/B VPWR VGND sg13cmos5l_nor2_1
X_5026_ _5026_/Y _5974_/Q _5025_/Y _5973_/Q VPWR VGND sg13cmos5l_o21ai_1
X_5928_ _5928_/Q Tile_X0Y0_FrameData[26] Tile_X0Y1_FrameStrobe[11] VPWR VGND sg13cmos5l_dlhq_1
XFILLER_110_67 VPWR VGND sg13cmos5l_fill_2
X_5859_ _5859_/Q Tile_X0Y0_FrameData[31] Tile_X0Y1_FrameStrobe[9] VPWR VGND sg13cmos5l_dlhq_1
XFILLER_70_49 VPWR VGND sg13cmos5l_fill_2
XFILLER_107_378 VPWR VGND sg13cmos5l_fill_2
XFILLER_107_367 VPWR VGND sg13cmos5l_fill_1
XFILLER_107_356 VPWR VGND sg13cmos5l_decap_8
XFILLER_0_100 VPWR VGND sg13cmos5l_fill_1
X_4190_ _4191_/B _4189_/A _4256_/A _4187_/Y VPWR VGND sg13cmos5l_a21oi_1
X_3210_ _3210_/X Tile_X0Y1_N1END[0] Tile_X0Y1_N2END[0] Tile_X0Y1_E1END[0] Tile_X0Y1_EE4END[0]
+ _6144_/Q _6143_/Q VPWR VGND sg13cmos5l_mux4_1
XFILLER_79_251 VPWR VGND sg13cmos5l_fill_1
XFILLER_5_99 VPWR VGND sg13cmos5l_fill_1
X_3141_ _3141_/Y _6420_/Q _3916_/Y _3140_/Y VPWR VGND sg13cmos5l_o21ai_1
X_3072_ _3072_/Y _3072_/A _5697_/Q VPWR VGND sg13cmos5l_nor2b_1
X_6831_ Tile_X0Y1_W2BEG[7] Tile_X0Y1_W2END[7] VPWR VGND sg13cmos5l_buf_1
XFILLER_50_324 VPWR VGND sg13cmos5l_fill_2
X_6762_ Tile_X0Y1_FrameData_O[27] Tile_X0Y1_FrameData[27] VPWR VGND sg13cmos5l_buf_1
X_3974_ _3975_/B _5856_/Q _3973_/X _5855_/Q VPWR VGND sg13cmos5l_o21ai_1
X_5713_ _5713_/Q Tile_X0Y0_FrameData[17] Tile_X0Y1_FrameStrobe[4] VPWR VGND sg13cmos5l_dlhq_1
X_6693_ Tile_X0Y1_E2BEG[2] _6693_/A VPWR VGND sg13cmos5l_buf_1
X_2925_ _2925_/X Tile_X0Y1_N1END[1] Tile_X0Y1_N2END[3] Tile_X0Y1_E6END[1] Tile_X0Y0_S2MID[3]
+ _6132_/Q _6130_/Q VPWR VGND sg13cmos5l_mux4_1
X_5644_ _5644_/Q Tile_X0Y0_FrameData[22] Tile_X0Y1_FrameStrobe[2] VPWR VGND sg13cmos5l_dlhq_1
X_2856_ _2856_/Y _5646_/Q VPWR VGND sg13cmos5l_inv_1
XFILLER_40_19 VPWR VGND sg13cmos5l_fill_2
X_5575_ _5575_/Q Tile_X0Y0_FrameData[27] Tile_X0Y1_FrameStrobe[0] VPWR VGND sg13cmos5l_dlhq_1
X_2787_ _2787_/Y Tile_X0Y1_N1END[2] VPWR VGND sg13cmos5l_inv_1
X_4526_ _5243_/B _5775_/Q _4525_/X _4524_/Y VPWR VGND sg13cmos5l_o21ai_1
X_4457_ _4457_/X _6696_/A _6698_/A _6275_/Q VPWR VGND sg13cmos5l_mux2_1
X_3408_ _3409_/B _4515_/Y _4509_/Y _6060_/Q VPWR VGND sg13cmos5l_mux2_1
XFILLER_104_359 VPWR VGND sg13cmos5l_fill_1
X_6127_ _6127_/Q Tile_X0Y1_FrameData[13] Tile_X0Y1_FrameStrobe[3] VPWR VGND sg13cmos5l_dlhq_1
X_4388_ _4504_/B _4388_/A _4388_/B VPWR VGND sg13cmos5l_xnor2_1
X_3339_ _3339_/X _3217_/A _3325_/A _2750_/Y _2789_/Y _6052_/Q _6051_/Q VPWR VGND sg13cmos5l_mux4_1
XFILLER_105_45 VPWR VGND sg13cmos5l_fill_2
X_6058_ _6058_/Q Tile_X0Y1_FrameData[18] Tile_X0Y1_FrameStrobe[1] VPWR VGND sg13cmos5l_dlhq_1
XFILLER_105_67 VPWR VGND sg13cmos5l_fill_1
XANTENNA_106 Tile_X0Y0_SS4END[6] VPWR VGND sg13cmos5l_antennanp
X_5009_ _5009_/Y _6423_/Q _5551_/B _5008_/Y VPWR VGND sg13cmos5l_o21ai_1
XANTENNA_117 Tile_X0Y0_W2MID[5] VPWR VGND sg13cmos5l_antennanp
XANTENNA_128 Tile_X0Y0_WW4END[0] VPWR VGND sg13cmos5l_antennanp
XANTENNA_139 Tile_X0Y0_WW4END[2] VPWR VGND sg13cmos5l_antennanp
XFILLER_110_307 VPWR VGND sg13cmos5l_fill_2
X_2710_ _2710_/Y _6278_/Q VPWR VGND sg13cmos5l_inv_1
XFILLER_71_70 VPWR VGND sg13cmos5l_fill_1
X_3690_ _3690_/Y _6102_/Q _3689_/Y _6103_/Q VPWR VGND sg13cmos5l_o21ai_1
X_5360_ _5360_/Y _6369_/Q _5357_/X _5358_/Y _5359_/Y VPWR VGND sg13cmos5l_a22oi_1
X_5291_ _5291_/Y _6397_/Q _5493_/B VPWR VGND sg13cmos5l_nand2_1
X_4311_ _4311_/Y _6016_/Q Tile_X0Y1_E6END[1] VPWR VGND sg13cmos5l_nor2b_1
X_4242_ _4277_/A _4305_/A _4305_/B _4214_/Y VPWR VGND sg13cmos5l_o21ai_1
X_4173_ _6645_/A _4162_/Y _4164_/Y _4172_/Y VPWR VGND sg13cmos5l_o21ai_1
X_3124_ _3137_/A _3115_/Y _3117_/X _3123_/Y VPWR VGND sg13cmos5l_o21ai_1
X_3055_ _3055_/Y Tile_X0Y1_N2MID[6] _5646_/Q VPWR VGND sg13cmos5l_nand2_1
XFILLER_82_257 VPWR VGND sg13cmos5l_fill_1
X_6814_ Tile_X0Y1_SS4BEG[11] _6814_/A VPWR VGND sg13cmos5l_buf_1
XFILLER_35_195 VPWR VGND sg13cmos5l_fill_2
XFILLER_23_357 VPWR VGND sg13cmos5l_fill_1
X_6745_ Tile_X0Y1_FrameData_O[10] Tile_X0Y1_FrameData[10] VPWR VGND sg13cmos5l_buf_1
X_3957_ _3958_/B _5720_/Q _3953_/X _3956_/Y VPWR VGND sg13cmos5l_a21oi_1
X_2908_ _2908_/X _4943_/Y _5062_/B _5660_/Q VPWR VGND sg13cmos5l_mux2_1
X_6676_ Tile_X0Y0_WW4BEG[5] Tile_X0Y0_WW4END[9] VPWR VGND sg13cmos5l_buf_1
X_3888_ _3888_/Y _3888_/A _6070_/Q VPWR VGND sg13cmos5l_nor2_1
X_5627_ _5627_/Q Tile_X0Y0_FrameData[7] Tile_X0Y1_FrameStrobe[1] VPWR VGND sg13cmos5l_dlhq_1
X_2839_ _2839_/Y _5994_/Q VPWR VGND sg13cmos5l_inv_1
X_5558_ _5558_/Q Tile_X0Y1_UserCLK _5558_/D _6474_/L_HI VPWR VGND sg13cmos5l_dfrbpq_1
X_4509_ _4509_/Y _6423_/Q _5533_/B _4508_/Y VPWR VGND sg13cmos5l_o21ai_1
X_5489_ _6866_/A _5479_/X _5482_/Y _5488_/Y VPWR VGND sg13cmos5l_a21oi_1
XFILLER_14_313 VPWR VGND sg13cmos5l_fill_2
XFILLER_14_346 VPWR VGND sg13cmos5l_decap_8
XFILLER_41_95 VPWR VGND sg13cmos5l_fill_1
XFILLER_49_221 VPWR VGND sg13cmos5l_fill_2
XANTENNA__6793__X Tile_X0Y1_S4BEG[6] VPWR VGND sg13cmos5l_antennanp
XFILLER_2_67 VPWR VGND sg13cmos5l_decap_8
X_4860_ _4860_/Y _5841_/Q _4854_/X _5842_/Q VPWR VGND sg13cmos5l_a21oi_1
X_3811_ _3811_/Y Tile_X0Y0_S2MID[6] _6056_/Q _6055_/Q VPWR VGND sg13cmos5l_o21ai_1
XANTENNA_17 Tile_X0Y0_E2END[7] VPWR VGND sg13cmos5l_antennanp
XANTENNA_28 Tile_X0Y0_E2END[7] VPWR VGND sg13cmos5l_antennanp
XANTENNA_39 Tile_X0Y0_E2MID[0] VPWR VGND sg13cmos5l_antennanp
X_6530_ Tile_X0Y0_EE4BEG[12] _6530_/A VPWR VGND sg13cmos5l_buf_1
X_4791_ _4791_/Y Tile_X0Y1_N4END[7] _5578_/Q _4790_/Y VPWR VGND sg13cmos5l_o21ai_1
X_3742_ _3745_/A _2811_/Y _3738_/Y _3741_/Y VPWR VGND sg13cmos5l_a21oi_1
XFILLER_20_349 VPWR VGND sg13cmos5l_fill_1
X_6461_ _6461_/L_HI VPWR VGND sg13cmos5l_tiehi
X_3673_ _3673_/X Tile_X0Y1_N2END[4] Tile_X0Y1_E2END[4] Tile_X0Y0_SS4END[6] Tile_X0Y1_W2END[4]
+ _6192_/Q _6191_/Q VPWR VGND sg13cmos5l_mux4_1
X_5412_ _5412_/Y _6344_/Q _5498_/B _6343_/Q VPWR VGND sg13cmos5l_a21oi_1
X_6392_ _6392_/Q Tile_X0Y1_FrameData[4] Tile_X0Y1_FrameStrobe[11] VPWR VGND sg13cmos5l_dlhq_1
X_5343_ _5343_/Y _6374_/Q _5498_/B _6373_/Q VPWR VGND sg13cmos5l_o21ai_1
XFILLER_99_110 VPWR VGND sg13cmos5l_decap_4
XFILLER_99_121 VPWR VGND sg13cmos5l_decap_4
X_5274_ _5274_/Y _6403_/Q _5468_/B VPWR VGND sg13cmos5l_nand2_1
X_4225_ _4239_/A _4231_/A _4231_/B _4222_/X VPWR VGND sg13cmos5l_o21ai_1
X_4156_ _4156_/Y _2713_/Y _5812_/Q _5811_/Q VPWR VGND sg13cmos5l_a21oi_1
X_3107_ _3111_/B _5689_/Q _4934_/Y _3106_/Y VPWR VGND sg13cmos5l_o21ai_1
X_4087_ _4087_/Y _2755_/Y _5598_/Q _5597_/Q VPWR VGND sg13cmos5l_a21oi_1
X_3038_ _3038_/Y _6065_/Q _3038_/B VPWR VGND sg13cmos5l_nor2_1
XFILLER_102_13 VPWR VGND sg13cmos5l_fill_2
XFILLER_63_290 VPWR VGND sg13cmos5l_fill_1
X_4989_ _4989_/Y _5669_/Q _4989_/B VPWR VGND sg13cmos5l_nand2_1
X_6728_ Tile_X0Y1_EE4BEG[9] Tile_X0Y1_EE4END[13] VPWR VGND sg13cmos5l_buf_1
X_6659_ Tile_X0Y0_W6BEG[0] Tile_X0Y0_W6END[2] VPWR VGND sg13cmos5l_buf_1
XFILLER_11_54 VPWR VGND sg13cmos5l_fill_1
XFILLER_11_43 VPWR VGND sg13cmos5l_fill_1
XANTENNA__6788__X Tile_X0Y1_S4BEG[1] VPWR VGND sg13cmos5l_antennanp
XFILLER_6_342 VPWR VGND sg13cmos5l_decap_8
X_4010_ _4145_/A _4139_/A _4011_/B VPWR VGND sg13cmos5l_nor2b_1
XFILLER_96_157 VPWR VGND sg13cmos5l_decap_4
X_5961_ _5961_/Q Tile_X0Y0_FrameData[25] Tile_X0Y1_FrameStrobe[12] VPWR VGND sg13cmos5l_dlhq_1
X_4912_ _4912_/Y _5832_/Q _3620_/B _5831_/Q VPWR VGND sg13cmos5l_a21oi_1
XFILLER_52_238 VPWR VGND sg13cmos5l_fill_1
X_5892_ _5892_/Q Tile_X0Y0_FrameData[30] Tile_X0Y1_FrameStrobe[10] VPWR VGND sg13cmos5l_dlhq_1
X_4843_ _4843_/Y _5612_/Q _4707_/Y VPWR VGND sg13cmos5l_nor2b_1
X_4774_ _4774_/Y _5576_/Q Tile_X0Y0_W2END[2] _5575_/Q VPWR VGND sg13cmos5l_o21ai_1
X_6513_ Tile_X0Y0_E6BEG[7] Tile_X0Y0_E6END[9] VPWR VGND sg13cmos5l_buf_1
X_3725_ _3727_/B _3725_/A _3725_/B VPWR VGND sg13cmos5l_xnor2_1
XANTENNA__6698__X Tile_X0Y1_E2BEG[7] VPWR VGND sg13cmos5l_antennanp
X_6444_ _6444_/L_HI VPWR VGND sg13cmos5l_tiehi
X_3656_ _3662_/B _6100_/Q _3654_/Y _3655_/Y VPWR VGND sg13cmos5l_a21o_1
X_6375_ _6375_/Q Tile_X0Y1_FrameData[21] Tile_X0Y1_FrameStrobe[11] VPWR VGND sg13cmos5l_dlhq_1
X_3587_ _4137_/A _5979_/D _5979_/Q _6428_/Q VPWR VGND sg13cmos5l_mux2_1
X_5326_ _6732_/A _5323_/Y _5325_/Y _5321_/Y VPWR VGND sg13cmos5l_a21oi_1
X_5257_ _5257_/X _4937_/Y _4909_/X _5062_/B _5009_/Y _5868_/Q _5867_/Q VPWR VGND sg13cmos5l_mux4_1
XFILLER_57_17 VPWR VGND sg13cmos5l_fill_1
X_4208_ _4210_/B _4208_/A _4208_/B VPWR VGND sg13cmos5l_xnor2_1
X_5188_ _6639_/A _5011_/X _6782_/A _3206_/X _3187_/X _5891_/Q _5892_/Q VPWR VGND sg13cmos5l_mux4_1
X_4139_ _4192_/A _4139_/A _4139_/B VPWR VGND sg13cmos5l_nor2_1
XFILLER_51_282 VPWR VGND sg13cmos5l_fill_1
XFILLER_98_46 VPWR VGND sg13cmos5l_fill_1
XFILLER_78_124 VPWR VGND sg13cmos5l_decap_4
XFILLER_93_127 VPWR VGND sg13cmos5l_fill_1
XFILLER_42_271 VPWR VGND sg13cmos5l_decap_4
X_3510_ _3511_/B _6310_/Q _3504_/X _3509_/Y VPWR VGND sg13cmos5l_o21ai_1
X_4490_ _4492_/B _4490_/A _4490_/B VPWR VGND sg13cmos5l_xnor2_1
X_3441_ _3442_/A _2747_/Y _5650_/Q _3440_/Y VPWR VGND sg13cmos5l_a21oi_1
X_6160_ _6160_/Q Tile_X0Y1_FrameData[12] Tile_X0Y1_FrameStrobe[4] VPWR VGND sg13cmos5l_dlhq_1
X_3372_ _3373_/B _4515_/Y _4509_/Y _5390_/B _5374_/B _6156_/Q _6154_/Q VPWR VGND sg13cmos5l_mux4_1
X_5111_ _5111_/X _4127_/A _4625_/X _5937_/Q VPWR VGND sg13cmos5l_mux2_1
X_6091_ _6091_/Q Tile_X0Y1_FrameData[17] Tile_X0Y1_FrameStrobe[2] VPWR VGND sg13cmos5l_dlhq_1
X_5042_ _5042_/Y _5958_/Q _5042_/B VPWR VGND sg13cmos5l_nor2_1
XFILLER_111_287 VPWR VGND sg13cmos5l_decap_8
XFILLER_19_0 VPWR VGND sg13cmos5l_fill_2
X_5944_ _5944_/Q Tile_X0Y0_FrameData[10] Tile_X0Y1_FrameStrobe[11] VPWR VGND sg13cmos5l_dlhq_1
X_5875_ _5875_/Q Tile_X0Y0_FrameData[15] Tile_X0Y1_FrameStrobe[9] VPWR VGND sg13cmos5l_dlhq_1
X_4826_ _4864_/A _6425_/Q _5565_/Q VPWR VGND sg13cmos5l_nand2_1
X_4757_ _4758_/B _3063_/X Tile_X0Y0_S1END[1] Tile_X0Y1_N2MID[7] Tile_X0Y0_S1END[3]
+ _5672_/Q _5674_/Q VPWR VGND sg13cmos5l_mux4_1
X_4688_ _4714_/A _4689_/A _4689_/B _4689_/C VPWR VGND sg13cmos5l_o21ai_1
X_3708_ _3708_/Y _3703_/Y _3706_/Y _3707_/X _2871_/Y VPWR VGND sg13cmos5l_a22oi_1
XFILLER_111_9 VPWR VGND sg13cmos5l_fill_1
X_6427_ _6427_/Q Tile_X0Y1_FrameData[1] Tile_X0Y1_FrameStrobe[12] VPWR VGND sg13cmos5l_dlhq_1
X_3639_ _3639_/Y _3639_/A VPWR VGND sg13cmos5l_inv_1
X_6358_ _6358_/Q Tile_X0Y1_FrameData[6] Tile_X0Y1_FrameStrobe[10] VPWR VGND sg13cmos5l_dlhq_1
X_5309_ _5309_/Y _6386_/Q _5500_/B VPWR VGND sg13cmos5l_nand2_1
XFILLER_0_337 VPWR VGND sg13cmos5l_decap_8
X_6289_ _6289_/Q Tile_X0Y1_FrameData[11] Tile_X0Y1_FrameStrobe[8] VPWR VGND sg13cmos5l_dlhq_1
XFILLER_71_344 VPWR VGND sg13cmos5l_fill_2
X_3990_ _3991_/A _2747_/Y _5714_/Q _3989_/Y VPWR VGND sg13cmos5l_a21oi_1
X_2941_ _2941_/X _4515_/Y _5390_/B _6062_/Q VPWR VGND sg13cmos5l_mux2_1
XFILLER_22_208 VPWR VGND sg13cmos5l_fill_2
X_5660_ _5660_/Q Tile_X0Y0_FrameData[6] Tile_X0Y1_FrameStrobe[2] VPWR VGND sg13cmos5l_dlhq_1
X_4611_ _4612_/B _4611_/A _4611_/B VPWR VGND sg13cmos5l_xnor2_1
X_2872_ _2872_/Y _6059_/Q VPWR VGND sg13cmos5l_inv_1
X_5591_ _5591_/Q Tile_X0Y0_FrameData[11] Tile_X0Y1_FrameStrobe[0] VPWR VGND sg13cmos5l_dlhq_1
X_4542_ _4542_/Y _5676_/Q _4707_/Y VPWR VGND sg13cmos5l_nor2b_1
X_4473_ _4473_/X _4599_/A _4602_/A _4474_/B VPWR VGND sg13cmos5l_or3_1
X_6212_ _6212_/Q Tile_X0Y1_FrameData[24] Tile_X0Y1_FrameStrobe[6] VPWR VGND sg13cmos5l_dlhq_1
X_3424_ _3424_/Y _6276_/Q _3383_/Y _3423_/Y VPWR VGND sg13cmos5l_o21ai_1
XFILLER_89_208 VPWR VGND sg13cmos5l_fill_2
X_6143_ _6143_/Q Tile_X0Y1_FrameData[29] Tile_X0Y1_FrameStrobe[4] VPWR VGND sg13cmos5l_dlhq_1
X_3355_ _3355_/X _3325_/A _2790_/Y _2750_/Y _2789_/Y _6147_/Q _6148_/Q VPWR VGND sg13cmos5l_mux4_1
X_6074_ _6074_/Q Tile_X0Y1_FrameData[2] Tile_X0Y1_FrameStrobe[1] VPWR VGND sg13cmos5l_dlhq_1
X_3286_ _3287_/B _6150_/Q _3286_/B VPWR VGND sg13cmos5l_nor2_1
XFILLER_57_105 VPWR VGND sg13cmos5l_fill_1
X_5025_ _5025_/Y _5633_/Q _5016_/Y _5018_/Y _5024_/Y VPWR VGND sg13cmos5l_a22oi_1
X_5927_ _5927_/Q Tile_X0Y0_FrameData[27] Tile_X0Y1_FrameStrobe[11] VPWR VGND sg13cmos5l_dlhq_1
X_5858_ _5858_/Q Tile_X0Y0_FrameData[0] Tile_X0Y1_FrameStrobe[8] VPWR VGND sg13cmos5l_dlhq_1
X_5789_ _5789_/Q Tile_X0Y0_FrameData[5] Tile_X0Y1_FrameStrobe[6] VPWR VGND sg13cmos5l_dlhq_1
X_4809_ _4809_/Y _5703_/Q _4809_/B VPWR VGND sg13cmos5l_nor2_1
XFILLER_56_171 VPWR VGND sg13cmos5l_fill_2
XFILLER_60_94 VPWR VGND sg13cmos5l_fill_2
XANTENNA__6796__X Tile_X0Y1_S4BEG[9] VPWR VGND sg13cmos5l_antennanp
X_3140_ _3140_/Y _6420_/Q _5450_/B VPWR VGND sg13cmos5l_nand2_1
XFILLER_94_222 VPWR VGND sg13cmos5l_fill_1
X_3071_ _3072_/A _2771_/Y _5698_/Q _3070_/Y VPWR VGND sg13cmos5l_a21oi_1
X_6830_ Tile_X0Y1_W2BEG[6] _6830_/A VPWR VGND sg13cmos5l_buf_1
XFILLER_35_355 VPWR VGND sg13cmos5l_fill_1
X_6761_ Tile_X0Y1_FrameData_O[26] Tile_X0Y1_FrameData[26] VPWR VGND sg13cmos5l_buf_1
X_5712_ _5712_/Q Tile_X0Y0_FrameData[18] Tile_X0Y1_FrameStrobe[4] VPWR VGND sg13cmos5l_dlhq_1
X_3973_ _3973_/X Tile_X0Y1_NN4END[7] Tile_X0Y0_S2END[6] Tile_X0Y0_E2END[6] Tile_X0Y0_W2END[6]
+ _5753_/Q _5754_/Q VPWR VGND sg13cmos5l_mux4_1
X_6692_ Tile_X0Y1_E2BEG[1] _6692_/A VPWR VGND sg13cmos5l_buf_1
X_2924_ _2924_/Y _2921_/Y _2923_/Y _2845_/Y VPWR VGND sg13cmos5l_a21oi_1
XFILLER_86_0 VPWR VGND sg13cmos5l_fill_2
X_5643_ _5643_/Q Tile_X0Y0_FrameData[23] Tile_X0Y1_FrameStrobe[2] VPWR VGND sg13cmos5l_dlhq_1
X_2855_ _2855_/Y _5996_/Q VPWR VGND sg13cmos5l_inv_1
X_5574_ _5574_/Q Tile_X0Y0_FrameData[28] Tile_X0Y1_FrameStrobe[0] VPWR VGND sg13cmos5l_dlhq_1
X_4525_ _4525_/X _6601_/A Tile_X0Y0_E2MID[3] _5776_/Q VPWR VGND sg13cmos5l_mux2_1
X_2786_ _2786_/Y Tile_X0Y1_W6END[0] VPWR VGND sg13cmos5l_inv_1
X_4456_ _4456_/Y _6275_/Q _4431_/A _4415_/Y VPWR VGND sg13cmos5l_a21oi_1
X_4387_ _4504_/A _4510_/A _4510_/B _4355_/Y VPWR VGND sg13cmos5l_o21ai_1
X_3407_ _6695_/A _3407_/A VPWR VGND sg13cmos5l_inv_1
X_6126_ _6126_/Q Tile_X0Y1_FrameData[14] Tile_X0Y1_FrameStrobe[3] VPWR VGND sg13cmos5l_dlhq_1
X_3338_ _6697_/A _3338_/A VPWR VGND sg13cmos5l_inv_1
XFILLER_105_24 VPWR VGND sg13cmos5l_decap_8
X_6057_ _6057_/Q Tile_X0Y1_FrameData[19] Tile_X0Y1_FrameStrobe[1] VPWR VGND sg13cmos5l_dlhq_1
X_3269_ _3269_/Y _6158_/Q _2888_/Y _3268_/Y VPWR VGND sg13cmos5l_o21ai_1
XANTENNA_107 Tile_X0Y0_SS4END[6] VPWR VGND sg13cmos5l_antennanp
X_5008_ _5008_/Y _5571_/Q _6423_/Q VPWR VGND sg13cmos5l_nand2_1
XANTENNA_118 Tile_X0Y0_W2MID[5] VPWR VGND sg13cmos5l_antennanp
XANTENNA_129 Tile_X0Y0_WW4END[0] VPWR VGND sg13cmos5l_antennanp
XFILLER_39_40 VPWR VGND sg13cmos5l_fill_2
XFILLER_39_73 VPWR VGND sg13cmos5l_fill_2
XFILLER_55_50 VPWR VGND sg13cmos5l_fill_2
XFILLER_40_380 VPWR VGND sg13cmos5l_fill_1
X_5290_ _5294_/A _6397_/Q _3574_/Y _5289_/Y VPWR VGND sg13cmos5l_a21oi_1
X_4310_ _4310_/Y _4310_/A _4308_/Y VPWR VGND sg13cmos5l_nor2b_1
X_4241_ _4305_/B _4241_/A _4241_/B VPWR VGND sg13cmos5l_xor2_1
X_4172_ _4172_/Y _5624_/Q _4165_/X _4171_/Y VPWR VGND sg13cmos5l_o21ai_1
XFILLER_67_211 VPWR VGND sg13cmos5l_fill_1
X_3123_ _3123_/Y _5635_/Q _3123_/B VPWR VGND sg13cmos5l_nor2_1
X_3054_ _3054_/Y Tile_X0Y0_S1END[2] _2856_/Y _3053_/X VPWR VGND sg13cmos5l_a21oi_1
XFILLER_67_299 VPWR VGND sg13cmos5l_fill_2
X_6813_ Tile_X0Y1_SS4BEG[10] _6813_/A VPWR VGND sg13cmos5l_buf_1
X_6744_ Tile_X0Y1_FrameData_O[9] Tile_X0Y1_FrameData[9] VPWR VGND sg13cmos5l_buf_1
X_3956_ _3956_/Y _5720_/Q _3955_/Y _5721_/Q VPWR VGND sg13cmos5l_o21ai_1
X_6675_ Tile_X0Y0_WW4BEG[4] Tile_X0Y0_WW4END[8] VPWR VGND sg13cmos5l_buf_1
X_2907_ _2907_/X _2889_/Y _2890_/Y _5660_/Q VPWR VGND sg13cmos5l_mux2_1
X_5626_ _5626_/Q Tile_X0Y0_FrameData[8] Tile_X0Y1_FrameStrobe[1] VPWR VGND sg13cmos5l_dlhq_1
X_3887_ _3893_/B _6071_/Q _3887_/B VPWR VGND sg13cmos5l_nor2_1
X_2838_ _2838_/Y _6294_/Q VPWR VGND sg13cmos5l_inv_1
X_5557_ _5557_/Q Tile_X0Y1_UserCLK _5557_/D _6475_/L_HI VPWR VGND sg13cmos5l_dfrbpq_1
X_2769_ _2769_/Y _5827_/Q VPWR VGND sg13cmos5l_inv_1
X_5488_ _5488_/Y _5488_/A _5488_/B VPWR VGND sg13cmos5l_nor2_1
X_4508_ _4508_/Y _6423_/Q _5553_/Q VPWR VGND sg13cmos5l_nand2_1
XFILLER_2_218 VPWR VGND sg13cmos5l_fill_1
X_4439_ _4439_/Y _6112_/Q _4503_/Y _4438_/Y VPWR VGND sg13cmos5l_o21ai_1
XFILLER_4_9 VPWR VGND sg13cmos5l_decap_8
XFILLER_104_168 VPWR VGND sg13cmos5l_fill_2
XFILLER_58_222 VPWR VGND sg13cmos5l_fill_1
X_6109_ _6109_/Q Tile_X0Y1_FrameData[31] Tile_X0Y1_FrameStrobe[3] VPWR VGND sg13cmos5l_dlhq_1
XFILLER_14_369 VPWR VGND sg13cmos5l_decap_8
XFILLER_49_233 VPWR VGND sg13cmos5l_fill_2
X_4790_ _4790_/Y Tile_X0Y0_EE4END[0] _5578_/Q VPWR VGND sg13cmos5l_nand2b_1
X_3810_ _3810_/Y _6056_/Q _3208_/Y _3809_/Y VPWR VGND sg13cmos5l_o21ai_1
XANTENNA_18 Tile_X0Y0_E2END[7] VPWR VGND sg13cmos5l_antennanp
XANTENNA_29 Tile_X0Y0_E2END[7] VPWR VGND sg13cmos5l_antennanp
X_3741_ _3741_/Y _3739_/Y _3740_/Y _6119_/Q VPWR VGND sg13cmos5l_o21ai_1
XFILLER_9_340 VPWR VGND sg13cmos5l_fill_1
X_6460_ _6460_/L_HI VPWR VGND sg13cmos5l_tiehi
X_3672_ _3675_/A _6031_/Q _3668_/X _3671_/Y VPWR VGND sg13cmos5l_a21oi_1
XFILLER_9_362 VPWR VGND sg13cmos5l_decap_8
X_5411_ _5411_/Y _6342_/Q _5411_/B VPWR VGND sg13cmos5l_nor2_1
X_6391_ _6391_/Q Tile_X0Y1_FrameData[5] Tile_X0Y1_FrameStrobe[11] VPWR VGND sg13cmos5l_dlhq_1
X_5342_ _5342_/X _6374_/Q _5342_/B VPWR VGND sg13cmos5l_and2_1
X_5273_ _5273_/X _2788_/Y _3643_/Y _5272_/Y VPWR VGND sg13cmos5l_a21o_1
X_4224_ _4231_/B _4224_/A _4224_/B VPWR VGND sg13cmos5l_xor2_1
XFILLER_101_127 VPWR VGND sg13cmos5l_fill_2
X_4155_ _4155_/Y _5812_/Q _3231_/Y _4154_/Y VPWR VGND sg13cmos5l_a21oi_1
X_3106_ _3106_/Y _5689_/Q _2886_/Y _5688_/Q VPWR VGND sg13cmos5l_a21oi_1
X_4086_ _4090_/A _5598_/Q _2915_/A _4085_/Y VPWR VGND sg13cmos5l_a21oi_1
XFILLER_55_258 VPWR VGND sg13cmos5l_fill_1
X_3037_ _3038_/B _6066_/Q _3033_/X _3036_/Y VPWR VGND sg13cmos5l_a21oi_1
X_4988_ _4988_/Y _5668_/Q _2894_/Y _4987_/Y VPWR VGND sg13cmos5l_a21oi_1
X_6727_ Tile_X0Y1_EE4BEG[8] Tile_X0Y1_EE4END[12] VPWR VGND sg13cmos5l_buf_1
X_3939_ _3940_/C _5815_/Q _3939_/B VPWR VGND sg13cmos5l_nor2_1
X_6658_ Tile_X0Y0_W2BEGb[7] Tile_X0Y0_W2MID[7] VPWR VGND sg13cmos5l_buf_1
X_5609_ _5609_/Q Tile_X0Y0_FrameData[25] Tile_X0Y1_FrameStrobe[1] VPWR VGND sg13cmos5l_dlhq_1
X_6589_ Tile_X0Y0_N1BEG[3] _6589_/A VPWR VGND sg13cmos5l_buf_1
X_5960_ _5960_/Q Tile_X0Y0_FrameData[26] Tile_X0Y1_FrameStrobe[12] VPWR VGND sg13cmos5l_dlhq_1
XFILLER_92_375 VPWR VGND sg13cmos5l_decap_4
XFILLER_52_217 VPWR VGND sg13cmos5l_fill_1
X_5891_ _5891_/Q Tile_X0Y0_FrameData[31] Tile_X0Y1_FrameStrobe[10] VPWR VGND sg13cmos5l_dlhq_1
X_4911_ _4911_/X _4910_/Y _5565_/Q _6423_/Q VPWR VGND sg13cmos5l_mux2_1
X_4842_ _4842_/Y _5612_/Q _2889_/Y _4841_/Y VPWR VGND sg13cmos5l_o21ai_1
X_4773_ _4773_/Y _4768_/Y _4771_/X _4772_/Y VPWR VGND sg13cmos5l_o21ai_1
X_6512_ Tile_X0Y0_E6BEG[6] Tile_X0Y0_E6END[8] VPWR VGND sg13cmos5l_buf_1
X_3724_ _3725_/B _3724_/A _3901_/A VPWR VGND sg13cmos5l_xnor2_1
XFILLER_20_169 VPWR VGND sg13cmos5l_decap_8
X_6443_ _6443_/L_HI VPWR VGND sg13cmos5l_tiehi
X_3655_ _3655_/Y _6100_/Q _3652_/X _6099_/Q VPWR VGND sg13cmos5l_o21ai_1
X_6374_ _6374_/Q Tile_X0Y1_FrameData[22] Tile_X0Y1_FrameStrobe[11] VPWR VGND sg13cmos5l_dlhq_1
X_3586_ _5979_/D _3575_/Y _3582_/Y _3585_/Y VPWR VGND sg13cmos5l_a21oi_1
X_5325_ _5325_/Y _2794_/Y _5324_/X _6381_/Q VPWR VGND sg13cmos5l_a21oi_1
X_5256_ _5256_/X _5209_/B _4127_/Y _5229_/B _4744_/Y _5868_/Q _5867_/Q VPWR VGND sg13cmos5l_mux4_1
X_4207_ _4207_/Y _4208_/A _4208_/B VPWR VGND sg13cmos5l_nand2b_1
X_5187_ _6814_/A _5186_/X _5185_/X _5893_/Q VPWR VGND sg13cmos5l_mux2_1
X_4138_ _4189_/A _4138_/A _4709_/A VPWR VGND sg13cmos5l_and2_1
XFILLER_95_180 VPWR VGND sg13cmos5l_fill_2
X_4069_ _4069_/Y _2749_/Y _5794_/Q _5793_/Q VPWR VGND sg13cmos5l_a21oi_1
XFILLER_11_147 VPWR VGND sg13cmos5l_fill_1
XFILLER_78_103 VPWR VGND sg13cmos5l_fill_1
XFILLER_59_350 VPWR VGND sg13cmos5l_decap_4
XFILLER_47_51 VPWR VGND sg13cmos5l_fill_1
XANTENNA__6799__X Tile_X0Y1_S4BEG[12] VPWR VGND sg13cmos5l_antennanp
X_3440_ _3440_/Y Tile_X0Y0_W1END[1] _5650_/Q _5649_/Q VPWR VGND sg13cmos5l_o21ai_1
X_3371_ _6777_/A _3371_/A VPWR VGND sg13cmos5l_inv_1
X_6090_ _6090_/Q Tile_X0Y1_FrameData[18] Tile_X0Y1_FrameStrobe[2] VPWR VGND sg13cmos5l_dlhq_1
X_5110_ _5110_/Y _5937_/Q _4909_/X _5109_/Y VPWR VGND sg13cmos5l_o21ai_1
X_5041_ _5042_/B _4944_/X Tile_X0Y0_W1END[2] Tile_X0Y0_E1END[2] _4707_/Y _5959_/Q
+ _5960_/Q VPWR VGND sg13cmos5l_mux4_1
XFILLER_111_233 VPWR VGND sg13cmos5l_decap_8
XFILLER_111_266 VPWR VGND sg13cmos5l_decap_8
X_5943_ _5943_/Q Tile_X0Y0_FrameData[11] Tile_X0Y1_FrameStrobe[11] VPWR VGND sg13cmos5l_dlhq_1
X_5874_ _5874_/Q Tile_X0Y0_FrameData[16] Tile_X0Y1_FrameStrobe[9] VPWR VGND sg13cmos5l_dlhq_1
XFILLER_33_261 VPWR VGND sg13cmos5l_fill_2
X_4825_ _4825_/Y _4872_/B _4872_/A VPWR VGND sg13cmos5l_nor2b_1
XANTENNA__6502__X Tile_X0Y0_E2BEGb[4] VPWR VGND sg13cmos5l_antennanp
X_4756_ _4756_/Y _5673_/Q _4755_/X _4754_/Y VPWR VGND sg13cmos5l_a21oi_1
X_4687_ _4689_/C _4687_/A _4687_/B VPWR VGND sg13cmos5l_xnor2_1
X_3707_ _3707_/X Tile_X0Y1_N2END[4] Tile_X0Y1_EE4END[0] Tile_X0Y0_S2MID[4] Tile_X0Y1_W2END[4]
+ _6200_/Q _6199_/Q VPWR VGND sg13cmos5l_mux4_1
X_6426_ _6426_/Q Tile_X0Y1_FrameData[2] Tile_X0Y1_FrameStrobe[12] VPWR VGND sg13cmos5l_dlhq_1
X_3638_ _3639_/A _6256_/Q _6783_/A _6255_/Q VPWR VGND sg13cmos5l_o21ai_1
XFILLER_108_35 VPWR VGND sg13cmos5l_fill_1
X_6357_ _6357_/Q Tile_X0Y1_FrameData[7] Tile_X0Y1_FrameStrobe[10] VPWR VGND sg13cmos5l_dlhq_1
X_3569_ _3569_/X _4509_/Y _5374_/B _6126_/Q VPWR VGND sg13cmos5l_mux2_1
X_5308_ _5308_/Y _2792_/Y _5307_/Y _6384_/Q VPWR VGND sg13cmos5l_a21oi_1
X_6288_ _6288_/Q Tile_X0Y1_FrameData[12] Tile_X0Y1_FrameStrobe[8] VPWR VGND sg13cmos5l_dlhq_1
X_5239_ _5240_/A _4940_/Y _4934_/Y _4943_/Y _5011_/X _5872_/Q _5870_/Q VPWR VGND sg13cmos5l_mux4_1
XFILLER_56_320 VPWR VGND sg13cmos5l_fill_2
XFILLER_33_75 VPWR VGND sg13cmos5l_fill_2
X_2940_ _2940_/X _4509_/Y _5374_/B _6062_/Q VPWR VGND sg13cmos5l_mux2_1
X_2871_ _2871_/Y _6306_/Q VPWR VGND sg13cmos5l_inv_1
XFILLER_30_220 VPWR VGND sg13cmos5l_fill_1
X_4610_ _4610_/Y _4611_/A _4611_/B VPWR VGND sg13cmos5l_nand2_1
X_5590_ _5590_/Q Tile_X0Y0_FrameData[12] Tile_X0Y1_FrameStrobe[0] VPWR VGND sg13cmos5l_dlhq_1
XFILLER_30_297 VPWR VGND sg13cmos5l_fill_2
X_4541_ _4541_/Y _5676_/Q _2889_/Y _4540_/Y VPWR VGND sg13cmos5l_o21ai_1
X_4472_ _4474_/B _4472_/A _4472_/B VPWR VGND sg13cmos5l_xnor2_1
X_6211_ _6211_/Q Tile_X0Y1_FrameData[25] Tile_X0Y1_FrameStrobe[6] VPWR VGND sg13cmos5l_dlhq_1
X_3423_ _3423_/Y _6276_/Q _6775_/A VPWR VGND sg13cmos5l_nand2_1
X_6142_ _6142_/Q Tile_X0Y1_FrameData[30] Tile_X0Y1_FrameStrobe[4] VPWR VGND sg13cmos5l_dlhq_1
X_3354_ _4046_/B _3354_/A _3354_/B VPWR VGND sg13cmos5l_nor2_1
XFILLER_97_231 VPWR VGND sg13cmos5l_fill_2
XFILLER_31_0 VPWR VGND sg13cmos5l_fill_1
X_6073_ _6073_/Q Tile_X0Y1_FrameData[3] Tile_X0Y1_FrameStrobe[1] VPWR VGND sg13cmos5l_dlhq_1
X_3285_ _3286_/B Tile_X0Y1_N1END[2] Tile_X0Y1_E1END[2] Tile_X0Y1_N2END[6] Tile_X0Y1_E2END[6]
+ _6151_/Q _6152_/Q VPWR VGND sg13cmos5l_mux4_1
XFILLER_97_264 VPWR VGND sg13cmos5l_fill_2
X_5024_ _5024_/Y _5633_/Q _5024_/B VPWR VGND sg13cmos5l_nor2_1
XFILLER_38_353 VPWR VGND sg13cmos5l_fill_2
XFILLER_38_342 VPWR VGND sg13cmos5l_fill_1
X_5926_ _5926_/Q Tile_X0Y0_FrameData[28] Tile_X0Y1_FrameStrobe[11] VPWR VGND sg13cmos5l_dlhq_1
XFILLER_53_367 VPWR VGND sg13cmos5l_fill_1
X_5857_ _5857_/Q Tile_X0Y0_FrameData[1] Tile_X0Y1_FrameStrobe[8] VPWR VGND sg13cmos5l_dlhq_1
X_5788_ _5788_/Q Tile_X0Y0_FrameData[6] Tile_X0Y1_FrameStrobe[6] VPWR VGND sg13cmos5l_dlhq_1
X_4808_ _4809_/B _5706_/Q _4806_/Y _4807_/Y VPWR VGND sg13cmos5l_a21oi_1
X_4739_ _4739_/Y Tile_X0Y0_W2MID[5] _5766_/Q VPWR VGND sg13cmos5l_nor2b_1
XFILLER_107_325 VPWR VGND sg13cmos5l_fill_1
X_6409_ _6409_/Q Tile_X0Y1_FrameData[19] Tile_X0Y1_FrameStrobe[12] VPWR VGND sg13cmos5l_dlhq_1
XFILLER_95_48 VPWR VGND sg13cmos5l_fill_1
XFILLER_12_264 VPWR VGND sg13cmos5l_fill_2
XFILLER_8_268 VPWR VGND sg13cmos5l_fill_1
XFILLER_5_46 VPWR VGND sg13cmos5l_fill_2
XFILLER_106_380 VPWR VGND sg13cmos5l_fill_1
X_3070_ _3070_/Y Tile_X0Y0_W2END[1] _5698_/Q _5696_/Q VPWR VGND sg13cmos5l_o21ai_1
XFILLER_35_312 VPWR VGND sg13cmos5l_fill_2
X_6760_ Tile_X0Y1_FrameData_O[25] Tile_X0Y1_FrameData[25] VPWR VGND sg13cmos5l_buf_1
X_5711_ _5711_/Q Tile_X0Y0_FrameData[19] Tile_X0Y1_FrameStrobe[4] VPWR VGND sg13cmos5l_dlhq_1
X_3972_ _3975_/A _5593_/Q _3968_/X _3971_/Y VPWR VGND sg13cmos5l_a21oi_1
XFILLER_50_326 VPWR VGND sg13cmos5l_fill_1
X_6691_ Tile_X0Y1_E2BEG[0] _6691_/A VPWR VGND sg13cmos5l_buf_1
X_2923_ _2923_/Y _6132_/Q _2922_/X _2926_/B VPWR VGND sg13cmos5l_a21oi_1
X_5642_ _5642_/Q Tile_X0Y0_FrameData[24] Tile_X0Y1_FrameStrobe[2] VPWR VGND sg13cmos5l_dlhq_1
X_2854_ _2854_/Y _6089_/Q VPWR VGND sg13cmos5l_inv_1
X_5573_ _5573_/Q Tile_X0Y0_FrameData[29] Tile_X0Y1_FrameStrobe[0] VPWR VGND sg13cmos5l_dlhq_1
X_2785_ _4344_/A Tile_X0Y1_N4END[2] VPWR VGND sg13cmos5l_inv_1
XFILLER_79_0 VPWR VGND sg13cmos5l_fill_1
X_4524_ _4524_/Y _5775_/Q _4524_/B _4524_/C VPWR VGND sg13cmos5l_nand3_1
X_4455_ _4455_/Y _4454_/A _4737_/B _4454_/Y VPWR VGND sg13cmos5l_a21oi_1
X_4386_ _4510_/B _4386_/A _4386_/B VPWR VGND sg13cmos5l_xnor2_1
X_3406_ _3407_/A _3475_/B _3475_/C VPWR VGND sg13cmos5l_nor2_1
X_6125_ _6125_/Q Tile_X0Y1_FrameData[15] Tile_X0Y1_FrameStrobe[3] VPWR VGND sg13cmos5l_dlhq_1
X_3337_ _3338_/A _3337_/A _3337_/B VPWR VGND sg13cmos5l_nor2_1
X_6056_ _6056_/Q Tile_X0Y1_FrameData[20] Tile_X0Y1_FrameStrobe[1] VPWR VGND sg13cmos5l_dlhq_1
X_3268_ _3268_/Y _6158_/Q _5422_/B VPWR VGND sg13cmos5l_nand2_1
X_5007_ _5551_/B _5007_/A _5007_/B VPWR VGND sg13cmos5l_xnor2_1
X_3199_ _3199_/Y _3199_/A _3198_/Y VPWR VGND sg13cmos5l_nor2b_1
XANTENNA_108 Tile_X0Y0_SS4END[6] VPWR VGND sg13cmos5l_antennanp
XANTENNA_119 Tile_X0Y0_W2MID[7] VPWR VGND sg13cmos5l_antennanp
X_5909_ _5909_/Q Tile_X0Y0_FrameData[13] Tile_X0Y1_FrameStrobe[10] VPWR VGND sg13cmos5l_dlhq_1
XANTENNA__6600__X Tile_X0Y0_N2BEGb[2] VPWR VGND sg13cmos5l_antennanp
X_4240_ _4305_/A _4330_/A _4330_/B _4227_/X VPWR VGND sg13cmos5l_a21oi_1
XFILLER_99_359 VPWR VGND sg13cmos5l_fill_1
X_4171_ _4171_/Y _4167_/Y _4170_/Y _5623_/Q VPWR VGND sg13cmos5l_a21oi_1
X_3122_ _3123_/B _5637_/Q _3120_/Y _3121_/Y VPWR VGND sg13cmos5l_a21oi_1
X_3053_ _3053_/X Tile_X0Y0_S2END[6] _5646_/Q VPWR VGND sg13cmos5l_and2_1
XFILLER_82_237 VPWR VGND sg13cmos5l_fill_1
X_6812_ Tile_X0Y1_SS4BEG[9] _6812_/A VPWR VGND sg13cmos5l_buf_1
X_6743_ Tile_X0Y1_FrameData_O[8] Tile_X0Y1_FrameData[8] VPWR VGND sg13cmos5l_buf_1
X_3955_ _3955_/Y Tile_X0Y0_E2END[3] _5722_/Q _3954_/Y VPWR VGND sg13cmos5l_a21oi_1
X_6674_ Tile_X0Y0_WW4BEG[3] Tile_X0Y0_WW4END[7] VPWR VGND sg13cmos5l_buf_1
X_2906_ _2906_/Y _2901_/Y _2903_/Y _5659_/Q VPWR VGND sg13cmos5l_a21oi_1
X_5625_ _5625_/Q Tile_X0Y0_FrameData[9] Tile_X0Y1_FrameStrobe[1] VPWR VGND sg13cmos5l_dlhq_1
X_3886_ _3887_/B Tile_X0Y1_N1END[0] Tile_X0Y0_S2MID[2] Tile_X0Y1_N2END[2] Tile_X0Y0_S4END[6]
+ _6070_/Q _6072_/Q VPWR VGND sg13cmos5l_mux4_1
X_2837_ _2837_/Y _6150_/Q VPWR VGND sg13cmos5l_inv_1
X_5556_ _5556_/Q Tile_X0Y1_UserCLK _5556_/D _6476_/L_HI VPWR VGND sg13cmos5l_dfrbpq_1
X_2768_ _2768_/Y _5701_/Q VPWR VGND sg13cmos5l_inv_1
XANTENNA__6510__X Tile_X0Y0_E6BEG[4] VPWR VGND sg13cmos5l_antennanp
X_5487_ _5488_/B _2805_/Y _5486_/Y _6322_/Q VPWR VGND sg13cmos5l_o21ai_1
X_4507_ _5533_/B _4507_/A _4507_/B VPWR VGND sg13cmos5l_xnor2_1
X_4438_ _4438_/Y _6112_/Q _2891_/Y _6110_/Q VPWR VGND sg13cmos5l_a21oi_1
X_4369_ _4369_/Y Tile_X0Y0_S4END[7] _6020_/Q _6019_/Q VPWR VGND sg13cmos5l_o21ai_1
X_6108_ _6108_/Q Tile_X0Y1_FrameData[0] Tile_X0Y1_FrameStrobe[2] VPWR VGND sg13cmos5l_dlhq_1
XFILLER_58_256 VPWR VGND sg13cmos5l_fill_2
X_6039_ _6039_/Q Tile_X0Y1_FrameData[5] Tile_X0Y1_FrameStrobe[0] VPWR VGND sg13cmos5l_dlhq_1
XFILLER_9_0 VPWR VGND sg13cmos5l_fill_1
XFILLER_2_14 VPWR VGND sg13cmos5l_decap_4
XFILLER_110_128 VPWR VGND sg13cmos5l_fill_1
XFILLER_2_36 VPWR VGND sg13cmos5l_fill_2
XFILLER_49_267 VPWR VGND sg13cmos5l_fill_1
XANTENNA_19 Tile_X0Y0_E2END[7] VPWR VGND sg13cmos5l_antennanp
X_3740_ _3740_/Y _6120_/Q _5262_/X _6118_/Q VPWR VGND sg13cmos5l_o21ai_1
X_3671_ _3671_/Y _6031_/Q _3670_/Y _6298_/Q VPWR VGND sg13cmos5l_o21ai_1
XFILLER_9_374 VPWR VGND sg13cmos5l_decap_8
X_5410_ _5411_/B Tile_X0Y1_N1END[0] Tile_X0Y1_E1END[0] Tile_X0Y1_W1END[0] _4518_/Y
+ _6344_/Q _6343_/Q VPWR VGND sg13cmos5l_mux4_1
X_6390_ _6390_/Q Tile_X0Y1_FrameData[6] Tile_X0Y1_FrameStrobe[11] VPWR VGND sg13cmos5l_dlhq_1
X_5341_ _5341_/Y _6374_/Q _5500_/B _5340_/Y VPWR VGND sg13cmos5l_o21ai_1
X_5272_ _5272_/Y _2788_/Y _3761_/X _6402_/Q VPWR VGND sg13cmos5l_o21ai_1
X_4223_ _4231_/A _4219_/A _4219_/B _4217_/Y VPWR VGND sg13cmos5l_a21oi_1
X_4154_ _4154_/Y Tile_X0Y0_W2MID[0] _5812_/Q _5811_/Q VPWR VGND sg13cmos5l_o21ai_1
X_4085_ _4085_/Y Tile_X0Y0_W6END[1] _5598_/Q _5597_/Q VPWR VGND sg13cmos5l_o21ai_1
X_3105_ _3113_/A _5690_/Q _3105_/B VPWR VGND sg13cmos5l_nor2_1
X_3036_ _3036_/Y _6066_/Q _3035_/Y _6067_/Q VPWR VGND sg13cmos5l_o21ai_1
XFILLER_55_226 VPWR VGND sg13cmos5l_decap_4
XANTENNA__6505__X Tile_X0Y0_E2BEGb[7] VPWR VGND sg13cmos5l_antennanp
X_6726_ Tile_X0Y1_EE4BEG[7] Tile_X0Y1_EE4END[11] VPWR VGND sg13cmos5l_buf_1
X_4987_ _4987_/Y _5668_/Q _4911_/X _5670_/Q VPWR VGND sg13cmos5l_o21ai_1
X_3938_ _3939_/B Tile_X0Y0_E2MID[2] _5816_/Q _3937_/Y VPWR VGND sg13cmos5l_a21oi_1
X_6657_ Tile_X0Y0_W2BEGb[6] Tile_X0Y0_W2MID[6] VPWR VGND sg13cmos5l_buf_1
X_3869_ _3869_/Y _6427_/Q _5989_/Q VPWR VGND sg13cmos5l_nand2_1
XFILLER_109_228 VPWR VGND sg13cmos5l_decap_4
X_5608_ _5608_/Q Tile_X0Y0_FrameData[26] Tile_X0Y1_FrameStrobe[1] VPWR VGND sg13cmos5l_dlhq_1
X_6588_ Tile_X0Y0_N1BEG[2] _6588_/A VPWR VGND sg13cmos5l_buf_1
X_5539_ _5559_/D _5551_/A _5261_/X VPWR VGND sg13cmos5l_nor2b_1
XFILLER_2_7 VPWR VGND sg13cmos5l_decap_8
XFILLER_36_97 VPWR VGND sg13cmos5l_fill_2
XFILLER_14_145 VPWR VGND sg13cmos5l_fill_1
XFILLER_10_351 VPWR VGND sg13cmos5l_decap_8
XFILLER_108_272 VPWR VGND sg13cmos5l_fill_1
X_5890_ _5890_/Q Tile_X0Y0_FrameData[0] Tile_X0Y1_FrameStrobe[9] VPWR VGND sg13cmos5l_dlhq_1
X_4910_ _4910_/Y _4910_/A _4910_/B VPWR VGND sg13cmos5l_xnor2_1
X_4841_ _4841_/Y _5612_/Q _5009_/Y VPWR VGND sg13cmos5l_nand2_1
X_4772_ _4772_/Y _5838_/Q _3276_/Y _5837_/Q VPWR VGND sg13cmos5l_a21oi_1
X_6511_ Tile_X0Y0_E6BEG[5] Tile_X0Y0_E6END[7] VPWR VGND sg13cmos5l_buf_1
X_3723_ _3723_/Y _3724_/A _3901_/A VPWR VGND sg13cmos5l_nand2_1
X_6442_ _6442_/L_HI VPWR VGND sg13cmos5l_tiehi
X_3654_ _3654_/Y _6098_/Q _2888_/Y _3653_/Y VPWR VGND sg13cmos5l_o21ai_1
X_6373_ _6373_/Q Tile_X0Y1_FrameData[23] Tile_X0Y1_FrameStrobe[11] VPWR VGND sg13cmos5l_dlhq_1
X_3585_ _3585_/Y _6308_/Q _3583_/X _3584_/Y VPWR VGND sg13cmos5l_a21oi_1
X_5324_ _5324_/X Tile_X0Y1_N1END[3] Tile_X0Y1_E1END[3] _6383_/Q VPWR VGND sg13cmos5l_mux2_1
X_5255_ _5255_/Y _5867_/Q _5253_/X _5254_/Y VPWR VGND sg13cmos5l_a21oi_1
X_4206_ _4208_/B _4206_/A _4206_/B VPWR VGND sg13cmos5l_xor2_1
X_5186_ _5186_/X _3172_/Y Tile_X0Y0_E1END[1] Tile_X0Y0_W1END[1] _5011_/X _5895_/Q
+ _5894_/Q VPWR VGND sg13cmos5l_mux4_1
XFILLER_28_204 VPWR VGND sg13cmos5l_fill_2
X_4137_ _4139_/B _4137_/A _4709_/A VPWR VGND sg13cmos5l_nand2_1
X_4068_ _4068_/Y _4046_/Y _4048_/Y _4067_/Y VPWR VGND sg13cmos5l_o21ai_1
XFILLER_83_365 VPWR VGND sg13cmos5l_fill_1
X_3019_ _3019_/Y _3019_/A _3019_/B VPWR VGND sg13cmos5l_nor2_1
XFILLER_51_240 VPWR VGND sg13cmos5l_decap_4
X_6709_ Tile_X0Y1_E6BEG[2] Tile_X0Y1_E6END[4] VPWR VGND sg13cmos5l_buf_1
XFILLER_3_369 VPWR VGND sg13cmos5l_fill_2
XFILLER_3_347 VPWR VGND sg13cmos5l_decap_8
XFILLER_105_253 VPWR VGND sg13cmos5l_fill_2
XFILLER_105_297 VPWR VGND sg13cmos5l_fill_1
XFILLER_86_170 VPWR VGND sg13cmos5l_fill_1
X_3370_ _3371_/A _3362_/X _3364_/Y _3369_/Y VPWR VGND sg13cmos5l_a21oi_1
XFILLER_111_212 VPWR VGND sg13cmos5l_decap_8
X_5040_ _6621_/A Tile_X0Y1_N2MID[1] Tile_X0Y0_W6END[0] Tile_X0Y1_N4END[4] _4909_/X
+ _5961_/Q _5962_/Q VPWR VGND sg13cmos5l_mux4_1
XFILLER_2_380 VPWR VGND sg13cmos5l_fill_1
X_5942_ _5942_/Q Tile_X0Y0_FrameData[12] Tile_X0Y1_FrameStrobe[11] VPWR VGND sg13cmos5l_dlhq_1
XFILLER_92_162 VPWR VGND sg13cmos5l_fill_2
X_5873_ _5873_/Q Tile_X0Y0_FrameData[17] Tile_X0Y1_FrameStrobe[9] VPWR VGND sg13cmos5l_dlhq_1
X_4824_ _4872_/B _4824_/A _4824_/B VPWR VGND sg13cmos5l_xnor2_1
X_4755_ _4755_/X _4707_/Y _4909_/X _4911_/X _5062_/B _5672_/Q _5674_/Q VPWR VGND sg13cmos5l_mux4_1
X_3706_ _3706_/Y _3704_/Y _3705_/Y _2871_/Y VPWR VGND sg13cmos5l_a21oi_1
X_4686_ _4712_/B _4687_/A _4687_/B VPWR VGND sg13cmos5l_nor2b_1
X_6425_ _6425_/Q Tile_X0Y1_FrameData[3] Tile_X0Y1_FrameStrobe[12] VPWR VGND sg13cmos5l_dlhq_1
X_3637_ _3637_/Y _6256_/Q _4308_/B _4308_/C VPWR VGND sg13cmos5l_nand3_1
XFILLER_108_14 VPWR VGND sg13cmos5l_decap_8
X_6356_ _6356_/Q Tile_X0Y1_FrameData[8] Tile_X0Y1_FrameStrobe[10] VPWR VGND sg13cmos5l_dlhq_1
X_3568_ _3568_/Y _6126_/Q _2888_/Y _3567_/Y VPWR VGND sg13cmos5l_o21ai_1
X_5307_ _5307_/Y _2787_/Y _6386_/Q _5306_/Y VPWR VGND sg13cmos5l_o21ai_1
X_6287_ _6287_/Q Tile_X0Y1_FrameData[13] Tile_X0Y1_FrameStrobe[8] VPWR VGND sg13cmos5l_dlhq_1
X_3499_ _3499_/Y _5642_/Q _3496_/X _5641_/Q VPWR VGND sg13cmos5l_o21ai_1
X_5238_ _5238_/X Tile_X0Y0_E1END[3] Tile_X0Y0_W1END[3] _4707_/Y _4911_/X _5872_/Q
+ _5870_/Q VPWR VGND sg13cmos5l_mux4_1
XFILLER_102_256 VPWR VGND sg13cmos5l_fill_1
X_5169_ _5169_/Y _5900_/Q _5169_/B VPWR VGND sg13cmos5l_nand2_1
XFILLER_68_181 VPWR VGND sg13cmos5l_fill_2
XFILLER_3_133 VPWR VGND sg13cmos5l_fill_1
XFILLER_109_0 VPWR VGND sg13cmos5l_decap_8
X_2870_ _2870_/Y _6100_/Q VPWR VGND sg13cmos5l_inv_1
XANTENNA__6603__X Tile_X0Y0_N2BEGb[5] VPWR VGND sg13cmos5l_antennanp
X_4540_ _4540_/Y _5676_/Q _5009_/Y VPWR VGND sg13cmos5l_nand2_1
X_4471_ _4472_/B _4471_/A _4709_/A VPWR VGND sg13cmos5l_nand2_1
X_6210_ _6210_/Q Tile_X0Y1_FrameData[26] Tile_X0Y1_FrameStrobe[6] VPWR VGND sg13cmos5l_dlhq_1
X_3422_ _3422_/X _3338_/A _3349_/A _3407_/A _3421_/Y _6276_/Q _2710_/Y VPWR VGND sg13cmos5l_mux4_1
X_6141_ _6141_/Q Tile_X0Y1_FrameData[31] Tile_X0Y1_FrameStrobe[4] VPWR VGND sg13cmos5l_dlhq_1
X_3353_ _3354_/B _2877_/Y _3352_/X _6145_/Q VPWR VGND sg13cmos5l_o21ai_1
X_6072_ _6072_/Q Tile_X0Y1_FrameData[4] Tile_X0Y1_FrameStrobe[1] VPWR VGND sg13cmos5l_dlhq_1
X_3284_ _3284_/Y _6151_/Q _3280_/X _3283_/Y VPWR VGND sg13cmos5l_o21ai_1
XFILLER_24_0 VPWR VGND sg13cmos5l_fill_2
X_5023_ _5024_/B _5634_/Q _5021_/Y _5022_/Y VPWR VGND sg13cmos5l_a21oi_1
XFILLER_65_151 VPWR VGND sg13cmos5l_fill_1
XFILLER_53_313 VPWR VGND sg13cmos5l_fill_1
X_5925_ _5925_/Q Tile_X0Y0_FrameData[29] Tile_X0Y1_FrameStrobe[11] VPWR VGND sg13cmos5l_dlhq_1
X_5856_ _5856_/Q Tile_X0Y0_FrameData[2] Tile_X0Y1_FrameStrobe[8] VPWR VGND sg13cmos5l_dlhq_1
XFILLER_110_37 VPWR VGND sg13cmos5l_fill_2
XANTENNA__6513__X Tile_X0Y0_E6BEG[7] VPWR VGND sg13cmos5l_antennanp
X_4807_ _4807_/Y _5706_/Q _4804_/X _5705_/Q VPWR VGND sg13cmos5l_o21ai_1
X_5787_ _5787_/Q Tile_X0Y0_FrameData[7] Tile_X0Y1_FrameStrobe[6] VPWR VGND sg13cmos5l_dlhq_1
X_2999_ _2999_/Y _6167_/Q _2995_/X _2998_/Y VPWR VGND sg13cmos5l_o21ai_1
X_4738_ _4738_/Y _2740_/Y _5766_/Q _5765_/Q VPWR VGND sg13cmos5l_a21oi_1
X_4669_ _4669_/Y _5229_/B VPWR VGND sg13cmos5l_inv_1
XFILLER_107_337 VPWR VGND sg13cmos5l_decap_8
X_6408_ _6408_/Q Tile_X0Y1_FrameData[20] Tile_X0Y1_FrameStrobe[12] VPWR VGND sg13cmos5l_dlhq_1
X_6339_ _6339_/Q Tile_X0Y1_FrameData[25] Tile_X0Y1_FrameStrobe[10] VPWR VGND sg13cmos5l_dlhq_1
XFILLER_0_114 VPWR VGND sg13cmos5l_fill_1
XFILLER_29_321 VPWR VGND sg13cmos5l_fill_1
XFILLER_71_187 VPWR VGND sg13cmos5l_fill_1
XFILLER_12_298 VPWR VGND sg13cmos5l_fill_1
X_3971_ _3971_/Y _5593_/Q _3970_/Y _5856_/Q VPWR VGND sg13cmos5l_o21ai_1
X_5710_ _5710_/Q Tile_X0Y0_FrameData[20] Tile_X0Y1_FrameStrobe[4] VPWR VGND sg13cmos5l_dlhq_1
X_2922_ _2922_/X _4518_/Y _5422_/B _6130_/Q VPWR VGND sg13cmos5l_mux2_1
X_6690_ Tile_X0Y1_E1BEG[3] _6690_/A VPWR VGND sg13cmos5l_buf_1
X_5641_ _5641_/Q Tile_X0Y0_FrameData[25] Tile_X0Y1_FrameStrobe[2] VPWR VGND sg13cmos5l_dlhq_1
X_2853_ _3641_/A _6255_/Q VPWR VGND sg13cmos5l_inv_1
X_5572_ _5572_/Q Tile_X0Y0_FrameData[30] Tile_X0Y1_FrameStrobe[0] VPWR VGND sg13cmos5l_dlhq_1
X_2784_ _2784_/Y _5875_/Q VPWR VGND sg13cmos5l_inv_1
X_4523_ _4524_/C _5776_/Q Tile_X0Y0_S2MID[3] VPWR VGND sg13cmos5l_nand2b_1
X_4454_ _4454_/Y _4454_/A _6605_/A VPWR VGND sg13cmos5l_nor2_1
X_4385_ _4510_/A _4382_/A _4382_/B _4384_/Y VPWR VGND sg13cmos5l_a21oi_1
X_3405_ _3475_/C _3398_/Y _3402_/Y _3404_/Y VPWR VGND sg13cmos5l_a21oi_1
X_6124_ _6124_/Q Tile_X0Y1_FrameData[16] Tile_X0Y1_FrameStrobe[3] VPWR VGND sg13cmos5l_dlhq_1
X_3336_ _3337_/B _3336_/A _3336_/B VPWR VGND sg13cmos5l_nor2_1
X_6055_ _6055_/Q Tile_X0Y1_FrameData[21] Tile_X0Y1_FrameStrobe[1] VPWR VGND sg13cmos5l_dlhq_1
XFILLER_85_202 VPWR VGND sg13cmos5l_fill_2
X_5006_ _5007_/B _5006_/A _5006_/B VPWR VGND sg13cmos5l_xor2_1
X_3267_ _3267_/X _4409_/B _2892_/Y _6158_/Q VPWR VGND sg13cmos5l_mux2_1
XANTENNA__6508__X Tile_X0Y0_E6BEG[2] VPWR VGND sg13cmos5l_antennanp
X_3198_ _3198_/Y _3189_/A _3192_/X _5683_/Q VPWR VGND sg13cmos5l_a21oi_1
XANTENNA_109 Tile_X0Y0_SS4END[6] VPWR VGND sg13cmos5l_antennanp
X_5908_ _5908_/Q Tile_X0Y0_FrameData[14] Tile_X0Y1_FrameStrobe[10] VPWR VGND sg13cmos5l_dlhq_1
X_5839_ _5839_/Q Tile_X0Y0_FrameData[19] Tile_X0Y1_FrameStrobe[8] VPWR VGND sg13cmos5l_dlhq_1
XFILLER_55_52 VPWR VGND sg13cmos5l_fill_1
XFILLER_32_316 VPWR VGND sg13cmos5l_fill_1
XFILLER_71_95 VPWR VGND sg13cmos5l_fill_1
X_4170_ _4170_/Y _4170_/A _5624_/Q VPWR VGND sg13cmos5l_nor2b_1
X_3121_ _3121_/Y _5637_/Q _3118_/X _5636_/Q VPWR VGND sg13cmos5l_o21ai_1
X_3052_ _3052_/Y _5645_/Q _3051_/X _3050_/Y VPWR VGND sg13cmos5l_o21ai_1
XFILLER_67_279 VPWR VGND sg13cmos5l_fill_1
X_6811_ Tile_X0Y1_SS4BEG[8] _6811_/A VPWR VGND sg13cmos5l_buf_1
X_6742_ Tile_X0Y1_FrameData_O[7] Tile_X0Y1_FrameData[7] VPWR VGND sg13cmos5l_buf_1
X_3954_ _3954_/Y _5722_/Q Tile_X0Y0_E1END[1] VPWR VGND sg13cmos5l_nor2b_1
X_6673_ Tile_X0Y0_WW4BEG[2] Tile_X0Y0_WW4END[6] VPWR VGND sg13cmos5l_buf_1
X_3885_ _3885_/X _3884_/X _3883_/Y _3879_/Y _3881_/Y _6072_/Q _6071_/Q VPWR VGND sg13cmos5l_mux4_1
X_2905_ _2905_/Y _2904_/X _2905_/B VPWR VGND sg13cmos5l_nand2b_1
X_5624_ _5624_/Q Tile_X0Y0_FrameData[10] Tile_X0Y1_FrameStrobe[1] VPWR VGND sg13cmos5l_dlhq_1
X_2836_ _3279_/B _6152_/Q VPWR VGND sg13cmos5l_inv_1
X_5555_ _5555_/Q Tile_X0Y1_UserCLK _5555_/D _6477_/L_HI VPWR VGND sg13cmos5l_dfrbpq_1
X_2767_ _2767_/Y _5700_/Q VPWR VGND sg13cmos5l_inv_1
X_5486_ _5486_/Y _6324_/Q _5342_/B _5485_/Y VPWR VGND sg13cmos5l_o21ai_1
X_4506_ _5374_/B _6423_/Q _5538_/B _4505_/Y VPWR VGND sg13cmos5l_o21ai_1
XFILLER_104_104 VPWR VGND sg13cmos5l_fill_2
X_4437_ _4444_/C _6110_/Q _4433_/Y _4436_/Y VPWR VGND sg13cmos5l_o21ai_1
X_6107_ _6107_/Q Tile_X0Y1_FrameData[1] Tile_X0Y1_FrameStrobe[2] VPWR VGND sg13cmos5l_dlhq_1
X_4368_ _4368_/Y _4358_/Y _4361_/Y _4367_/Y VPWR VGND sg13cmos5l_o21ai_1
X_4299_ _4300_/C _6205_/Q _4295_/Y _4298_/Y VPWR VGND sg13cmos5l_a21oi_1
X_3319_ _3319_/X Tile_X0Y1_NN4END[7] Tile_X0Y0_S4END[3] _5602_/Q VPWR VGND sg13cmos5l_mux2_1
X_6038_ _6038_/Q Tile_X0Y1_FrameData[6] Tile_X0Y1_FrameStrobe[0] VPWR VGND sg13cmos5l_dlhq_1
XFILLER_26_132 VPWR VGND sg13cmos5l_fill_2
XFILLER_41_113 VPWR VGND sg13cmos5l_fill_1
XFILLER_41_124 VPWR VGND sg13cmos5l_fill_1
XANTENNA__6701__X Tile_X0Y1_E2BEGb[2] VPWR VGND sg13cmos5l_antennanp
XFILLER_89_360 VPWR VGND sg13cmos5l_fill_2
XFILLER_1_264 VPWR VGND sg13cmos5l_fill_2
XFILLER_72_282 VPWR VGND sg13cmos5l_fill_1
XANTENNA__6611__X Tile_X0Y0_N4BEG[5] VPWR VGND sg13cmos5l_antennanp
X_3670_ _3670_/Y Tile_X0Y1_EE4END[1] _6032_/Q _3669_/Y VPWR VGND sg13cmos5l_a21oi_1
X_5340_ _5340_/Y _6374_/Q _3481_/A _6373_/Q VPWR VGND sg13cmos5l_a21oi_1
X_5271_ _5271_/Y _6401_/Q _5271_/B VPWR VGND sg13cmos5l_nor2_1
X_4222_ _4222_/X _4228_/A _4228_/B _4224_/B VPWR VGND sg13cmos5l_or3_1
XFILLER_101_118 VPWR VGND sg13cmos5l_decap_4
X_4153_ _4191_/A _4253_/A _4681_/A VPWR VGND sg13cmos5l_nand2_1
X_4084_ _4148_/A _4084_/A _4221_/B VPWR VGND sg13cmos5l_nor2_1
X_3104_ _3105_/B _4940_/Y _4911_/X _5011_/X _4909_/X _5689_/Q _5688_/Q VPWR VGND sg13cmos5l_mux4_1
X_3035_ _3035_/Y Tile_X0Y1_E6END[1] _6068_/Q _3034_/Y VPWR VGND sg13cmos5l_a21oi_1
X_4986_ _4989_/B _5668_/Q _4707_/Y _4985_/Y VPWR VGND sg13cmos5l_o21ai_1
X_6725_ Tile_X0Y1_EE4BEG[6] Tile_X0Y1_EE4END[10] VPWR VGND sg13cmos5l_buf_1
X_3937_ _3937_/Y _5816_/Q _4769_/B VPWR VGND sg13cmos5l_nor2_1
X_6656_ Tile_X0Y0_W2BEGb[5] Tile_X0Y0_W2MID[5] VPWR VGND sg13cmos5l_buf_1
X_3868_ _5989_/D _3868_/A VPWR VGND sg13cmos5l_inv_1
XANTENNA__6521__X Tile_X0Y0_EE4BEG[3] VPWR VGND sg13cmos5l_antennanp
X_5607_ _5607_/Q Tile_X0Y0_FrameData[27] Tile_X0Y1_FrameStrobe[1] VPWR VGND sg13cmos5l_dlhq_1
X_6587_ Tile_X0Y0_N1BEG[1] _6587_/A VPWR VGND sg13cmos5l_buf_1
X_3799_ _3799_/X Tile_X0Y1_NN4END[2] Tile_X0Y1_E2END[1] Tile_X0Y0_S2MID[1] Tile_X0Y1_W2END[1]
+ _6182_/Q _6181_/Q VPWR VGND sg13cmos5l_mux4_1
X_2819_ _3085_/A _5653_/Q VPWR VGND sg13cmos5l_inv_1
X_5538_ _5558_/D _5551_/A _5538_/B VPWR VGND sg13cmos5l_nor2_1
X_5469_ _5469_/Y _6327_/Q _5262_/X _5468_/Y VPWR VGND sg13cmos5l_o21ai_1
XFILLER_46_238 VPWR VGND sg13cmos5l_fill_2
XFILLER_46_216 VPWR VGND sg13cmos5l_fill_1
XFILLER_6_323 VPWR VGND sg13cmos5l_fill_2
XFILLER_6_356 VPWR VGND sg13cmos5l_decap_4
XFILLER_108_295 VPWR VGND sg13cmos5l_fill_2
XFILLER_96_138 VPWR VGND sg13cmos5l_fill_2
XFILLER_92_311 VPWR VGND sg13cmos5l_decap_8
XFILLER_92_366 VPWR VGND sg13cmos5l_fill_2
XFILLER_92_344 VPWR VGND sg13cmos5l_fill_2
XANTENNA__6606__X Tile_X0Y0_N4BEG[0] VPWR VGND sg13cmos5l_antennanp
XANTENNA_270 Tile_X0Y1_FrameData[29] VPWR VGND sg13cmos5l_antennanp
X_4840_ _4840_/Y _4836_/Y _4840_/B VPWR VGND sg13cmos5l_nand2b_1
X_6510_ Tile_X0Y0_E6BEG[4] Tile_X0Y0_E6END[6] VPWR VGND sg13cmos5l_buf_1
X_4771_ _4771_/X _4769_/Y _4770_/Y _5838_/Q VPWR VGND sg13cmos5l_a21o_1
X_3722_ _3901_/A _4216_/A _4254_/A VPWR VGND sg13cmos5l_nor2_1
X_6441_ _6441_/L_HI VPWR VGND sg13cmos5l_tiehi
X_3653_ _3653_/Y _6098_/Q _5440_/B VPWR VGND sg13cmos5l_nand2_1
X_6372_ _6372_/Q Tile_X0Y1_FrameData[24] Tile_X0Y1_FrameStrobe[11] VPWR VGND sg13cmos5l_dlhq_1
X_5323_ _5323_/Y _6383_/Q _3325_/Y _5322_/Y VPWR VGND sg13cmos5l_o21ai_1
X_3584_ _3584_/Y _6308_/Q _3574_/Y _6307_/Q VPWR VGND sg13cmos5l_o21ai_1
XFILLER_54_0 VPWR VGND sg13cmos5l_decap_8
X_5254_ _5254_/Y _5867_/Q _5252_/X VPWR VGND sg13cmos5l_nor2b_1
X_5185_ _5185_/X _5009_/Y _4669_/Y _4745_/B _3020_/X _5895_/Q _5894_/Q VPWR VGND sg13cmos5l_mux4_1
X_4205_ _4206_/B _4205_/A _4683_/A VPWR VGND sg13cmos5l_or2_1
X_4136_ _4709_/A _5992_/D _5992_/Q _6427_/Q VPWR VGND sg13cmos5l_mux2_1
X_4067_ _4067_/Y _5825_/Q _4066_/X _5864_/Q VPWR VGND sg13cmos5l_a21oi_1
XANTENNA__6516__X Tile_X0Y0_E6BEG[10] VPWR VGND sg13cmos5l_antennanp
X_3018_ _3019_/B _5595_/Q _3017_/Y _5858_/Q VPWR VGND sg13cmos5l_o21ai_1
XFILLER_83_377 VPWR VGND sg13cmos5l_fill_1
X_4969_ _4969_/Y _5701_/Q _4969_/B VPWR VGND sg13cmos5l_nor2_1
X_6708_ Tile_X0Y1_E6BEG[1] Tile_X0Y1_E6END[3] VPWR VGND sg13cmos5l_buf_1
X_6639_ Tile_X0Y0_W1BEG[0] _6639_/A VPWR VGND sg13cmos5l_buf_1
XFILLER_3_326 VPWR VGND sg13cmos5l_decap_8
XFILLER_3_304 VPWR VGND sg13cmos5l_fill_1
XFILLER_105_232 VPWR VGND sg13cmos5l_decap_4
XFILLER_59_341 VPWR VGND sg13cmos5l_decap_4
XFILLER_42_285 VPWR VGND sg13cmos5l_decap_4
X_5941_ _5941_/Q Tile_X0Y0_FrameData[13] Tile_X0Y1_FrameStrobe[11] VPWR VGND sg13cmos5l_dlhq_1
XFILLER_92_185 VPWR VGND sg13cmos5l_fill_1
X_5872_ _5872_/Q Tile_X0Y0_FrameData[18] Tile_X0Y1_FrameStrobe[9] VPWR VGND sg13cmos5l_dlhq_1
XFILLER_33_263 VPWR VGND sg13cmos5l_fill_1
X_4823_ _4872_/A _4823_/A _4823_/B VPWR VGND sg13cmos5l_nand2_1
X_4754_ _4754_/Y _5673_/Q _4753_/X VPWR VGND sg13cmos5l_nor2b_1
X_3705_ _3705_/Y Tile_X0Y1_E6END[1] _6040_/Q _6039_/Q VPWR VGND sg13cmos5l_a21oi_1
X_4685_ _4687_/B _4685_/A _4719_/A VPWR VGND sg13cmos5l_xor2_1
X_6424_ _6424_/Q Tile_X0Y1_FrameData[4] Tile_X0Y1_FrameStrobe[12] VPWR VGND sg13cmos5l_dlhq_1
X_3636_ _3727_/A _3767_/A _3767_/B VPWR VGND sg13cmos5l_nand2b_1
XFILLER_108_26 VPWR VGND sg13cmos5l_decap_8
X_6355_ _6355_/Q Tile_X0Y1_FrameData[9] Tile_X0Y1_FrameStrobe[10] VPWR VGND sg13cmos5l_dlhq_1
X_3567_ _3567_/Y _6126_/Q _5440_/B VPWR VGND sg13cmos5l_nand2_1
X_6286_ _6286_/Q Tile_X0Y1_FrameData[14] Tile_X0Y1_FrameStrobe[8] VPWR VGND sg13cmos5l_dlhq_1
X_5306_ _5306_/Y Tile_X0Y1_E1END[2] _6386_/Q VPWR VGND sg13cmos5l_nand2_1
X_5237_ _6686_/A _5237_/A VPWR VGND sg13cmos5l_inv_1
X_3498_ _3498_/Y Tile_X0Y0_W1END[3] _5640_/Q _3497_/Y VPWR VGND sg13cmos5l_a21oi_1
X_5168_ _5169_/B _4127_/A _4854_/X _5901_/Q VPWR VGND sg13cmos5l_mux2_1
XFILLER_56_322 VPWR VGND sg13cmos5l_fill_1
X_5099_ _5099_/Y _5942_/Q _6592_/A _5941_/Q VPWR VGND sg13cmos5l_o21ai_1
X_4119_ _4120_/B _5852_/Q _4118_/X _5851_/Q VPWR VGND sg13cmos5l_o21ai_1
XFILLER_71_303 VPWR VGND sg13cmos5l_fill_2
XFILLER_56_377 VPWR VGND sg13cmos5l_fill_1
XFILLER_101_290 VPWR VGND sg13cmos5l_fill_1
XFILLER_74_174 VPWR VGND sg13cmos5l_fill_1
XFILLER_15_285 VPWR VGND sg13cmos5l_fill_1
XFILLER_30_299 VPWR VGND sg13cmos5l_fill_1
X_4470_ _4581_/A _4470_/A _4708_/A VPWR VGND sg13cmos5l_nor2_1
X_3421_ _3421_/Y _3852_/B _3852_/C VPWR VGND sg13cmos5l_nor2_1
X_6140_ _6140_/Q Tile_X0Y1_FrameData[0] Tile_X0Y1_FrameStrobe[3] VPWR VGND sg13cmos5l_dlhq_1
X_3352_ _3352_/X _4503_/Y _5262_/X _3916_/Y _5440_/B _6146_/Q _6148_/Q VPWR VGND sg13cmos5l_mux4_1
X_6071_ _6071_/Q Tile_X0Y1_FrameData[5] Tile_X0Y1_FrameStrobe[1] VPWR VGND sg13cmos5l_dlhq_1
X_3283_ _3283_/Y _6151_/Q _3282_/Y _2837_/Y VPWR VGND sg13cmos5l_a21oi_1
X_5022_ _5022_/Y _5634_/Q _5019_/X _5631_/Q VPWR VGND sg13cmos5l_o21ai_1
XFILLER_17_0 VPWR VGND sg13cmos5l_fill_1
XFILLER_0_70 VPWR VGND sg13cmos5l_decap_4
X_5924_ _5924_/Q Tile_X0Y0_FrameData[30] Tile_X0Y1_FrameStrobe[11] VPWR VGND sg13cmos5l_dlhq_1
X_5855_ _5855_/Q Tile_X0Y0_FrameData[3] Tile_X0Y1_FrameStrobe[8] VPWR VGND sg13cmos5l_dlhq_1
X_4806_ _4806_/Y _5704_/Q Tile_X0Y0_W1END[3] _4805_/Y VPWR VGND sg13cmos5l_a21oi_1
X_5786_ _5786_/Q Tile_X0Y0_FrameData[8] Tile_X0Y1_FrameStrobe[6] VPWR VGND sg13cmos5l_dlhq_1
X_2998_ _2998_/Y _6167_/Q _2998_/B VPWR VGND sg13cmos5l_nand2_1
X_4737_ _4737_/Y _5766_/Q _4737_/B VPWR VGND sg13cmos5l_nand2b_1
X_4668_ _5229_/B _3383_/Y _2739_/Y _2738_/Y _3061_/A _5806_/Q _5805_/Q VPWR VGND sg13cmos5l_mux4_1
X_6407_ _6407_/Q Tile_X0Y1_FrameData[21] Tile_X0Y1_FrameStrobe[12] VPWR VGND sg13cmos5l_dlhq_1
X_3619_ _3619_/Y _3619_/A VPWR VGND sg13cmos5l_inv_1
X_4599_ _4605_/A _4599_/A _4683_/A VPWR VGND sg13cmos5l_or2_1
X_6338_ _6338_/Q Tile_X0Y1_FrameData[26] Tile_X0Y1_FrameStrobe[10] VPWR VGND sg13cmos5l_dlhq_1
XFILLER_0_104 VPWR VGND sg13cmos5l_fill_2
X_6269_ _6269_/Q Tile_X0Y1_FrameData[31] Tile_X0Y1_FrameStrobe[8] VPWR VGND sg13cmos5l_dlhq_1
XFILLER_44_314 VPWR VGND sg13cmos5l_fill_2
XANTENNA__6704__X Tile_X0Y1_E2BEGb[5] VPWR VGND sg13cmos5l_antennanp
XFILLER_52_380 VPWR VGND sg13cmos5l_fill_1
XFILLER_12_200 VPWR VGND sg13cmos5l_fill_1
X_3970_ _3970_/Y Tile_X0Y0_SS4END[3] _5594_/Q _3969_/Y VPWR VGND sg13cmos5l_a21oi_1
XANTENNA__6614__X Tile_X0Y0_N4BEG[8] VPWR VGND sg13cmos5l_antennanp
X_2921_ _2921_/Y _6132_/Q _2921_/B VPWR VGND sg13cmos5l_nand2b_1
X_5640_ _5640_/Q Tile_X0Y0_FrameData[26] Tile_X0Y1_FrameStrobe[2] VPWR VGND sg13cmos5l_dlhq_1
X_2852_ _2852_/Y _5723_/Q VPWR VGND sg13cmos5l_inv_1
X_5571_ _5571_/Q Tile_X0Y1_UserCLK _5571_/D _6431_/L_HI VPWR VGND sg13cmos5l_dfrbpq_1
X_2783_ _2783_/Y _5877_/Q VPWR VGND sg13cmos5l_inv_1
X_4522_ _4524_/B _5776_/Q Tile_X0Y0_W2MID[3] VPWR VGND sg13cmos5l_nand2_1
X_4453_ _6698_/A _4450_/Y _4452_/Y _4444_/Y VPWR VGND sg13cmos5l_o21ai_1
X_3404_ _3404_/Y _6123_/Q _3403_/X _6121_/Q VPWR VGND sg13cmos5l_o21ai_1
X_4384_ _4384_/Y _4516_/A _4516_/B VPWR VGND sg13cmos5l_nor2b_1
X_6123_ _6123_/Q Tile_X0Y1_FrameData[17] Tile_X0Y1_FrameStrobe[3] VPWR VGND sg13cmos5l_dlhq_1
X_3335_ _3336_/B _6115_/Q _3334_/X _6113_/Q VPWR VGND sg13cmos5l_o21ai_1
X_6054_ _6054_/Q Tile_X0Y1_FrameData[22] Tile_X0Y1_FrameStrobe[1] VPWR VGND sg13cmos5l_dlhq_1
X_3266_ _3266_/Y _6159_/Q _3259_/X _3265_/Y VPWR VGND sg13cmos5l_o21ai_1
XFILLER_105_38 VPWR VGND sg13cmos5l_decap_4
X_5005_ _5006_/B _6425_/Q _5571_/Q _5003_/X _5004_/Y VPWR VGND sg13cmos5l_a22oi_1
X_3197_ _3199_/A _3193_/Y _3194_/Y _3196_/Y _5686_/Q _3189_/A VPWR VGND sg13cmos5l_a221oi_1
XANTENNA__6524__X Tile_X0Y0_EE4BEG[6] VPWR VGND sg13cmos5l_antennanp
X_5907_ _5907_/Q Tile_X0Y0_FrameData[15] Tile_X0Y1_FrameStrobe[10] VPWR VGND sg13cmos5l_dlhq_1
X_5838_ _5838_/Q Tile_X0Y0_FrameData[20] Tile_X0Y1_FrameStrobe[8] VPWR VGND sg13cmos5l_dlhq_1
X_5769_ _5769_/Q Tile_X0Y0_FrameData[25] Tile_X0Y1_FrameStrobe[6] VPWR VGND sg13cmos5l_dlhq_1
XANTENNA__6609__X Tile_X0Y0_N4BEG[3] VPWR VGND sg13cmos5l_antennanp
X_3120_ _3120_/Y _2725_/Y _5638_/Q _3119_/Y VPWR VGND sg13cmos5l_o21ai_1
X_3051_ _3051_/X _4940_/Y _4934_/Y _4943_/Y _4937_/Y _5646_/Q _5644_/Q VPWR VGND sg13cmos5l_mux4_1
X_6810_ Tile_X0Y1_SS4BEG[7] Tile_X0Y0_SS4END[15] VPWR VGND sg13cmos5l_buf_1
X_6741_ Tile_X0Y1_FrameData_O[6] Tile_X0Y1_FrameData[6] VPWR VGND sg13cmos5l_buf_1
X_3953_ _3953_/X Tile_X0Y0_W2END[3] Tile_X0Y0_WW4END[1] _5722_/Q VPWR VGND sg13cmos5l_mux2_1
X_6672_ Tile_X0Y0_WW4BEG[1] Tile_X0Y0_WW4END[5] VPWR VGND sg13cmos5l_buf_1
X_3884_ _3884_/X _4515_/Y _5390_/B _6070_/Q VPWR VGND sg13cmos5l_mux2_1
X_2904_ _2904_/X Tile_X0Y1_NN4END[6] Tile_X0Y0_S4END[2] Tile_X0Y0_E1END[0] Tile_X0Y0_SS4END[2]
+ _5660_/Q _5662_/Q VPWR VGND sg13cmos5l_mux4_1
X_5623_ _5623_/Q Tile_X0Y0_FrameData[11] Tile_X0Y1_FrameStrobe[1] VPWR VGND sg13cmos5l_dlhq_1
X_2835_ _2835_/Y _5637_/Q VPWR VGND sg13cmos5l_inv_1
XFILLER_84_0 VPWR VGND sg13cmos5l_fill_1
X_5554_ _5554_/Q Tile_X0Y1_UserCLK _5554_/D _6478_/L_HI VPWR VGND sg13cmos5l_dfrbpq_1
X_2766_ _2766_/Y _5828_/Q VPWR VGND sg13cmos5l_inv_1
X_5485_ _5485_/Y _3673_/X _6324_/Q VPWR VGND sg13cmos5l_nand2b_1
X_4505_ _4505_/Y _6423_/Q _5558_/Q VPWR VGND sg13cmos5l_nand2_1
X_4436_ _4436_/Y _6110_/Q _4435_/Y _6111_/Q VPWR VGND sg13cmos5l_a21oi_1
XFILLER_104_116 VPWR VGND sg13cmos5l_fill_1
X_4367_ _4367_/Y _4363_/Y _4366_/X _6285_/Q VPWR VGND sg13cmos5l_a21oi_1
XANTENNA__6519__X Tile_X0Y0_EE4BEG[1] VPWR VGND sg13cmos5l_antennanp
X_6106_ _6106_/Q Tile_X0Y1_FrameData[2] Tile_X0Y1_FrameStrobe[2] VPWR VGND sg13cmos5l_dlhq_1
X_3318_ _6591_/A _3303_/Y _3305_/Y _3317_/Y VPWR VGND sg13cmos5l_o21ai_1
X_4298_ _4298_/Y _6280_/Q _4298_/B VPWR VGND sg13cmos5l_nand2_1
X_6037_ _6037_/Q Tile_X0Y1_FrameData[7] Tile_X0Y1_FrameStrobe[0] VPWR VGND sg13cmos5l_dlhq_1
X_3249_ _3250_/B _4551_/A _5694_/Q _3248_/Y VPWR VGND sg13cmos5l_a21oi_1
XFILLER_22_350 VPWR VGND sg13cmos5l_fill_1
XFILLER_2_38 VPWR VGND sg13cmos5l_fill_1
XFILLER_13_361 VPWR VGND sg13cmos5l_decap_8
XFILLER_9_332 VPWR VGND sg13cmos5l_fill_1
X_5270_ _5271_/B Tile_X0Y1_N1END[3] Tile_X0Y1_E1END[3] Tile_X0Y1_W1END[3] _3916_/Y
+ _6403_/Q _6402_/Q VPWR VGND sg13cmos5l_mux4_1
XFILLER_99_125 VPWR VGND sg13cmos5l_fill_1
XFILLER_99_114 VPWR VGND sg13cmos5l_fill_2
X_4221_ _4224_/B _4221_/A _4221_/B VPWR VGND sg13cmos5l_xor2_1
X_4152_ _4211_/A _4146_/A _4146_/B _4144_/Y VPWR VGND sg13cmos5l_o21ai_1
X_4083_ _4221_/B _4083_/A _4083_/B VPWR VGND sg13cmos5l_xor2_1
X_3103_ _3213_/A _6141_/Q _3103_/B VPWR VGND sg13cmos5l_nand2_1
X_3034_ _3034_/Y _6068_/Q Tile_X0Y1_E2END[3] VPWR VGND sg13cmos5l_nor2b_1
XFILLER_102_39 VPWR VGND sg13cmos5l_fill_1
X_4985_ _4985_/Y _5668_/Q _2887_/Y _5670_/Q VPWR VGND sg13cmos5l_a21oi_1
X_6724_ Tile_X0Y1_EE4BEG[5] Tile_X0Y1_EE4END[9] VPWR VGND sg13cmos5l_buf_1
X_3936_ _3940_/B _5816_/Q _3934_/A _3935_/Y VPWR VGND sg13cmos5l_a21oi_1
XANTENNA__6802__X Tile_X0Y1_S4BEG[15] VPWR VGND sg13cmos5l_antennanp
X_6655_ Tile_X0Y0_W2BEGb[4] Tile_X0Y0_W2MID[4] VPWR VGND sg13cmos5l_buf_1
X_3867_ _3868_/A _3856_/Y _3857_/Y _3866_/Y VPWR VGND sg13cmos5l_a21oi_1
XFILLER_31_191 VPWR VGND sg13cmos5l_fill_1
X_5606_ _5606_/Q Tile_X0Y0_FrameData[28] Tile_X0Y1_FrameStrobe[1] VPWR VGND sg13cmos5l_dlhq_1
X_6586_ Tile_X0Y0_N1BEG[0] _6586_/A VPWR VGND sg13cmos5l_buf_1
X_3798_ _3798_/Y _6021_/Q _3795_/X _3796_/X _3797_/Y _2881_/Y VPWR VGND sg13cmos5l_a221oi_1
X_2818_ _2818_/Y _6155_/Q VPWR VGND sg13cmos5l_inv_1
X_5537_ _5557_/D _5551_/A _5537_/B VPWR VGND sg13cmos5l_nor2_1
X_2749_ _2749_/Y Tile_X0Y0_E2MID[7] VPWR VGND sg13cmos5l_inv_1
X_5468_ _5468_/Y _6327_/Q _5468_/B VPWR VGND sg13cmos5l_nand2_1
X_5399_ _5400_/B Tile_X0Y1_N1END[2] Tile_X0Y1_E1END[2] Tile_X0Y1_W1END[2] _4503_/Y
+ _6350_/Q _6349_/Q VPWR VGND sg13cmos5l_mux4_1
X_4419_ _4419_/Y _6078_/Q _4503_/Y _4418_/Y VPWR VGND sg13cmos5l_o21ai_1
XANTENNA__6712__X Tile_X0Y1_E6BEG[5] VPWR VGND sg13cmos5l_antennanp
XFILLER_93_83 VPWR VGND sg13cmos5l_fill_1
XANTENNA_260 Tile_X0Y1_FrameData[29] VPWR VGND sg13cmos5l_antennanp
XFILLER_45_283 VPWR VGND sg13cmos5l_fill_1
XANTENNA_271 Tile_X0Y1_FrameData[29] VPWR VGND sg13cmos5l_antennanp
XANTENNA__6622__X Tile_X0Y0_NN4BEG[0] VPWR VGND sg13cmos5l_antennanp
X_4770_ _4770_/Y _2730_/Y _5800_/Q _5799_/Q VPWR VGND sg13cmos5l_a21oi_1
X_3721_ _3721_/Y _4247_/A _4253_/A VPWR VGND sg13cmos5l_nand2_1
X_6440_ _6440_/L_HI VPWR VGND sg13cmos5l_tiehi
X_3652_ _3652_/X _2891_/Y _2892_/Y _6098_/Q VPWR VGND sg13cmos5l_mux2_1
X_6371_ _6371_/Q Tile_X0Y1_FrameData[25] Tile_X0Y1_FrameStrobe[11] VPWR VGND sg13cmos5l_dlhq_1
X_3583_ _3583_/X Tile_X0Y1_EE4END[2] Tile_X0Y1_W2END[7] Tile_X0Y0_S4END[6] _6692_/A
+ _6041_/Q _6042_/Q VPWR VGND sg13cmos5l_mux4_1
X_5322_ _5322_/Y _6383_/Q _2891_/Y _2794_/Y VPWR VGND sg13cmos5l_a21oi_1
X_5253_ _5253_/X _4940_/Y _4934_/Y _4943_/Y _5011_/X _5868_/Q _5866_/Q VPWR VGND sg13cmos5l_mux4_1
X_5184_ _6813_/A _5174_/Y _5177_/Y _5183_/Y VPWR VGND sg13cmos5l_a21oi_1
X_4204_ _4206_/A _4112_/A _4112_/B _4110_/X VPWR VGND sg13cmos5l_a21oi_1
XFILLER_68_331 VPWR VGND sg13cmos5l_fill_2
X_4135_ _5992_/D _4128_/Y _4134_/X _4120_/X VPWR VGND sg13cmos5l_o21ai_1
X_4066_ _4066_/X Tile_X0Y0_W2MID[6] _6593_/A _5826_/Q VPWR VGND sg13cmos5l_mux2_1
X_3017_ _3017_/Y _5596_/Q Tile_X0Y1_N4END[4] _3016_/Y VPWR VGND sg13cmos5l_o21ai_1
XFILLER_51_264 VPWR VGND sg13cmos5l_fill_2
XANTENNA__6532__X Tile_X0Y0_EE4BEG[14] VPWR VGND sg13cmos5l_antennanp
X_4968_ _4969_/B _4940_/Y _4934_/Y _4943_/Y _5011_/X _5702_/Q _5700_/Q VPWR VGND sg13cmos5l_mux4_1
X_6707_ Tile_X0Y1_E6BEG[0] Tile_X0Y1_E6END[2] VPWR VGND sg13cmos5l_buf_1
X_4899_ _4900_/A _2759_/Y _4895_/X _4898_/Y VPWR VGND sg13cmos5l_a21oi_1
X_3919_ _4392_/A _6425_/Q _5560_/Q _3917_/X _3918_/Y VPWR VGND sg13cmos5l_a22oi_1
X_6638_ Tile_X0Y0_UserCLKo Tile_X0Y0_UserCLK VPWR VGND sg13cmos5l_buf_1
X_6569_ Tile_X0Y0_FrameStrobe_O[3] Tile_X0Y1_FrameStrobe[3] VPWR VGND sg13cmos5l_buf_1
XFILLER_78_128 VPWR VGND sg13cmos5l_fill_2
XFILLER_86_161 VPWR VGND sg13cmos5l_fill_2
XANTENNA__6707__X Tile_X0Y1_E6BEG[0] VPWR VGND sg13cmos5l_antennanp
XFILLER_42_275 VPWR VGND sg13cmos5l_fill_2
XANTENNA__6617__X Tile_X0Y0_N4BEG[11] VPWR VGND sg13cmos5l_antennanp
X_5940_ _5940_/Q Tile_X0Y0_FrameData[14] Tile_X0Y1_FrameStrobe[11] VPWR VGND sg13cmos5l_dlhq_1
X_5871_ _5871_/Q Tile_X0Y0_FrameData[19] Tile_X0Y1_FrameStrobe[9] VPWR VGND sg13cmos5l_dlhq_1
X_4822_ _4823_/B _6426_/Q _6008_/D _4821_/Y VPWR VGND sg13cmos5l_o21ai_1
X_4753_ _4753_/X _4940_/Y _4934_/Y _4943_/Y _5011_/X _5674_/Q _5672_/Q VPWR VGND sg13cmos5l_mux4_1
X_3704_ _3704_/Y _6040_/Q Tile_X0Y1_N4END[1] VPWR VGND sg13cmos5l_nand2b_1
X_6423_ _6423_/Q Tile_X0Y1_FrameData[5] Tile_X0Y1_FrameStrobe[12] VPWR VGND sg13cmos5l_dlhq_1
X_4684_ _4712_/A _4685_/A _4719_/A VPWR VGND sg13cmos5l_and2_1
X_3635_ _4513_/A _4186_/A _4216_/A VPWR VGND sg13cmos5l_or2_1
X_6354_ _6354_/Q Tile_X0Y1_FrameData[10] Tile_X0Y1_FrameStrobe[10] VPWR VGND sg13cmos5l_dlhq_1
X_3566_ _3566_/Y _6126_/Q _4409_/B _3565_/Y VPWR VGND sg13cmos5l_o21ai_1
X_6285_ _6285_/Q Tile_X0Y1_FrameData[15] Tile_X0Y1_FrameStrobe[8] VPWR VGND sg13cmos5l_dlhq_1
X_5305_ _5305_/Y _6386_/Q _3278_/Y _5304_/Y VPWR VGND sg13cmos5l_o21ai_1
X_3497_ _3497_/Y _5640_/Q Tile_X0Y0_E2END[7] VPWR VGND sg13cmos5l_nor2b_1
X_5236_ _5237_/A _5873_/Q _5235_/X _5234_/Y VPWR VGND sg13cmos5l_o21ai_1
X_5167_ _5167_/Y _5901_/Q _4909_/X _5166_/Y VPWR VGND sg13cmos5l_o21ai_1
XANTENNA__6527__X Tile_X0Y0_EE4BEG[9] VPWR VGND sg13cmos5l_antennanp
X_5098_ _6488_/A _5011_/X _5180_/B _6591_/A _3237_/Y _5944_/Q _5943_/Q VPWR VGND sg13cmos5l_mux4_1
X_4118_ _4118_/X Tile_X0Y1_N2MID[4] Tile_X0Y0_E2END[4] Tile_X0Y0_SS4END[2] Tile_X0Y0_W2END[4]
+ _5750_/Q _5749_/Q VPWR VGND sg13cmos5l_mux4_1
X_4049_ _4049_/X Tile_X0Y1_N2MID[4] Tile_X0Y0_E6END[0] Tile_X0Y1_N4END[4] Tile_X0Y0_S2END[4]
+ _5716_/Q _5718_/Q VPWR VGND sg13cmos5l_mux4_1
XFILLER_33_45 VPWR VGND sg13cmos5l_fill_1
XFILLER_47_323 VPWR VGND sg13cmos5l_fill_2
XFILLER_15_220 VPWR VGND sg13cmos5l_decap_4
X_3420_ _3852_/C _6058_/Q _3417_/X _3419_/Y VPWR VGND sg13cmos5l_a21oi_1
XFILLER_109_380 VPWR VGND sg13cmos5l_fill_1
X_3351_ _3354_/A _6147_/Q _3351_/B VPWR VGND sg13cmos5l_nor2_1
X_6070_ _6070_/Q Tile_X0Y1_FrameData[6] Tile_X0Y1_FrameStrobe[1] VPWR VGND sg13cmos5l_dlhq_1
X_3282_ _3282_/Y _2715_/Y _6152_/Q _3281_/Y VPWR VGND sg13cmos5l_a21oi_1
X_5021_ _5021_/Y _5632_/Q _4937_/Y _5020_/Y VPWR VGND sg13cmos5l_a21oi_1
XFILLER_65_186 VPWR VGND sg13cmos5l_decap_4
X_5923_ _5923_/Q Tile_X0Y0_FrameData[31] Tile_X0Y1_FrameStrobe[11] VPWR VGND sg13cmos5l_dlhq_1
XFILLER_0_82 VPWR VGND sg13cmos5l_decap_8
X_5854_ _5854_/Q Tile_X0Y0_FrameData[4] Tile_X0Y1_FrameStrobe[8] VPWR VGND sg13cmos5l_dlhq_1
X_4805_ _4805_/Y _5704_/Q Tile_X0Y0_E2END[7] VPWR VGND sg13cmos5l_nor2b_1
X_5785_ _5785_/Q Tile_X0Y0_FrameData[9] Tile_X0Y1_FrameStrobe[6] VPWR VGND sg13cmos5l_dlhq_1
X_2997_ _2998_/B _2997_/A VPWR VGND sg13cmos5l_inv_1
X_4736_ _4736_/Y _4730_/Y _4733_/Y _5835_/Q VPWR VGND sg13cmos5l_o21ai_1
XANTENNA__6810__X Tile_X0Y1_SS4BEG[7] VPWR VGND sg13cmos5l_antennanp
X_4667_ _4676_/A _5844_/Q _3099_/Y _4666_/Y VPWR VGND sg13cmos5l_a21oi_1
X_6406_ _6406_/Q Tile_X0Y1_FrameData[22] Tile_X0Y1_FrameStrobe[12] VPWR VGND sg13cmos5l_dlhq_1
X_3618_ _3619_/A _6260_/Q Tile_X0Y1_W2MID[6] _6259_/Q VPWR VGND sg13cmos5l_o21ai_1
X_6337_ _6337_/Q Tile_X0Y1_FrameData[27] Tile_X0Y1_FrameStrobe[10] VPWR VGND sg13cmos5l_dlhq_1
X_4598_ _4607_/A _4582_/A _4582_/B _4580_/Y VPWR VGND sg13cmos5l_o21ai_1
X_3549_ _3549_/Y _4621_/B _5656_/Q _3548_/Y VPWR VGND sg13cmos5l_o21ai_1
X_6268_ _6268_/Q Tile_X0Y1_FrameData[0] Tile_X0Y1_FrameStrobe[7] VPWR VGND sg13cmos5l_dlhq_1
X_6199_ _6199_/Q Tile_X0Y1_FrameData[5] Tile_X0Y1_FrameStrobe[5] VPWR VGND sg13cmos5l_dlhq_1
X_5219_ _5219_/Y Tile_X0Y0_W1END[0] _5878_/Q _5877_/Q VPWR VGND sg13cmos5l_o21ai_1
XFILLER_44_348 VPWR VGND sg13cmos5l_fill_1
XANTENNA__6720__X Tile_X0Y1_EE4BEG[1] VPWR VGND sg13cmos5l_antennanp
XFILLER_69_41 VPWR VGND sg13cmos5l_fill_2
XFILLER_109_92 VPWR VGND sg13cmos5l_fill_1
XFILLER_69_74 VPWR VGND sg13cmos5l_decap_4
XFILLER_39_109 VPWR VGND sg13cmos5l_fill_2
X_2920_ _2921_/B _3916_/Y _5262_/X _6130_/Q VPWR VGND sg13cmos5l_mux2_1
X_2851_ _2851_/Y _6121_/Q VPWR VGND sg13cmos5l_inv_1
X_5570_ _5570_/Q Tile_X0Y1_UserCLK _5570_/D _6482_/L_HI VPWR VGND sg13cmos5l_dfrbpq_1
X_2782_ _2782_/Y _5884_/Q VPWR VGND sg13cmos5l_inv_1
XANTENNA__6630__X Tile_X0Y0_NN4BEG[8] VPWR VGND sg13cmos5l_antennanp
X_4521_ _4566_/A _6425_/Q _5563_/Q VPWR VGND sg13cmos5l_nand2_1
X_4452_ _4452_/Y _6110_/Q _4451_/X _2719_/Y VPWR VGND sg13cmos5l_o21ai_1
X_3403_ _3403_/X _4515_/Y _4509_/Y _5390_/B _5374_/B _6124_/Q _6122_/Q VPWR VGND sg13cmos5l_mux4_1
X_4383_ _4516_/B _3914_/A _3911_/Y _3912_/Y VPWR VGND sg13cmos5l_a21oi_1
X_6122_ _6122_/Q Tile_X0Y1_FrameData[18] Tile_X0Y1_FrameStrobe[3] VPWR VGND sg13cmos5l_dlhq_1
X_3334_ _3334_/X _4515_/Y _4509_/Y _4518_/Y _5390_/B _6116_/Q _6114_/Q VPWR VGND sg13cmos5l_mux4_1
X_6053_ _6053_/Q Tile_X0Y1_FrameData[23] Tile_X0Y1_FrameStrobe[1] VPWR VGND sg13cmos5l_dlhq_1
X_3265_ _3265_/Y _6157_/Q _3265_/B VPWR VGND sg13cmos5l_nor2_1
XFILLER_105_17 VPWR VGND sg13cmos5l_decap_8
X_5004_ _5004_/Y _6426_/Q _2770_/Y _6425_/Q VPWR VGND sg13cmos5l_a21oi_1
X_3196_ _3196_/Y Tile_X0Y0_E2END[4] _3195_/B _3195_/Y VPWR VGND sg13cmos5l_a21oi_1
XANTENNA__6805__X Tile_X0Y1_SS4BEG[2] VPWR VGND sg13cmos5l_antennanp
XFILLER_26_359 VPWR VGND sg13cmos5l_fill_1
X_5906_ _5906_/Q Tile_X0Y0_FrameData[16] Tile_X0Y1_FrameStrobe[10] VPWR VGND sg13cmos5l_dlhq_1
X_5837_ _5837_/Q Tile_X0Y0_FrameData[21] Tile_X0Y1_FrameStrobe[8] VPWR VGND sg13cmos5l_dlhq_1
X_5768_ _5768_/Q Tile_X0Y0_FrameData[26] Tile_X0Y1_FrameStrobe[6] VPWR VGND sg13cmos5l_dlhq_1
XANTENNA__6540__X Tile_X0Y0_FrameData_O[6] VPWR VGND sg13cmos5l_antennanp
X_4719_ _4721_/B _4719_/A _4708_/Y VPWR VGND sg13cmos5l_nor2b_1
X_5699_ _5699_/Q Tile_X0Y0_FrameData[31] Tile_X0Y1_FrameStrobe[4] VPWR VGND sg13cmos5l_dlhq_1
XANTENNA__6715__X Tile_X0Y1_E6BEG[8] VPWR VGND sg13cmos5l_antennanp
XFILLER_55_87 VPWR VGND sg13cmos5l_fill_2
XFILLER_4_263 VPWR VGND sg13cmos5l_fill_1
X_3050_ _3050_/Y _5645_/Q _3050_/B VPWR VGND sg13cmos5l_nand2_1
XANTENNA__6625__X Tile_X0Y0_NN4BEG[3] VPWR VGND sg13cmos5l_antennanp
X_6740_ Tile_X0Y1_FrameData_O[5] Tile_X0Y1_FrameData[5] VPWR VGND sg13cmos5l_buf_1
X_3952_ _3952_/X Tile_X0Y1_N2MID[3] Tile_X0Y0_E6END[1] Tile_X0Y1_N4END[7] Tile_X0Y0_S2END[3]
+ _5720_/Q _5722_/Q VPWR VGND sg13cmos5l_mux4_1
X_6671_ Tile_X0Y0_WW4BEG[0] Tile_X0Y0_WW4END[4] VPWR VGND sg13cmos5l_buf_1
X_3883_ _3883_/Y _6070_/Q _4409_/B _3882_/Y VPWR VGND sg13cmos5l_o21ai_1
X_2903_ _2903_/Y _5660_/Q _2902_/X _2905_/B VPWR VGND sg13cmos5l_a21oi_1
XFILLER_31_362 VPWR VGND sg13cmos5l_fill_1
X_5622_ _5622_/Q Tile_X0Y0_FrameData[12] Tile_X0Y1_FrameStrobe[1] VPWR VGND sg13cmos5l_dlhq_1
X_2834_ _3118_/S _5638_/Q VPWR VGND sg13cmos5l_inv_1
X_5553_ _5553_/Q Tile_X0Y1_UserCLK _5553_/D _6479_/L_HI VPWR VGND sg13cmos5l_dfrbpq_1
XFILLER_77_0 VPWR VGND sg13cmos5l_fill_2
X_4504_ _5538_/B _4504_/A _4504_/B VPWR VGND sg13cmos5l_xnor2_1
X_2765_ _4999_/A _5829_/Q VPWR VGND sg13cmos5l_inv_1
X_5484_ _5488_/A _6324_/Q _5498_/B _5483_/Y VPWR VGND sg13cmos5l_a21oi_1
X_4435_ _4435_/Y _6112_/Q _2888_/Y _4434_/Y VPWR VGND sg13cmos5l_o21ai_1
X_4366_ _4366_/X _6286_/Q _4366_/B VPWR VGND sg13cmos5l_and2_1
X_6105_ _6105_/Q Tile_X0Y1_FrameData[3] Tile_X0Y1_FrameStrobe[2] VPWR VGND sg13cmos5l_dlhq_1
X_3317_ _3317_/Y _5723_/Q _3317_/B _3317_/C VPWR VGND sg13cmos5l_nand3_1
X_4297_ _4298_/B Tile_X0Y1_N2MID[1] _6206_/Q _4296_/Y VPWR VGND sg13cmos5l_o21ai_1
XFILLER_58_237 VPWR VGND sg13cmos5l_decap_4
X_6036_ _6036_/Q Tile_X0Y1_FrameData[8] Tile_X0Y1_FrameStrobe[0] VPWR VGND sg13cmos5l_dlhq_1
X_3248_ _3248_/Y Tile_X0Y1_N4END[6] _5694_/Q _5693_/Q VPWR VGND sg13cmos5l_o21ai_1
XFILLER_100_378 VPWR VGND sg13cmos5l_fill_2
X_3179_ _3179_/Y Tile_X0Y0_E6END[1] _5690_/Q _3178_/Y VPWR VGND sg13cmos5l_o21ai_1
XANTENNA__6535__X Tile_X0Y0_FrameData_O[1] VPWR VGND sg13cmos5l_antennanp
XFILLER_89_362 VPWR VGND sg13cmos5l_fill_1
XFILLER_106_93 VPWR VGND sg13cmos5l_decap_8
XFILLER_66_75 VPWR VGND sg13cmos5l_fill_1
XFILLER_9_355 VPWR VGND sg13cmos5l_decap_8
X_4220_ _4224_/A _4228_/A _4228_/B VPWR VGND sg13cmos5l_nor2_1
X_4151_ _4213_/A _4101_/Y _4106_/B _4104_/Y VPWR VGND sg13cmos5l_o21ai_1
X_4082_ _4147_/B _4216_/A _4600_/A _4083_/B VPWR VGND sg13cmos5l_or3_1
X_3102_ _3103_/B _3100_/X _3101_/X _6144_/Q VPWR VGND sg13cmos5l_mux2_1
X_3033_ _3033_/X Tile_X0Y1_W2END[3] Tile_X0Y1_W6END[1] _6068_/Q VPWR VGND sg13cmos5l_mux2_1
XFILLER_63_273 VPWR VGND sg13cmos5l_fill_1
XFILLER_63_240 VPWR VGND sg13cmos5l_fill_1
X_4984_ _4984_/Y _5669_/Q _4984_/B VPWR VGND sg13cmos5l_nor2_1
X_6723_ Tile_X0Y1_EE4BEG[4] Tile_X0Y1_EE4END[8] VPWR VGND sg13cmos5l_buf_1
X_3935_ _3935_/Y Tile_X0Y0_W2MID[2] _5816_/Q _5815_/Q VPWR VGND sg13cmos5l_o21ai_1
X_6654_ Tile_X0Y0_W2BEGb[3] Tile_X0Y0_W2MID[3] VPWR VGND sg13cmos5l_buf_1
X_5605_ _5605_/Q Tile_X0Y0_FrameData[29] Tile_X0Y1_FrameStrobe[1] VPWR VGND sg13cmos5l_dlhq_1
X_3866_ _3866_/Y _3866_/A _3866_/B VPWR VGND sg13cmos5l_nor2_1
X_6585_ Tile_X0Y0_FrameStrobe_O[19] Tile_X0Y1_FrameStrobe[19] VPWR VGND sg13cmos5l_buf_1
X_3797_ _3797_/Y _2797_/Y _6022_/Q _6021_/Q VPWR VGND sg13cmos5l_a21oi_1
X_2817_ _2817_/Y _6153_/Q VPWR VGND sg13cmos5l_inv_1
X_5536_ _5556_/D _5551_/A _5536_/B VPWR VGND sg13cmos5l_nor2_1
X_2748_ _2748_/Y Tile_X0Y0_S1END[3] VPWR VGND sg13cmos5l_inv_1
X_5467_ _5471_/A _2803_/Y _3643_/Y _5466_/Y VPWR VGND sg13cmos5l_a21oi_1
X_4418_ _4418_/Y _5374_/B _6078_/Q VPWR VGND sg13cmos5l_nand2b_1
X_5398_ _6802_/A Tile_X0Y0_S2MID[1] Tile_X0Y1_W6END[0] Tile_X0Y0_S4END[4] _3916_/Y
+ _6351_/Q _6352_/Q VPWR VGND sg13cmos5l_mux4_1
X_4349_ _4349_/Y _6284_/Q _4348_/X _6283_/Q VPWR VGND sg13cmos5l_o21ai_1
XFILLER_98_170 VPWR VGND sg13cmos5l_decap_4
XFILLER_100_142 VPWR VGND sg13cmos5l_fill_1
X_6019_ _6019_/Q Tile_X0Y1_FrameData[25] Tile_X0Y1_FrameStrobe[0] VPWR VGND sg13cmos5l_dlhq_1
XFILLER_36_67 VPWR VGND sg13cmos5l_fill_1
XFILLER_77_85 VPWR VGND sg13cmos5l_fill_1
XFILLER_92_379 VPWR VGND sg13cmos5l_fill_2
XANTENNA_250 Tile_X0Y0_W2MID[4] VPWR VGND sg13cmos5l_antennanp
XANTENNA_261 Tile_X0Y1_FrameData[29] VPWR VGND sg13cmos5l_antennanp
XANTENNA_272 Tile_X0Y1_FrameData[29] VPWR VGND sg13cmos5l_antennanp
X_3720_ _4253_/A _4254_/A VPWR VGND sg13cmos5l_inv_1
X_3651_ _3651_/X _6297_/Q _3651_/B VPWR VGND sg13cmos5l_or2_1
X_6370_ _6370_/Q Tile_X0Y1_FrameData[26] Tile_X0Y1_FrameStrobe[11] VPWR VGND sg13cmos5l_dlhq_1
X_3582_ _3582_/Y _3578_/Y _3581_/Y _6307_/Q VPWR VGND sg13cmos5l_a21oi_1
X_5321_ _5321_/Y _5321_/A _5321_/B VPWR VGND sg13cmos5l_nor2_1
X_5252_ _5252_/X Tile_X0Y0_E1END[2] Tile_X0Y0_W1END[2] _4707_/Y _4911_/X _5868_/Q
+ _5866_/Q VPWR VGND sg13cmos5l_mux4_1
X_5183_ _5183_/Y _5183_/A _5183_/B VPWR VGND sg13cmos5l_nor2_1
X_4203_ _4208_/A _4216_/A _4709_/B VPWR VGND sg13cmos5l_nand2b_1
X_4134_ _4134_/X _4130_/Y _4133_/Y _5851_/Q VPWR VGND sg13cmos5l_a21o_1
XFILLER_3_82 VPWR VGND sg13cmos5l_fill_1
XFILLER_95_173 VPWR VGND sg13cmos5l_decap_8
X_4065_ _6593_/A _5715_/Q _4052_/Y _4064_/Y VPWR VGND sg13cmos5l_o21ai_1
X_3016_ _3016_/Y _5596_/Q _3016_/B VPWR VGND sg13cmos5l_nand2_1
XFILLER_36_284 VPWR VGND sg13cmos5l_decap_4
XFILLER_36_273 VPWR VGND sg13cmos5l_fill_2
XANTENNA__6813__X Tile_X0Y1_SS4BEG[10] VPWR VGND sg13cmos5l_antennanp
X_4967_ _4967_/Y _4965_/Y _4966_/Y _2769_/Y VPWR VGND sg13cmos5l_a21oi_1
XFILLER_51_287 VPWR VGND sg13cmos5l_fill_1
X_6706_ Tile_X0Y1_E2BEGb[7] Tile_X0Y1_E2MID[7] VPWR VGND sg13cmos5l_buf_1
X_4898_ _4898_/Y _5834_/Q _3236_/X _4897_/Y VPWR VGND sg13cmos5l_a21oi_1
X_3918_ _3918_/Y _6426_/Q _2711_/Y _6425_/Q VPWR VGND sg13cmos5l_a21oi_1
X_6637_ Tile_X0Y0_NN4BEG[15] _6637_/A VPWR VGND sg13cmos5l_buf_1
X_3849_ _3849_/X _6426_/Q _5997_/D VPWR VGND sg13cmos5l_or2_1
X_6568_ Tile_X0Y0_FrameStrobe_O[2] Tile_X0Y1_FrameStrobe[2] VPWR VGND sg13cmos5l_buf_1
X_5519_ _5519_/X _5374_/B _5262_/X _5440_/B _5422_/B _6314_/Q _6313_/Q VPWR VGND sg13cmos5l_mux4_1
XFILLER_98_29 VPWR VGND sg13cmos5l_fill_1
X_6499_ Tile_X0Y0_E2BEGb[1] Tile_X0Y0_E2MID[1] VPWR VGND sg13cmos5l_buf_1
XFILLER_0_7 VPWR VGND sg13cmos5l_decap_8
XFILLER_59_354 VPWR VGND sg13cmos5l_fill_1
XANTENNA__6723__X Tile_X0Y1_EE4BEG[4] VPWR VGND sg13cmos5l_antennanp
XFILLER_8_38 VPWR VGND sg13cmos5l_fill_2
XFILLER_111_226 VPWR VGND sg13cmos5l_decap_8
XFILLER_111_259 VPWR VGND sg13cmos5l_decap_8
X_5870_ _5870_/Q Tile_X0Y0_FrameData[20] Tile_X0Y1_FrameStrobe[9] VPWR VGND sg13cmos5l_dlhq_1
XANTENNA__6633__X Tile_X0Y0_NN4BEG[11] VPWR VGND sg13cmos5l_antennanp
X_4821_ _4821_/Y _6426_/Q _2752_/Y _6425_/Q VPWR VGND sg13cmos5l_a21oi_1
X_4752_ _4785_/A _6425_/Q _5567_/Q VPWR VGND sg13cmos5l_nand2_1
X_4683_ _4719_/A _4683_/A _4709_/A VPWR VGND sg13cmos5l_nor2b_1
X_3703_ _3703_/Y _6039_/Q _3703_/B _3703_/C VPWR VGND sg13cmos5l_nand3_1
X_6422_ _6422_/Q Tile_X0Y1_FrameData[6] Tile_X0Y1_FrameStrobe[12] VPWR VGND sg13cmos5l_dlhq_1
X_3634_ _3724_/A _4205_/A _4188_/A VPWR VGND sg13cmos5l_nor2_1
X_6353_ _6353_/Q Tile_X0Y1_FrameData[11] Tile_X0Y1_FrameStrobe[10] VPWR VGND sg13cmos5l_dlhq_1
X_3565_ _3565_/Y _6126_/Q _5262_/X VPWR VGND sg13cmos5l_nand2_1
X_6284_ _6284_/Q Tile_X0Y1_FrameData[16] Tile_X0Y1_FrameStrobe[8] VPWR VGND sg13cmos5l_dlhq_1
X_5304_ _5304_/Y _6386_/Q _4409_/B _2792_/Y VPWR VGND sg13cmos5l_a21oi_1
X_3496_ _3496_/X Tile_X0Y0_E1END[3] Tile_X0Y0_W1END[1] _5640_/Q VPWR VGND sg13cmos5l_mux2_1
X_5235_ _5235_/X Tile_X0Y0_S1END[1] _3172_/Y _5011_/X Tile_X0Y0_W1END[1] _2784_/Y
+ _5874_/Q VPWR VGND sg13cmos5l_mux4_1
XANTENNA__6808__X Tile_X0Y1_SS4BEG[5] VPWR VGND sg13cmos5l_antennanp
X_5166_ _5166_/Y _5901_/Q _5209_/B VPWR VGND sg13cmos5l_nand2_1
XFILLER_56_302 VPWR VGND sg13cmos5l_decap_4
X_5097_ _6487_/A _5945_/Q _5096_/Y _5094_/X VPWR VGND sg13cmos5l_o21ai_1
X_4117_ _4120_/A _5589_/Q _4113_/X _4116_/Y VPWR VGND sg13cmos5l_a21oi_1
X_4048_ _4048_/Y _5825_/Q _4048_/B VPWR VGND sg13cmos5l_nand2b_1
XANTENNA__6543__X Tile_X0Y0_FrameData_O[9] VPWR VGND sg13cmos5l_antennanp
X_5999_ _5999_/Q Tile_X0Y1_UserCLK _5999_/D _6453_/L_HI VPWR VGND sg13cmos5l_dfrbpq_1
XFILLER_24_265 VPWR VGND sg13cmos5l_fill_1
XANTENNA__6718__X Tile_X0Y1_E6BEG[11] VPWR VGND sg13cmos5l_antennanp
XFILLER_99_72 VPWR VGND sg13cmos5l_fill_2
X_3350_ _3351_/B _4515_/Y _4509_/Y _4518_/Y _5390_/B _6148_/Q _6146_/Q VPWR VGND sg13cmos5l_mux4_1
X_5020_ _5020_/Y _5632_/Q _4707_/Y VPWR VGND sg13cmos5l_nor2b_1
X_3281_ _3281_/Y Tile_X0Y1_W1END[0] _6152_/Q VPWR VGND sg13cmos5l_nor2_1
XFILLER_2_180 VPWR VGND sg13cmos5l_fill_1
XANTENNA__6628__X Tile_X0Y0_NN4BEG[6] VPWR VGND sg13cmos5l_antennanp
XFILLER_53_327 VPWR VGND sg13cmos5l_fill_1
X_5922_ _5922_/Q Tile_X0Y0_FrameData[0] Tile_X0Y1_FrameStrobe[10] VPWR VGND sg13cmos5l_dlhq_1
XFILLER_80_135 VPWR VGND sg13cmos5l_fill_1
X_5853_ _5853_/Q Tile_X0Y0_FrameData[5] Tile_X0Y1_FrameStrobe[8] VPWR VGND sg13cmos5l_dlhq_1
X_5784_ _5784_/Q Tile_X0Y0_FrameData[10] Tile_X0Y1_FrameStrobe[6] VPWR VGND sg13cmos5l_dlhq_1
X_4804_ _4804_/X Tile_X0Y0_E1END[3] Tile_X0Y0_W1END[1] _5704_/Q VPWR VGND sg13cmos5l_mux2_1
X_4735_ _4735_/Y _5836_/Q _4735_/B VPWR VGND sg13cmos5l_nor2_1
X_2996_ _2997_/A _3916_/Y _5262_/X _4518_/Y _5422_/B _6166_/Q _6168_/Q VPWR VGND sg13cmos5l_mux4_1
X_4666_ _4666_/Y _5844_/Q _4665_/X _5843_/Q VPWR VGND sg13cmos5l_o21ai_1
XFILLER_107_318 VPWR VGND sg13cmos5l_fill_2
X_6405_ _6405_/Q Tile_X0Y1_FrameData[23] Tile_X0Y1_FrameStrobe[12] VPWR VGND sg13cmos5l_dlhq_1
X_4597_ _4611_/A _4575_/Y _4585_/B _4583_/Y VPWR VGND sg13cmos5l_o21ai_1
X_3617_ _3617_/Y _6260_/Q _4123_/B _4123_/C VPWR VGND sg13cmos5l_nand3_1
X_6336_ _6336_/Q Tile_X0Y1_FrameData[28] Tile_X0Y1_FrameStrobe[10] VPWR VGND sg13cmos5l_dlhq_1
X_3548_ _3548_/Y Tile_X0Y0_W2END[3] _5656_/Q VPWR VGND sg13cmos5l_nand2_1
X_6267_ _6267_/Q Tile_X0Y1_FrameData[1] Tile_X0Y1_FrameStrobe[7] VPWR VGND sg13cmos5l_dlhq_1
X_3479_ _3479_/Y _3475_/Y _3476_/Y _3478_/Y VPWR VGND sg13cmos5l_o21ai_1
XANTENNA__6538__X Tile_X0Y0_FrameData_O[4] VPWR VGND sg13cmos5l_antennanp
X_6198_ _6198_/Q Tile_X0Y1_FrameData[6] Tile_X0Y1_FrameStrobe[5] VPWR VGND sg13cmos5l_dlhq_1
X_5218_ _5218_/Y _5878_/Q _5058_/B _5217_/Y VPWR VGND sg13cmos5l_o21ai_1
X_5149_ _5149_/X _5209_/B _4127_/Y _5229_/B _4744_/Y _5924_/Q _5923_/Q VPWR VGND sg13cmos5l_mux4_1
XFILLER_71_168 VPWR VGND sg13cmos5l_fill_2
XFILLER_8_239 VPWR VGND sg13cmos5l_fill_2
XFILLER_69_20 VPWR VGND sg13cmos5l_fill_1
XFILLER_107_0 VPWR VGND sg13cmos5l_decap_8
XFILLER_35_327 VPWR VGND sg13cmos5l_fill_1
X_2850_ _2850_/Y _5987_/Q VPWR VGND sg13cmos5l_inv_1
X_2781_ _2781_/Y _5897_/Q VPWR VGND sg13cmos5l_inv_1
X_4520_ _5440_/B _4519_/X _5560_/Q _6423_/Q VPWR VGND sg13cmos5l_mux2_1
X_4451_ _4451_/X Tile_X0Y1_N1END[0] Tile_X0Y1_N2END[0] Tile_X0Y1_E1END[0] Tile_X0Y1_E2END[0]
+ _6112_/Q _6111_/Q VPWR VGND sg13cmos5l_mux4_1
X_3402_ _3402_/Y _3402_/A VPWR VGND sg13cmos5l_inv_1
X_6121_ _6121_/Q Tile_X0Y1_FrameData[19] Tile_X0Y1_FrameStrobe[3] VPWR VGND sg13cmos5l_dlhq_1
X_4382_ _4516_/A _4382_/A _4382_/B VPWR VGND sg13cmos5l_xnor2_1
X_3333_ _3336_/A _6114_/Q _3331_/X _3332_/Y VPWR VGND sg13cmos5l_a21oi_1
X_6052_ _6052_/Q Tile_X0Y1_FrameData[24] Tile_X0Y1_FrameStrobe[1] VPWR VGND sg13cmos5l_dlhq_1
X_3264_ _3265_/B _6158_/Q _3260_/X _3263_/Y VPWR VGND sg13cmos5l_a21oi_1
XFILLER_22_0 VPWR VGND sg13cmos5l_fill_2
X_5003_ _5003_/X _6426_/Q _6013_/D VPWR VGND sg13cmos5l_or2_1
X_3195_ _3195_/Y _3195_/A _3195_/B VPWR VGND sg13cmos5l_nor2_1
X_5905_ _5905_/Q Tile_X0Y0_FrameData[17] Tile_X0Y1_FrameStrobe[10] VPWR VGND sg13cmos5l_dlhq_1
XANTENNA__6821__X Tile_X0Y1_W1BEG[1] VPWR VGND sg13cmos5l_antennanp
X_5836_ _5836_/Q Tile_X0Y0_FrameData[22] Tile_X0Y1_FrameStrobe[8] VPWR VGND sg13cmos5l_dlhq_1
X_5767_ _5767_/Q Tile_X0Y0_FrameData[27] Tile_X0Y1_FrameStrobe[6] VPWR VGND sg13cmos5l_dlhq_1
X_2979_ _2979_/Y _6171_/Q _2973_/X _6169_/Q VPWR VGND sg13cmos5l_o21ai_1
X_5698_ _5698_/Q Tile_X0Y0_FrameData[0] Tile_X0Y1_FrameStrobe[3] VPWR VGND sg13cmos5l_dlhq_1
X_4718_ _4824_/A _4695_/A _4722_/B _4866_/A VPWR VGND sg13cmos5l_a21oi_1
X_4649_ _4649_/Y _5810_/Q Tile_X0Y0_W2MID[6] _5809_/Q VPWR VGND sg13cmos5l_o21ai_1
XFILLER_107_104 VPWR VGND sg13cmos5l_fill_1
X_6319_ _6319_/Q Tile_X0Y1_FrameData[13] Tile_X0Y1_FrameStrobe[9] VPWR VGND sg13cmos5l_dlhq_1
XFILLER_76_205 VPWR VGND sg13cmos5l_fill_2
XFILLER_103_354 VPWR VGND sg13cmos5l_decap_8
XANTENNA__6731__X Tile_X0Y1_EE4BEG[12] VPWR VGND sg13cmos5l_antennanp
XFILLER_82_219 VPWR VGND sg13cmos5l_fill_1
X_3951_ _4009_/A _4477_/A _4471_/A VPWR VGND sg13cmos5l_nand2_1
XFILLER_23_308 VPWR VGND sg13cmos5l_fill_2
XFILLER_16_360 VPWR VGND sg13cmos5l_decap_8
X_2902_ _2902_/X Tile_X0Y0_W2END[2] Tile_X0Y0_W6END[0] _5662_/Q VPWR VGND sg13cmos5l_mux2_1
XFILLER_50_138 VPWR VGND sg13cmos5l_fill_1
X_6670_ Tile_X0Y0_W6BEG[11] _6670_/A VPWR VGND sg13cmos5l_buf_1
X_3882_ _3882_/Y _6070_/Q _5374_/B VPWR VGND sg13cmos5l_nand2_1
XANTENNA__6641__X Tile_X0Y0_W1BEG[2] VPWR VGND sg13cmos5l_antennanp
X_5621_ _5621_/Q Tile_X0Y0_FrameData[13] Tile_X0Y1_FrameStrobe[1] VPWR VGND sg13cmos5l_dlhq_1
X_2833_ _2833_/Y _5692_/Q VPWR VGND sg13cmos5l_inv_1
X_5552_ _5552_/Q Tile_X0Y1_UserCLK _5552_/D _6430_/L_HI VPWR VGND sg13cmos5l_dfrbpq_1
X_2764_ _2764_/Y Tile_X0Y0_E1END[0] VPWR VGND sg13cmos5l_inv_1
X_4503_ _4503_/Y _6423_/Q _5534_/B _4502_/Y VPWR VGND sg13cmos5l_o21ai_1
X_5483_ _5483_/Y _6324_/Q _5440_/B _2805_/Y VPWR VGND sg13cmos5l_o21ai_1
X_4434_ _4434_/Y _6112_/Q _5390_/B VPWR VGND sg13cmos5l_nand2_1
X_4365_ _4366_/B Tile_X0Y1_N2MID[7] _6212_/Q _4364_/Y VPWR VGND sg13cmos5l_o21ai_1
X_6104_ _6104_/Q Tile_X0Y1_FrameData[4] Tile_X0Y1_FrameStrobe[2] VPWR VGND sg13cmos5l_dlhq_1
X_3316_ _3317_/C _5726_/Q _3314_/Y _3315_/Y VPWR VGND sg13cmos5l_o21ai_1
X_6035_ _6035_/Q Tile_X0Y1_FrameData[9] Tile_X0Y1_FrameStrobe[0] VPWR VGND sg13cmos5l_dlhq_1
X_4296_ _4296_/Y _2843_/Y _6206_/Q _6205_/Q VPWR VGND sg13cmos5l_a21oi_1
XFILLER_58_249 VPWR VGND sg13cmos5l_decap_8
X_3247_ _3247_/Y _5694_/Q _5058_/B _3246_/Y VPWR VGND sg13cmos5l_o21ai_1
XANTENNA__6816__X Tile_X0Y1_SS4BEG[13] VPWR VGND sg13cmos5l_antennanp
X_3178_ _3178_/Y _2733_/Y _5690_/Q _5689_/Q VPWR VGND sg13cmos5l_a21oi_1
XFILLER_81_241 VPWR VGND sg13cmos5l_fill_1
XANTENNA__6551__X Tile_X0Y0_FrameData_O[17] VPWR VGND sg13cmos5l_antennanp
X_5819_ _5819_/Q Tile_X0Y0_FrameData[7] Tile_X0Y1_FrameStrobe[7] VPWR VGND sg13cmos5l_dlhq_1
X_6799_ Tile_X0Y1_S4BEG[12] _6799_/A VPWR VGND sg13cmos5l_buf_1
XFILLER_1_245 VPWR VGND sg13cmos5l_fill_2
XFILLER_2_18 VPWR VGND sg13cmos5l_fill_1
XANTENNA__6726__X Tile_X0Y1_EE4BEG[7] VPWR VGND sg13cmos5l_antennanp
X_4150_ _4241_/A _4148_/A _4148_/B _4149_/Y VPWR VGND sg13cmos5l_a21o_1
X_3101_ _3101_/X _4509_/Y _3916_/Y _5390_/B _5422_/B _6143_/Q _6142_/Q VPWR VGND sg13cmos5l_mux4_1
X_4081_ _4083_/B _4081_/A _4081_/B VPWR VGND sg13cmos5l_xnor2_1
XANTENNA__6636__X Tile_X0Y0_NN4BEG[14] VPWR VGND sg13cmos5l_antennanp
X_3032_ _3032_/X Tile_X0Y1_N1END[1] Tile_X0Y1_N2END[3] Tile_X0Y0_S2MID[3] Tile_X0Y0_S4END[7]
+ _6068_/Q _6066_/Q VPWR VGND sg13cmos5l_mux4_1
XFILLER_63_263 VPWR VGND sg13cmos5l_fill_2
X_4983_ _4984_/B _4940_/Y _4934_/Y _4943_/Y _5011_/X _5670_/Q _5668_/Q VPWR VGND sg13cmos5l_mux4_1
X_6722_ Tile_X0Y1_EE4BEG[3] Tile_X0Y1_EE4END[7] VPWR VGND sg13cmos5l_buf_1
X_3934_ _6494_/A _3934_/A VPWR VGND sg13cmos5l_inv_1
X_6653_ Tile_X0Y0_W2BEGb[2] Tile_X0Y0_W2MID[2] VPWR VGND sg13cmos5l_buf_1
X_3865_ _3866_/B _6296_/Q _3864_/A _6295_/Q VPWR VGND sg13cmos5l_o21ai_1
X_5604_ _5604_/Q Tile_X0Y0_FrameData[30] Tile_X0Y1_FrameStrobe[1] VPWR VGND sg13cmos5l_dlhq_1
X_2816_ _2816_/Y _6302_/Q VPWR VGND sg13cmos5l_inv_1
X_6584_ Tile_X0Y0_FrameStrobe_O[18] Tile_X0Y1_FrameStrobe[18] VPWR VGND sg13cmos5l_buf_1
X_3796_ _3796_/X Tile_X0Y1_EE4END[3] _6022_/Q VPWR VGND sg13cmos5l_or2_1
X_5535_ _5555_/D _5551_/A _5535_/B VPWR VGND sg13cmos5l_nor2_1
X_2747_ _2747_/Y Tile_X0Y0_W1END[3] VPWR VGND sg13cmos5l_inv_1
X_5466_ _5466_/Y _2803_/Y _3430_/X _6326_/Q VPWR VGND sg13cmos5l_o21ai_1
X_4417_ _4417_/X _6079_/Q _4417_/B VPWR VGND sg13cmos5l_or2_1
X_5397_ _6801_/A Tile_X0Y0_S2MID[0] Tile_X0Y1_W6END[1] Tile_X0Y0_S4END[7] _4503_/Y
+ _6353_/Q _6354_/Q VPWR VGND sg13cmos5l_mux4_1
X_4348_ _4348_/X Tile_X0Y1_N2END[3] Tile_X0Y1_E2END[3] Tile_X0Y0_SS4END[4] Tile_X0Y1_W2END[3]
+ _6178_/Q _6177_/Q VPWR VGND sg13cmos5l_mux4_1
X_4279_ _4304_/A _6425_/Q _5559_/Q VPWR VGND sg13cmos5l_nand2_1
XANTENNA__6546__X Tile_X0Y0_FrameData_O[12] VPWR VGND sg13cmos5l_antennanp
X_6018_ _6018_/Q Tile_X0Y1_FrameData[26] Tile_X0Y1_FrameStrobe[0] VPWR VGND sg13cmos5l_dlhq_1
XFILLER_10_344 VPWR VGND sg13cmos5l_decap_8
XFILLER_96_119 VPWR VGND sg13cmos5l_fill_2
XANTENNA_240 Tile_X0Y0_S4END[5] VPWR VGND sg13cmos5l_antennanp
XANTENNA_251 Tile_X0Y0_W2MID[4] VPWR VGND sg13cmos5l_antennanp
XANTENNA_262 Tile_X0Y1_FrameData[29] VPWR VGND sg13cmos5l_antennanp
X_3650_ _3651_/B _6223_/Q _3646_/Y _3649_/Y VPWR VGND sg13cmos5l_a21oi_1
X_3581_ _3581_/Y _6265_/Q _3580_/Y _6308_/Q VPWR VGND sg13cmos5l_a21oi_1
X_5320_ _5321_/B _6382_/Q _5319_/Y _6381_/Q VPWR VGND sg13cmos5l_o21ai_1
X_5251_ _6669_/A _5248_/Y _5250_/Y _5242_/Y VPWR VGND sg13cmos5l_o21ai_1
X_4202_ _4709_/B _5985_/D _5985_/Q _6428_/Q VPWR VGND sg13cmos5l_mux2_1
X_5182_ _5183_/B _5180_/Y _5181_/Y _5896_/Q VPWR VGND sg13cmos5l_o21ai_1
X_4133_ _4133_/Y _4133_/A _5852_/Q VPWR VGND sg13cmos5l_nor2b_1
XFILLER_68_333 VPWR VGND sg13cmos5l_fill_1
X_4064_ _4064_/Y _5715_/Q _4064_/B _4064_/C VPWR VGND sg13cmos5l_nand3_1
X_3015_ _3019_/A _5596_/Q _2964_/Y _3014_/Y VPWR VGND sg13cmos5l_a21oi_1
XFILLER_83_358 VPWR VGND sg13cmos5l_decap_8
XFILLER_51_244 VPWR VGND sg13cmos5l_fill_2
X_6705_ Tile_X0Y1_E2BEGb[6] Tile_X0Y1_E2MID[6] VPWR VGND sg13cmos5l_buf_1
X_4966_ _4966_/Y _4999_/A _4849_/A _2766_/Y VPWR VGND sg13cmos5l_a21oi_1
X_4897_ _4897_/Y _5834_/Q _4896_/X _5833_/Q VPWR VGND sg13cmos5l_o21ai_1
X_3917_ _3917_/X _6426_/Q _6002_/D VPWR VGND sg13cmos5l_or2_1
XFILLER_51_299 VPWR VGND sg13cmos5l_fill_2
X_6636_ Tile_X0Y0_NN4BEG[14] _6636_/A VPWR VGND sg13cmos5l_buf_1
X_3848_ _5997_/D _3798_/Y _3800_/Y _3847_/Y VPWR VGND sg13cmos5l_o21ai_1
X_6567_ Tile_X0Y0_FrameStrobe_O[1] Tile_X0Y1_FrameStrobe[1] VPWR VGND sg13cmos5l_buf_1
X_3779_ _3779_/Y Tile_X0Y1_E2MID[6] _6252_/Q VPWR VGND sg13cmos5l_nand2b_1
X_5518_ _5518_/Y _5518_/A _5518_/B VPWR VGND sg13cmos5l_nor2_1
X_6498_ Tile_X0Y0_E2BEGb[0] Tile_X0Y0_E2MID[0] VPWR VGND sg13cmos5l_buf_1
X_5449_ _5449_/X _6336_/Q _3162_/Y _5448_/Y VPWR VGND sg13cmos5l_a21o_1
XFILLER_59_333 VPWR VGND sg13cmos5l_fill_2
XFILLER_103_84 VPWR VGND sg13cmos5l_fill_2
XFILLER_111_205 VPWR VGND sg13cmos5l_decap_8
XFILLER_80_339 VPWR VGND sg13cmos5l_decap_4
X_4820_ _6008_/D _4794_/Y _4795_/Y _4819_/X VPWR VGND sg13cmos5l_o21ai_1
XFILLER_33_233 VPWR VGND sg13cmos5l_fill_1
X_4751_ _4751_/Y _4877_/B _5006_/A VPWR VGND sg13cmos5l_nor2b_1
X_4682_ _4710_/A _4683_/A _4708_/A VPWR VGND sg13cmos5l_nor2_1
X_3702_ _3703_/C _6040_/Q Tile_X0Y1_W6END[1] VPWR VGND sg13cmos5l_nand2b_1
X_6421_ _6421_/Q Tile_X0Y1_FrameData[7] Tile_X0Y1_FrameStrobe[12] VPWR VGND sg13cmos5l_dlhq_1
X_3633_ _3767_/B _4188_/A _4216_/A VPWR VGND sg13cmos5l_nor2_1
X_6352_ _6352_/Q Tile_X0Y1_FrameData[12] Tile_X0Y1_FrameStrobe[10] VPWR VGND sg13cmos5l_dlhq_1
X_3564_ _3564_/Y _3557_/Y _3558_/Y _3562_/Y _3563_/Y _6125_/Q VPWR VGND sg13cmos5l_a221oi_1
XFILLER_52_0 VPWR VGND sg13cmos5l_fill_2
X_6283_ _6283_/Q Tile_X0Y1_FrameData[17] Tile_X0Y1_FrameStrobe[8] VPWR VGND sg13cmos5l_dlhq_1
X_5303_ _6690_/A _5374_/B _3715_/B _6600_/A _3031_/X _6388_/Q _6387_/Q VPWR VGND sg13cmos5l_mux4_1
X_3495_ _3495_/Y _5641_/Q _3495_/B VPWR VGND sg13cmos5l_nand2b_1
X_5234_ _5234_/Y _5874_/Q _5230_/Y _5233_/Y VPWR VGND sg13cmos5l_o21ai_1
X_5165_ _6811_/A _5161_/Y _5164_/Y _5159_/Y VPWR VGND sg13cmos5l_a21oi_1
XFILLER_102_249 VPWR VGND sg13cmos5l_fill_2
X_4116_ _4116_/Y _5589_/Q _4115_/Y _5852_/Q VPWR VGND sg13cmos5l_o21ai_1
XFILLER_68_152 VPWR VGND sg13cmos5l_fill_2
X_5096_ _5096_/Y _5946_/Q _4943_/Y _5095_/Y VPWR VGND sg13cmos5l_o21ai_1
XFILLER_68_196 VPWR VGND sg13cmos5l_decap_8
X_4047_ _4048_/B Tile_X0Y0_S2MID[6] _5826_/Q VPWR VGND sg13cmos5l_nand2b_1
XANTENNA__6824__X Tile_X0Y1_W2BEG[0] VPWR VGND sg13cmos5l_antennanp
X_5998_ _5998_/Q Tile_X0Y1_UserCLK _5998_/D _6452_/L_HI VPWR VGND sg13cmos5l_dfrbpq_1
X_4949_ _4949_/Y _2727_/Y _5606_/Q _5605_/Q VPWR VGND sg13cmos5l_a21oi_1
XFILLER_24_288 VPWR VGND sg13cmos5l_fill_2
X_6619_ Tile_X0Y0_N4BEG[13] _6619_/A VPWR VGND sg13cmos5l_buf_1
XFILLER_47_325 VPWR VGND sg13cmos5l_fill_1
XFILLER_74_155 VPWR VGND sg13cmos5l_fill_2
XANTENNA__6734__X Tile_X0Y1_EE4BEG[15] VPWR VGND sg13cmos5l_antennanp
XFILLER_74_76 VPWR VGND sg13cmos5l_fill_1
X_3280_ _3280_/X _3279_/B _5455_/B _3279_/Y VPWR VGND sg13cmos5l_a21o_1
XANTENNA__6644__X Tile_X0Y0_W2BEG[1] VPWR VGND sg13cmos5l_antennanp
X_5921_ _5921_/Q Tile_X0Y0_FrameData[1] Tile_X0Y1_FrameStrobe[10] VPWR VGND sg13cmos5l_dlhq_1
XFILLER_46_380 VPWR VGND sg13cmos5l_fill_1
X_5852_ _5852_/Q Tile_X0Y0_FrameData[6] Tile_X0Y1_FrameStrobe[8] VPWR VGND sg13cmos5l_dlhq_1
X_5783_ _5783_/Q Tile_X0Y0_FrameData[11] Tile_X0Y1_FrameStrobe[6] VPWR VGND sg13cmos5l_dlhq_1
X_4803_ _4803_/Y _5705_/Q _4803_/B VPWR VGND sg13cmos5l_nand2b_1
X_4734_ _4735_/B Tile_X0Y1_NN4END[5] Tile_X0Y0_S2END[5] Tile_X0Y0_E2END[5] Tile_X0Y0_W2END[5]
+ _5733_/Q _5734_/Q VPWR VGND sg13cmos5l_mux4_1
X_2995_ _2995_/X _4515_/Y _4503_/Y _5390_/B _5374_/B _6168_/Q _6166_/Q VPWR VGND sg13cmos5l_mux4_1
X_4665_ _4665_/X Tile_X0Y1_N2MID[5] Tile_X0Y0_E2END[5] Tile_X0Y0_SS4END[1] Tile_X0Y0_W2END[5]
+ _5742_/Q _5741_/Q VPWR VGND sg13cmos5l_mux4_1
X_6404_ _6404_/Q Tile_X0Y1_FrameData[24] Tile_X0Y1_FrameStrobe[12] VPWR VGND sg13cmos5l_dlhq_1
X_4596_ _4614_/A _4588_/A _4588_/B _4586_/Y VPWR VGND sg13cmos5l_a21o_1
X_3616_ _3616_/Y _3616_/A _3616_/B VPWR VGND sg13cmos5l_nor2_1
X_6335_ _6335_/Q Tile_X0Y1_FrameData[29] Tile_X0Y1_FrameStrobe[10] VPWR VGND sg13cmos5l_dlhq_1
X_3547_ _3547_/Y _5657_/Q _3547_/B VPWR VGND sg13cmos5l_nand2b_1
XANTENNA__6819__X Tile_X0Y1_UserCLKo VPWR VGND sg13cmos5l_antennanp
X_6266_ _6266_/Q Tile_X0Y1_FrameData[2] Tile_X0Y1_FrameStrobe[7] VPWR VGND sg13cmos5l_dlhq_1
X_3478_ _3478_/Y _2849_/Y _3477_/X _6300_/Q VPWR VGND sg13cmos5l_a21oi_1
X_6197_ _6197_/Q Tile_X0Y1_FrameData[7] Tile_X0Y1_FrameStrobe[5] VPWR VGND sg13cmos5l_dlhq_1
X_5217_ _5217_/Y _2729_/Y _5878_/Q _5877_/Q VPWR VGND sg13cmos5l_a21oi_1
X_5148_ _5148_/Y _5923_/Q _5146_/X _5147_/Y VPWR VGND sg13cmos5l_a21oi_1
X_5079_ _5082_/B _5728_/Q _4911_/X _5078_/Y VPWR VGND sg13cmos5l_o21ai_1
XANTENNA__6554__X Tile_X0Y0_FrameData_O[20] VPWR VGND sg13cmos5l_antennanp
XFILLER_109_72 VPWR VGND sg13cmos5l_fill_2
XANTENNA__6729__X Tile_X0Y1_EE4BEG[10] VPWR VGND sg13cmos5l_antennanp
XFILLER_69_43 VPWR VGND sg13cmos5l_fill_1
XFILLER_106_363 VPWR VGND sg13cmos5l_fill_2
XFILLER_35_306 VPWR VGND sg13cmos5l_fill_1
X_2780_ _2780_/Y _5898_/Q VPWR VGND sg13cmos5l_inv_1
X_4450_ _4450_/Y _4445_/Y _4446_/Y _4449_/Y VPWR VGND sg13cmos5l_a21oi_1
X_4381_ _4382_/B _4381_/A _4381_/B VPWR VGND sg13cmos5l_xnor2_1
X_3401_ _3402_/A _3399_/Y _3400_/Y _6123_/Q VPWR VGND sg13cmos5l_o21ai_1
X_6120_ _6120_/Q Tile_X0Y1_FrameData[20] Tile_X0Y1_FrameStrobe[3] VPWR VGND sg13cmos5l_dlhq_1
X_3332_ _3332_/Y _6114_/Q _3330_/X _6115_/Q VPWR VGND sg13cmos5l_o21ai_1
XANTENNA__6639__X Tile_X0Y0_W1BEG[0] VPWR VGND sg13cmos5l_antennanp
X_6051_ _6051_/Q Tile_X0Y1_FrameData[25] Tile_X0Y1_FrameStrobe[1] VPWR VGND sg13cmos5l_dlhq_1
X_3263_ _3263_/Y _6158_/Q _3262_/Y _6159_/Q VPWR VGND sg13cmos5l_o21ai_1
X_5002_ _6013_/D _4947_/Y _4967_/Y _4982_/Y _5001_/Y VPWR VGND sg13cmos5l_a22oi_1
X_3194_ _3194_/Y Tile_X0Y1_N4END[4] _3195_/B _5686_/Q VPWR VGND sg13cmos5l_a21oi_1
XFILLER_15_0 VPWR VGND sg13cmos5l_fill_2
X_5904_ _5904_/Q Tile_X0Y0_FrameData[18] Tile_X0Y1_FrameStrobe[10] VPWR VGND sg13cmos5l_dlhq_1
X_5835_ _5835_/Q Tile_X0Y0_FrameData[23] Tile_X0Y1_FrameStrobe[8] VPWR VGND sg13cmos5l_dlhq_1
X_5766_ _5766_/Q Tile_X0Y0_FrameData[28] Tile_X0Y1_FrameStrobe[6] VPWR VGND sg13cmos5l_dlhq_1
X_2978_ _2978_/Y _6172_/Q _2975_/Y _2977_/Y VPWR VGND sg13cmos5l_a21oi_1
X_5697_ _5697_/Q Tile_X0Y0_FrameData[1] Tile_X0Y1_FrameStrobe[3] VPWR VGND sg13cmos5l_dlhq_1
X_4717_ _4866_/A _4865_/A _4865_/B _4865_/C VPWR VGND sg13cmos5l_a21oi_1
X_4648_ _6595_/A _4648_/A VPWR VGND sg13cmos5l_inv_1
X_4579_ _4581_/B _4602_/A _4709_/A VPWR VGND sg13cmos5l_nor2b_1
XANTENNA__6549__X Tile_X0Y0_FrameData_O[15] VPWR VGND sg13cmos5l_antennanp
X_6318_ _6318_/Q Tile_X0Y1_FrameData[14] Tile_X0Y1_FrameStrobe[9] VPWR VGND sg13cmos5l_dlhq_1
X_6249_ _6249_/Q Tile_X0Y1_FrameData[19] Tile_X0Y1_FrameStrobe[7] VPWR VGND sg13cmos5l_dlhq_1
XFILLER_103_377 VPWR VGND sg13cmos5l_decap_4
XFILLER_76_239 VPWR VGND sg13cmos5l_fill_2
XFILLER_55_67 VPWR VGND sg13cmos5l_fill_2
XFILLER_55_89 VPWR VGND sg13cmos5l_fill_1
X_3950_ _4139_/A _4138_/A _4681_/A VPWR VGND sg13cmos5l_nand2_1
X_2901_ _2901_/Y _5660_/Q _2901_/B VPWR VGND sg13cmos5l_nand2b_1
X_3881_ _3881_/Y _6070_/Q _2888_/Y _3880_/Y VPWR VGND sg13cmos5l_o21ai_1
XFILLER_31_353 VPWR VGND sg13cmos5l_fill_1
X_5620_ _5620_/Q Tile_X0Y0_FrameData[14] Tile_X0Y1_FrameStrobe[1] VPWR VGND sg13cmos5l_dlhq_1
X_2832_ _2832_/Y Tile_X0Y0_W2END[0] VPWR VGND sg13cmos5l_inv_1
X_5551_ _5571_/D _5551_/A _5551_/B VPWR VGND sg13cmos5l_nor2_1
X_2763_ _2763_/Y _5668_/Q VPWR VGND sg13cmos5l_inv_1
X_4502_ _4502_/Y _6423_/Q _5554_/Q VPWR VGND sg13cmos5l_nand2_1
X_5482_ _5482_/Y _6322_/Q _5482_/B VPWR VGND sg13cmos5l_nor2_1
X_4433_ _4433_/Y _6112_/Q _4515_/Y _4432_/Y VPWR VGND sg13cmos5l_o21ai_1
XFILLER_6_72 VPWR VGND sg13cmos5l_decap_4
X_4364_ _4364_/Y _2826_/Y _6212_/Q _6211_/Q VPWR VGND sg13cmos5l_a21oi_1
X_6103_ _6103_/Q Tile_X0Y1_FrameData[5] Tile_X0Y1_FrameStrobe[2] VPWR VGND sg13cmos5l_dlhq_1
X_4295_ _4295_/Y _6206_/Q _2915_/A _4294_/Y VPWR VGND sg13cmos5l_o21ai_1
X_3315_ _3315_/Y _5726_/Q _3312_/X _5725_/Q VPWR VGND sg13cmos5l_a21oi_1
X_6034_ _6034_/Q Tile_X0Y1_FrameData[10] Tile_X0Y1_FrameStrobe[0] VPWR VGND sg13cmos5l_dlhq_1
X_3246_ _3246_/Y Tile_X0Y1_N2MID[2] _5694_/Q VPWR VGND sg13cmos5l_nand2b_1
XFILLER_100_358 VPWR VGND sg13cmos5l_fill_2
X_3177_ _3177_/Y _5689_/Q _3173_/X _3176_/Y VPWR VGND sg13cmos5l_o21ai_1
XANTENNA__6832__X Tile_X0Y1_W2BEGb[0] VPWR VGND sg13cmos5l_antennanp
X_6867_ Tile_X0Y1_WW4BEG[15] _6867_/A VPWR VGND sg13cmos5l_buf_1
X_5818_ _5818_/Q Tile_X0Y0_FrameData[8] Tile_X0Y1_FrameStrobe[7] VPWR VGND sg13cmos5l_dlhq_1
X_6798_ Tile_X0Y1_S4BEG[11] _6798_/A VPWR VGND sg13cmos5l_buf_1
X_5749_ _5749_/Q Tile_X0Y0_FrameData[13] Tile_X0Y1_FrameStrobe[5] VPWR VGND sg13cmos5l_dlhq_1
XFILLER_1_202 VPWR VGND sg13cmos5l_fill_2
XFILLER_103_141 VPWR VGND sg13cmos5l_fill_1
XANTENNA__6742__X Tile_X0Y1_FrameData_O[7] VPWR VGND sg13cmos5l_antennanp
X_3100_ _3100_/X _4515_/Y _4503_/Y _4518_/Y _5374_/B _6143_/Q _6142_/Q VPWR VGND sg13cmos5l_mux4_1
X_4080_ _4147_/A _4081_/A _4081_/B VPWR VGND sg13cmos5l_nand2_1
X_3031_ _3031_/X Tile_X0Y1_NN4END[3] Tile_X0Y0_S4END[7] Tile_X0Y1_WW4END[0] _6599_/A
+ _6044_/Q _6043_/Q VPWR VGND sg13cmos5l_mux4_1
XFILLER_95_378 VPWR VGND sg13cmos5l_fill_2
X_4982_ _4982_/Y _4999_/A _6597_/A _4981_/Y VPWR VGND sg13cmos5l_o21ai_1
XANTENNA__6652__X Tile_X0Y0_W2BEGb[1] VPWR VGND sg13cmos5l_antennanp
X_6721_ Tile_X0Y1_EE4BEG[2] Tile_X0Y1_EE4END[6] VPWR VGND sg13cmos5l_buf_1
X_3933_ _3934_/A _3933_/A _3932_/Y VPWR VGND sg13cmos5l_nor2b_1
X_6652_ Tile_X0Y0_W2BEGb[1] Tile_X0Y0_W2MID[1] VPWR VGND sg13cmos5l_buf_1
X_3864_ _3864_/Y _3864_/A VPWR VGND sg13cmos5l_inv_1
X_5603_ _5603_/Q Tile_X0Y0_FrameData[31] Tile_X0Y1_FrameStrobe[1] VPWR VGND sg13cmos5l_dlhq_1
X_2815_ _2815_/Y _5995_/Q VPWR VGND sg13cmos5l_inv_1
X_6583_ Tile_X0Y0_FrameStrobe_O[17] Tile_X0Y1_FrameStrobe[17] VPWR VGND sg13cmos5l_buf_1
X_3795_ _3795_/X Tile_X0Y1_WW4END[1] _2952_/A _6022_/Q VPWR VGND sg13cmos5l_mux2_1
X_5534_ _5554_/D _5551_/A _5534_/B VPWR VGND sg13cmos5l_nor2_1
X_2746_ _2746_/Y Tile_X0Y0_W1END[1] VPWR VGND sg13cmos5l_inv_1
X_5465_ _6864_/A _5461_/Y _5464_/Y _5459_/Y VPWR VGND sg13cmos5l_a21oi_1
X_4416_ _4417_/B _4515_/Y _4509_/Y _4518_/Y _5390_/B _6080_/Q _6078_/Q VPWR VGND sg13cmos5l_mux4_1
X_5396_ _6800_/A Tile_X0Y1_E6END[0] Tile_X0Y0_S4END[6] Tile_X0Y0_S2MID[3] _4509_/Y
+ _6355_/Q _6356_/Q VPWR VGND sg13cmos5l_mux4_1
X_4347_ _4347_/Y _4347_/A _4347_/B VPWR VGND sg13cmos5l_nor2_1
XANTENNA__6827__X Tile_X0Y1_W2BEG[3] VPWR VGND sg13cmos5l_antennanp
X_4278_ _4278_/Y _4392_/A _4392_/B VPWR VGND sg13cmos5l_nor2_1
X_6017_ _6017_/Q Tile_X0Y1_FrameData[27] Tile_X0Y1_FrameStrobe[0] VPWR VGND sg13cmos5l_dlhq_1
X_3229_ _3229_/X _4707_/Y _4909_/X _4911_/X _5062_/B _5616_/Q _5618_/Q VPWR VGND sg13cmos5l_mux4_1
XANTENNA__6562__X Tile_X0Y0_FrameData_O[28] VPWR VGND sg13cmos5l_antennanp
XFILLER_6_349 VPWR VGND sg13cmos5l_decap_8
XFILLER_77_10 VPWR VGND sg13cmos5l_fill_1
XFILLER_89_183 VPWR VGND sg13cmos5l_fill_2
XFILLER_77_301 VPWR VGND sg13cmos5l_fill_1
XANTENNA__6737__X Tile_X0Y1_FrameData_O[2] VPWR VGND sg13cmos5l_antennanp
XFILLER_77_345 VPWR VGND sg13cmos5l_fill_1
XANTENNA_230 Tile_X0Y0_S4END[4] VPWR VGND sg13cmos5l_antennanp
XANTENNA_241 Tile_X0Y0_S4END[5] VPWR VGND sg13cmos5l_antennanp
XANTENNA_252 Tile_X0Y0_W2MID[4] VPWR VGND sg13cmos5l_antennanp
XANTENNA_263 Tile_X0Y1_FrameData[29] VPWR VGND sg13cmos5l_antennanp
X_3580_ _3580_/Y _6266_/Q _6694_/A _3579_/Y VPWR VGND sg13cmos5l_a21oi_1
X_5250_ _5250_/Y _5870_/Q _5249_/X _5869_/Q VPWR VGND sg13cmos5l_o21ai_1
X_4201_ _4210_/A _4201_/A _4201_/B VPWR VGND sg13cmos5l_xnor2_1
X_5181_ _5181_/Y _2780_/Y _4181_/X _5897_/Q VPWR VGND sg13cmos5l_o21ai_1
XANTENNA__6647__X Tile_X0Y0_W2BEG[4] VPWR VGND sg13cmos5l_antennanp
X_4132_ _4133_/A _2742_/Y _5782_/Q _4131_/Y VPWR VGND sg13cmos5l_a21oi_1
X_4063_ _4064_/C _5718_/Q _4059_/Y _4062_/Y VPWR VGND sg13cmos5l_a21o_1
X_3014_ _3014_/Y _5596_/Q Tile_X0Y0_S4END[0] _5595_/Q VPWR VGND sg13cmos5l_o21ai_1
X_4965_ _4965_/Y _4964_/Y _4965_/B VPWR VGND sg13cmos5l_nand2b_1
X_6704_ Tile_X0Y1_E2BEGb[5] Tile_X0Y1_E2MID[5] VPWR VGND sg13cmos5l_buf_1
X_3916_ _3916_/Y _6423_/Q _5535_/B _3915_/Y VPWR VGND sg13cmos5l_o21ai_1
X_4896_ _4896_/X Tile_X0Y1_N2MID[1] Tile_X0Y0_S2END[1] Tile_X0Y0_EE4END[3] Tile_X0Y0_W2END[1]
+ _5731_/Q _5732_/Q VPWR VGND sg13cmos5l_mux4_1
X_6635_ Tile_X0Y0_NN4BEG[13] _6635_/A VPWR VGND sg13cmos5l_buf_1
X_3847_ _3847_/Y _6287_/Q _3847_/B VPWR VGND sg13cmos5l_nand2b_1
X_6566_ Tile_X0Y0_FrameStrobe_O[0] Tile_X0Y1_FrameStrobe[0] VPWR VGND sg13cmos5l_buf_1
X_3778_ _3778_/Y _6252_/Q _4737_/B _3777_/Y VPWR VGND sg13cmos5l_a21oi_1
X_5517_ _5518_/B _3714_/Y _3643_/A _3458_/A _5420_/B _6314_/Q _6313_/Q VPWR VGND sg13cmos5l_mux4_1
X_2729_ _2729_/Y Tile_X0Y0_S1END[0] VPWR VGND sg13cmos5l_inv_1
X_6497_ Tile_X0Y0_E2BEG[7] _6497_/A VPWR VGND sg13cmos5l_buf_1
X_5448_ _5448_/Y _6336_/Q _6771_/A _6335_/Q VPWR VGND sg13cmos5l_o21ai_1
X_5379_ _5386_/B _6140_/Q _5377_/Y _5378_/Y VPWR VGND sg13cmos5l_o21ai_1
XANTENNA__6557__X Tile_X0Y0_FrameData_O[23] VPWR VGND sg13cmos5l_antennanp
XFILLER_42_234 VPWR VGND sg13cmos5l_fill_2
XFILLER_42_289 VPWR VGND sg13cmos5l_fill_2
XFILLER_2_341 VPWR VGND sg13cmos5l_decap_8
XFILLER_80_307 VPWR VGND sg13cmos5l_fill_1
X_4750_ _4877_/B _6425_/Q _5568_/Q _4748_/X _4749_/Y VPWR VGND sg13cmos5l_a22oi_1
X_4681_ _4687_/A _4681_/A _4709_/B VPWR VGND sg13cmos5l_nand2_1
X_3701_ _3703_/B _6040_/Q _6772_/A VPWR VGND sg13cmos5l_nand2_1
X_6420_ _6420_/Q Tile_X0Y1_FrameData[8] Tile_X0Y1_FrameStrobe[12] VPWR VGND sg13cmos5l_dlhq_1
X_3632_ _4216_/A _3631_/A _2829_/Y _6427_/Q VPWR VGND sg13cmos5l_mux2_1
X_6351_ _6351_/Q Tile_X0Y1_FrameData[13] Tile_X0Y1_FrameStrobe[10] VPWR VGND sg13cmos5l_dlhq_1
X_5302_ _6689_/A _5390_/B _6599_/A _5342_/B _4284_/Y _6389_/Q _6390_/Q VPWR VGND sg13cmos5l_mux4_1
X_3563_ _3563_/Y _3563_/A _6127_/Q VPWR VGND sg13cmos5l_nor2b_1
X_6282_ _6282_/Q Tile_X0Y1_FrameData[18] Tile_X0Y1_FrameStrobe[8] VPWR VGND sg13cmos5l_dlhq_1
X_3494_ _3495_/B _3063_/X Tile_X0Y0_S1END[3] Tile_X0Y1_N2MID[7] Tile_X0Y0_S2END[7]
+ _5640_/Q _5642_/Q VPWR VGND sg13cmos5l_mux4_1
X_5233_ _5233_/Y _5233_/A _5873_/Q VPWR VGND sg13cmos5l_nor2b_1
X_5164_ _5164_/Y _5164_/A _5902_/Q VPWR VGND sg13cmos5l_nor2b_1
X_4115_ _4115_/Y Tile_X0Y0_EE4END[1] _5590_/Q _4114_/Y VPWR VGND sg13cmos5l_a21oi_1
X_5095_ _5095_/Y _5946_/Q _5191_/B VPWR VGND sg13cmos5l_nand2_1
XFILLER_110_283 VPWR VGND sg13cmos5l_fill_2
X_4046_ _4046_/Y _5826_/Q _4046_/B _4046_/C VPWR VGND sg13cmos5l_nor3_1
X_5997_ _5997_/Q Tile_X0Y1_UserCLK _5997_/D _6451_/L_HI VPWR VGND sg13cmos5l_dfrbpq_1
X_4948_ _4948_/X _5058_/B Tile_X0Y0_E1END[0] Tile_X0Y1_N2MID[0] Tile_X0Y0_E2END[0]
+ _5605_/Q _5606_/Q VPWR VGND sg13cmos5l_mux4_1
XANTENNA__6840__X Tile_X0Y1_W6BEG[0] VPWR VGND sg13cmos5l_antennanp
X_4879_ _4905_/B _6425_/Q _5569_/Q VPWR VGND sg13cmos5l_and2_1
X_6618_ Tile_X0Y0_N4BEG[12] _6618_/A VPWR VGND sg13cmos5l_buf_1
X_6549_ Tile_X0Y0_FrameData_O[15] Tile_X0Y0_FrameData[15] VPWR VGND sg13cmos5l_buf_1
XFILLER_59_175 VPWR VGND sg13cmos5l_fill_2
XFILLER_101_283 VPWR VGND sg13cmos5l_decap_4
XANTENNA__6750__X Tile_X0Y1_FrameData_O[15] VPWR VGND sg13cmos5l_antennanp
XFILLER_90_87 VPWR VGND sg13cmos5l_fill_1
XFILLER_38_337 VPWR VGND sg13cmos5l_fill_1
X_5920_ _5920_/Q Tile_X0Y0_FrameData[2] Tile_X0Y1_FrameStrobe[10] VPWR VGND sg13cmos5l_dlhq_1
XFILLER_0_96 VPWR VGND sg13cmos5l_decap_4
XFILLER_0_63 VPWR VGND sg13cmos5l_decap_8
X_5851_ _5851_/Q Tile_X0Y0_FrameData[7] Tile_X0Y1_FrameStrobe[8] VPWR VGND sg13cmos5l_dlhq_1
X_5782_ _5782_/Q Tile_X0Y0_FrameData[12] Tile_X0Y1_FrameStrobe[6] VPWR VGND sg13cmos5l_dlhq_1
X_4802_ _4803_/B _3063_/X Tile_X0Y0_S1END[3] Tile_X0Y1_N2MID[7] Tile_X0Y0_S2END[7]
+ _5704_/Q _5706_/Q VPWR VGND sg13cmos5l_mux4_1
X_2994_ _2994_/X _6598_/A Tile_X0Y0_E2MID[0] Tile_X0Y0_S2MID[0] _2993_/Y _5820_/Q
+ _5819_/Q VPWR VGND sg13cmos5l_mux4_1
XANTENNA__6660__X Tile_X0Y0_W6BEG[1] VPWR VGND sg13cmos5l_antennanp
X_4733_ _4733_/Y _5573_/Q _4732_/Y _5836_/Q VPWR VGND sg13cmos5l_o21ai_1
XFILLER_21_259 VPWR VGND sg13cmos5l_fill_1
X_6403_ _6403_/Q Tile_X0Y1_FrameData[25] Tile_X0Y1_FrameStrobe[12] VPWR VGND sg13cmos5l_dlhq_1
X_4664_ _4679_/A _6425_/Q _5564_/Q VPWR VGND sg13cmos5l_nand2_1
X_4595_ _4617_/A _4657_/A _4593_/Y _4594_/A VPWR VGND sg13cmos5l_a21oi_1
X_3615_ _3616_/B _6302_/Q _3614_/A _6301_/Q VPWR VGND sg13cmos5l_o21ai_1
X_6334_ _6334_/Q Tile_X0Y1_FrameData[30] Tile_X0Y1_FrameStrobe[10] VPWR VGND sg13cmos5l_dlhq_1
X_3546_ _3547_/B Tile_X0Y1_NN4END[7] Tile_X0Y0_E1END[1] Tile_X0Y0_S2END[3] Tile_X0Y0_S4END[3]
+ _5658_/Q _5656_/Q VPWR VGND sg13cmos5l_mux4_1
X_6265_ _6265_/Q Tile_X0Y1_FrameData[3] Tile_X0Y1_FrameStrobe[7] VPWR VGND sg13cmos5l_dlhq_1
X_5216_ _6684_/A _5216_/A _5216_/B VPWR VGND sg13cmos5l_nor2_1
X_3477_ _3477_/X Tile_X0Y1_N2MID[2] Tile_X0Y1_E2MID[2] _6258_/Q VPWR VGND sg13cmos5l_mux2_1
X_6196_ _6196_/Q Tile_X0Y1_FrameData[8] Tile_X0Y1_FrameStrobe[5] VPWR VGND sg13cmos5l_dlhq_1
X_5147_ _5147_/Y _5923_/Q _5145_/X VPWR VGND sg13cmos5l_nor2b_1
XFILLER_56_101 VPWR VGND sg13cmos5l_decap_4
XANTENNA__6835__X Tile_X0Y1_W2BEGb[3] VPWR VGND sg13cmos5l_antennanp
X_5078_ _5078_/Y _5728_/Q _2890_/Y _5730_/Q VPWR VGND sg13cmos5l_a21oi_1
XFILLER_56_134 VPWR VGND sg13cmos5l_fill_1
X_4029_ _4030_/B _5862_/Q _4028_/X _5861_/Q VPWR VGND sg13cmos5l_o21ai_1
XFILLER_44_329 VPWR VGND sg13cmos5l_fill_2
XFILLER_71_126 VPWR VGND sg13cmos5l_fill_2
XFILLER_44_47 VPWR VGND sg13cmos5l_fill_1
XANTENNA__6570__X Tile_X0Y0_FrameStrobe_O[4] VPWR VGND sg13cmos5l_antennanp
XFILLER_12_259 VPWR VGND sg13cmos5l_fill_1
XFILLER_106_342 VPWR VGND sg13cmos5l_decap_8
XANTENNA__6745__X Tile_X0Y1_FrameData_O[10] VPWR VGND sg13cmos5l_antennanp
XFILLER_62_137 VPWR VGND sg13cmos5l_fill_2
X_4380_ _4382_/A _4380_/A _4380_/B VPWR VGND sg13cmos5l_nand2_1
X_3400_ _3400_/Y _6124_/Q _5262_/X _6122_/Q VPWR VGND sg13cmos5l_o21ai_1
X_3331_ _3331_/X _5262_/X _5422_/B _6116_/Q VPWR VGND sg13cmos5l_mux2_1
X_6050_ _6050_/Q Tile_X0Y1_FrameData[26] Tile_X0Y1_FrameStrobe[1] VPWR VGND sg13cmos5l_dlhq_1
X_3262_ _3262_/Y Tile_X0Y1_E2END[4] _6160_/Q _3261_/Y VPWR VGND sg13cmos5l_a21oi_1
X_5001_ _5001_/Y _5828_/Q _5000_/Y _5827_/Q VPWR VGND sg13cmos5l_a21oi_1
X_3193_ _3193_/Y Tile_X0Y0_W2END[4] _5684_/Q VPWR VGND sg13cmos5l_nand2_1
XANTENNA__6655__X Tile_X0Y0_W2BEGb[4] VPWR VGND sg13cmos5l_antennanp
XFILLER_93_262 VPWR VGND sg13cmos5l_fill_2
X_5903_ _5903_/Q Tile_X0Y0_FrameData[19] Tile_X0Y1_FrameStrobe[10] VPWR VGND sg13cmos5l_dlhq_1
X_5834_ _5834_/Q Tile_X0Y0_FrameData[24] Tile_X0Y1_FrameStrobe[8] VPWR VGND sg13cmos5l_dlhq_1
XFILLER_14_17 VPWR VGND sg13cmos5l_fill_1
X_5765_ _5765_/Q Tile_X0Y0_FrameData[29] Tile_X0Y1_FrameStrobe[6] VPWR VGND sg13cmos5l_dlhq_1
X_2977_ _2977_/Y _6172_/Q _2976_/X _6171_/Q VPWR VGND sg13cmos5l_o21ai_1
X_5696_ _5696_/Q Tile_X0Y0_FrameData[2] Tile_X0Y1_FrameStrobe[3] VPWR VGND sg13cmos5l_dlhq_1
X_4716_ _4865_/C _4722_/B _4716_/B VPWR VGND sg13cmos5l_xnor2_1
X_4647_ _4648_/A _5707_/Q _4637_/X _4646_/Y VPWR VGND sg13cmos5l_a21oi_1
XFILLER_107_139 VPWR VGND sg13cmos5l_fill_2
X_6317_ _6317_/Q Tile_X0Y1_FrameData[15] Tile_X0Y1_FrameStrobe[9] VPWR VGND sg13cmos5l_dlhq_1
X_4578_ _4603_/A _4602_/A _4708_/A VPWR VGND sg13cmos5l_nor2_1
X_3529_ _3529_/Y _6136_/Q _3526_/Y _6135_/Q VPWR VGND sg13cmos5l_a21oi_1
X_6248_ _6248_/Q Tile_X0Y1_FrameData[20] Tile_X0Y1_FrameStrobe[7] VPWR VGND sg13cmos5l_dlhq_1
X_6179_ _6179_/Q Tile_X0Y1_FrameData[25] Tile_X0Y1_FrameStrobe[5] VPWR VGND sg13cmos5l_dlhq_1
XANTENNA__6565__X Tile_X0Y0_FrameData_O[31] VPWR VGND sg13cmos5l_antennanp
XFILLER_55_57 VPWR VGND sg13cmos5l_fill_1
XFILLER_25_351 VPWR VGND sg13cmos5l_fill_2
XFILLER_52_170 VPWR VGND sg13cmos5l_decap_4
XFILLER_111_63 VPWR VGND sg13cmos5l_decap_4
XFILLER_111_96 VPWR VGND sg13cmos5l_decap_8
XFILLER_4_244 VPWR VGND sg13cmos5l_fill_2
XFILLER_29_80 VPWR VGND sg13cmos5l_fill_1
XFILLER_90_221 VPWR VGND sg13cmos5l_fill_2
X_2900_ _2901_/B Tile_X0Y0_EE4END[2] Tile_X0Y0_E6END[0] _5662_/Q VPWR VGND sg13cmos5l_mux2_1
XFILLER_90_298 VPWR VGND sg13cmos5l_fill_2
X_3880_ _3880_/Y _6070_/Q _5440_/B VPWR VGND sg13cmos5l_nand2_1
X_2831_ _2831_/Y Tile_X0Y1_NN4END[4] VPWR VGND sg13cmos5l_inv_1
X_5550_ _5570_/D _5551_/A _5550_/B VPWR VGND sg13cmos5l_nor2_1
X_2762_ _2762_/Y _6012_/Q VPWR VGND sg13cmos5l_inv_1
X_5481_ _5482_/B _6324_/Q _2888_/Y _5480_/Y VPWR VGND sg13cmos5l_a21oi_1
X_4501_ _5534_/B _4501_/A _4501_/B VPWR VGND sg13cmos5l_xor2_1
X_4432_ _4432_/Y _4509_/Y _6112_/Q VPWR VGND sg13cmos5l_nand2b_1
X_4363_ _4363_/Y _6212_/Q _6786_/A _4362_/Y VPWR VGND sg13cmos5l_o21ai_1
X_6102_ _6102_/Q Tile_X0Y1_FrameData[6] Tile_X0Y1_FrameStrobe[2] VPWR VGND sg13cmos5l_dlhq_1
X_4294_ _4294_/Y Tile_X0Y1_W2MID[1] _6206_/Q VPWR VGND sg13cmos5l_nand2_1
X_3314_ _3314_/Y _5724_/Q _5011_/X _3313_/Y VPWR VGND sg13cmos5l_a21oi_1
X_6033_ _6033_/Q Tile_X0Y1_FrameData[11] Tile_X0Y1_FrameStrobe[0] VPWR VGND sg13cmos5l_dlhq_1
X_3245_ _3245_/Y _3245_/A _3245_/B VPWR VGND sg13cmos5l_nor2_1
X_3176_ _3176_/Y _5688_/Q _3176_/B VPWR VGND sg13cmos5l_nor2_1
X_6866_ Tile_X0Y1_WW4BEG[14] _6866_/A VPWR VGND sg13cmos5l_buf_1
X_5817_ _5817_/Q Tile_X0Y0_FrameData[9] Tile_X0Y1_FrameStrobe[7] VPWR VGND sg13cmos5l_dlhq_1
X_6797_ Tile_X0Y1_S4BEG[10] _6797_/A VPWR VGND sg13cmos5l_buf_1
X_5748_ _5748_/Q Tile_X0Y0_FrameData[14] Tile_X0Y1_FrameStrobe[5] VPWR VGND sg13cmos5l_dlhq_1
X_5679_ _5679_/Q Tile_X0Y0_FrameData[19] Tile_X0Y1_FrameStrobe[3] VPWR VGND sg13cmos5l_dlhq_1
XFILLER_103_164 VPWR VGND sg13cmos5l_decap_4
XFILLER_13_354 VPWR VGND sg13cmos5l_decap_8
XFILLER_9_336 VPWR VGND sg13cmos5l_decap_4
XFILLER_9_369 VPWR VGND sg13cmos5l_fill_2
X_3030_ _3074_/A _3025_/Y _3028_/Y _3029_/Y VPWR VGND sg13cmos5l_a21oi_1
X_4981_ _4981_/Y _4999_/A _4648_/A _5828_/Q VPWR VGND sg13cmos5l_a21oi_1
X_6720_ Tile_X0Y1_EE4BEG[1] Tile_X0Y1_EE4END[5] VPWR VGND sg13cmos5l_buf_1
X_3932_ _3932_/Y _5680_/Q _3925_/X _3931_/Y VPWR VGND sg13cmos5l_o21ai_1
X_6651_ Tile_X0Y0_W2BEGb[0] Tile_X0Y0_W2MID[0] VPWR VGND sg13cmos5l_buf_1
X_3863_ _3864_/A Tile_X0Y1_N2END[0] Tile_X0Y1_EE4END[1] Tile_X0Y0_S2MID[0] Tile_X0Y1_W2END[0]
+ _6190_/Q _6189_/Q VPWR VGND sg13cmos5l_mux4_1
X_5602_ _5602_/Q Tile_X0Y0_FrameData[0] Tile_X0Y1_FrameStrobe[0] VPWR VGND sg13cmos5l_dlhq_1
X_6582_ Tile_X0Y0_FrameStrobe_O[16] Tile_X0Y1_FrameStrobe[16] VPWR VGND sg13cmos5l_buf_1
X_2814_ _2814_/Y Tile_X0Y1_E2MID[3] VPWR VGND sg13cmos5l_inv_1
X_5533_ _5553_/D _5551_/A _5533_/B VPWR VGND sg13cmos5l_nor2_1
X_3794_ _3914_/A _3792_/A _3792_/B _3793_/Y VPWR VGND sg13cmos5l_a21oi_1
X_2745_ _2745_/Y Tile_X0Y0_S4END[3] VPWR VGND sg13cmos5l_inv_1
XFILLER_8_380 VPWR VGND sg13cmos5l_fill_1
X_5464_ _5464_/Y _5464_/A _6328_/Q VPWR VGND sg13cmos5l_nor2b_1
X_5395_ _6799_/A Tile_X0Y1_E6END[1] Tile_X0Y0_S4END[5] Tile_X0Y0_S2MID[2] _4515_/Y
+ _6357_/Q _6358_/Q VPWR VGND sg13cmos5l_mux4_1
X_4415_ _4415_/Y _6275_/Q _6776_/A VPWR VGND sg13cmos5l_nor2_1
X_4346_ _4347_/B _6017_/Q _4345_/Y _6284_/Q VPWR VGND sg13cmos5l_o21ai_1
XFILLER_86_302 VPWR VGND sg13cmos5l_fill_2
X_4277_ _4392_/B _4277_/A _4277_/B VPWR VGND sg13cmos5l_xnor2_1
X_6016_ _6016_/Q Tile_X0Y1_FrameData[28] Tile_X0Y1_FrameStrobe[0] VPWR VGND sg13cmos5l_dlhq_1
X_3228_ _3228_/X _4940_/Y _4934_/Y _5011_/X _4937_/Y _5618_/Q _5616_/Q VPWR VGND sg13cmos5l_mux4_1
X_3159_ _3161_/B _6024_/Q _6774_/A VPWR VGND sg13cmos5l_nand2_1
XANTENNA__6843__X Tile_X0Y1_W6BEG[3] VPWR VGND sg13cmos5l_antennanp
XFILLER_54_276 VPWR VGND sg13cmos5l_fill_1
X_6849_ Tile_X0Y1_W6BEG[9] Tile_X0Y1_W6END[11] VPWR VGND sg13cmos5l_buf_1
XFILLER_52_69 VPWR VGND sg13cmos5l_fill_1
XFILLER_52_58 VPWR VGND sg13cmos5l_fill_1
XFILLER_108_212 VPWR VGND sg13cmos5l_fill_2
XFILLER_89_162 VPWR VGND sg13cmos5l_fill_1
XFILLER_77_335 VPWR VGND sg13cmos5l_fill_1
XANTENNA__6753__X Tile_X0Y1_FrameData_O[18] VPWR VGND sg13cmos5l_antennanp
XANTENNA_220 Tile_X0Y1_W2MID[7] VPWR VGND sg13cmos5l_antennanp
XANTENNA_231 Tile_X0Y0_S4END[4] VPWR VGND sg13cmos5l_antennanp
XANTENNA_242 Tile_X0Y0_S4END[5] VPWR VGND sg13cmos5l_antennanp
XANTENNA_253 Tile_X0Y0_W2END[7] VPWR VGND sg13cmos5l_antennanp
XANTENNA_264 Tile_X0Y1_FrameData[29] VPWR VGND sg13cmos5l_antennanp
XFILLER_5_350 VPWR VGND sg13cmos5l_decap_4
X_4200_ _4201_/B _4200_/A _4200_/B VPWR VGND sg13cmos5l_xor2_1
X_5180_ _5180_/Y _5898_/Q _5180_/B VPWR VGND sg13cmos5l_nor2_1
X_4131_ _4131_/Y Tile_X0Y0_S2MID[5] _5782_/Q _5781_/Q VPWR VGND sg13cmos5l_o21ai_1
X_4062_ _4062_/Y _5718_/Q _4061_/Y _5717_/Q VPWR VGND sg13cmos5l_o21ai_1
XFILLER_68_379 VPWR VGND sg13cmos5l_fill_2
X_3013_ _3013_/Y _5858_/Q _2994_/X _3012_/Y VPWR VGND sg13cmos5l_o21ai_1
XANTENNA__6663__X Tile_X0Y0_W6BEG[4] VPWR VGND sg13cmos5l_antennanp
XFILLER_51_213 VPWR VGND sg13cmos5l_fill_1
X_4964_ _4964_/Y _4962_/Y _4963_/Y _5829_/Q VPWR VGND sg13cmos5l_o21ai_1
X_6703_ Tile_X0Y1_E2BEGb[4] Tile_X0Y1_E2MID[4] VPWR VGND sg13cmos5l_buf_1
X_3915_ _3915_/Y _6423_/Q _5555_/Q VPWR VGND sg13cmos5l_nand2_1
X_4895_ _4895_/X _4893_/X _4894_/X _5834_/Q VPWR VGND sg13cmos5l_mux2_1
X_6634_ Tile_X0Y0_NN4BEG[12] _6634_/A VPWR VGND sg13cmos5l_buf_1
X_3846_ _3847_/B _3821_/X _3839_/Y _3842_/Y _3845_/Y VPWR VGND sg13cmos5l_a22oi_1
X_6565_ Tile_X0Y0_FrameData_O[31] Tile_X0Y0_FrameData[31] VPWR VGND sg13cmos5l_buf_1
X_3777_ _3777_/Y Tile_X0Y1_W2MID[6] _6252_/Q _6251_/Q VPWR VGND sg13cmos5l_o21ai_1
X_5516_ _5516_/Y _6313_/Q _5512_/X _5515_/Y VPWR VGND sg13cmos5l_o21ai_1
X_6496_ Tile_X0Y0_E2BEG[6] _6496_/A VPWR VGND sg13cmos5l_buf_1
X_2728_ _2728_/Y _6004_/Q VPWR VGND sg13cmos5l_inv_1
X_5447_ _6771_/A _5438_/Y _5447_/B VPWR VGND sg13cmos5l_nand2b_1
XANTENNA__6838__X Tile_X0Y1_W2BEGb[6] VPWR VGND sg13cmos5l_antennanp
X_5378_ _5378_/Y _6140_/Q _5375_/Y _6139_/Q VPWR VGND sg13cmos5l_a21oi_1
X_4329_ _4388_/A _4329_/A _4329_/B VPWR VGND sg13cmos5l_nand2_1
XFILLER_59_335 VPWR VGND sg13cmos5l_fill_1
XANTENNA__6573__X Tile_X0Y0_FrameStrobe_O[7] VPWR VGND sg13cmos5l_antennanp
XFILLER_63_24 VPWR VGND sg13cmos5l_fill_2
XFILLER_103_86 VPWR VGND sg13cmos5l_fill_1
XANTENNA__6748__X Tile_X0Y1_FrameData_O[13] VPWR VGND sg13cmos5l_antennanp
XFILLER_2_375 VPWR VGND sg13cmos5l_fill_2
X_3700_ _6772_/A _3698_/Y _3699_/Y _3692_/Y VPWR VGND sg13cmos5l_o21ai_1
X_4680_ _4696_/A _4612_/A _4612_/B _4610_/Y VPWR VGND sg13cmos5l_o21ai_1
X_3631_ _5986_/D _3631_/A VPWR VGND sg13cmos5l_inv_1
X_6350_ _6350_/Q Tile_X0Y1_FrameData[14] Tile_X0Y1_FrameStrobe[10] VPWR VGND sg13cmos5l_dlhq_1
X_3562_ _3562_/Y Tile_X0Y1_N4END[0] _6128_/Q _3561_/Y VPWR VGND sg13cmos5l_o21ai_1
X_5301_ _6688_/A _6391_/Q _5300_/Y _5298_/X VPWR VGND sg13cmos5l_o21ai_1
XFILLER_52_2 VPWR VGND sg13cmos5l_fill_1
X_6281_ _6281_/Q Tile_X0Y1_FrameData[19] Tile_X0Y1_FrameStrobe[8] VPWR VGND sg13cmos5l_dlhq_1
X_3493_ _3493_/Y _5641_/Q _3492_/X _3491_/Y VPWR VGND sg13cmos5l_a21oi_1
XANTENNA__6658__X Tile_X0Y0_W2BEGb[7] VPWR VGND sg13cmos5l_antennanp
X_5232_ _5233_/A _2784_/Y _4744_/Y _5231_/Y VPWR VGND sg13cmos5l_a21oi_1
X_5163_ _5164_/A _2779_/Y _3942_/Y _5162_/Y VPWR VGND sg13cmos5l_a21oi_1
X_4114_ _4114_/Y _5590_/Q Tile_X0Y1_NN4END[5] VPWR VGND sg13cmos5l_nor2b_1
X_5094_ _5094_/X _5946_/Q _3099_/Y _5093_/Y VPWR VGND sg13cmos5l_a21o_1
XFILLER_56_338 VPWR VGND sg13cmos5l_fill_2
X_4045_ _4045_/Y _5864_/Q _3323_/Y _4044_/Y VPWR VGND sg13cmos5l_a21oi_1
X_5996_ _5996_/Q Tile_X0Y1_UserCLK _5996_/D _6450_/L_HI VPWR VGND sg13cmos5l_dfrbpq_1
X_4947_ _4947_/Y _4999_/A _6786_/A _4946_/Y VPWR VGND sg13cmos5l_o21ai_1
X_4878_ _4908_/A _4935_/A _4935_/B _4751_/Y VPWR VGND sg13cmos5l_a21oi_1
X_6617_ Tile_X0Y0_N4BEG[11] _6617_/A VPWR VGND sg13cmos5l_buf_1
X_3829_ _3829_/Y _5665_/Q _3822_/X _3828_/Y VPWR VGND sg13cmos5l_o21ai_1
X_6548_ Tile_X0Y0_FrameData_O[14] Tile_X0Y0_FrameData[14] VPWR VGND sg13cmos5l_buf_1
X_6479_ _6479_/L_HI VPWR VGND sg13cmos5l_tiehi
XANTENNA__6568__X Tile_X0Y0_FrameStrobe_O[2] VPWR VGND sg13cmos5l_antennanp
XFILLER_62_319 VPWR VGND sg13cmos5l_fill_2
XFILLER_109_362 VPWR VGND sg13cmos5l_fill_1
XFILLER_17_5 VPWR VGND sg13cmos5l_fill_1
XFILLER_0_42 VPWR VGND sg13cmos5l_decap_8
X_5850_ _5850_/Q Tile_X0Y0_FrameData[8] Tile_X0Y1_FrameStrobe[8] VPWR VGND sg13cmos5l_dlhq_1
X_5781_ _5781_/Q Tile_X0Y0_FrameData[13] Tile_X0Y1_FrameStrobe[6] VPWR VGND sg13cmos5l_dlhq_1
X_4801_ _4801_/Y _5705_/Q _4800_/X _4799_/Y VPWR VGND sg13cmos5l_a21oi_1
X_2993_ _2993_/Y _2991_/Y _2992_/Y _2984_/Y VPWR VGND sg13cmos5l_o21ai_1
X_4732_ _4732_/Y _5574_/Q Tile_X0Y0_E6END[1] _4731_/Y VPWR VGND sg13cmos5l_o21ai_1
XFILLER_21_249 VPWR VGND sg13cmos5l_fill_2
X_4663_ _4705_/A _4932_/A _4932_/B _4618_/Y VPWR VGND sg13cmos5l_o21ai_1
X_6402_ _6402_/Q Tile_X0Y1_FrameData[26] Tile_X0Y1_FrameStrobe[12] VPWR VGND sg13cmos5l_dlhq_1
X_3614_ _3614_/Y _3614_/A VPWR VGND sg13cmos5l_inv_1
X_4594_ _4657_/B _4594_/A _4593_/Y VPWR VGND sg13cmos5l_nor2b_1
X_6333_ _6333_/Q Tile_X0Y1_FrameData[31] Tile_X0Y1_FrameStrobe[10] VPWR VGND sg13cmos5l_dlhq_1
X_3545_ _3545_/X _3544_/Y _3542_/Y _3538_/Y _3540_/Y _5658_/Q _5657_/Q VPWR VGND sg13cmos5l_mux4_1
X_6264_ _6264_/Q Tile_X0Y1_FrameData[4] Tile_X0Y1_FrameStrobe[7] VPWR VGND sg13cmos5l_dlhq_1
X_3476_ _3476_/Y Tile_X0Y1_W2MID[2] _6258_/Q _6257_/Q VPWR VGND sg13cmos5l_o21ai_1
X_5215_ _5216_/B _5879_/Q _5215_/B VPWR VGND sg13cmos5l_nor2_1
XFILLER_88_238 VPWR VGND sg13cmos5l_fill_1
X_6195_ _6195_/Q Tile_X0Y1_FrameData[9] Tile_X0Y1_FrameStrobe[5] VPWR VGND sg13cmos5l_dlhq_1
X_5146_ _5146_/X _4940_/Y _4934_/Y _4943_/Y _5011_/X _5924_/Q _5922_/Q VPWR VGND sg13cmos5l_mux4_1
X_5077_ _5077_/Y _5727_/Q _5077_/B VPWR VGND sg13cmos5l_nor2_1
X_4028_ _4028_/X Tile_X0Y1_NN4END[4] Tile_X0Y0_S2END[2] Tile_X0Y0_E2END[2] Tile_X0Y0_W2END[2]
+ _5759_/Q _5760_/Q VPWR VGND sg13cmos5l_mux4_1
XFILLER_52_341 VPWR VGND sg13cmos5l_fill_2
XANTENNA__6851__X Tile_X0Y1_W6BEG[11] VPWR VGND sg13cmos5l_antennanp
X_5979_ _5979_/Q Tile_X0Y1_UserCLK _5979_/D _6433_/L_HI VPWR VGND sg13cmos5l_dfrbpq_1
XFILLER_109_96 VPWR VGND sg13cmos5l_fill_2
XFILLER_69_78 VPWR VGND sg13cmos5l_fill_1
XFILLER_85_66 VPWR VGND sg13cmos5l_fill_1
XANTENNA__6761__X Tile_X0Y1_FrameData_O[26] VPWR VGND sg13cmos5l_antennanp
XFILLER_7_286 VPWR VGND sg13cmos5l_fill_1
X_3330_ _3330_/X _4409_/B _2891_/Y _6116_/Q VPWR VGND sg13cmos5l_mux2_1
X_5000_ _5000_/Y _4999_/A _4548_/A _4999_/Y VPWR VGND sg13cmos5l_a21oi_1
X_3261_ _3261_/Y _6160_/Q Tile_X0Y1_E1END[2] VPWR VGND sg13cmos5l_nor2b_1
X_3192_ _3192_/X _4944_/X Tile_X0Y1_N2MID[4] Tile_X0Y0_E6END[0] Tile_X0Y0_S2END[4]
+ _5686_/Q _5684_/Q VPWR VGND sg13cmos5l_mux4_1
X_5902_ _5902_/Q Tile_X0Y0_FrameData[20] Tile_X0Y1_FrameStrobe[10] VPWR VGND sg13cmos5l_dlhq_1
XANTENNA__6671__X Tile_X0Y0_WW4BEG[0] VPWR VGND sg13cmos5l_antennanp
X_5833_ _5833_/Q Tile_X0Y0_FrameData[25] Tile_X0Y1_FrameStrobe[8] VPWR VGND sg13cmos5l_dlhq_1
X_5764_ _5764_/Q Tile_X0Y0_FrameData[30] Tile_X0Y1_FrameStrobe[6] VPWR VGND sg13cmos5l_dlhq_1
X_2976_ _2976_/X _2891_/Y _2892_/Y _6170_/Q VPWR VGND sg13cmos5l_mux2_1
X_5695_ _5695_/Q Tile_X0Y0_FrameData[3] Tile_X0Y1_FrameStrobe[3] VPWR VGND sg13cmos5l_dlhq_1
X_4715_ _4716_/B _4715_/A _4715_/B VPWR VGND sg13cmos5l_nand2_1
X_4646_ _4646_/Y _4639_/Y _4645_/X _5707_/Q VPWR VGND sg13cmos5l_a21oi_1
X_4577_ _4582_/A _4681_/A _4601_/A VPWR VGND sg13cmos5l_nand2_1
X_6316_ _6316_/Q Tile_X0Y1_FrameData[16] Tile_X0Y1_FrameStrobe[9] VPWR VGND sg13cmos5l_dlhq_1
X_3528_ _3528_/Y _6134_/Q _5390_/B _3527_/Y VPWR VGND sg13cmos5l_a21oi_1
X_6247_ _6247_/Q Tile_X0Y1_FrameData[21] Tile_X0Y1_FrameStrobe[7] VPWR VGND sg13cmos5l_dlhq_1
X_3459_ _3459_/Y Tile_X0Y1_W2MID[5] _6216_/Q VPWR VGND sg13cmos5l_nand2_1
XANTENNA__6846__X Tile_X0Y1_W6BEG[6] VPWR VGND sg13cmos5l_antennanp
X_6178_ _6178_/Q Tile_X0Y1_FrameData[26] Tile_X0Y1_FrameStrobe[5] VPWR VGND sg13cmos5l_dlhq_1
X_5129_ _5129_/Y _5931_/Q _5129_/B VPWR VGND sg13cmos5l_nand2_1
XFILLER_84_296 VPWR VGND sg13cmos5l_fill_1
XFILLER_55_69 VPWR VGND sg13cmos5l_fill_1
XANTENNA__6581__X Tile_X0Y0_FrameStrobe_O[15] VPWR VGND sg13cmos5l_antennanp
XFILLER_111_42 VPWR VGND sg13cmos5l_decap_8
XFILLER_4_201 VPWR VGND sg13cmos5l_fill_1
XANTENNA__6756__X Tile_X0Y1_FrameData_O[21] VPWR VGND sg13cmos5l_antennanp
XANTENNA__6491__X Tile_X0Y0_E2BEG[1] VPWR VGND sg13cmos5l_antennanp
XFILLER_16_374 VPWR VGND sg13cmos5l_decap_8
X_2830_ _2830_/Y Tile_X0Y1_E2END[4] VPWR VGND sg13cmos5l_inv_1
X_2761_ _2761_/Y _5832_/Q VPWR VGND sg13cmos5l_inv_1
X_5480_ _5480_/Y Tile_X0Y1_W1END[0] _6324_/Q _6323_/Q VPWR VGND sg13cmos5l_o21ai_1
X_4500_ _5422_/B _6423_/Q _5541_/B _4499_/Y VPWR VGND sg13cmos5l_o21ai_1
XANTENNA_1 _6590_/A VPWR VGND sg13cmos5l_antennanp
X_4431_ _6778_/A _4431_/A VPWR VGND sg13cmos5l_inv_1
X_4362_ _4362_/Y _2828_/Y _6212_/Q _2879_/Y VPWR VGND sg13cmos5l_a21oi_1
X_6101_ _6101_/Q Tile_X0Y1_FrameData[7] Tile_X0Y1_FrameStrobe[2] VPWR VGND sg13cmos5l_dlhq_1
X_4293_ _4300_/B _6280_/Q _4293_/B _4293_/C VPWR VGND sg13cmos5l_nor3_1
X_3313_ _3313_/Y _5724_/Q _4940_/Y VPWR VGND sg13cmos5l_nor2b_1
XANTENNA__6666__X Tile_X0Y0_W6BEG[7] VPWR VGND sg13cmos5l_antennanp
X_6032_ _6032_/Q Tile_X0Y1_FrameData[12] Tile_X0Y1_FrameStrobe[0] VPWR VGND sg13cmos5l_dlhq_1
X_3244_ _3245_/B _3242_/Y _3243_/Y _5691_/Q VPWR VGND sg13cmos5l_o21ai_1
XFILLER_20_0 VPWR VGND sg13cmos5l_fill_1
X_3175_ _3176_/B _4621_/B _5690_/Q _3174_/Y VPWR VGND sg13cmos5l_a21oi_1
XFILLER_81_277 VPWR VGND sg13cmos5l_fill_2
X_6865_ Tile_X0Y1_WW4BEG[13] _6865_/A VPWR VGND sg13cmos5l_buf_1
X_5816_ _5816_/Q Tile_X0Y0_FrameData[10] Tile_X0Y1_FrameStrobe[7] VPWR VGND sg13cmos5l_dlhq_1
X_6796_ Tile_X0Y1_S4BEG[9] _6796_/A VPWR VGND sg13cmos5l_buf_1
X_5747_ _5747_/Q Tile_X0Y0_FrameData[15] Tile_X0Y1_FrameStrobe[5] VPWR VGND sg13cmos5l_dlhq_1
X_2959_ _2960_/A _3195_/A _5630_/Q _2958_/Y VPWR VGND sg13cmos5l_a21oi_1
X_5678_ _5678_/Q Tile_X0Y0_FrameData[20] Tile_X0Y1_FrameStrobe[3] VPWR VGND sg13cmos5l_dlhq_1
X_4629_ _4629_/Y _5810_/Q _6604_/A _4628_/Y VPWR VGND sg13cmos5l_o21ai_1
XANTENNA__6576__X Tile_X0Y0_FrameStrobe_O[10] VPWR VGND sg13cmos5l_antennanp
XFILLER_106_53 VPWR VGND sg13cmos5l_fill_2
XFILLER_57_263 VPWR VGND sg13cmos5l_fill_1
XFILLER_72_244 VPWR VGND sg13cmos5l_fill_2
XFILLER_13_377 VPWR VGND sg13cmos5l_decap_4
XFILLER_9_348 VPWR VGND sg13cmos5l_decap_8
XANTENNA__6486__X Tile_X0Y0_E1BEG[0] VPWR VGND sg13cmos5l_antennanp
XFILLER_48_296 VPWR VGND sg13cmos5l_fill_2
X_4980_ _6597_/A _4969_/Y _4971_/Y _4979_/Y VPWR VGND sg13cmos5l_o21ai_1
X_3931_ _3931_/Y _3927_/Y _3930_/Y _5679_/Q VPWR VGND sg13cmos5l_a21oi_1
XFILLER_63_299 VPWR VGND sg13cmos5l_decap_8
X_6650_ Tile_X0Y0_W2BEG[7] Tile_X0Y0_W2END[7] VPWR VGND sg13cmos5l_buf_1
X_3862_ _3866_/A _6029_/Q _3858_/X _3861_/Y VPWR VGND sg13cmos5l_a21oi_1
XFILLER_31_130 VPWR VGND sg13cmos5l_fill_2
X_5601_ _5601_/Q Tile_X0Y0_FrameData[1] Tile_X0Y1_FrameStrobe[0] VPWR VGND sg13cmos5l_dlhq_1
X_6581_ Tile_X0Y0_FrameStrobe_O[15] Tile_X0Y1_FrameStrobe[15] VPWR VGND sg13cmos5l_buf_1
X_2813_ _2813_/Y Tile_X0Y1_W2MID[3] VPWR VGND sg13cmos5l_inv_1
X_5532_ _5552_/D _5551_/A _5532_/B VPWR VGND sg13cmos5l_nor2_1
X_3793_ _3793_/Y _4501_/B _4501_/A VPWR VGND sg13cmos5l_nor2b_1
X_2744_ _2744_/Y _6007_/Q VPWR VGND sg13cmos5l_inv_1
X_5463_ _5464_/A _2802_/Y _3481_/Y _5462_/Y VPWR VGND sg13cmos5l_a21oi_1
X_5394_ _6770_/A _5262_/X _6693_/A _3715_/B _3031_/X _6359_/Q _6360_/Q VPWR VGND sg13cmos5l_mux4_1
X_4414_ _4414_/Y _4454_/A _4414_/B _4414_/C VPWR VGND sg13cmos5l_nor3_1
X_4345_ _4345_/Y Tile_X0Y0_SS4END[6] _6018_/Q _4344_/Y VPWR VGND sg13cmos5l_a21oi_1
XFILLER_98_174 VPWR VGND sg13cmos5l_fill_1
X_4276_ _4277_/B _4276_/A _4276_/B VPWR VGND sg13cmos5l_xor2_1
XFILLER_86_347 VPWR VGND sg13cmos5l_fill_1
XFILLER_100_124 VPWR VGND sg13cmos5l_fill_1
XFILLER_100_102 VPWR VGND sg13cmos5l_fill_1
X_6015_ _6015_/Q Tile_X0Y1_FrameData[29] Tile_X0Y1_FrameStrobe[0] VPWR VGND sg13cmos5l_dlhq_1
X_3227_ _3227_/Y _3223_/Y _3226_/Y _5615_/Q VPWR VGND sg13cmos5l_a21oi_1
XFILLER_86_358 VPWR VGND sg13cmos5l_fill_2
X_3158_ _3158_/X Tile_X0Y1_N4END[1] Tile_X0Y0_SS4END[5] _6024_/Q VPWR VGND sg13cmos5l_mux2_1
XFILLER_36_38 VPWR VGND sg13cmos5l_fill_2
X_3089_ _3090_/B _5654_/Q _3086_/X _5653_/Q VPWR VGND sg13cmos5l_o21ai_1
X_6848_ Tile_X0Y1_W6BEG[8] Tile_X0Y1_W6END[10] VPWR VGND sg13cmos5l_buf_1
XFILLER_22_185 VPWR VGND sg13cmos5l_fill_1
X_6779_ Tile_X0Y1_S2BEGb[0] _6779_/A VPWR VGND sg13cmos5l_buf_1
XFILLER_6_307 VPWR VGND sg13cmos5l_fill_2
XFILLER_10_358 VPWR VGND sg13cmos5l_decap_8
XANTENNA_210 Tile_X0Y1_W2MID[6] VPWR VGND sg13cmos5l_antennanp
XANTENNA_221 Tile_X0Y1_W2MID[7] VPWR VGND sg13cmos5l_antennanp
XANTENNA_232 Tile_X0Y0_S4END[4] VPWR VGND sg13cmos5l_antennanp
XANTENNA_243 Tile_X0Y0_S4END[5] VPWR VGND sg13cmos5l_antennanp
XANTENNA_254 Tile_X0Y0_W2END[7] VPWR VGND sg13cmos5l_antennanp
XANTENNA_265 Tile_X0Y1_FrameData[29] VPWR VGND sg13cmos5l_antennanp
X_4130_ _4130_/Y _5782_/Q _6603_/A _4129_/Y VPWR VGND sg13cmos5l_o21ai_1
XFILLER_3_42 VPWR VGND sg13cmos5l_fill_2
X_4061_ _4061_/Y _5716_/Q _4909_/X _4060_/Y VPWR VGND sg13cmos5l_a21oi_1
X_3012_ _3012_/Y _5858_/Q _3011_/Y _5857_/Q VPWR VGND sg13cmos5l_a21oi_1
X_4963_ _4963_/Y _5605_/Q _4956_/X _5603_/Q VPWR VGND sg13cmos5l_o21ai_1
X_6702_ Tile_X0Y1_E2BEGb[3] Tile_X0Y1_E2MID[3] VPWR VGND sg13cmos5l_buf_1
X_3914_ _5535_/B _3914_/A _3914_/B VPWR VGND sg13cmos5l_xnor2_1
X_6633_ Tile_X0Y0_NN4BEG[11] _6633_/A VPWR VGND sg13cmos5l_buf_1
X_4894_ _4894_/X _6599_/A Tile_X0Y0_E2MID[1] Tile_X0Y0_S2MID[1] Tile_X0Y0_W2MID[1]
+ _5764_/Q _5763_/Q VPWR VGND sg13cmos5l_mux4_1
X_3845_ _3845_/Y _3843_/X _3844_/Y _2881_/Y VPWR VGND sg13cmos5l_a21oi_1
XFILLER_22_18 VPWR VGND sg13cmos5l_fill_1
X_6564_ Tile_X0Y0_FrameData_O[30] Tile_X0Y0_FrameData[30] VPWR VGND sg13cmos5l_buf_1
X_3776_ _3776_/Y _6294_/Q _3775_/X _6293_/Q VPWR VGND sg13cmos5l_o21ai_1
X_5515_ _5515_/Y _6313_/Q _5514_/Y _6311_/Q VPWR VGND sg13cmos5l_a21oi_1
X_6495_ Tile_X0Y0_E2BEG[5] _6495_/A VPWR VGND sg13cmos5l_buf_1
X_2727_ _2727_/Y Tile_X0Y0_S1END[2] VPWR VGND sg13cmos5l_inv_1
X_5446_ _5447_/B _5445_/Y _5446_/B VPWR VGND sg13cmos5l_nand2b_1
X_5377_ _5377_/Y _6138_/Q _5390_/B _5376_/Y VPWR VGND sg13cmos5l_a21oi_1
X_4328_ _4329_/B _6426_/Q _6000_/D _4327_/Y VPWR VGND sg13cmos5l_o21ai_1
X_4259_ _4259_/Y _4260_/A _4260_/B VPWR VGND sg13cmos5l_nand2_1
XANTENNA__6854__X Tile_X0Y1_WW4BEG[2] VPWR VGND sg13cmos5l_antennanp
XFILLER_74_328 VPWR VGND sg13cmos5l_fill_1
XFILLER_10_111 VPWR VGND sg13cmos5l_fill_1
XFILLER_10_188 VPWR VGND sg13cmos5l_fill_1
XFILLER_111_219 VPWR VGND sg13cmos5l_decap_8
XANTENNA__6764__X Tile_X0Y1_FrameData_O[29] VPWR VGND sg13cmos5l_antennanp
XFILLER_58_380 VPWR VGND sg13cmos5l_fill_1
X_3630_ _3631_/A _3623_/X _3629_/Y _3616_/Y VPWR VGND sg13cmos5l_a21oi_1
X_3561_ _3561_/Y _6128_/Q _2830_/Y _6126_/Q VPWR VGND sg13cmos5l_a21oi_1
X_5300_ _5300_/Y _6392_/Q _4518_/Y _5299_/Y VPWR VGND sg13cmos5l_o21ai_1
X_6280_ _6280_/Q Tile_X0Y1_FrameData[20] Tile_X0Y1_FrameStrobe[8] VPWR VGND sg13cmos5l_dlhq_1
X_3492_ _3492_/X _4707_/Y _4909_/X _4911_/X _5009_/Y _5640_/Q _5642_/Q VPWR VGND sg13cmos5l_mux4_1
X_5231_ _5231_/Y _2784_/Y _4091_/X _5874_/Q VPWR VGND sg13cmos5l_o21ai_1
X_5162_ _5162_/Y _2779_/Y _4896_/X _5903_/Q VPWR VGND sg13cmos5l_o21ai_1
X_5093_ _5093_/Y _5946_/Q _6590_/A _5945_/Q VPWR VGND sg13cmos5l_o21ai_1
X_4113_ _4113_/X Tile_X0Y0_S4END[1] _6781_/A _5590_/Q VPWR VGND sg13cmos5l_mux2_1
XFILLER_110_230 VPWR VGND sg13cmos5l_fill_2
XANTENNA__6674__X Tile_X0Y0_WW4BEG[3] VPWR VGND sg13cmos5l_antennanp
XFILLER_56_306 VPWR VGND sg13cmos5l_fill_1
X_4044_ _4044_/Y _5864_/Q _5129_/B _5863_/Q VPWR VGND sg13cmos5l_o21ai_1
XFILLER_110_285 VPWR VGND sg13cmos5l_fill_1
X_5995_ _5995_/Q Tile_X0Y1_UserCLK _5995_/D _6449_/L_HI VPWR VGND sg13cmos5l_dfrbpq_1
X_4946_ _4946_/Y _4999_/A _3061_/A _5828_/Q VPWR VGND sg13cmos5l_a21oi_1
X_4877_ _4935_/B _5006_/A _4877_/B VPWR VGND sg13cmos5l_xnor2_1
XFILLER_32_280 VPWR VGND sg13cmos5l_fill_2
X_6616_ Tile_X0Y0_N4BEG[10] _6616_/A VPWR VGND sg13cmos5l_buf_1
X_3828_ _3828_/Y _5663_/Q _3828_/B VPWR VGND sg13cmos5l_nor2_1
X_6547_ Tile_X0Y0_FrameData_O[13] Tile_X0Y0_FrameData[13] VPWR VGND sg13cmos5l_buf_1
XANTENNA__6849__X Tile_X0Y1_W6BEG[9] VPWR VGND sg13cmos5l_antennanp
X_3759_ _3759_/Y _6292_/Q _3759_/B VPWR VGND sg13cmos5l_nand2_1
X_6478_ _6478_/L_HI VPWR VGND sg13cmos5l_tiehi
X_5429_ _5429_/Y Tile_X0Y1_E6END[1] _6108_/Q _5428_/Y VPWR VGND sg13cmos5l_a21oi_1
XANTENNA__6584__X Tile_X0Y0_FrameStrobe_O[18] VPWR VGND sg13cmos5l_antennanp
XFILLER_47_317 VPWR VGND sg13cmos5l_fill_1
XFILLER_59_199 VPWR VGND sg13cmos5l_fill_2
XFILLER_70_353 VPWR VGND sg13cmos5l_fill_1
XFILLER_70_342 VPWR VGND sg13cmos5l_fill_1
XFILLER_109_341 VPWR VGND sg13cmos5l_fill_1
XANTENNA__6759__X Tile_X0Y1_FrameData_O[24] VPWR VGND sg13cmos5l_antennanp
XANTENNA__6494__X Tile_X0Y0_E2BEG[4] VPWR VGND sg13cmos5l_antennanp
XFILLER_53_309 VPWR VGND sg13cmos5l_decap_4
XFILLER_0_21 VPWR VGND sg13cmos5l_decap_8
X_4800_ _4800_/X _4707_/Y _4909_/X _4911_/X _5009_/Y _5704_/Q _5706_/Q VPWR VGND sg13cmos5l_mux4_1
X_5780_ _5780_/Q Tile_X0Y0_FrameData[14] Tile_X0Y1_FrameStrobe[6] VPWR VGND sg13cmos5l_dlhq_1
X_2992_ _2992_/Y _5621_/Q _2985_/X _5619_/Q VPWR VGND sg13cmos5l_o21ai_1
X_4731_ _4731_/Y Tile_X0Y0_S4END[1] _5574_/Q VPWR VGND sg13cmos5l_nand2b_1
X_4662_ _4932_/B _4662_/A _4662_/B VPWR VGND sg13cmos5l_xnor2_1
X_6401_ _6401_/Q Tile_X0Y1_FrameData[27] Tile_X0Y1_FrameStrobe[12] VPWR VGND sg13cmos5l_dlhq_1
X_3613_ _3614_/A Tile_X0Y1_NN4END[3] Tile_X0Y1_E2END[6] Tile_X0Y0_S2MID[6] Tile_X0Y1_W2END[6]
+ _6196_/Q _6195_/Q VPWR VGND sg13cmos5l_mux4_1
X_4593_ _4593_/Y _4593_/A _4593_/B _4593_/C VPWR VGND sg13cmos5l_nand3_1
XANTENNA__6669__X Tile_X0Y0_W6BEG[10] VPWR VGND sg13cmos5l_antennanp
X_6332_ _6332_/Q Tile_X0Y1_FrameData[0] Tile_X0Y1_FrameStrobe[9] VPWR VGND sg13cmos5l_dlhq_1
X_3544_ _3544_/Y _5656_/Q _2885_/Y _3543_/Y VPWR VGND sg13cmos5l_a21oi_1
XFILLER_50_0 VPWR VGND sg13cmos5l_fill_1
X_6263_ _6263_/Q Tile_X0Y1_FrameData[5] Tile_X0Y1_FrameStrobe[7] VPWR VGND sg13cmos5l_dlhq_1
X_3475_ _3475_/Y _3475_/A _3475_/B _3475_/C VPWR VGND sg13cmos5l_nor3_1
X_5214_ _5215_/B _3063_/X Tile_X0Y0_S1END[3] Tile_X0Y0_W1END[3] _4911_/X _5881_/Q
+ _5880_/Q VPWR VGND sg13cmos5l_mux4_1
X_6194_ _6194_/Q Tile_X0Y1_FrameData[10] Tile_X0Y1_FrameStrobe[5] VPWR VGND sg13cmos5l_dlhq_1
X_5145_ _5145_/X Tile_X0Y0_E1END[2] Tile_X0Y0_W1END[2] _4707_/Y _4911_/X _5924_/Q
+ _5922_/Q VPWR VGND sg13cmos5l_mux4_1
XFILLER_96_272 VPWR VGND sg13cmos5l_decap_8
XFILLER_29_317 VPWR VGND sg13cmos5l_decap_4
XFILLER_29_306 VPWR VGND sg13cmos5l_fill_1
X_5076_ _5077_/B Tile_X0Y0_E1END[3] Tile_X0Y0_E2END[1] Tile_X0Y0_W2END[1] Tile_X0Y0_W6END[1]
+ _5730_/Q _5728_/Q VPWR VGND sg13cmos5l_mux4_1
XFILLER_96_283 VPWR VGND sg13cmos5l_fill_1
X_4027_ _4030_/A _4027_/A _4027_/B VPWR VGND sg13cmos5l_nor2_1
X_5978_ _5978_/Q Tile_X0Y1_UserCLK _5978_/D _6432_/L_HI VPWR VGND sg13cmos5l_dfrbpq_1
X_4929_ _5550_/B _4929_/A _4929_/B VPWR VGND sg13cmos5l_xnor2_1
XFILLER_100_77 VPWR VGND sg13cmos5l_fill_2
XANTENNA__6579__X Tile_X0Y0_FrameStrobe_O[13] VPWR VGND sg13cmos5l_antennanp
XFILLER_109_53 VPWR VGND sg13cmos5l_fill_2
XFILLER_47_158 VPWR VGND sg13cmos5l_fill_1
XFILLER_34_82 VPWR VGND sg13cmos5l_fill_2
XANTENNA__6489__X Tile_X0Y0_E1BEG[3] VPWR VGND sg13cmos5l_antennanp
X_3260_ _3260_/X Tile_X0Y1_W2END[4] Tile_X0Y1_W6END[0] _6160_/Q VPWR VGND sg13cmos5l_mux2_1
X_3191_ _3191_/Y _5685_/Q _3190_/X _3189_/X VPWR VGND sg13cmos5l_a21oi_1
X_5901_ _5901_/Q Tile_X0Y0_FrameData[21] Tile_X0Y1_FrameStrobe[10] VPWR VGND sg13cmos5l_dlhq_1
X_5832_ _5832_/Q Tile_X0Y0_FrameData[26] Tile_X0Y1_FrameStrobe[8] VPWR VGND sg13cmos5l_dlhq_1
X_5763_ _5763_/Q Tile_X0Y0_FrameData[31] Tile_X0Y1_FrameStrobe[6] VPWR VGND sg13cmos5l_dlhq_1
XFILLER_98_0 VPWR VGND sg13cmos5l_fill_1
X_4714_ _4722_/B _4714_/A _4714_/B VPWR VGND sg13cmos5l_xor2_1
X_2975_ _2975_/Y _6170_/Q _2888_/Y _2974_/Y VPWR VGND sg13cmos5l_o21ai_1
X_5694_ _5694_/Q Tile_X0Y0_FrameData[4] Tile_X0Y1_FrameStrobe[3] VPWR VGND sg13cmos5l_dlhq_1
X_4645_ _4645_/X _5710_/Q _4641_/Y _4644_/Y VPWR VGND sg13cmos5l_a21o_1
X_4576_ _4584_/A _4472_/A _4472_/B _4473_/X VPWR VGND sg13cmos5l_o21ai_1
X_6315_ _6315_/Q Tile_X0Y1_FrameData[17] Tile_X0Y1_FrameStrobe[9] VPWR VGND sg13cmos5l_dlhq_1
X_3527_ _3527_/Y _6134_/Q _4515_/Y VPWR VGND sg13cmos5l_nor2b_1
X_6246_ _6246_/Q Tile_X0Y1_FrameData[22] Tile_X0Y1_FrameStrobe[7] VPWR VGND sg13cmos5l_dlhq_1
X_3458_ _5493_/B _3458_/A VPWR VGND sg13cmos5l_inv_1
XFILLER_103_347 VPWR VGND sg13cmos5l_decap_8
X_6177_ _6177_/Q Tile_X0Y1_FrameData[27] Tile_X0Y1_FrameStrobe[5] VPWR VGND sg13cmos5l_dlhq_1
X_3389_ _3389_/X Tile_X0Y1_N1END[1] Tile_X0Y1_E1END[1] Tile_X0Y1_N2END[5] Tile_X0Y1_E2END[5]
+ _6091_/Q _6092_/Q VPWR VGND sg13cmos5l_mux4_1
XFILLER_103_369 VPWR VGND sg13cmos5l_fill_2
X_5128_ _5128_/Y _5931_/Q _5009_/Y _5127_/Y VPWR VGND sg13cmos5l_o21ai_1
XANTENNA__6862__X Tile_X0Y1_WW4BEG[10] VPWR VGND sg13cmos5l_antennanp
X_5059_ _5059_/Y _2764_/Y _5954_/Q _5058_/Y VPWR VGND sg13cmos5l_a21oi_1
XFILLER_102_380 VPWR VGND sg13cmos5l_fill_1
XANTENNA__6772__X Tile_X0Y1_S2BEG[1] VPWR VGND sg13cmos5l_antennanp
XFILLER_31_334 VPWR VGND sg13cmos5l_fill_2
X_2760_ _2760_/Y Tile_X0Y1_N2MID[1] VPWR VGND sg13cmos5l_inv_1
XANTENNA_2 _6782_/A VPWR VGND sg13cmos5l_antennanp
X_4430_ _4431_/A _4417_/X _4424_/Y _4429_/Y VPWR VGND sg13cmos5l_a21oi_1
X_6100_ _6100_/Q Tile_X0Y1_FrameData[8] Tile_X0Y1_FrameStrobe[2] VPWR VGND sg13cmos5l_dlhq_1
X_4361_ _4361_/Y _6243_/Q _4360_/Y _2878_/Y VPWR VGND sg13cmos5l_o21ai_1
X_4292_ _4293_/C _6237_/Q _4292_/B _4292_/C VPWR VGND sg13cmos5l_nor3_1
X_3312_ _3312_/X _4707_/Y _4937_/Y _5724_/Q VPWR VGND sg13cmos5l_mux2_1
X_6031_ _6031_/Q Tile_X0Y1_FrameData[13] Tile_X0Y1_FrameStrobe[0] VPWR VGND sg13cmos5l_dlhq_1
X_3243_ _3243_/Y _5694_/Q _3240_/X _5693_/Q VPWR VGND sg13cmos5l_o21ai_1
X_3174_ _3174_/Y Tile_X0Y1_N4END[7] _5690_/Q _5689_/Q VPWR VGND sg13cmos5l_o21ai_1
XANTENNA__6682__X Tile_X0Y0_WW4BEG[11] VPWR VGND sg13cmos5l_antennanp
X_6864_ Tile_X0Y1_WW4BEG[12] _6864_/A VPWR VGND sg13cmos5l_buf_1
X_5815_ _5815_/Q Tile_X0Y0_FrameData[11] Tile_X0Y1_FrameStrobe[7] VPWR VGND sg13cmos5l_dlhq_1
XFILLER_34_194 VPWR VGND sg13cmos5l_fill_2
X_6795_ Tile_X0Y1_S4BEG[8] _6795_/A VPWR VGND sg13cmos5l_buf_1
X_5746_ _5746_/Q Tile_X0Y0_FrameData[16] Tile_X0Y1_FrameStrobe[5] VPWR VGND sg13cmos5l_dlhq_1
X_2958_ _2958_/Y Tile_X0Y0_W2END[2] _5630_/Q _5629_/Q VPWR VGND sg13cmos5l_o21ai_1
X_5677_ _5677_/Q Tile_X0Y0_FrameData[21] Tile_X0Y1_FrameStrobe[3] VPWR VGND sg13cmos5l_dlhq_1
X_4628_ _4628_/Y _5810_/Q _2724_/Y _5809_/Q VPWR VGND sg13cmos5l_a21oi_1
X_2889_ _2889_/Y _4911_/X VPWR VGND sg13cmos5l_inv_1
X_4559_ _4559_/Y _5808_/Q _2730_/Y _5807_/Q VPWR VGND sg13cmos5l_o21ai_1
XFILLER_1_216 VPWR VGND sg13cmos5l_fill_2
XANTENNA__6857__X Tile_X0Y1_WW4BEG[5] VPWR VGND sg13cmos5l_antennanp
X_6229_ _6229_/Q Tile_X0Y1_FrameData[7] Tile_X0Y1_FrameStrobe[6] VPWR VGND sg13cmos5l_dlhq_1
XFILLER_106_32 VPWR VGND sg13cmos5l_decap_8
XANTENNA__6592__X Tile_X0Y0_N2BEG[2] VPWR VGND sg13cmos5l_antennanp
XANTENNA__6767__X Tile_X0Y1_S1BEG[0] VPWR VGND sg13cmos5l_antennanp
X_3930_ _3930_/Y _3930_/A _5680_/Q VPWR VGND sg13cmos5l_nor2b_1
X_3861_ _3861_/Y _6029_/Q _3860_/Y _6296_/Q VPWR VGND sg13cmos5l_o21ai_1
X_5600_ _5600_/Q Tile_X0Y0_FrameData[2] Tile_X0Y1_FrameStrobe[0] VPWR VGND sg13cmos5l_dlhq_1
X_6580_ Tile_X0Y0_FrameStrobe_O[14] Tile_X0Y1_FrameStrobe[14] VPWR VGND sg13cmos5l_buf_1
X_3792_ _4501_/B _3792_/A _3792_/B VPWR VGND sg13cmos5l_xnor2_1
X_2812_ _2812_/Y _6292_/Q VPWR VGND sg13cmos5l_inv_1
X_5531_ _5551_/A _6269_/Q _5526_/Y _5528_/Y _5530_/Y VPWR VGND sg13cmos5l_a22oi_1
X_2743_ _2743_/Y _6006_/Q VPWR VGND sg13cmos5l_inv_1
X_5462_ _5462_/Y _2802_/Y _4315_/B _6329_/Q VPWR VGND sg13cmos5l_o21ai_1
X_5393_ _6769_/A _5374_/B _6692_/A _5342_/B _4284_/Y _6361_/Q _6362_/Q VPWR VGND sg13cmos5l_mux4_1
X_4413_ _4414_/C _4413_/A _4413_/B _4413_/C VPWR VGND sg13cmos5l_nor3_1
XANTENNA__6677__X Tile_X0Y0_WW4BEG[6] VPWR VGND sg13cmos5l_antennanp
X_4344_ _4344_/Y _4344_/A _6018_/Q VPWR VGND sg13cmos5l_nor2_1
X_6014_ _6014_/Q Tile_X0Y1_FrameData[30] Tile_X0Y1_FrameStrobe[0] VPWR VGND sg13cmos5l_dlhq_1
X_4275_ _4275_/Y _4276_/A _4276_/B VPWR VGND sg13cmos5l_nor2_1
X_3226_ _3226_/Y _3226_/A _5616_/Q VPWR VGND sg13cmos5l_nor2b_1
X_3157_ _6774_/A _3155_/Y _3156_/Y _3149_/Y VPWR VGND sg13cmos5l_o21ai_1
X_3088_ _3090_/A _5652_/Q Tile_X0Y0_WW4END[2] _3087_/Y VPWR VGND sg13cmos5l_a21oi_1
X_6847_ Tile_X0Y1_W6BEG[7] Tile_X0Y1_W6END[9] VPWR VGND sg13cmos5l_buf_1
X_6778_ Tile_X0Y1_S2BEG[7] _6778_/A VPWR VGND sg13cmos5l_buf_1
X_5729_ _5729_/Q Tile_X0Y0_FrameData[1] Tile_X0Y1_FrameStrobe[4] VPWR VGND sg13cmos5l_dlhq_1
XFILLER_6_319 VPWR VGND sg13cmos5l_decap_4
XANTENNA__6587__X Tile_X0Y0_N1BEG[1] VPWR VGND sg13cmos5l_antennanp
XFILLER_92_318 VPWR VGND sg13cmos5l_fill_1
XANTENNA_200 Tile_X0Y1_W2MID[6] VPWR VGND sg13cmos5l_antennanp
XFILLER_93_56 VPWR VGND sg13cmos5l_fill_1
XFILLER_93_45 VPWR VGND sg13cmos5l_fill_1
XANTENNA_211 Tile_X0Y1_W2MID[6] VPWR VGND sg13cmos5l_antennanp
XANTENNA_222 Tile_X0Y0_E2MID[5] VPWR VGND sg13cmos5l_antennanp
XANTENNA_233 Tile_X0Y0_S4END[4] VPWR VGND sg13cmos5l_antennanp
XANTENNA_244 Tile_X0Y0_S4END[5] VPWR VGND sg13cmos5l_antennanp
XANTENNA_255 Tile_X0Y0_W2END[7] VPWR VGND sg13cmos5l_antennanp
XANTENNA_266 Tile_X0Y1_FrameData[29] VPWR VGND sg13cmos5l_antennanp
XFILLER_9_157 VPWR VGND sg13cmos5l_fill_2
XFILLER_54_7 VPWR VGND sg13cmos5l_decap_4
XANTENNA__6497__X Tile_X0Y0_E2BEG[7] VPWR VGND sg13cmos5l_antennanp
XFILLER_3_21 VPWR VGND sg13cmos5l_decap_4
X_4060_ _4060_/Y _5716_/Q _4707_/Y VPWR VGND sg13cmos5l_nor2b_1
X_3011_ _3011_/Y _3011_/A VPWR VGND sg13cmos5l_inv_1
XFILLER_91_362 VPWR VGND sg13cmos5l_fill_2
X_4962_ _4962_/Y _5606_/Q _4958_/Y _4961_/Y VPWR VGND sg13cmos5l_a21oi_1
X_6701_ Tile_X0Y1_E2BEGb[2] Tile_X0Y1_E2MID[2] VPWR VGND sg13cmos5l_buf_1
X_4893_ _4893_/X _6598_/A Tile_X0Y0_W2MID[0] Tile_X0Y0_E2MID[0] _6649_/A _5795_/Q
+ _5796_/Q VPWR VGND sg13cmos5l_mux4_1
X_3913_ _3914_/B _3913_/A _3913_/B VPWR VGND sg13cmos5l_xor2_1
X_6632_ Tile_X0Y0_NN4BEG[10] _6632_/A VPWR VGND sg13cmos5l_buf_1
X_3844_ _3844_/Y _2843_/Y _6214_/Q _6213_/Q VPWR VGND sg13cmos5l_a21oi_1
XFILLER_80_0 VPWR VGND sg13cmos5l_fill_1
X_6563_ Tile_X0Y0_FrameData_O[29] Tile_X0Y0_FrameData[29] VPWR VGND sg13cmos5l_buf_1
X_3775_ _3775_/X Tile_X0Y1_N2END[7] Tile_X0Y1_EE4END[2] Tile_X0Y0_S2MID[7] Tile_X0Y1_W2END[7]
+ _6188_/Q _6187_/Q VPWR VGND sg13cmos5l_mux4_1
X_5514_ _5514_/Y _5514_/A VPWR VGND sg13cmos5l_inv_1
X_6494_ Tile_X0Y0_E2BEG[4] _6494_/A VPWR VGND sg13cmos5l_buf_1
X_2726_ _4640_/B Tile_X0Y0_E2END[6] VPWR VGND sg13cmos5l_inv_1
X_5445_ _5445_/Y _6107_/Q _5444_/X _6105_/Q VPWR VGND sg13cmos5l_o21ai_1
X_5376_ _5376_/Y _6138_/Q _4509_/Y VPWR VGND sg13cmos5l_nor2b_1
X_4327_ _4327_/Y _6426_/Q _2864_/Y _6425_/Q VPWR VGND sg13cmos5l_a21oi_1
XFILLER_86_101 VPWR VGND sg13cmos5l_fill_2
X_4258_ _4260_/B _4258_/A _4258_/B VPWR VGND sg13cmos5l_xnor2_1
X_3209_ _3209_/X _3729_/B _2714_/Y _2713_/Y _2715_/Y _6143_/Q _6144_/Q VPWR VGND sg13cmos5l_mux4_1
X_4189_ _4189_/Y _4189_/A _4256_/A VPWR VGND sg13cmos5l_nand2_1
XFILLER_6_105 VPWR VGND sg13cmos5l_fill_2
XFILLER_2_355 VPWR VGND sg13cmos5l_decap_4
XANTENNA__6780__X Tile_X0Y1_S2BEGb[1] VPWR VGND sg13cmos5l_antennanp
X_3560_ _3563_/A _2786_/Y _6128_/Q _3559_/Y VPWR VGND sg13cmos5l_a21oi_1
X_5230_ _5230_/Y _5875_/Q _5009_/Y _5229_/Y VPWR VGND sg13cmos5l_o21ai_1
X_3491_ _3491_/Y _5641_/Q _3490_/X VPWR VGND sg13cmos5l_nor2b_1
X_5161_ _5161_/Y _5904_/Q _4937_/Y _5160_/Y VPWR VGND sg13cmos5l_o21ai_1
X_5092_ _6590_/A _5077_/Y _5083_/Y _5091_/Y VPWR VGND sg13cmos5l_o21ai_1
X_4112_ _4143_/A _4112_/A _4112_/B VPWR VGND sg13cmos5l_xnor2_1
X_4043_ _5129_/B Tile_X0Y1_N2MID[6] Tile_X0Y0_SS4END[3] Tile_X0Y0_E2END[6] Tile_X0Y0_W2END[6]
+ _5761_/Q _5762_/Q VPWR VGND sg13cmos5l_mux4_1
X_5994_ _5994_/Q Tile_X0Y1_UserCLK _5994_/D _6448_/L_HI VPWR VGND sg13cmos5l_dfrbpq_1
XANTENNA__6690__X Tile_X0Y1_E1BEG[3] VPWR VGND sg13cmos5l_antennanp
X_4945_ _5007_/A _4929_/A _4929_/B _4926_/Y VPWR VGND sg13cmos5l_a21oi_1
X_4876_ _4935_/A _5010_/A _4874_/Y _4786_/Y VPWR VGND sg13cmos5l_o21ai_1
X_6615_ Tile_X0Y0_N4BEG[9] _6615_/A VPWR VGND sg13cmos5l_buf_1
X_3827_ _3828_/B _5664_/Q _3823_/X _3826_/Y VPWR VGND sg13cmos5l_a21oi_1
X_6546_ Tile_X0Y0_FrameData_O[12] Tile_X0Y0_FrameData[12] VPWR VGND sg13cmos5l_buf_1
X_3758_ _3759_/B Tile_X0Y1_NN4END[2] _6026_/Q _3757_/Y VPWR VGND sg13cmos5l_o21ai_1
X_2709_ _2709_/Y Tile_X0Y0_S2END[0] VPWR VGND sg13cmos5l_inv_1
X_6477_ _6477_/L_HI VPWR VGND sg13cmos5l_tiehi
X_3689_ _3689_/Y Tile_X0Y1_E6END[0] _6104_/Q _3688_/Y VPWR VGND sg13cmos5l_a21oi_1
X_5428_ _5428_/Y _6108_/Q Tile_X0Y1_E2END[1] VPWR VGND sg13cmos5l_nor2b_1
X_5359_ _5359_/Y _6370_/Q _3643_/Y _6369_/Q VPWR VGND sg13cmos5l_a21oi_1
XFILLER_59_101 VPWR VGND sg13cmos5l_decap_8
XANTENNA__6865__X Tile_X0Y1_WW4BEG[13] VPWR VGND sg13cmos5l_antennanp
XFILLER_47_307 VPWR VGND sg13cmos5l_fill_2
XFILLER_101_264 VPWR VGND sg13cmos5l_fill_2
XFILLER_23_51 VPWR VGND sg13cmos5l_fill_2
XFILLER_109_353 VPWR VGND sg13cmos5l_fill_1
XANTENNA__6775__X Tile_X0Y1_S2BEG[4] VPWR VGND sg13cmos5l_antennanp
XFILLER_48_70 VPWR VGND sg13cmos5l_fill_1
XFILLER_48_81 VPWR VGND sg13cmos5l_fill_1
X_2991_ _2991_/Y _5622_/Q _2987_/Y _2990_/Y VPWR VGND sg13cmos5l_a21oi_1
XFILLER_21_218 VPWR VGND sg13cmos5l_decap_4
X_4730_ _4730_/Y _5574_/Q _3446_/Y _4729_/Y VPWR VGND sg13cmos5l_a21oi_1
XFILLER_9_53 VPWR VGND sg13cmos5l_fill_2
X_4661_ _4932_/A _4938_/A _4938_/B _4658_/Y VPWR VGND sg13cmos5l_a21oi_1
X_6400_ _6400_/Q Tile_X0Y1_FrameData[28] Tile_X0Y1_FrameStrobe[12] VPWR VGND sg13cmos5l_dlhq_1
X_3612_ _3616_/A _3612_/A _3612_/B VPWR VGND sg13cmos5l_nor2_1
X_6331_ _6331_/Q Tile_X0Y1_FrameData[1] Tile_X0Y1_FrameStrobe[9] VPWR VGND sg13cmos5l_dlhq_1
X_4592_ _4657_/A _4493_/A _4493_/B _4491_/Y VPWR VGND sg13cmos5l_o21ai_1
X_3543_ _3543_/Y _5656_/Q _4940_/Y VPWR VGND sg13cmos5l_nor2_1
X_6262_ _6262_/Q Tile_X0Y1_FrameData[6] Tile_X0Y1_FrameStrobe[7] VPWR VGND sg13cmos5l_dlhq_1
X_3474_ _3474_/Y _6300_/Q _2934_/X _3473_/Y VPWR VGND sg13cmos5l_a21oi_1
XFILLER_43_0 VPWR VGND sg13cmos5l_fill_2
X_6193_ _6193_/Q Tile_X0Y1_FrameData[11] Tile_X0Y1_FrameStrobe[5] VPWR VGND sg13cmos5l_dlhq_1
X_5213_ _5216_/A _5880_/Q _5211_/X _5212_/Y VPWR VGND sg13cmos5l_a21oi_1
XANTENNA__6685__X Tile_X0Y0_WW4BEG[14] VPWR VGND sg13cmos5l_antennanp
X_5144_ _6516_/A _5925_/Q _5139_/Y _5143_/X VPWR VGND sg13cmos5l_o21ai_1
X_5075_ _6486_/A _4911_/X _3206_/X _6593_/A _3187_/X _5948_/Q _5947_/Q VPWR VGND sg13cmos5l_mux4_1
X_4026_ _4027_/B _5599_/Q _4025_/Y _5862_/Q VPWR VGND sg13cmos5l_o21ai_1
XFILLER_56_159 VPWR VGND sg13cmos5l_fill_2
X_5977_ _5977_/Q Tile_X0Y0_FrameData[31] Tile_X0Y1_FrameStrobe[0] VPWR VGND sg13cmos5l_dlhq_1
XFILLER_12_218 VPWR VGND sg13cmos5l_fill_2
X_4928_ _4929_/B _4908_/A _4907_/A _4906_/Y VPWR VGND sg13cmos5l_a21oi_1
X_4859_ _4859_/Y _5841_/Q _4859_/B VPWR VGND sg13cmos5l_nand2b_1
XFILLER_109_32 VPWR VGND sg13cmos5l_decap_4
X_6529_ Tile_X0Y0_EE4BEG[11] Tile_X0Y0_EE4END[15] VPWR VGND sg13cmos5l_buf_1
XFILLER_106_301 VPWR VGND sg13cmos5l_fill_1
XFILLER_106_356 VPWR VGND sg13cmos5l_decap_8
XFILLER_106_378 VPWR VGND sg13cmos5l_fill_2
XANTENNA__6595__X Tile_X0Y0_N2BEG[5] VPWR VGND sg13cmos5l_antennanp
XFILLER_59_80 VPWR VGND sg13cmos5l_fill_1
X_3190_ _3190_/X _4707_/Y _4909_/X _4943_/Y _5009_/Y _5684_/Q _5686_/Q VPWR VGND sg13cmos5l_mux4_1
XFILLER_38_148 VPWR VGND sg13cmos5l_fill_2
X_5900_ _5900_/Q Tile_X0Y0_FrameData[22] Tile_X0Y1_FrameStrobe[10] VPWR VGND sg13cmos5l_dlhq_1
XFILLER_19_362 VPWR VGND sg13cmos5l_fill_2
X_5831_ _5831_/Q Tile_X0Y0_FrameData[27] Tile_X0Y1_FrameStrobe[8] VPWR VGND sg13cmos5l_dlhq_1
X_5762_ _5762_/Q Tile_X0Y0_FrameData[0] Tile_X0Y1_FrameStrobe[5] VPWR VGND sg13cmos5l_dlhq_1
X_2974_ _2974_/Y _6170_/Q _5440_/B VPWR VGND sg13cmos5l_nand2_1
X_4713_ _4714_/B _4721_/A _4713_/B VPWR VGND sg13cmos5l_nand2_1
X_5693_ _5693_/Q Tile_X0Y0_FrameData[5] Tile_X0Y1_FrameStrobe[3] VPWR VGND sg13cmos5l_dlhq_1
X_4644_ _4644_/Y _5710_/Q _4643_/Y _5709_/Q VPWR VGND sg13cmos5l_o21ai_1
X_4575_ _4575_/Y _4585_/A VPWR VGND sg13cmos5l_inv_1
X_6314_ _6314_/Q Tile_X0Y1_FrameData[18] Tile_X0Y1_FrameStrobe[9] VPWR VGND sg13cmos5l_dlhq_1
X_3526_ _3526_/Y _6134_/Q _4409_/B _3525_/Y VPWR VGND sg13cmos5l_o21ai_1
X_6245_ _6245_/Q Tile_X0Y1_FrameData[23] Tile_X0Y1_FrameStrobe[7] VPWR VGND sg13cmos5l_dlhq_1
X_3457_ _3458_/A Tile_X0Y1_N2MID[4] Tile_X0Y1_W2MID[4] _6783_/A _6776_/A _6247_/Q
+ _6248_/Q VPWR VGND sg13cmos5l_mux4_1
X_6176_ _6176_/Q Tile_X0Y1_FrameData[28] Tile_X0Y1_FrameStrobe[5] VPWR VGND sg13cmos5l_dlhq_1
X_3388_ _3388_/X _3217_/A _2790_/Y _2741_/Y _2789_/Y _6091_/Q _6092_/Q VPWR VGND sg13cmos5l_mux4_1
X_5127_ _5127_/Y _5931_/Q _5229_/B VPWR VGND sg13cmos5l_nand2_1
X_5058_ _5058_/Y _5954_/Q _5058_/B VPWR VGND sg13cmos5l_nor2_1
X_4009_ _4011_/B _4009_/A _4009_/B VPWR VGND sg13cmos5l_xnor2_1
XFILLER_106_186 VPWR VGND sg13cmos5l_fill_2
XFILLER_96_56 VPWR VGND sg13cmos5l_fill_2
XFILLER_91_8 VPWR VGND sg13cmos5l_fill_1
XFILLER_31_379 VPWR VGND sg13cmos5l_fill_2
XFILLER_61_81 VPWR VGND sg13cmos5l_fill_1
XANTENNA_3 _6598_/A VPWR VGND sg13cmos5l_antennanp
X_4360_ _4360_/Y Tile_X0Y1_E2MID[6] _6244_/Q _4359_/Y VPWR VGND sg13cmos5l_a21oi_1
X_3311_ _3317_/B _5725_/Q _3311_/B _3311_/C VPWR VGND sg13cmos5l_nand3_1
X_4291_ _4292_/C Tile_X0Y1_N2MID[0] _6238_/Q VPWR VGND sg13cmos5l_nor2_1
X_6030_ _6030_/Q Tile_X0Y1_FrameData[14] Tile_X0Y1_FrameStrobe[0] VPWR VGND sg13cmos5l_dlhq_1
X_3242_ _3242_/Y _5692_/Q _2894_/Y _3241_/Y VPWR VGND sg13cmos5l_a21oi_1
XFILLER_98_379 VPWR VGND sg13cmos5l_fill_2
X_3173_ _3173_/X _3171_/X _2734_/Y _5690_/Q VPWR VGND sg13cmos5l_mux2_1
XFILLER_66_298 VPWR VGND sg13cmos5l_fill_1
X_6863_ Tile_X0Y1_WW4BEG[11] Tile_X0Y1_WW4END[15] VPWR VGND sg13cmos5l_buf_1
X_5814_ _5814_/Q Tile_X0Y0_FrameData[12] Tile_X0Y1_FrameStrobe[7] VPWR VGND sg13cmos5l_dlhq_1
X_6794_ Tile_X0Y1_S4BEG[7] Tile_X0Y0_S4END[15] VPWR VGND sg13cmos5l_buf_1
X_5745_ _5745_/Q Tile_X0Y0_FrameData[17] Tile_X0Y1_FrameStrobe[5] VPWR VGND sg13cmos5l_dlhq_1
X_2957_ _2957_/Y Tile_X0Y0_S2END[2] _5630_/Q _2956_/Y VPWR VGND sg13cmos5l_o21ai_1
X_5676_ _5676_/Q Tile_X0Y0_FrameData[22] Tile_X0Y1_FrameStrobe[3] VPWR VGND sg13cmos5l_dlhq_1
X_2888_ _2888_/Y _4518_/Y VPWR VGND sg13cmos5l_inv_1
X_4627_ _4653_/A _4627_/A _4627_/B VPWR VGND sg13cmos5l_nor2_1
X_4558_ _4558_/Y _5808_/Q _4769_/B _4557_/Y VPWR VGND sg13cmos5l_o21ai_1
X_4489_ _4593_/B _4490_/A _4490_/B VPWR VGND sg13cmos5l_or2_1
X_3509_ _3509_/Y _6310_/Q _3509_/B _3509_/C VPWR VGND sg13cmos5l_nand3_1
XFILLER_106_11 VPWR VGND sg13cmos5l_decap_8
X_6228_ _6228_/Q Tile_X0Y1_FrameData[8] Tile_X0Y1_FrameStrobe[6] VPWR VGND sg13cmos5l_dlhq_1
XFILLER_89_379 VPWR VGND sg13cmos5l_fill_2
X_6159_ _6159_/Q Tile_X0Y1_FrameData[13] Tile_X0Y1_FrameStrobe[4] VPWR VGND sg13cmos5l_dlhq_1
XFILLER_9_328 VPWR VGND sg13cmos5l_decap_4
XFILLER_31_95 VPWR VGND sg13cmos5l_fill_1
XFILLER_110_0 VPWR VGND sg13cmos5l_fill_2
XANTENNA__6783__X Tile_X0Y1_S2BEGb[4] VPWR VGND sg13cmos5l_antennanp
XFILLER_48_221 VPWR VGND sg13cmos5l_fill_1
XFILLER_48_287 VPWR VGND sg13cmos5l_fill_1
X_3860_ _3860_/Y Tile_X0Y0_SS4END[4] _6030_/Q _3859_/Y VPWR VGND sg13cmos5l_a21oi_1
X_3791_ _4501_/A _4507_/A _4507_/B _3768_/Y VPWR VGND sg13cmos5l_o21ai_1
X_2811_ _2811_/Y _6118_/Q VPWR VGND sg13cmos5l_inv_1
X_5530_ _5530_/Y _5524_/A _5529_/X _6269_/Q VPWR VGND sg13cmos5l_a21oi_1
X_2742_ _2742_/Y Tile_X0Y0_W2MID[5] VPWR VGND sg13cmos5l_inv_1
X_5461_ _5461_/Y _6330_/Q _5374_/B _5460_/Y VPWR VGND sg13cmos5l_o21ai_1
X_4412_ _4413_/C _6048_/Q _4408_/Y _4411_/Y VPWR VGND sg13cmos5l_a21oi_1
X_5392_ _6768_/A _2796_/Y _5391_/Y _5389_/Y VPWR VGND sg13cmos5l_a21o_1
X_4343_ _4347_/A _6018_/Q _3407_/A _4342_/Y VPWR VGND sg13cmos5l_a21oi_1
X_4274_ _4276_/B _4274_/A _4274_/B VPWR VGND sg13cmos5l_xnor2_1
X_6013_ _6013_/Q Tile_X0Y1_UserCLK _6013_/D _6481_/L_HI VPWR VGND sg13cmos5l_dfrbpq_1
X_3225_ _3226_/A _2746_/Y _5618_/Q _3224_/Y VPWR VGND sg13cmos5l_a21oi_1
XANTENNA__6693__X Tile_X0Y1_E2BEG[2] VPWR VGND sg13cmos5l_antennanp
X_3156_ _3156_/Y _6095_/Q _3150_/X _6093_/Q VPWR VGND sg13cmos5l_o21ai_1
X_3087_ _3087_/Y _3016_/B _5652_/Q _5654_/Q VPWR VGND sg13cmos5l_o21ai_1
XFILLER_39_287 VPWR VGND sg13cmos5l_decap_4
X_6846_ Tile_X0Y1_W6BEG[6] Tile_X0Y1_W6END[8] VPWR VGND sg13cmos5l_buf_1
X_6777_ Tile_X0Y1_S2BEG[6] _6777_/A VPWR VGND sg13cmos5l_buf_1
X_5728_ _5728_/Q Tile_X0Y0_FrameData[2] Tile_X0Y1_FrameStrobe[4] VPWR VGND sg13cmos5l_dlhq_1
X_3989_ _3989_/Y Tile_X0Y0_W1END[1] _5714_/Q _5713_/Q VPWR VGND sg13cmos5l_o21ai_1
XFILLER_10_338 VPWR VGND sg13cmos5l_fill_1
X_5659_ _5659_/Q Tile_X0Y0_FrameData[7] Tile_X0Y1_FrameStrobe[2] VPWR VGND sg13cmos5l_dlhq_1
XFILLER_89_176 VPWR VGND sg13cmos5l_decap_8
XFILLER_77_58 VPWR VGND sg13cmos5l_fill_1
XANTENNA_201 Tile_X0Y1_W2MID[6] VPWR VGND sg13cmos5l_antennanp
XANTENNA_212 Tile_X0Y1_W2MID[6] VPWR VGND sg13cmos5l_antennanp
XANTENNA_223 Tile_X0Y0_E2MID[5] VPWR VGND sg13cmos5l_antennanp
XANTENNA_234 Tile_X0Y0_S4END[4] VPWR VGND sg13cmos5l_antennanp
XANTENNA_245 Tile_X0Y0_S4END[5] VPWR VGND sg13cmos5l_antennanp
XANTENNA_256 Tile_X0Y0_W2END[7] VPWR VGND sg13cmos5l_antennanp
XANTENNA_267 Tile_X0Y1_FrameData[29] VPWR VGND sg13cmos5l_antennanp
XANTENNA__6778__X Tile_X0Y1_S2BEG[7] VPWR VGND sg13cmos5l_antennanp
XFILLER_68_305 VPWR VGND sg13cmos5l_fill_2
X_3010_ _3011_/A _6599_/A Tile_X0Y0_E2MID[1] Tile_X0Y0_S2MID[1] Tile_X0Y0_W2MID[1]
+ _5788_/Q _5787_/Q VPWR VGND sg13cmos5l_mux4_1
X_4961_ _4961_/Y _5606_/Q _4960_/Y _5605_/Q VPWR VGND sg13cmos5l_o21ai_1
X_6700_ Tile_X0Y1_E2BEGb[1] Tile_X0Y1_E2MID[1] VPWR VGND sg13cmos5l_buf_1
X_4892_ _6649_/A _5607_/Q _4883_/Y _4885_/Y _4891_/Y VPWR VGND sg13cmos5l_a22oi_1
X_3912_ _3912_/Y _3913_/B _3913_/A VPWR VGND sg13cmos5l_nor2b_1
X_6631_ Tile_X0Y0_NN4BEG[9] _6631_/A VPWR VGND sg13cmos5l_buf_1
X_3843_ _3843_/X Tile_X0Y1_N2MID[1] _6214_/Q VPWR VGND sg13cmos5l_or2_1
X_6562_ Tile_X0Y0_FrameData_O[28] Tile_X0Y0_FrameData[28] VPWR VGND sg13cmos5l_buf_1
X_3774_ _3774_/Y _6027_/Q _3770_/X _3773_/Y VPWR VGND sg13cmos5l_a21oi_1
XFILLER_73_0 VPWR VGND sg13cmos5l_fill_2
X_5513_ _5514_/A _4515_/Y _4509_/Y _4518_/Y _5390_/B _6314_/Q _6312_/Q VPWR VGND sg13cmos5l_mux4_1
X_6493_ Tile_X0Y0_E2BEG[3] _6493_/A VPWR VGND sg13cmos5l_buf_1
X_2725_ _2725_/Y Tile_X0Y0_W1END[0] VPWR VGND sg13cmos5l_inv_1
XANTENNA__6688__X Tile_X0Y1_E1BEG[1] VPWR VGND sg13cmos5l_antennanp
X_5444_ _5444_/X _4509_/Y _4503_/Y _5390_/B _5374_/B _6108_/Q _6106_/Q VPWR VGND sg13cmos5l_mux4_1
XFILLER_8_191 VPWR VGND sg13cmos5l_fill_1
X_5375_ _5375_/Y _6138_/Q _4409_/B _5374_/Y VPWR VGND sg13cmos5l_o21ai_1
X_4326_ _6000_/D _4315_/Y _4316_/Y _4325_/Y VPWR VGND sg13cmos5l_o21ai_1
X_4257_ _4257_/Y _4258_/A _4258_/B VPWR VGND sg13cmos5l_nand2b_1
X_4188_ _4256_/A _4188_/A _4708_/A VPWR VGND sg13cmos5l_nor2_1
X_3208_ _3208_/Y _3729_/B VPWR VGND sg13cmos5l_inv_1
XFILLER_86_168 VPWR VGND sg13cmos5l_fill_2
X_3139_ _5450_/B _3626_/A _2826_/Y _3138_/A _2828_/Y _6220_/Q _6219_/Q VPWR VGND sg13cmos5l_mux4_1
X_6829_ Tile_X0Y1_W2BEG[5] _6829_/A VPWR VGND sg13cmos5l_buf_1
XANTENNA__6598__X Tile_X0Y0_N2BEGb[0] VPWR VGND sg13cmos5l_antennanp
XFILLER_2_334 VPWR VGND sg13cmos5l_decap_8
XFILLER_18_246 VPWR VGND sg13cmos5l_fill_2
X_3490_ _3490_/X _4940_/Y _4934_/Y _4943_/Y _5011_/X _5642_/Q _5640_/Q VPWR VGND sg13cmos5l_mux4_1
X_5160_ _5160_/Y _5904_/Q _5245_/B _5903_/Q VPWR VGND sg13cmos5l_a21oi_1
X_5091_ _5091_/Y _5727_/Q _5084_/X _5090_/Y VPWR VGND sg13cmos5l_o21ai_1
X_4111_ _4112_/B _4111_/A _4111_/B VPWR VGND sg13cmos5l_xor2_1
XFILLER_68_124 VPWR VGND sg13cmos5l_fill_1
X_4042_ _4081_/A _4215_/A _4041_/B _4038_/Y VPWR VGND sg13cmos5l_o21ai_1
XFILLER_110_298 VPWR VGND sg13cmos5l_fill_1
XFILLER_110_276 VPWR VGND sg13cmos5l_decap_8
XFILLER_64_352 VPWR VGND sg13cmos5l_fill_2
X_5993_ _5993_/Q Tile_X0Y1_UserCLK _5993_/D _6447_/L_HI VPWR VGND sg13cmos5l_dfrbpq_1
X_4944_ _4944_/X _4518_/Y _6825_/A _5342_/B _4284_/Y _6417_/Q _6418_/Q VPWR VGND sg13cmos5l_mux4_1
X_4875_ _5010_/B _4875_/A _4875_/B VPWR VGND sg13cmos5l_xor2_1
X_6614_ Tile_X0Y0_N4BEG[8] _6614_/A VPWR VGND sg13cmos5l_buf_1
X_3826_ _3826_/Y _5664_/Q _3825_/Y _5665_/Q VPWR VGND sg13cmos5l_o21ai_1
X_6545_ Tile_X0Y0_FrameData_O[11] Tile_X0Y0_FrameData[11] VPWR VGND sg13cmos5l_buf_1
X_3757_ _3757_/Y _3888_/A _6026_/Q _6025_/Q VPWR VGND sg13cmos5l_a21oi_1
X_2708_ _3016_/B Tile_X0Y0_E6END[0] VPWR VGND sg13cmos5l_inv_1
X_6476_ _6476_/L_HI VPWR VGND sg13cmos5l_tiehi
X_3688_ _3688_/Y _6104_/Q Tile_X0Y1_EE4END[2] VPWR VGND sg13cmos5l_nor2b_1
X_5427_ _6820_/A _5390_/B _2917_/X _6774_/A _2935_/X _6338_/Q _6337_/Q VPWR VGND sg13cmos5l_mux4_1
X_5358_ _5358_/Y _6370_/Q _5468_/B VPWR VGND sg13cmos5l_nand2b_1
X_4309_ _4310_/A Tile_X0Y1_WW4END[3] _6016_/Q _6015_/Q VPWR VGND sg13cmos5l_o21ai_1
X_5289_ _5289_/Y _6397_/Q _5420_/B _6396_/Q VPWR VGND sg13cmos5l_o21ai_1
XFILLER_3_0 VPWR VGND sg13cmos5l_decap_8
XANTENNA__6791__X Tile_X0Y1_S4BEG[4] VPWR VGND sg13cmos5l_antennanp
XFILLER_0_56 VPWR VGND sg13cmos5l_decap_8
XFILLER_61_333 VPWR VGND sg13cmos5l_fill_2
XFILLER_61_322 VPWR VGND sg13cmos5l_fill_2
XFILLER_0_89 VPWR VGND sg13cmos5l_decap_8
X_2990_ _2990_/Y _5622_/Q _2989_/Y _5621_/Q VPWR VGND sg13cmos5l_o21ai_1
X_4660_ _4938_/B _4498_/A _4495_/A _4497_/B VPWR VGND sg13cmos5l_a21oi_1
X_3611_ _3612_/B _6035_/Q _3610_/Y _6302_/Q VPWR VGND sg13cmos5l_o21ai_1
XFILLER_80_91 VPWR VGND sg13cmos5l_fill_1
X_6330_ _6330_/Q Tile_X0Y1_FrameData[2] Tile_X0Y1_FrameStrobe[9] VPWR VGND sg13cmos5l_dlhq_1
X_4591_ _4594_/A _4593_/A _4593_/B _4593_/C VPWR VGND sg13cmos5l_a21oi_1
X_3542_ _3542_/Y _5656_/Q _2887_/Y _3541_/Y VPWR VGND sg13cmos5l_a21oi_1
X_6261_ _6261_/Q Tile_X0Y1_FrameData[7] Tile_X0Y1_FrameStrobe[7] VPWR VGND sg13cmos5l_dlhq_1
X_3473_ _3473_/Y _6300_/Q _3473_/B VPWR VGND sg13cmos5l_nor2_1
X_6192_ _6192_/Q Tile_X0Y1_FrameData[12] Tile_X0Y1_FrameStrobe[5] VPWR VGND sg13cmos5l_dlhq_1
X_5212_ _5212_/Y _5880_/Q _5210_/Y _5879_/Q VPWR VGND sg13cmos5l_o21ai_1
X_5143_ _5143_/X _5926_/Q _5140_/X _5142_/Y VPWR VGND sg13cmos5l_a21o_1
X_5074_ _6637_/A _5074_/A VPWR VGND sg13cmos5l_inv_1
X_4025_ _4025_/Y Tile_X0Y0_EE4END[2] _5600_/Q _4024_/Y VPWR VGND sg13cmos5l_o21ai_1
XFILLER_52_333 VPWR VGND sg13cmos5l_fill_2
X_5976_ _5976_/Q Tile_X0Y0_FrameData[10] Tile_X0Y1_FrameStrobe[12] VPWR VGND sg13cmos5l_dlhq_1
X_4927_ _4929_/A _5006_/A _4927_/B VPWR VGND sg13cmos5l_xnor2_1
X_4858_ _4858_/Y _5841_/Q _4855_/X _4857_/X VPWR VGND sg13cmos5l_o21ai_1
XFILLER_60_17 VPWR VGND sg13cmos5l_fill_2
X_3809_ _3809_/Y _6056_/Q _5455_/B VPWR VGND sg13cmos5l_nand2_1
X_4789_ _4789_/Y _5578_/Q _3995_/A _4788_/Y VPWR VGND sg13cmos5l_a21oi_1
X_6528_ Tile_X0Y0_EE4BEG[10] Tile_X0Y0_EE4END[14] VPWR VGND sg13cmos5l_buf_1
X_6459_ _6459_/L_HI VPWR VGND sg13cmos5l_tiehi
XFILLER_62_119 VPWR VGND sg13cmos5l_fill_1
XFILLER_43_366 VPWR VGND sg13cmos5l_fill_1
XFILLER_109_195 VPWR VGND sg13cmos5l_fill_2
XANTENNA__6786__X Tile_X0Y1_S2BEGb[7] VPWR VGND sg13cmos5l_antennanp
XFILLER_46_182 VPWR VGND sg13cmos5l_fill_1
X_5830_ _5830_/Q Tile_X0Y0_FrameData[28] Tile_X0Y1_FrameStrobe[8] VPWR VGND sg13cmos5l_dlhq_1
X_5761_ _5761_/Q Tile_X0Y0_FrameData[1] Tile_X0Y1_FrameStrobe[5] VPWR VGND sg13cmos5l_dlhq_1
X_2973_ _2973_/X _4509_/Y _4503_/Y _5390_/B _5374_/B _6172_/Q _6170_/Q VPWR VGND sg13cmos5l_mux4_1
X_4712_ _4713_/B _4712_/A _4712_/B _4712_/C VPWR VGND sg13cmos5l_or3_1
X_5692_ _5692_/Q Tile_X0Y0_FrameData[6] Tile_X0Y1_FrameStrobe[3] VPWR VGND sg13cmos5l_dlhq_1
X_4643_ _4643_/Y _5708_/Q _2725_/Y _4642_/Y VPWR VGND sg13cmos5l_a21oi_1
X_4574_ _4585_/A _4612_/A _4574_/B VPWR VGND sg13cmos5l_and2_1
X_6313_ _6313_/Q Tile_X0Y1_FrameData[19] Tile_X0Y1_FrameStrobe[9] VPWR VGND sg13cmos5l_dlhq_1
X_3525_ _3525_/Y _6134_/Q _5374_/B VPWR VGND sg13cmos5l_nand2_1
XANTENNA__6696__X Tile_X0Y1_E2BEG[5] VPWR VGND sg13cmos5l_antennanp
X_6244_ _6244_/Q Tile_X0Y1_FrameData[24] Tile_X0Y1_FrameStrobe[7] VPWR VGND sg13cmos5l_dlhq_1
X_3456_ _6776_/A _3448_/Y _3450_/Y _3455_/Y VPWR VGND sg13cmos5l_o21ai_1
X_6175_ _6175_/Q Tile_X0Y1_FrameData[29] Tile_X0Y1_FrameStrobe[5] VPWR VGND sg13cmos5l_dlhq_1
X_3387_ _4308_/B _6091_/Q _3384_/X _3386_/Y VPWR VGND sg13cmos5l_o21ai_1
XFILLER_69_241 VPWR VGND sg13cmos5l_fill_1
X_5126_ _6532_/A _5116_/Y _5119_/Y _5123_/X _5125_/Y VPWR VGND sg13cmos5l_a22oi_1
XFILLER_69_274 VPWR VGND sg13cmos5l_decap_4
X_5057_ _6635_/A _5055_/Y _5056_/Y _5051_/Y VPWR VGND sg13cmos5l_a21oi_1
X_4008_ _4009_/B _4007_/A _4111_/A _4005_/Y VPWR VGND sg13cmos5l_a21oi_1
XFILLER_111_56 VPWR VGND sg13cmos5l_decap_8
XFILLER_111_34 VPWR VGND sg13cmos5l_decap_4
X_5959_ _5959_/Q Tile_X0Y0_FrameData[27] Tile_X0Y1_FrameStrobe[12] VPWR VGND sg13cmos5l_dlhq_1
XFILLER_111_67 VPWR VGND sg13cmos5l_fill_1
XFILLER_106_132 VPWR VGND sg13cmos5l_decap_4
XFILLER_105_3 VPWR VGND sg13cmos5l_fill_1
XFILLER_75_277 VPWR VGND sg13cmos5l_fill_2
XANTENNA_4 _6598_/A VPWR VGND sg13cmos5l_antennanp
X_3310_ _3311_/C _5726_/Q _3310_/B VPWR VGND sg13cmos5l_nand2_1
X_4290_ _4292_/B Tile_X0Y1_E2MID[0] _6238_/Q VPWR VGND sg13cmos5l_nor2b_1
X_3241_ _3241_/Y _5692_/Q _4943_/Y _5694_/Q VPWR VGND sg13cmos5l_o21ai_1
X_3172_ _3172_/Y _6419_/Q _3141_/Y _3170_/X VPWR VGND sg13cmos5l_o21ai_1
X_6862_ Tile_X0Y1_WW4BEG[10] Tile_X0Y1_WW4END[14] VPWR VGND sg13cmos5l_buf_1
X_5813_ _5813_/Q Tile_X0Y0_FrameData[13] Tile_X0Y1_FrameStrobe[7] VPWR VGND sg13cmos5l_dlhq_1
X_6793_ Tile_X0Y1_S4BEG[6] Tile_X0Y0_S4END[14] VPWR VGND sg13cmos5l_buf_1
X_5744_ _5744_/Q Tile_X0Y0_FrameData[18] Tile_X0Y1_FrameStrobe[5] VPWR VGND sg13cmos5l_dlhq_1
X_2956_ _2956_/Y _4024_/A _5630_/Q _5629_/Q VPWR VGND sg13cmos5l_a21oi_1
X_5675_ _5675_/Q Tile_X0Y0_FrameData[23] Tile_X0Y1_FrameStrobe[3] VPWR VGND sg13cmos5l_dlhq_1
X_2887_ _2887_/Y _4937_/Y VPWR VGND sg13cmos5l_inv_1
X_4626_ _4627_/B _5848_/Q _4625_/X _5847_/Q VPWR VGND sg13cmos5l_o21ai_1
X_4557_ _4557_/Y _5808_/Q Tile_X0Y0_E2MID[2] _5807_/Q VPWR VGND sg13cmos5l_a21oi_1
X_4488_ _4490_/B _4488_/A _4488_/B VPWR VGND sg13cmos5l_xnor2_1
X_3508_ _3509_/C Tile_X0Y1_N2MID[7] _6236_/Q _3507_/Y VPWR VGND sg13cmos5l_o21ai_1
XFILLER_103_124 VPWR VGND sg13cmos5l_decap_4
X_6227_ _6227_/Q Tile_X0Y1_FrameData[9] Tile_X0Y1_FrameStrobe[6] VPWR VGND sg13cmos5l_dlhq_1
X_3439_ _3439_/Y Tile_X0Y0_S1END[1] _5650_/Q _3438_/Y VPWR VGND sg13cmos5l_o21ai_1
X_6158_ _6158_/Q Tile_X0Y1_FrameData[14] Tile_X0Y1_FrameStrobe[4] VPWR VGND sg13cmos5l_dlhq_1
X_5109_ _5109_/Y _5937_/Q _5209_/B VPWR VGND sg13cmos5l_nand2_1
X_6089_ _6089_/Q Tile_X0Y1_FrameData[19] Tile_X0Y1_FrameStrobe[2] VPWR VGND sg13cmos5l_dlhq_1
XFILLER_72_214 VPWR VGND sg13cmos5l_fill_2
XFILLER_25_174 VPWR VGND sg13cmos5l_decap_4
XFILLER_13_347 VPWR VGND sg13cmos5l_decap_8
XFILLER_31_74 VPWR VGND sg13cmos5l_fill_2
XFILLER_103_0 VPWR VGND sg13cmos5l_fill_1
XFILLER_0_251 VPWR VGND sg13cmos5l_fill_2
XFILLER_16_141 VPWR VGND sg13cmos5l_fill_1
XFILLER_16_152 VPWR VGND sg13cmos5l_fill_1
XFILLER_31_122 VPWR VGND sg13cmos5l_fill_2
X_3790_ _4507_/B _3790_/A _3790_/B VPWR VGND sg13cmos5l_xor2_1
X_2810_ _2810_/Y Tile_X0Y1_W2END[7] VPWR VGND sg13cmos5l_inv_1
XFILLER_31_144 VPWR VGND sg13cmos5l_fill_1
X_2741_ _2741_/Y Tile_X0Y0_S2MID[5] VPWR VGND sg13cmos5l_inv_1
X_5460_ _5460_/Y _6330_/Q _5500_/B _6329_/Q VPWR VGND sg13cmos5l_a21oi_1
XFILLER_8_362 VPWR VGND sg13cmos5l_decap_8
X_4411_ _4411_/Y _6048_/Q _4410_/Y _6047_/Q VPWR VGND sg13cmos5l_o21ai_1
X_5391_ _5391_/Y _6364_/Q _5450_/B _5390_/Y VPWR VGND sg13cmos5l_a21oi_1
X_4342_ _4342_/Y Tile_X0Y1_W2END[2] _6018_/Q _6017_/Q VPWR VGND sg13cmos5l_o21ai_1
X_4273_ _4274_/B _4273_/A _4273_/B VPWR VGND sg13cmos5l_xnor2_1
X_6012_ _6012_/Q Tile_X0Y1_UserCLK _6012_/D _6480_/L_HI VPWR VGND sg13cmos5l_dfrbpq_1
X_3224_ _3224_/Y Tile_X0Y0_S2END[5] _5618_/Q _5617_/Q VPWR VGND sg13cmos5l_o21ai_1
.ends
