* NGSPICE file created from N_IO.ext - technology: ihp-sg13cmos5l

* Black-box entry subcircuit for sg13cmos5l_antennanp abstract view
.subckt sg13cmos5l_antennanp A VDD VSS
.ends

* Black-box entry subcircuit for sg13cmos5l_decap_8 abstract view
.subckt sg13cmos5l_decap_8 VDD VSS
.ends

* Black-box entry subcircuit for sg13cmos5l_decap_4 abstract view
.subckt sg13cmos5l_decap_4 VDD VSS
.ends

* Black-box entry subcircuit for sg13cmos5l_fill_1 abstract view
.subckt sg13cmos5l_fill_1 VDD VSS
.ends

* Black-box entry subcircuit for sg13cmos5l_fill_2 abstract view
.subckt sg13cmos5l_fill_2 VDD VSS
.ends

* Black-box entry subcircuit for sg13cmos5l_buf_1 abstract view
.subckt sg13cmos5l_buf_1 X A VDD VSS
.ends

* Black-box entry subcircuit for sg13cmos5l_buf_8 abstract view
.subckt sg13cmos5l_buf_8 X A VDD VSS
.ends

.subckt N_IO Ci FrameData[0] FrameData[10] FrameData[11] FrameData[12] FrameData[13]
+ FrameData[14] FrameData[15] FrameData[16] FrameData[17] FrameData[18] FrameData[19]
+ FrameData[1] FrameData[20] FrameData[21] FrameData[22] FrameData[23] FrameData[24]
+ FrameData[25] FrameData[26] FrameData[27] FrameData[28] FrameData[29] FrameData[2]
+ FrameData[30] FrameData[31] FrameData[3] FrameData[4] FrameData[5] FrameData[6]
+ FrameData[7] FrameData[8] FrameData[9] FrameData_O[0] FrameData_O[10] FrameData_O[11]
+ FrameData_O[12] FrameData_O[13] FrameData_O[14] FrameData_O[15] FrameData_O[16]
+ FrameData_O[17] FrameData_O[18] FrameData_O[19] FrameData_O[1] FrameData_O[20] FrameData_O[21]
+ FrameData_O[22] FrameData_O[23] FrameData_O[24] FrameData_O[25] FrameData_O[26]
+ FrameData_O[27] FrameData_O[28] FrameData_O[29] FrameData_O[2] FrameData_O[30] FrameData_O[31]
+ FrameData_O[3] FrameData_O[4] FrameData_O[5] FrameData_O[6] FrameData_O[7] FrameData_O[8]
+ FrameData_O[9] FrameStrobe[0] FrameStrobe[10] FrameStrobe[11] FrameStrobe[12] FrameStrobe[13]
+ FrameStrobe[14] FrameStrobe[15] FrameStrobe[16] FrameStrobe[17] FrameStrobe[18]
+ FrameStrobe[19] FrameStrobe[1] FrameStrobe[2] FrameStrobe[3] FrameStrobe[4] FrameStrobe[5]
+ FrameStrobe[6] FrameStrobe[7] FrameStrobe[8] FrameStrobe[9] FrameStrobe_O[0] FrameStrobe_O[10]
+ FrameStrobe_O[11] FrameStrobe_O[12] FrameStrobe_O[13] FrameStrobe_O[14] FrameStrobe_O[15]
+ FrameStrobe_O[16] FrameStrobe_O[17] FrameStrobe_O[18] FrameStrobe_O[19] FrameStrobe_O[1]
+ FrameStrobe_O[2] FrameStrobe_O[3] FrameStrobe_O[4] FrameStrobe_O[5] FrameStrobe_O[6]
+ FrameStrobe_O[7] FrameStrobe_O[8] FrameStrobe_O[9] N1END[0] N1END[1] N1END[2] N1END[3]
+ N2END[0] N2END[1] N2END[2] N2END[3] N2END[4] N2END[5] N2END[6] N2END[7] N2MID[0]
+ N2MID[1] N2MID[2] N2MID[3] N2MID[4] N2MID[5] N2MID[6] N2MID[7] N4END[0] N4END[10]
+ N4END[11] N4END[12] N4END[13] N4END[14] N4END[15] N4END[1] N4END[2] N4END[3] N4END[4]
+ N4END[5] N4END[6] N4END[7] N4END[8] N4END[9] NN4END[0] NN4END[10] NN4END[11] NN4END[12]
+ NN4END[13] NN4END[14] NN4END[15] NN4END[1] NN4END[2] NN4END[3] NN4END[4] NN4END[5]
+ NN4END[6] NN4END[7] NN4END[8] NN4END[9] S1BEG[0] S1BEG[1] S1BEG[2] S1BEG[3] S2BEG[0]
+ S2BEG[1] S2BEG[2] S2BEG[3] S2BEG[4] S2BEG[5] S2BEG[6] S2BEG[7] S2BEGb[0] S2BEGb[1]
+ S2BEGb[2] S2BEGb[3] S2BEGb[4] S2BEGb[5] S2BEGb[6] S2BEGb[7] S4BEG[0] S4BEG[10] S4BEG[11]
+ S4BEG[12] S4BEG[13] S4BEG[14] S4BEG[15] S4BEG[1] S4BEG[2] S4BEG[3] S4BEG[4] S4BEG[5]
+ S4BEG[6] S4BEG[7] S4BEG[8] S4BEG[9] SS4BEG[0] SS4BEG[10] SS4BEG[11] SS4BEG[12] SS4BEG[13]
+ SS4BEG[14] SS4BEG[15] SS4BEG[1] SS4BEG[2] SS4BEG[3] SS4BEG[4] SS4BEG[5] SS4BEG[6]
+ SS4BEG[7] SS4BEG[8] SS4BEG[9] UIO_TOP_UIN0 UIO_TOP_UIN1 UIO_TOP_UIN10 UIO_TOP_UIN11
+ UIO_TOP_UIN12 UIO_TOP_UIN13 UIO_TOP_UIN14 UIO_TOP_UIN15 UIO_TOP_UIN16 UIO_TOP_UIN17
+ UIO_TOP_UIN18 UIO_TOP_UIN19 UIO_TOP_UIN2 UIO_TOP_UIN3 UIO_TOP_UIN4 UIO_TOP_UIN5
+ UIO_TOP_UIN6 UIO_TOP_UIN7 UIO_TOP_UIN8 UIO_TOP_UIN9 UIO_TOP_UOUT0 UIO_TOP_UOUT1
+ UIO_TOP_UOUT10 UIO_TOP_UOUT11 UIO_TOP_UOUT12 UIO_TOP_UOUT13 UIO_TOP_UOUT14 UIO_TOP_UOUT15
+ UIO_TOP_UOUT16 UIO_TOP_UOUT17 UIO_TOP_UOUT18 UIO_TOP_UOUT19 UIO_TOP_UOUT2 UIO_TOP_UOUT3
+ UIO_TOP_UOUT4 UIO_TOP_UOUT5 UIO_TOP_UOUT6 UIO_TOP_UOUT7 UIO_TOP_UOUT8 UIO_TOP_UOUT9
+ UserCLK UserCLKo VGND VPWR
XANTENNA__043__X S2BEGb[5] VPWR VGND sg13cmos5l_antennanp
XFILLER_10_339 VPWR VGND sg13cmos5l_decap_8
XFILLER_3_23 VPWR VGND sg13cmos5l_decap_4
XFILLER_5_343 VPWR VGND sg13cmos5l_fill_1
XFILLER_5_387 VPWR VGND sg13cmos5l_fill_1
XFILLER_5_398 VPWR VGND sg13cmos5l_decap_4
XFILLER_9_148 VPWR VGND sg13cmos5l_decap_8
XANTENNA__038__X S2BEGb[0] VPWR VGND sg13cmos5l_antennanp
XFILLER_8_181 VPWR VGND sg13cmos5l_fill_1
XFILLER_10_158 VPWR VGND sg13cmos5l_fill_2
XFILLER_2_302 VPWR VGND sg13cmos5l_decap_8
XFILLER_2_368 VPWR VGND sg13cmos5l_decap_8
XANTENNA__124__A FrameData[31] VPWR VGND sg13cmos5l_antennanp
XANTENNA__034__A UIO_TOP_UIN3 VPWR VGND sg13cmos5l_antennanp
XFILLER_11_434 VPWR VGND sg13cmos5l_decap_4
X_062_ UIO_TOP_UOUT16 NN4END[3] VPWR VGND sg13cmos5l_buf_1
XANTENNA__119__A FrameData[26] VPWR VGND sg13cmos5l_antennanp
XFILLER_2_187 VPWR VGND sg13cmos5l_decap_8
XFILLER_9_44 VPWR VGND sg13cmos5l_fill_2
XANTENNA__029__A UIO_TOP_UIN8 VPWR VGND sg13cmos5l_antennanp
XANTENNA__051__X S2BEG[5] VPWR VGND sg13cmos5l_antennanp
XFILLER_11_231 VPWR VGND sg13cmos5l_decap_8
X_045_ S2BEGb[7] N2END[0] VPWR VGND sg13cmos5l_buf_1
X_114_ FrameData_O[21] FrameData[21] VPWR VGND sg13cmos5l_buf_1
XFILLER_7_268 VPWR VGND sg13cmos5l_decap_8
XFILLER_7_235 VPWR VGND sg13cmos5l_decap_8
XANTENNA__046__X S2BEG[0] VPWR VGND sg13cmos5l_antennanp
XFILLER_0_433 VPWR VGND sg13cmos5l_decap_4
XFILLER_3_293 VPWR VGND sg13cmos5l_decap_8
XFILLER_6_12 VPWR VGND sg13cmos5l_decap_8
X_028_ S4BEG[6] UIO_TOP_UIN9 VPWR VGND sg13cmos5l_buf_1
XANTENNA__042__A N2END[3] VPWR VGND sg13cmos5l_antennanp
XFILLER_0_285 VPWR VGND sg13cmos5l_decap_8
XFILLER_8_330 VPWR VGND sg13cmos5l_decap_8
XANTENNA__037__A UIO_TOP_UIN0 VPWR VGND sg13cmos5l_antennanp
XFILLER_11_0 VPWR VGND sg13cmos5l_decap_8
XFILLER_5_355 VPWR VGND sg13cmos5l_fill_1
XFILLER_5_366 VPWR VGND sg13cmos5l_decap_8
XFILLER_9_127 VPWR VGND sg13cmos5l_decap_8
XFILLER_9_105 VPWR VGND sg13cmos5l_decap_4
XFILLER_8_171 VPWR VGND sg13cmos5l_fill_2
XANTENNA__054__X UIO_TOP_UOUT0 VPWR VGND sg13cmos5l_antennanp
XFILLER_10_104 VPWR VGND sg13cmos5l_fill_2
XFILLER_10_126 VPWR VGND sg13cmos5l_decap_8
XFILLER_2_347 VPWR VGND sg13cmos5l_decap_8
XFILLER_6_119 VPWR VGND sg13cmos5l_decap_4
XFILLER_1_391 VPWR VGND sg13cmos5l_decap_8
XANTENNA__049__X S2BEG[3] VPWR VGND sg13cmos5l_antennanp
XANTENNA__050__A N2MID[3] VPWR VGND sg13cmos5l_antennanp
XFILLER_11_413 VPWR VGND sg13cmos5l_decap_8
XFILLER_7_406 VPWR VGND sg13cmos5l_fill_2
XFILLER_2_166 VPWR VGND sg13cmos5l_decap_8
X_061_ UIO_TOP_UOUT15 NN4END[0] VPWR VGND sg13cmos5l_buf_1
XFILLER_9_67 VPWR VGND sg13cmos5l_fill_2
XFILLER_9_56 VPWR VGND sg13cmos5l_decap_8
XFILLER_9_34 VPWR VGND sg13cmos5l_fill_2
XFILLER_9_23 VPWR VGND sg13cmos5l_decap_8
XFILLER_7_428 VPWR VGND sg13cmos5l_decap_8
XANTENNA__045__A N2END[0] VPWR VGND sg13cmos5l_antennanp
XFILLER_11_210 VPWR VGND sg13cmos5l_decap_8
XFILLER_11_287 VPWR VGND sg13cmos5l_decap_8
XFILLER_3_431 VPWR VGND sg13cmos5l_decap_8
X_044_ S2BEGb[6] N2END[1] VPWR VGND sg13cmos5l_buf_1
X_113_ FrameData_O[20] FrameData[20] VPWR VGND sg13cmos5l_buf_1
XFILLER_7_214 VPWR VGND sg13cmos5l_decap_8
XANTENNA__062__X UIO_TOP_UOUT16 VPWR VGND sg13cmos5l_antennanp
XFILLER_0_412 VPWR VGND sg13cmos5l_decap_8
XFILLER_4_239 VPWR VGND sg13cmos5l_decap_8
X_027_ S4BEG[5] UIO_TOP_UIN10 VPWR VGND sg13cmos5l_buf_1
XFILLER_6_46 VPWR VGND sg13cmos5l_fill_1
XANTENNA__057__X UIO_TOP_UOUT11 VPWR VGND sg13cmos5l_antennanp
XFILLER_0_264 VPWR VGND sg13cmos5l_decap_8
XFILLER_10_308 VPWR VGND sg13cmos5l_fill_2
XANTENNA__053__A N2MID[0] VPWR VGND sg13cmos5l_antennanp
XFILLER_5_334 VPWR VGND sg13cmos5l_decap_8
XFILLER_9_139 VPWR VGND sg13cmos5l_fill_2
XFILLER_8_194 VPWR VGND sg13cmos5l_fill_2
XFILLER_8_150 VPWR VGND sg13cmos5l_decap_8
XANTENNA__048__A N2MID[5] VPWR VGND sg13cmos5l_antennanp
XANTENNA__070__X UIO_TOP_UOUT6 VPWR VGND sg13cmos5l_antennanp
XFILLER_1_370 VPWR VGND sg13cmos5l_decap_8
XFILLER_5_164 VPWR VGND sg13cmos5l_decap_8
XFILLER_5_186 VPWR VGND sg13cmos5l_decap_8
XFILLER_5_197 VPWR VGND sg13cmos5l_decap_4
XANTENNA__065__X UIO_TOP_UOUT19 VPWR VGND sg13cmos5l_antennanp
XFILLER_0_59 VPWR VGND sg13cmos5l_decap_8
XFILLER_2_112 VPWR VGND sg13cmos5l_decap_8
XFILLER_2_145 VPWR VGND sg13cmos5l_decap_8
XFILLER_3_3 VPWR VGND sg13cmos5l_decap_8
X_060_ UIO_TOP_UOUT14 NN4END[1] VPWR VGND sg13cmos5l_buf_1
XANTENNA__061__A NN4END[0] VPWR VGND sg13cmos5l_antennanp
XFILLER_11_266 VPWR VGND sg13cmos5l_decap_8
X_043_ S2BEGb[5] N2END[2] VPWR VGND sg13cmos5l_buf_1
X_112_ FrameData_O[19] FrameData[19] VPWR VGND sg13cmos5l_buf_1
XFILLER_7_248 VPWR VGND sg13cmos5l_decap_8
XFILLER_6_281 VPWR VGND sg13cmos5l_fill_1
XANTENNA__056__A NN4END[5] VPWR VGND sg13cmos5l_antennanp
XFILLER_1_91 VPWR VGND sg13cmos5l_fill_2
XFILLER_4_218 VPWR VGND sg13cmos5l_decap_8
X_026_ S4BEG[4] UIO_TOP_UIN11 VPWR VGND sg13cmos5l_buf_1
XFILLER_6_69 VPWR VGND sg13cmos5l_decap_8
XANTENNA__073__X FrameStrobe_O[2] VPWR VGND sg13cmos5l_antennanp
XFILLER_0_210 VPWR VGND sg13cmos5l_decap_8
XFILLER_0_243 VPWR VGND sg13cmos5l_decap_8
X_009_ SS4BEG[3] UIO_TOP_UIN16 VPWR VGND sg13cmos5l_buf_1
XFILLER_8_398 VPWR VGND sg13cmos5l_decap_8
XFILLER_8_376 VPWR VGND sg13cmos5l_fill_2
XFILLER_8_365 VPWR VGND sg13cmos5l_decap_8
XANTENNA__068__X UIO_TOP_UOUT4 VPWR VGND sg13cmos5l_antennanp
XFILLER_5_313 VPWR VGND sg13cmos5l_decap_4
XFILLER_8_173 VPWR VGND sg13cmos5l_fill_1
XANTENNA__064__A NN4END[1] VPWR VGND sg13cmos5l_antennanp
XFILLER_10_106 VPWR VGND sg13cmos5l_fill_1
XFILLER_2_316 VPWR VGND sg13cmos5l_decap_8
XFILLER_5_7 VPWR VGND sg13cmos5l_fill_2
XFILLER_5_143 VPWR VGND sg13cmos5l_decap_8
XFILLER_4_91 VPWR VGND sg13cmos5l_fill_2
XANTENNA__059__A NN4END[2] VPWR VGND sg13cmos5l_antennanp
XANTENNA__081__X FrameStrobe_O[10] VPWR VGND sg13cmos5l_antennanp
XFILLER_0_16 VPWR VGND sg13cmos5l_decap_8
XFILLER_0_27 VPWR VGND sg13cmos5l_fill_1
XFILLER_0_38 VPWR VGND sg13cmos5l_decap_8
XANTENNA__076__X FrameStrobe_O[5] VPWR VGND sg13cmos5l_antennanp
XFILLER_11_245 VPWR VGND sg13cmos5l_decap_8
X_042_ S2BEGb[4] N2END[3] VPWR VGND sg13cmos5l_buf_1
X_111_ FrameData_O[18] FrameData[18] VPWR VGND sg13cmos5l_buf_1
XANTENNA__072__A FrameStrobe[1] VPWR VGND sg13cmos5l_antennanp
XFILLER_6_26 VPWR VGND sg13cmos5l_decap_8
X_025_ S4BEG[3] UIO_TOP_UIN12 VPWR VGND sg13cmos5l_buf_1
XFILLER_6_37 VPWR VGND sg13cmos5l_decap_8
XFILLER_10_90 VPWR VGND sg13cmos5l_fill_1
XANTENNA__067__A NN4END[12] VPWR VGND sg13cmos5l_antennanp
XFILLER_0_200 VPWR VGND sg13cmos5l_decap_8
XFILLER_0_299 VPWR VGND sg13cmos5l_decap_8
X_008_ SS4BEG[2] UIO_TOP_UIN17 VPWR VGND sg13cmos5l_buf_1
XFILLER_8_344 VPWR VGND sg13cmos5l_decap_8
XFILLER_8_311 VPWR VGND sg13cmos5l_fill_2
XFILLER_8_300 VPWR VGND sg13cmos5l_decap_8
XANTENNA__084__X FrameStrobe_O[13] VPWR VGND sg13cmos5l_antennanp
XFILLER_3_27 VPWR VGND sg13cmos5l_fill_2
XFILLER_3_49 VPWR VGND sg13cmos5l_fill_2
XFILLER_9_119 VPWR VGND sg13cmos5l_decap_4
XANTENNA__079__X FrameStrobe_O[8] VPWR VGND sg13cmos5l_antennanp
XANTENNA__080__A FrameStrobe[9] VPWR VGND sg13cmos5l_antennanp
XANTENNA__075__A FrameStrobe[4] VPWR VGND sg13cmos5l_antennanp
XFILLER_11_427 VPWR VGND sg13cmos5l_decap_8
XFILLER_4_81 VPWR VGND sg13cmos5l_decap_4
XFILLER_6_431 VPWR VGND sg13cmos5l_decap_8
XFILLER_6_420 VPWR VGND sg13cmos5l_fill_1
XANTENNA__092__X UIO_TOP_UOUT8 VPWR VGND sg13cmos5l_antennanp
XFILLER_11_224 VPWR VGND sg13cmos5l_decap_8
X_041_ S2BEGb[3] N2END[4] VPWR VGND sg13cmos5l_buf_1
X_110_ FrameData_O[17] FrameData[17] VPWR VGND sg13cmos5l_buf_1
Xclkload0 clkload0/X clkload0/A VPWR VGND sg13cmos5l_buf_1
XFILLER_7_228 VPWR VGND sg13cmos5l_fill_2
XFILLER_1_93 VPWR VGND sg13cmos5l_fill_1
XFILLER_6_261 VPWR VGND sg13cmos5l_decap_8
XFILLER_6_294 VPWR VGND sg13cmos5l_decap_8
XANTENNA__087__X FrameStrobe_O[16] VPWR VGND sg13cmos5l_antennanp
XFILLER_0_426 VPWR VGND sg13cmos5l_decap_8
XFILLER_0_437 VPWR VGND sg13cmos5l_fill_1
XFILLER_3_242 VPWR VGND sg13cmos5l_decap_8
XFILLER_3_286 VPWR VGND sg13cmos5l_decap_8
X_024_ S4BEG[2] UIO_TOP_UIN13 VPWR VGND sg13cmos5l_buf_1
XANTENNA__083__A FrameStrobe[12] VPWR VGND sg13cmos5l_antennanp
XFILLER_0_278 VPWR VGND sg13cmos5l_decap_8
X_007_ SS4BEG[1] UIO_TOP_UIN18 VPWR VGND sg13cmos5l_buf_1
XFILLER_8_323 VPWR VGND sg13cmos5l_decap_4
XANTENNA__078__A FrameStrobe[7] VPWR VGND sg13cmos5l_antennanp
XFILLER_3_17 VPWR VGND sg13cmos5l_fill_2
XFILLER_5_348 VPWR VGND sg13cmos5l_decap_8
XFILLER_5_359 VPWR VGND sg13cmos5l_decap_8
XFILLER_8_164 VPWR VGND sg13cmos5l_decap_8
XANTENNA__095__X FrameData_O[2] VPWR VGND sg13cmos5l_antennanp
XFILLER_10_119 VPWR VGND sg13cmos5l_fill_2
XFILLER_1_384 VPWR VGND sg13cmos5l_decap_8
XFILLER_5_123 VPWR VGND sg13cmos5l_fill_2
XANTENNA__091__A NN4END[8] VPWR VGND sg13cmos5l_antennanp
XFILLER_11_406 VPWR VGND sg13cmos5l_decap_8
XFILLER_4_60 VPWR VGND sg13cmos5l_decap_8
XFILLER_4_93 VPWR VGND sg13cmos5l_fill_1
XFILLER_2_126 VPWR VGND sg13cmos5l_fill_2
XFILLER_2_159 VPWR VGND sg13cmos5l_decap_8
XFILLER_9_49 VPWR VGND sg13cmos5l_decap_8
XFILLER_9_16 VPWR VGND sg13cmos5l_decap_8
XFILLER_9_292 VPWR VGND sg13cmos5l_fill_2
XANTENNA__086__A FrameStrobe[15] VPWR VGND sg13cmos5l_antennanp
XFILLER_11_203 VPWR VGND sg13cmos5l_decap_8
XFILLER_3_424 VPWR VGND sg13cmos5l_decap_8
X_040_ S2BEGb[2] N2END[5] VPWR VGND sg13cmos5l_buf_1
XFILLER_1_61 VPWR VGND sg13cmos5l_decap_4
XFILLER_0_405 VPWR VGND sg13cmos5l_decap_8
XFILLER_3_221 VPWR VGND sg13cmos5l_decap_8
X_023_ S4BEG[1] UIO_TOP_UIN14 VPWR VGND sg13cmos5l_buf_1
XANTENNA__098__X FrameData_O[5] VPWR VGND sg13cmos5l_antennanp
XFILLER_0_224 VPWR VGND sg13cmos5l_decap_4
XFILLER_0_257 VPWR VGND sg13cmos5l_decap_8
X_006_ SS4BEG[0] UIO_TOP_UIN19 VPWR VGND sg13cmos5l_buf_1
XANTENNA__094__A FrameData[1] VPWR VGND sg13cmos5l_antennanp
XFILLER_5_305 VPWR VGND sg13cmos5l_decap_4
XFILLER_5_327 VPWR VGND sg13cmos5l_decap_8
XFILLER_8_143 VPWR VGND sg13cmos5l_fill_2
XANTENNA__089__A FrameStrobe[18] VPWR VGND sg13cmos5l_antennanp
XFILLER_1_363 VPWR VGND sg13cmos5l_decap_8
XFILLER_5_102 VPWR VGND sg13cmos5l_decap_8
XFILLER_5_157 VPWR VGND sg13cmos5l_decap_8
XFILLER_5_179 VPWR VGND sg13cmos5l_decap_8
XFILLER_4_190 VPWR VGND sg13cmos5l_decap_4
XFILLER_2_105 VPWR VGND sg13cmos5l_decap_8
XFILLER_2_138 VPWR VGND sg13cmos5l_decap_8
XFILLER_6_400 VPWR VGND sg13cmos5l_decap_4
XFILLER_11_259 VPWR VGND sg13cmos5l_decap_8
XFILLER_1_4 VPWR VGND sg13cmos5l_fill_1
XFILLER_3_403 VPWR VGND sg13cmos5l_decap_8
XFILLER_7_208 VPWR VGND sg13cmos5l_fill_2
XFILLER_10_281 VPWR VGND sg13cmos5l_fill_2
XFILLER_6_230 VPWR VGND sg13cmos5l_decap_8
XFILLER_6_285 VPWR VGND sg13cmos5l_decap_4
X_099_ FrameData_O[6] FrameData[6] VPWR VGND sg13cmos5l_buf_1
XFILLER_1_51 VPWR VGND sg13cmos5l_fill_1
XANTENNA__097__A FrameData[4] VPWR VGND sg13cmos5l_antennanp
XFILLER_3_200 VPWR VGND sg13cmos5l_decap_8
XFILLER_3_266 VPWR VGND sg13cmos5l_decap_8
XFILLER_3_277 VPWR VGND sg13cmos5l_decap_4
X_022_ S4BEG[0] UIO_TOP_UIN15 VPWR VGND sg13cmos5l_buf_1
X_005_ S1BEG[3] N1END[0] VPWR VGND sg13cmos5l_buf_1
XFILLER_8_358 VPWR VGND sg13cmos5l_decap_8
XFILLER_7_61 VPWR VGND sg13cmos5l_decap_4
XFILLER_7_50 VPWR VGND sg13cmos5l_decap_8
XFILLER_5_317 VPWR VGND sg13cmos5l_fill_2
XFILLER_7_83 VPWR VGND sg13cmos5l_fill_2
XFILLER_3_19 VPWR VGND sg13cmos5l_fill_1
XFILLER_4_350 VPWR VGND sg13cmos5l_fill_1
XFILLER_8_199 VPWR VGND sg13cmos5l_decap_8
XFILLER_8_177 VPWR VGND sg13cmos5l_decap_4
XFILLER_8_122 VPWR VGND sg13cmos5l_decap_8
XFILLER_2_309 VPWR VGND sg13cmos5l_decap_8
XFILLER_5_136 VPWR VGND sg13cmos5l_decap_8
XFILLER_1_183 VPWR VGND sg13cmos5l_fill_1
XFILLER_9_261 VPWR VGND sg13cmos5l_fill_1
XFILLER_9_250 VPWR VGND sg13cmos5l_decap_8
XANTENNA__000__X UIO_TOP_UOUT9 VPWR VGND sg13cmos5l_antennanp
XFILLER_11_238 VPWR VGND sg13cmos5l_decap_8
XFILLER_9_283 VPWR VGND sg13cmos5l_decap_4
XFILLER_10_271 VPWR VGND sg13cmos5l_decap_8
XFILLER_6_242 VPWR VGND sg13cmos5l_decap_8
X_098_ FrameData_O[5] FrameData[5] VPWR VGND sg13cmos5l_buf_1
XFILLER_1_30 VPWR VGND sg13cmos5l_fill_1
XFILLER_10_83 VPWR VGND sg13cmos5l_decap_4
XFILLER_3_256 VPWR VGND sg13cmos5l_decap_8
XFILLER_6_19 VPWR VGND sg13cmos5l_decap_8
X_021_ SS4BEG[15] N4END[0] VPWR VGND sg13cmos5l_buf_1
XFILLER_0_237 VPWR VGND sg13cmos5l_fill_2
XFILLER_11_7 VPWR VGND sg13cmos5l_decap_8
X_004_ S1BEG[2] N1END[1] VPWR VGND sg13cmos5l_buf_1
XFILLER_8_337 VPWR VGND sg13cmos5l_decap_8
XFILLER_7_381 VPWR VGND sg13cmos5l_decap_8
XFILLER_8_145 VPWR VGND sg13cmos5l_fill_1
XFILLER_8_101 VPWR VGND sg13cmos5l_decap_8
XFILLER_4_362 VPWR VGND sg13cmos5l_decap_8
XANTENNA__003__X S1BEG[1] VPWR VGND sg13cmos5l_antennanp
XFILLER_1_398 VPWR VGND sg13cmos5l_fill_1
XFILLER_4_74 VPWR VGND sg13cmos5l_decap_4
XFILLER_4_85 VPWR VGND sg13cmos5l_fill_2
XFILLER_9_432 VPWR VGND sg13cmos5l_decap_4
XFILLER_1_151 VPWR VGND sg13cmos5l_fill_2
XFILLER_1_162 VPWR VGND sg13cmos5l_fill_1
XFILLER_6_424 VPWR VGND sg13cmos5l_decap_8
XFILLER_11_217 VPWR VGND sg13cmos5l_decap_8
XANTENNA__101__X FrameData_O[8] VPWR VGND sg13cmos5l_antennanp
XFILLER_10_283 VPWR VGND sg13cmos5l_fill_1
X_097_ FrameData_O[4] FrameData[4] VPWR VGND sg13cmos5l_buf_1
XANTENNA__011__X SS4BEG[5] VPWR VGND sg13cmos5l_antennanp
XFILLER_0_419 VPWR VGND sg13cmos5l_decap_8
XFILLER_10_62 VPWR VGND sg13cmos5l_fill_1
XFILLER_3_235 VPWR VGND sg13cmos5l_decap_8
X_020_ SS4BEG[14] N4END[1] VPWR VGND sg13cmos5l_buf_1
XFILLER_10_95 VPWR VGND sg13cmos5l_decap_4
XANTENNA__006__X SS4BEG[0] VPWR VGND sg13cmos5l_antennanp
X_003_ S1BEG[1] N1END[2] VPWR VGND sg13cmos5l_buf_1
XFILLER_8_316 VPWR VGND sg13cmos5l_fill_2
XANTENNA__002__A N1END[3] VPWR VGND sg13cmos5l_antennanp
XFILLER_7_96 VPWR VGND sg13cmos5l_decap_8
XFILLER_7_360 VPWR VGND sg13cmos5l_decap_8
XFILLER_4_396 VPWR VGND sg13cmos5l_decap_8
XFILLER_8_157 VPWR VGND sg13cmos5l_decap_8
XFILLER_5_116 VPWR VGND sg13cmos5l_decap_8
XANTENNA__104__X FrameData_O[11] VPWR VGND sg13cmos5l_antennanp
XFILLER_1_377 VPWR VGND sg13cmos5l_decap_8
XFILLER_9_411 VPWR VGND sg13cmos5l_decap_8
XANTENNA__014__X SS4BEG[8] VPWR VGND sg13cmos5l_antennanp
XFILLER_2_119 VPWR VGND sg13cmos5l_decap_8
XFILLER_4_53 VPWR VGND sg13cmos5l_decap_8
XFILLER_10_421 VPWR VGND sg13cmos5l_decap_8
XFILLER_8_0 VPWR VGND sg13cmos5l_decap_8
XANTENNA__010__A N4END[11] VPWR VGND sg13cmos5l_antennanp
XANTENNA__100__A FrameData[7] VPWR VGND sg13cmos5l_antennanp
XFILLER_9_230 VPWR VGND sg13cmos5l_decap_8
XANTENNA__009__X SS4BEG[3] VPWR VGND sg13cmos5l_antennanp
XFILLER_3_417 VPWR VGND sg13cmos5l_decap_8
XFILLER_10_251 VPWR VGND sg13cmos5l_fill_1
XFILLER_10_295 VPWR VGND sg13cmos5l_decap_4
X_096_ FrameData_O[3] FrameData[3] VPWR VGND sg13cmos5l_buf_1
XANTENNA__005__A N1END[0] VPWR VGND sg13cmos5l_antennanp
Xclkbuf_1_1__f_UserCLK _001_/A clkbuf_0_UserCLK/X VPWR VGND sg13cmos5l_buf_8
XFILLER_10_74 VPWR VGND sg13cmos5l_decap_4
XFILLER_3_214 VPWR VGND sg13cmos5l_decap_8
XANTENNA__112__X FrameData_O[19] VPWR VGND sg13cmos5l_antennanp
XFILLER_0_217 VPWR VGND sg13cmos5l_decap_8
X_079_ FrameStrobe_O[8] FrameStrobe[8] VPWR VGND sg13cmos5l_buf_1
XANTENNA__022__X S4BEG[0] VPWR VGND sg13cmos5l_antennanp
XFILLER_0_239 VPWR VGND sg13cmos5l_fill_1
X_002_ S1BEG[0] N1END[3] VPWR VGND sg13cmos5l_buf_1
XANTENNA__107__X FrameData_O[14] VPWR VGND sg13cmos5l_antennanp
XANTENNA__017__X SS4BEG[11] VPWR VGND sg13cmos5l_antennanp
XFILLER_5_309 VPWR VGND sg13cmos5l_fill_1
XANTENNA__103__A FrameData[10] VPWR VGND sg13cmos5l_antennanp
XFILLER_8_136 VPWR VGND sg13cmos5l_decap_8
XANTENNA__013__A N4END[8] VPWR VGND sg13cmos5l_antennanp
XFILLER_7_180 VPWR VGND sg13cmos5l_decap_8
XFILLER_1_356 VPWR VGND sg13cmos5l_decap_8
XANTENNA__008__A UIO_TOP_UIN17 VPWR VGND sg13cmos5l_antennanp
XANTENNA__120__X FrameData_O[27] VPWR VGND sg13cmos5l_antennanp
XFILLER_4_161 VPWR VGND sg13cmos5l_decap_8
XFILLER_4_183 VPWR VGND sg13cmos5l_fill_2
XFILLER_4_32 VPWR VGND sg13cmos5l_decap_8
XANTENNA__030__X S4BEG[8] VPWR VGND sg13cmos5l_antennanp
XFILLER_10_411 VPWR VGND sg13cmos5l_decap_4
XFILLER_6_404 VPWR VGND sg13cmos5l_fill_2
XANTENNA__115__X FrameData_O[22] VPWR VGND sg13cmos5l_antennanp
XFILLER_1_197 VPWR VGND sg13cmos5l_fill_2
XANTENNA__025__X S4BEG[3] VPWR VGND sg13cmos5l_antennanp
XANTENNA__111__A FrameData[18] VPWR VGND sg13cmos5l_antennanp
XFILLER_10_230 VPWR VGND sg13cmos5l_decap_4
XFILLER_10_263 VPWR VGND sg13cmos5l_fill_1
XFILLER_1_77 VPWR VGND sg13cmos5l_fill_2
XFILLER_6_223 VPWR VGND sg13cmos5l_decap_8
XFILLER_6_256 VPWR VGND sg13cmos5l_fill_1
XFILLER_6_289 VPWR VGND sg13cmos5l_fill_2
X_095_ FrameData_O[2] FrameData[2] VPWR VGND sg13cmos5l_buf_1
XANTENNA__021__A N4END[0] VPWR VGND sg13cmos5l_antennanp
XFILLER_10_31 VPWR VGND sg13cmos5l_decap_4
XANTENNA__016__A N4END[5] VPWR VGND sg13cmos5l_antennanp
XANTENNA__106__A FrameData[13] VPWR VGND sg13cmos5l_antennanp
XFILLER_2_281 VPWR VGND sg13cmos5l_decap_8
X_078_ FrameStrobe_O[7] FrameStrobe[7] VPWR VGND sg13cmos5l_buf_1
X_001_ UserCLKo _001_/A VPWR VGND sg13cmos5l_buf_1
XFILLER_8_318 VPWR VGND sg13cmos5l_fill_1
XFILLER_8_307 VPWR VGND sg13cmos5l_decap_4
XANTENNA__123__X FrameData_O[30] VPWR VGND sg13cmos5l_antennanp
XFILLER_7_76 VPWR VGND sg13cmos5l_decap_8
XFILLER_7_65 VPWR VGND sg13cmos5l_fill_1
XFILLER_7_43 VPWR VGND sg13cmos5l_decap_8
XFILLER_7_395 VPWR VGND sg13cmos5l_decap_8
XANTENNA__033__X S4BEG[11] VPWR VGND sg13cmos5l_antennanp
XFILLER_4_321 VPWR VGND sg13cmos5l_fill_2
XFILLER_4_343 VPWR VGND sg13cmos5l_decap_8
XFILLER_4_376 VPWR VGND sg13cmos5l_decap_8
XFILLER_8_115 VPWR VGND sg13cmos5l_decap_8
XANTENNA__118__X FrameData_O[25] VPWR VGND sg13cmos5l_antennanp
XANTENNA__028__X S4BEG[6] VPWR VGND sg13cmos5l_antennanp
XFILLER_5_129 VPWR VGND sg13cmos5l_decap_4
XANTENNA__114__A FrameData[21] VPWR VGND sg13cmos5l_antennanp
XFILLER_4_11 VPWR VGND sg13cmos5l_decap_8
XANTENNA__024__A UIO_TOP_UIN13 VPWR VGND sg13cmos5l_antennanp
XFILLER_6_416 VPWR VGND sg13cmos5l_decap_4
XANTENNA__109__A FrameData[16] VPWR VGND sg13cmos5l_antennanp
XFILLER_9_298 VPWR VGND sg13cmos5l_fill_2
XFILLER_9_287 VPWR VGND sg13cmos5l_fill_2
XFILLER_9_276 VPWR VGND sg13cmos5l_decap_8
XFILLER_9_243 VPWR VGND sg13cmos5l_decap_8
XANTENNA__019__A N4END[2] VPWR VGND sg13cmos5l_antennanp
XANTENNA__041__X S2BEGb[3] VPWR VGND sg13cmos5l_antennanp
XFILLER_10_220 VPWR VGND sg13cmos5l_fill_1
XFILLER_10_242 VPWR VGND sg13cmos5l_decap_4
XFILLER_6_202 VPWR VGND sg13cmos5l_decap_8
XFILLER_6_268 VPWR VGND sg13cmos5l_decap_8
XFILLER_6_279 VPWR VGND sg13cmos5l_fill_2
X_094_ FrameData_O[1] FrameData[1] VPWR VGND sg13cmos5l_buf_1
XANTENNA__036__X S4BEG[14] VPWR VGND sg13cmos5l_antennanp
XFILLER_3_249 VPWR VGND sg13cmos5l_decap_8
XANTENNA__122__A FrameData[29] VPWR VGND sg13cmos5l_antennanp
X_077_ FrameStrobe_O[6] FrameStrobe[6] VPWR VGND sg13cmos5l_buf_1
XANTENNA__032__A UIO_TOP_UIN5 VPWR VGND sg13cmos5l_antennanp
XANTENNA__117__A FrameData[24] VPWR VGND sg13cmos5l_antennanp
XFILLER_11_392 VPWR VGND sg13cmos5l_decap_8
X_000_ UIO_TOP_UOUT9 NN4END[6] VPWR VGND sg13cmos5l_buf_1
XFILLER_7_88 VPWR VGND sg13cmos5l_decap_4
XFILLER_7_374 VPWR VGND sg13cmos5l_decap_8
XFILLER_7_341 VPWR VGND sg13cmos5l_fill_2
XFILLER_7_22 VPWR VGND sg13cmos5l_fill_1
XFILLER_7_11 VPWR VGND sg13cmos5l_decap_8
XANTENNA__027__A UIO_TOP_UIN10 VPWR VGND sg13cmos5l_antennanp
XFILLER_4_333 VPWR VGND sg13cmos5l_decap_8
XFILLER_4_355 VPWR VGND sg13cmos5l_decap_8
XANTENNA__044__X S2BEGb[6] VPWR VGND sg13cmos5l_antennanp
XFILLER_1_303 VPWR VGND sg13cmos5l_decap_4
XFILLER_0_391 VPWR VGND sg13cmos5l_decap_8
XFILLER_4_130 VPWR VGND sg13cmos5l_decap_8
XFILLER_4_152 VPWR VGND sg13cmos5l_decap_4
XFILLER_4_185 VPWR VGND sg13cmos5l_fill_1
XFILLER_4_67 VPWR VGND sg13cmos5l_decap_8
XFILLER_9_436 VPWR VGND sg13cmos5l_fill_2
XFILLER_9_425 VPWR VGND sg13cmos5l_decap_8
XANTENNA__039__X S2BEGb[1] VPWR VGND sg13cmos5l_antennanp
XANTENNA__040__A N2END[5] VPWR VGND sg13cmos5l_antennanp
XFILLER_10_435 VPWR VGND sg13cmos5l_fill_2
XFILLER_9_266 VPWR VGND sg13cmos5l_decap_8
XANTENNA__035__A UIO_TOP_UIN2 VPWR VGND sg13cmos5l_antennanp
XFILLER_10_210 VPWR VGND sg13cmos5l_fill_2
XFILLER_2_431 VPWR VGND sg13cmos5l_decap_8
XFILLER_6_0 VPWR VGND sg13cmos5l_decap_8
X_093_ FrameData_O[0] FrameData[0] VPWR VGND sg13cmos5l_buf_1
XFILLER_5_291 VPWR VGND sg13cmos5l_decap_8
XANTENNA__052__X S2BEG[6] VPWR VGND sg13cmos5l_antennanp
XFILLER_10_99 VPWR VGND sg13cmos5l_fill_2
XFILLER_3_228 VPWR VGND sg13cmos5l_decap_8
XFILLER_2_250 VPWR VGND sg13cmos5l_decap_8
XFILLER_2_272 VPWR VGND sg13cmos5l_decap_4
X_076_ FrameStrobe_O[5] FrameStrobe[5] VPWR VGND sg13cmos5l_buf_1
XANTENNA__047__X S2BEG[1] VPWR VGND sg13cmos5l_antennanp
Xclkbuf_1_0__f_UserCLK clkload0/A clkbuf_0_UserCLK/X VPWR VGND sg13cmos5l_buf_8
XFILLER_11_371 VPWR VGND sg13cmos5l_decap_8
X_059_ UIO_TOP_UOUT13 NN4END[2] VPWR VGND sg13cmos5l_buf_1
XFILLER_7_353 VPWR VGND sg13cmos5l_decap_8
XANTENNA__043__A N2END[2] VPWR VGND sg13cmos5l_antennanp
XFILLER_4_389 VPWR VGND sg13cmos5l_decap_8
XFILLER_7_194 VPWR VGND sg13cmos5l_decap_8
XANTENNA__038__A N2END[7] VPWR VGND sg13cmos5l_antennanp
XANTENNA__060__X UIO_TOP_UOUT14 VPWR VGND sg13cmos5l_antennanp
XFILLER_5_109 VPWR VGND sg13cmos5l_decap_8
XFILLER_0_370 VPWR VGND sg13cmos5l_decap_8
XFILLER_4_197 VPWR VGND sg13cmos5l_decap_8
XFILLER_4_46 VPWR VGND sg13cmos5l_decap_8
XFILLER_9_404 VPWR VGND sg13cmos5l_decap_8
XANTENNA__055__X UIO_TOP_UOUT1 VPWR VGND sg13cmos5l_antennanp
XFILLER_1_145 VPWR VGND sg13cmos5l_fill_2
XFILLER_1_167 VPWR VGND sg13cmos5l_fill_2
XFILLER_9_223 VPWR VGND sg13cmos5l_decap_8
XANTENNA__051__A N2MID[2] VPWR VGND sg13cmos5l_antennanp
XFILLER_10_255 VPWR VGND sg13cmos5l_fill_2
XFILLER_1_47 VPWR VGND sg13cmos5l_decap_4
XFILLER_1_69 VPWR VGND sg13cmos5l_fill_1
XFILLER_2_410 VPWR VGND sg13cmos5l_decap_8
XFILLER_6_237 VPWR VGND sg13cmos5l_fill_2
X_092_ UIO_TOP_UOUT8 NN4END[7] VPWR VGND sg13cmos5l_buf_1
XANTENNA__046__A N2MID[7] VPWR VGND sg13cmos5l_antennanp
XFILLER_10_67 VPWR VGND sg13cmos5l_decap_8
XFILLER_10_78 VPWR VGND sg13cmos5l_fill_2
XFILLER_3_207 VPWR VGND sg13cmos5l_decap_8
XFILLER_2_295 VPWR VGND sg13cmos5l_decap_8
X_075_ FrameStrobe_O[4] FrameStrobe[4] VPWR VGND sg13cmos5l_buf_1
XANTENNA__063__X UIO_TOP_UOUT17 VPWR VGND sg13cmos5l_antennanp
XFILLER_11_350 VPWR VGND sg13cmos5l_decap_8
X_058_ UIO_TOP_UOUT12 NN4END[3] VPWR VGND sg13cmos5l_buf_1
XANTENNA__058__X UIO_TOP_UOUT12 VPWR VGND sg13cmos5l_antennanp
XFILLER_4_313 VPWR VGND sg13cmos5l_fill_1
XFILLER_8_129 VPWR VGND sg13cmos5l_decap_8
XFILLER_7_140 VPWR VGND sg13cmos5l_decap_8
XANTENNA__054__A NN4END[15] VPWR VGND sg13cmos5l_antennanp
XFILLER_7_173 VPWR VGND sg13cmos5l_decap_8
XFILLER_1_349 VPWR VGND sg13cmos5l_decap_8
XFILLER_4_110 VPWR VGND sg13cmos5l_fill_2
XFILLER_4_176 VPWR VGND sg13cmos5l_decap_4
XFILLER_4_25 VPWR VGND sg13cmos5l_decap_8
XANTENNA__049__A N2MID[4] VPWR VGND sg13cmos5l_antennanp
XANTENNA__071__X FrameStrobe_O[0] VPWR VGND sg13cmos5l_antennanp
XFILLER_10_415 VPWR VGND sg13cmos5l_fill_2
XFILLER_10_437 VPWR VGND sg13cmos5l_fill_1
XFILLER_5_430 VPWR VGND sg13cmos5l_decap_8
XFILLER_9_257 VPWR VGND sg13cmos5l_decap_4
XANTENNA__066__X UIO_TOP_UOUT2 VPWR VGND sg13cmos5l_antennanp
XFILLER_8_290 VPWR VGND sg13cmos5l_fill_1
XFILLER_2_400 VPWR VGND sg13cmos5l_fill_2
XFILLER_6_216 VPWR VGND sg13cmos5l_decap_8
XFILLER_6_249 VPWR VGND sg13cmos5l_decap_8
X_091_ UIO_TOP_UOUT7 NN4END[8] VPWR VGND sg13cmos5l_buf_1
XFILLER_5_260 VPWR VGND sg13cmos5l_decap_4
XANTENNA__062__A NN4END[3] VPWR VGND sg13cmos5l_antennanp
XFILLER_10_35 VPWR VGND sg13cmos5l_fill_1
X_074_ FrameStrobe_O[3] FrameStrobe[3] VPWR VGND sg13cmos5l_buf_1
XANTENNA__057__A NN4END[4] VPWR VGND sg13cmos5l_antennanp
XFILLER_2_91 VPWR VGND sg13cmos5l_decap_8
X_057_ UIO_TOP_UOUT11 NN4END[4] VPWR VGND sg13cmos5l_buf_1
XFILLER_7_69 VPWR VGND sg13cmos5l_decap_8
XFILLER_7_388 VPWR VGND sg13cmos5l_decap_8
XFILLER_7_322 VPWR VGND sg13cmos5l_fill_2
XANTENNA__074__X FrameStrobe_O[3] VPWR VGND sg13cmos5l_antennanp
XFILLER_4_369 VPWR VGND sg13cmos5l_decap_8
XFILLER_8_108 VPWR VGND sg13cmos5l_decap_8
X_109_ FrameData_O[16] FrameData[16] VPWR VGND sg13cmos5l_buf_1
XFILLER_7_163 VPWR VGND sg13cmos5l_decap_8
XANTENNA__069__X UIO_TOP_UOUT5 VPWR VGND sg13cmos5l_antennanp
XANTENNA__070__A NN4END[9] VPWR VGND sg13cmos5l_antennanp
XFILLER_4_100 VPWR VGND sg13cmos5l_decap_4
XFILLER_4_144 VPWR VGND sg13cmos5l_decap_4
XANTENNA__065__A NN4END[0] VPWR VGND sg13cmos5l_antennanp
XFILLER_1_136 VPWR VGND sg13cmos5l_fill_2
XFILLER_6_409 VPWR VGND sg13cmos5l_decap_8
XFILLER_9_203 VPWR VGND sg13cmos5l_fill_2
XANTENNA__082__X FrameStrobe_O[11] VPWR VGND sg13cmos5l_antennanp
XFILLER_10_224 VPWR VGND sg13cmos5l_fill_2
X_090_ FrameStrobe_O[19] FrameStrobe[19] VPWR VGND sg13cmos5l_buf_1
XANTENNA__077__X FrameStrobe_O[6] VPWR VGND sg13cmos5l_antennanp
XFILLER_10_14 VPWR VGND sg13cmos5l_fill_1
XFILLER_10_25 VPWR VGND sg13cmos5l_fill_2
XFILLER_2_264 VPWR VGND sg13cmos5l_decap_4
XFILLER_4_0 VPWR VGND sg13cmos5l_decap_8
X_073_ FrameStrobe_O[2] FrameStrobe[2] VPWR VGND sg13cmos5l_buf_1
XANTENNA__073__A FrameStrobe[2] VPWR VGND sg13cmos5l_antennanp
XFILLER_2_70 VPWR VGND sg13cmos5l_decap_8
XFILLER_11_385 VPWR VGND sg13cmos5l_decap_8
X_056_ UIO_TOP_UOUT10 NN4END[5] VPWR VGND sg13cmos5l_buf_1
XFILLER_7_37 VPWR VGND sg13cmos5l_fill_2
XFILLER_7_367 VPWR VGND sg13cmos5l_decap_8
XFILLER_7_334 VPWR VGND sg13cmos5l_fill_2
XFILLER_7_26 VPWR VGND sg13cmos5l_decap_8
XANTENNA__068__A NN4END[11] VPWR VGND sg13cmos5l_antennanp
XANTENNA__090__X FrameStrobe_O[19] VPWR VGND sg13cmos5l_antennanp
XFILLER_4_326 VPWR VGND sg13cmos5l_decap_8
XFILLER_11_182 VPWR VGND sg13cmos5l_decap_8
X_039_ S2BEGb[1] N2END[6] VPWR VGND sg13cmos5l_buf_1
X_108_ FrameData_O[15] FrameData[15] VPWR VGND sg13cmos5l_buf_1
XANTENNA__085__X FrameStrobe_O[14] VPWR VGND sg13cmos5l_antennanp
XFILLER_1_307 VPWR VGND sg13cmos5l_fill_1
XFILLER_1_318 VPWR VGND sg13cmos5l_fill_2
XFILLER_0_384 VPWR VGND sg13cmos5l_decap_8
XFILLER_4_112 VPWR VGND sg13cmos5l_fill_1
XFILLER_4_123 VPWR VGND sg13cmos5l_decap_8
XFILLER_4_156 VPWR VGND sg13cmos5l_fill_2
XFILLER_9_418 VPWR VGND sg13cmos5l_decap_8
XFILLER_10_428 VPWR VGND sg13cmos5l_decap_8
XANTENNA__081__A FrameStrobe[10] VPWR VGND sg13cmos5l_antennanp
XFILLER_5_421 VPWR VGND sg13cmos5l_decap_4
XFILLER_9_237 VPWR VGND sg13cmos5l_fill_2
XFILLER_5_81 VPWR VGND sg13cmos5l_decap_8
XANTENNA__076__A FrameStrobe[5] VPWR VGND sg13cmos5l_antennanp
XFILLER_2_424 VPWR VGND sg13cmos5l_decap_8
XFILLER_5_284 VPWR VGND sg13cmos5l_decap_8
XANTENNA__093__X FrameData_O[0] VPWR VGND sg13cmos5l_antennanp
XFILLER_2_243 VPWR VGND sg13cmos5l_decap_8
XFILLER_2_276 VPWR VGND sg13cmos5l_fill_2
X_072_ FrameStrobe_O[1] FrameStrobe[1] VPWR VGND sg13cmos5l_buf_1
XANTENNA__088__X FrameStrobe_O[17] VPWR VGND sg13cmos5l_antennanp
XFILLER_11_364 VPWR VGND sg13cmos5l_decap_8
X_055_ UIO_TOP_UOUT1 NN4END[14] VPWR VGND sg13cmos5l_buf_1
X_124_ FrameData_O[31] FrameData[31] VPWR VGND sg13cmos5l_buf_1
XFILLER_7_346 VPWR VGND sg13cmos5l_decap_8
XFILLER_7_302 VPWR VGND sg13cmos5l_decap_8
XFILLER_11_91 VPWR VGND sg13cmos5l_decap_8
XFILLER_6_390 VPWR VGND sg13cmos5l_fill_1
XANTENNA__084__A FrameStrobe[13] VPWR VGND sg13cmos5l_antennanp
XFILLER_11_161 VPWR VGND sg13cmos5l_decap_8
X_038_ S2BEGb[0] N2END[7] VPWR VGND sg13cmos5l_buf_1
X_107_ FrameData_O[14] FrameData[14] VPWR VGND sg13cmos5l_buf_1
XFILLER_7_187 VPWR VGND sg13cmos5l_decap_8
XFILLER_7_154 VPWR VGND sg13cmos5l_decap_4
XFILLER_7_121 VPWR VGND sg13cmos5l_fill_2
XFILLER_7_110 VPWR VGND sg13cmos5l_decap_4
XANTENNA__079__A FrameStrobe[8] VPWR VGND sg13cmos5l_antennanp
XFILLER_0_363 VPWR VGND sg13cmos5l_decap_8
XFILLER_4_168 VPWR VGND sg13cmos5l_fill_1
XFILLER_4_39 VPWR VGND sg13cmos5l_decap_8
XANTENNA__096__X FrameData_O[3] VPWR VGND sg13cmos5l_antennanp
XFILLER_1_116 VPWR VGND sg13cmos5l_fill_2
XFILLER_1_138 VPWR VGND sg13cmos5l_fill_1
XFILLER_9_216 VPWR VGND sg13cmos5l_decap_8
XFILLER_9_205 VPWR VGND sg13cmos5l_fill_1
XFILLER_0_193 VPWR VGND sg13cmos5l_decap_8
XANTENNA__092__A NN4END[7] VPWR VGND sg13cmos5l_antennanp
XFILLER_10_237 VPWR VGND sg13cmos5l_fill_2
XFILLER_5_60 VPWR VGND sg13cmos5l_decap_8
XFILLER_5_230 VPWR VGND sg13cmos5l_fill_1
XFILLER_5_274 VPWR VGND sg13cmos5l_decap_4
XFILLER_10_27 VPWR VGND sg13cmos5l_fill_1
XFILLER_10_49 VPWR VGND sg13cmos5l_fill_2
XANTENNA__087__A FrameStrobe[16] VPWR VGND sg13cmos5l_antennanp
XFILLER_2_222 VPWR VGND sg13cmos5l_decap_8
XFILLER_2_288 VPWR VGND sg13cmos5l_decap_8
X_071_ FrameStrobe_O[0] FrameStrobe[0] VPWR VGND sg13cmos5l_buf_1
XFILLER_11_343 VPWR VGND sg13cmos5l_decap_8
XFILLER_11_70 VPWR VGND sg13cmos5l_decap_8
X_054_ UIO_TOP_UOUT0 NN4END[15] VPWR VGND sg13cmos5l_buf_1
X_123_ FrameData_O[30] FrameData[30] VPWR VGND sg13cmos5l_buf_1
XFILLER_7_39 VPWR VGND sg13cmos5l_fill_1
XFILLER_7_336 VPWR VGND sg13cmos5l_fill_1
XANTENNA__099__X FrameData_O[6] VPWR VGND sg13cmos5l_antennanp
XFILLER_11_140 VPWR VGND sg13cmos5l_decap_8
X_037_ S4BEG[15] UIO_TOP_UIN0 VPWR VGND sg13cmos5l_buf_1
X_106_ FrameData_O[13] FrameData[13] VPWR VGND sg13cmos5l_buf_1
XFILLER_7_133 VPWR VGND sg13cmos5l_decap_8
XFILLER_3_383 VPWR VGND sg13cmos5l_decap_8
XANTENNA__095__A FrameData[2] VPWR VGND sg13cmos5l_antennanp
XFILLER_0_342 VPWR VGND sg13cmos5l_decap_8
XFILLER_4_18 VPWR VGND sg13cmos5l_decap_8
XFILLER_0_172 VPWR VGND sg13cmos5l_decap_8
XFILLER_10_205 VPWR VGND sg13cmos5l_fill_2
XFILLER_10_216 VPWR VGND sg13cmos5l_decap_4
XFILLER_10_249 VPWR VGND sg13cmos5l_fill_2
XFILLER_6_209 VPWR VGND sg13cmos5l_decap_8
XFILLER_8_294 VPWR VGND sg13cmos5l_fill_2
XFILLER_8_283 VPWR VGND sg13cmos5l_decap_8
XFILLER_5_242 VPWR VGND sg13cmos5l_decap_8
XFILLER_5_253 VPWR VGND sg13cmos5l_decap_8
XFILLER_10_39 VPWR VGND sg13cmos5l_decap_8
XFILLER_2_201 VPWR VGND sg13cmos5l_decap_8
X_070_ UIO_TOP_UOUT6 NN4END[9] VPWR VGND sg13cmos5l_buf_1
XFILLER_2_84 VPWR VGND sg13cmos5l_decap_8
XANTENNA__098__A FrameData[5] VPWR VGND sg13cmos5l_antennanp
XFILLER_11_322 VPWR VGND sg13cmos5l_decap_8
XFILLER_11_399 VPWR VGND sg13cmos5l_decap_8
XFILLER_2_0 VPWR VGND sg13cmos5l_fill_2
X_053_ S2BEG[7] N2MID[0] VPWR VGND sg13cmos5l_buf_1
X_122_ FrameData_O[29] FrameData[29] VPWR VGND sg13cmos5l_buf_1
XFILLER_7_315 VPWR VGND sg13cmos5l_fill_1
XFILLER_7_18 VPWR VGND sg13cmos5l_decap_4
XFILLER_6_381 VPWR VGND sg13cmos5l_decap_8
XFILLER_11_196 VPWR VGND sg13cmos5l_decap_8
X_105_ FrameData_O[12] FrameData[12] VPWR VGND sg13cmos5l_buf_1
XFILLER_3_362 VPWR VGND sg13cmos5l_decap_8
X_036_ S4BEG[14] UIO_TOP_UIN1 VPWR VGND sg13cmos5l_buf_1
XFILLER_8_94 VPWR VGND sg13cmos5l_decap_8
XFILLER_8_83 VPWR VGND sg13cmos5l_fill_1
XFILLER_4_104 VPWR VGND sg13cmos5l_fill_2
XFILLER_4_137 VPWR VGND sg13cmos5l_decap_8
XFILLER_0_398 VPWR VGND sg13cmos5l_decap_8
X_019_ SS4BEG[13] N4END[2] VPWR VGND sg13cmos5l_buf_1
XFILLER_8_410 VPWR VGND sg13cmos5l_fill_2
XFILLER_0_151 VPWR VGND sg13cmos5l_decap_8
XFILLER_5_402 VPWR VGND sg13cmos5l_fill_2
XFILLER_5_95 VPWR VGND sg13cmos5l_decap_8
XFILLER_8_251 VPWR VGND sg13cmos5l_decap_8
XFILLER_2_405 VPWR VGND sg13cmos5l_fill_2
XFILLER_6_7 VPWR VGND sg13cmos5l_fill_2
XFILLER_5_298 VPWR VGND sg13cmos5l_decap_8
XANTENNA__001__X UserCLKo VPWR VGND sg13cmos5l_antennanp
XFILLER_10_18 VPWR VGND sg13cmos5l_decap_4
XFILLER_2_257 VPWR VGND sg13cmos5l_decap_8
XFILLER_2_268 VPWR VGND sg13cmos5l_fill_1
XFILLER_2_63 VPWR VGND sg13cmos5l_decap_8
XFILLER_11_301 VPWR VGND sg13cmos5l_decap_8
XFILLER_11_378 VPWR VGND sg13cmos5l_decap_8
X_052_ S2BEG[6] N2MID[1] VPWR VGND sg13cmos5l_buf_1
X_121_ FrameData_O[28] FrameData[28] VPWR VGND sg13cmos5l_buf_1
XFILLER_7_327 VPWR VGND sg13cmos5l_decap_8
XFILLER_6_360 VPWR VGND sg13cmos5l_decap_8
XFILLER_11_175 VPWR VGND sg13cmos5l_decap_8
XFILLER_3_396 VPWR VGND sg13cmos5l_decap_8
X_035_ S4BEG[13] UIO_TOP_UIN2 VPWR VGND sg13cmos5l_buf_1
X_104_ FrameData_O[11] FrameData[11] VPWR VGND sg13cmos5l_buf_1
XFILLER_8_62 VPWR VGND sg13cmos5l_decap_8
XFILLER_0_377 VPWR VGND sg13cmos5l_decap_8
XFILLER_4_116 VPWR VGND sg13cmos5l_decap_8
X_018_ SS4BEG[12] N4END[3] VPWR VGND sg13cmos5l_buf_1
XFILLER_8_422 VPWR VGND sg13cmos5l_decap_8
XANTENNA__004__X S1BEG[2] VPWR VGND sg13cmos5l_antennanp
XFILLER_3_193 VPWR VGND sg13cmos5l_decap_8
XFILLER_0_130 VPWR VGND sg13cmos5l_decap_8
XFILLER_5_414 VPWR VGND sg13cmos5l_decap_8
XFILLER_5_425 VPWR VGND sg13cmos5l_fill_2
XANTENNA__000__A NN4END[6] VPWR VGND sg13cmos5l_antennanp
XFILLER_10_0 VPWR VGND sg13cmos5l_decap_8
XFILLER_5_74 VPWR VGND sg13cmos5l_decap_8
XFILLER_8_296 VPWR VGND sg13cmos5l_fill_1
XFILLER_8_274 VPWR VGND sg13cmos5l_decap_4
XFILLER_8_230 VPWR VGND sg13cmos5l_decap_8
XFILLER_2_417 VPWR VGND sg13cmos5l_decap_8
XFILLER_2_236 VPWR VGND sg13cmos5l_decap_8
XANTENNA__102__X FrameData_O[9] VPWR VGND sg13cmos5l_antennanp
XFILLER_1_291 VPWR VGND sg13cmos5l_fill_1
XFILLER_2_42 VPWR VGND sg13cmos5l_decap_8
XANTENNA__012__X SS4BEG[6] VPWR VGND sg13cmos5l_antennanp
XFILLER_11_357 VPWR VGND sg13cmos5l_decap_8
XFILLER_11_84 VPWR VGND sg13cmos5l_decap_8
X_051_ S2BEG[5] N2MID[2] VPWR VGND sg13cmos5l_buf_1
X_120_ FrameData_O[27] FrameData[27] VPWR VGND sg13cmos5l_buf_1
XFILLER_6_394 VPWR VGND sg13cmos5l_fill_2
XANTENNA__007__X SS4BEG[1] VPWR VGND sg13cmos5l_antennanp
XFILLER_4_309 VPWR VGND sg13cmos5l_decap_4
XFILLER_11_154 VPWR VGND sg13cmos5l_decap_8
X_034_ S4BEG[12] UIO_TOP_UIN3 VPWR VGND sg13cmos5l_buf_1
X_103_ FrameData_O[10] FrameData[10] VPWR VGND sg13cmos5l_buf_1
XFILLER_7_158 VPWR VGND sg13cmos5l_fill_2
XFILLER_7_147 VPWR VGND sg13cmos5l_decap_8
XFILLER_7_103 VPWR VGND sg13cmos5l_decap_8
XANTENNA__003__A N1END[2] VPWR VGND sg13cmos5l_antennanp
XFILLER_6_180 VPWR VGND sg13cmos5l_decap_4
XFILLER_0_323 VPWR VGND sg13cmos5l_fill_1
XFILLER_0_356 VPWR VGND sg13cmos5l_decap_8
XANTENNA__110__X FrameData_O[17] VPWR VGND sg13cmos5l_antennanp
XFILLER_3_172 VPWR VGND sg13cmos5l_decap_8
X_017_ SS4BEG[11] N4END[4] VPWR VGND sg13cmos5l_buf_1
XANTENNA__020__X SS4BEG[14] VPWR VGND sg13cmos5l_antennanp
XFILLER_1_109 VPWR VGND sg13cmos5l_decap_4
XFILLER_5_437 VPWR VGND sg13cmos5l_fill_1
XFILLER_9_209 VPWR VGND sg13cmos5l_decap_8
XANTENNA__105__X FrameData_O[12] VPWR VGND sg13cmos5l_antennanp
XFILLER_0_186 VPWR VGND sg13cmos5l_decap_8
XFILLER_5_53 VPWR VGND sg13cmos5l_decap_8
XANTENNA__015__X SS4BEG[9] VPWR VGND sg13cmos5l_antennanp
XANTENNA__101__A FrameData[8] VPWR VGND sg13cmos5l_antennanp
XFILLER_5_267 VPWR VGND sg13cmos5l_decap_8
XFILLER_5_278 VPWR VGND sg13cmos5l_fill_2
XANTENNA__011__A N4END[10] VPWR VGND sg13cmos5l_antennanp
XFILLER_2_215 VPWR VGND sg13cmos5l_decap_8
XFILLER_1_270 VPWR VGND sg13cmos5l_decap_8
XFILLER_2_21 VPWR VGND sg13cmos5l_decap_8
XFILLER_2_98 VPWR VGND sg13cmos5l_decap_8
XANTENNA__006__A UIO_TOP_UIN19 VPWR VGND sg13cmos5l_antennanp
XFILLER_11_336 VPWR VGND sg13cmos5l_decap_8
X_050_ S2BEG[4] N2MID[3] VPWR VGND sg13cmos5l_buf_1
XFILLER_9_392 VPWR VGND sg13cmos5l_fill_2
XANTENNA__113__X FrameData_O[20] VPWR VGND sg13cmos5l_antennanp
XFILLER_11_63 VPWR VGND sg13cmos5l_decap_8
XANTENNA__023__X S4BEG[1] VPWR VGND sg13cmos5l_antennanp
XFILLER_11_133 VPWR VGND sg13cmos5l_decap_8
XFILLER_3_310 VPWR VGND sg13cmos5l_decap_8
XFILLER_3_343 VPWR VGND sg13cmos5l_fill_2
XFILLER_3_376 VPWR VGND sg13cmos5l_decap_8
X_033_ S4BEG[11] UIO_TOP_UIN4 VPWR VGND sg13cmos5l_buf_1
X_102_ FrameData_O[9] FrameData[9] VPWR VGND sg13cmos5l_buf_1
XFILLER_7_126 VPWR VGND sg13cmos5l_decap_8
XANTENNA__108__X FrameData_O[15] VPWR VGND sg13cmos5l_antennanp
XFILLER_8_20 VPWR VGND sg13cmos5l_decap_4
XANTENNA__018__X SS4BEG[12] VPWR VGND sg13cmos5l_antennanp
XFILLER_0_313 VPWR VGND sg13cmos5l_decap_8
XANTENNA__104__A FrameData[11] VPWR VGND sg13cmos5l_antennanp
X_016_ SS4BEG[10] N4END[5] VPWR VGND sg13cmos5l_buf_1
XANTENNA__014__A N4END[7] VPWR VGND sg13cmos5l_antennanp
XFILLER_0_165 VPWR VGND sg13cmos5l_decap_8
XFILLER_8_221 VPWR VGND sg13cmos5l_decap_4
XANTENNA__009__A UIO_TOP_UIN16 VPWR VGND sg13cmos5l_antennanp
XANTENNA__121__X FrameData_O[28] VPWR VGND sg13cmos5l_antennanp
XFILLER_5_32 VPWR VGND sg13cmos5l_decap_8
XANTENNA__031__X S4BEG[9] VPWR VGND sg13cmos5l_antennanp
XFILLER_5_224 VPWR VGND sg13cmos5l_fill_1
XFILLER_5_235 VPWR VGND sg13cmos5l_decap_8
XANTENNA__116__X FrameData_O[23] VPWR VGND sg13cmos5l_antennanp
XANTENNA__026__X S4BEG[4] VPWR VGND sg13cmos5l_antennanp
XFILLER_4_7 VPWR VGND sg13cmos5l_fill_1
XANTENNA__112__A FrameData[19] VPWR VGND sg13cmos5l_antennanp
XFILLER_2_77 VPWR VGND sg13cmos5l_decap_8
XANTENNA__022__A UIO_TOP_UIN15 VPWR VGND sg13cmos5l_antennanp
XFILLER_11_315 VPWR VGND sg13cmos5l_decap_8
XFILLER_9_371 VPWR VGND sg13cmos5l_decap_8
XANTENNA__107__A FrameData[14] VPWR VGND sg13cmos5l_antennanp
XFILLER_11_42 VPWR VGND sg13cmos5l_decap_8
XANTENNA__017__A N4END[4] VPWR VGND sg13cmos5l_antennanp
XFILLER_6_396 VPWR VGND sg13cmos5l_fill_1
XFILLER_6_374 VPWR VGND sg13cmos5l_decap_8
XFILLER_6_330 VPWR VGND sg13cmos5l_fill_2
XFILLER_11_112 VPWR VGND sg13cmos5l_decap_8
XFILLER_11_189 VPWR VGND sg13cmos5l_decap_8
XFILLER_3_322 VPWR VGND sg13cmos5l_decap_8
XFILLER_3_355 VPWR VGND sg13cmos5l_decap_8
X_101_ FrameData_O[8] FrameData[8] VPWR VGND sg13cmos5l_buf_1
X_032_ S4BEG[10] UIO_TOP_UIN5 VPWR VGND sg13cmos5l_buf_1
XANTENNA__124__X FrameData_O[31] VPWR VGND sg13cmos5l_antennanp
XFILLER_8_87 VPWR VGND sg13cmos5l_decap_8
XFILLER_8_76 VPWR VGND sg13cmos5l_decap_8
XFILLER_8_43 VPWR VGND sg13cmos5l_fill_2
XANTENNA__034__X S4BEG[12] VPWR VGND sg13cmos5l_antennanp
XANTENNA__120__A FrameData[27] VPWR VGND sg13cmos5l_antennanp
XFILLER_3_152 VPWR VGND sg13cmos5l_fill_2
X_015_ SS4BEG[9] N4END[6] VPWR VGND sg13cmos5l_buf_1
XFILLER_8_436 VPWR VGND sg13cmos5l_fill_2
XANTENNA__029__X S4BEG[7] VPWR VGND sg13cmos5l_antennanp
XANTENNA__030__A UIO_TOP_UIN7 VPWR VGND sg13cmos5l_antennanp
XANTENNA__119__X FrameData_O[26] VPWR VGND sg13cmos5l_antennanp
XFILLER_0_144 VPWR VGND sg13cmos5l_decap_8
XANTENNA__115__A FrameData[22] VPWR VGND sg13cmos5l_antennanp
XFILLER_5_88 VPWR VGND sg13cmos5l_decap_8
XFILLER_8_244 VPWR VGND sg13cmos5l_decap_8
XANTENNA__025__A UIO_TOP_UIN12 VPWR VGND sg13cmos5l_antennanp
XFILLER_4_291 VPWR VGND sg13cmos5l_decap_8
XANTENNA__042__X S2BEGb[4] VPWR VGND sg13cmos5l_antennanp
XFILLER_1_283 VPWR VGND sg13cmos5l_fill_2
XFILLER_2_56 VPWR VGND sg13cmos5l_decap_8
XFILLER_9_383 VPWR VGND sg13cmos5l_fill_2
XFILLER_9_350 VPWR VGND sg13cmos5l_decap_8
XANTENNA__037__X S4BEG[15] VPWR VGND sg13cmos5l_antennanp
XFILLER_11_21 VPWR VGND sg13cmos5l_decap_8
XFILLER_11_98 VPWR VGND sg13cmos5l_decap_8
XFILLER_7_309 VPWR VGND sg13cmos5l_fill_2
XANTENNA__123__A FrameData[30] VPWR VGND sg13cmos5l_antennanp
XFILLER_10_360 VPWR VGND sg13cmos5l_decap_4
XFILLER_10_371 VPWR VGND sg13cmos5l_fill_1
XFILLER_6_353 VPWR VGND sg13cmos5l_decap_8
XFILLER_6_342 VPWR VGND sg13cmos5l_decap_8
XANTENNA__033__A UIO_TOP_UIN4 VPWR VGND sg13cmos5l_antennanp
XFILLER_11_168 VPWR VGND sg13cmos5l_decap_8
X_100_ FrameData_O[7] FrameData[7] VPWR VGND sg13cmos5l_buf_1
X_031_ S4BEG[9] UIO_TOP_UIN6 VPWR VGND sg13cmos5l_buf_1
XANTENNA__118__A FrameData[25] VPWR VGND sg13cmos5l_antennanp
XFILLER_10_190 VPWR VGND sg13cmos5l_fill_1
XFILLER_8_55 VPWR VGND sg13cmos5l_decap_8
XANTENNA__028__A UIO_TOP_UIN9 VPWR VGND sg13cmos5l_antennanp
XANTENNA__050__X S2BEG[4] VPWR VGND sg13cmos5l_antennanp
XFILLER_3_131 VPWR VGND sg13cmos5l_decap_8
XFILLER_3_186 VPWR VGND sg13cmos5l_decap_8
X_014_ SS4BEG[8] N4END[7] VPWR VGND sg13cmos5l_buf_1
XFILLER_8_415 VPWR VGND sg13cmos5l_decap_8
XANTENNA__045__X S2BEGb[7] VPWR VGND sg13cmos5l_antennanp
XFILLER_0_123 VPWR VGND sg13cmos5l_decap_8
XFILLER_5_407 VPWR VGND sg13cmos5l_fill_2
XFILLER_5_12 VPWR VGND sg13cmos5l_decap_8
XFILLER_5_67 VPWR VGND sg13cmos5l_decap_8
XFILLER_8_278 VPWR VGND sg13cmos5l_fill_1
XFILLER_8_267 VPWR VGND sg13cmos5l_decap_8
XANTENNA__041__A N2END[4] VPWR VGND sg13cmos5l_antennanp
XFILLER_5_215 VPWR VGND sg13cmos5l_fill_2
XANTENNA__036__A UIO_TOP_UIN1 VPWR VGND sg13cmos5l_antennanp
XFILLER_2_229 VPWR VGND sg13cmos5l_fill_1
XFILLER_2_35 VPWR VGND sg13cmos5l_decap_8
XANTENNA__053__X S2BEG[7] VPWR VGND sg13cmos5l_antennanp
XFILLER_11_77 VPWR VGND sg13cmos5l_decap_8
XANTENNA__048__X S2BEG[2] VPWR VGND sg13cmos5l_antennanp
XFILLER_11_147 VPWR VGND sg13cmos5l_decap_8
X_030_ S4BEG[8] UIO_TOP_UIN7 VPWR VGND sg13cmos5l_buf_1
XFILLER_8_34 VPWR VGND sg13cmos5l_fill_1
XANTENNA__044__A N2END[1] VPWR VGND sg13cmos5l_antennanp
XFILLER_6_173 VPWR VGND sg13cmos5l_decap_8
XFILLER_6_184 VPWR VGND sg13cmos5l_fill_1
XFILLER_6_195 VPWR VGND sg13cmos5l_decap_8
XFILLER_0_349 VPWR VGND sg13cmos5l_decap_8
XFILLER_3_154 VPWR VGND sg13cmos5l_fill_1
X_013_ SS4BEG[7] N4END[8] VPWR VGND sg13cmos5l_buf_1
XFILLER_8_405 VPWR VGND sg13cmos5l_fill_2
XFILLER_3_165 VPWR VGND sg13cmos5l_decap_8
XANTENNA__039__A N2END[6] VPWR VGND sg13cmos5l_antennanp
XANTENNA__061__X UIO_TOP_UOUT15 VPWR VGND sg13cmos5l_antennanp
XFILLER_0_102 VPWR VGND sg13cmos5l_decap_8
XFILLER_0_179 VPWR VGND sg13cmos5l_decap_8
XFILLER_5_24 VPWR VGND sg13cmos5l_decap_4
XFILLER_5_46 VPWR VGND sg13cmos5l_decap_8
XANTENNA__056__X UIO_TOP_UOUT10 VPWR VGND sg13cmos5l_antennanp
XFILLER_5_249 VPWR VGND sg13cmos5l_fill_1
XANTENNA__052__A N2MID[1] VPWR VGND sg13cmos5l_antennanp
XFILLER_2_208 VPWR VGND sg13cmos5l_decap_8
XFILLER_1_263 VPWR VGND sg13cmos5l_decap_8
XFILLER_2_14 VPWR VGND sg13cmos5l_decap_8
XFILLER_9_0 VPWR VGND sg13cmos5l_decap_4
XANTENNA__047__A N2MID[6] VPWR VGND sg13cmos5l_antennanp
XFILLER_11_329 VPWR VGND sg13cmos5l_decap_8
XFILLER_11_56 VPWR VGND sg13cmos5l_decap_8
XFILLER_6_388 VPWR VGND sg13cmos5l_fill_2
XFILLER_9_182 VPWR VGND sg13cmos5l_decap_8
XANTENNA__064__X UIO_TOP_UOUT18 VPWR VGND sg13cmos5l_antennanp
XFILLER_11_126 VPWR VGND sg13cmos5l_decap_8
XFILLER_3_303 VPWR VGND sg13cmos5l_decap_8
XFILLER_3_336 VPWR VGND sg13cmos5l_decap_8
XFILLER_3_369 VPWR VGND sg13cmos5l_decap_8
XFILLER_6_152 VPWR VGND sg13cmos5l_fill_2
X_089_ FrameStrobe_O[18] FrameStrobe[18] VPWR VGND sg13cmos5l_buf_1
XFILLER_8_13 VPWR VGND sg13cmos5l_decap_8
XANTENNA__059__X UIO_TOP_UOUT13 VPWR VGND sg13cmos5l_antennanp
XANTENNA__060__A NN4END[1] VPWR VGND sg13cmos5l_antennanp
XFILLER_0_306 VPWR VGND sg13cmos5l_decap_8
X_012_ SS4BEG[6] N4END[9] VPWR VGND sg13cmos5l_buf_1
XANTENNA__055__A NN4END[14] VPWR VGND sg13cmos5l_antennanp
XFILLER_5_409 VPWR VGND sg13cmos5l_fill_1
XFILLER_0_158 VPWR VGND sg13cmos5l_decap_8
XFILLER_8_258 VPWR VGND sg13cmos5l_fill_2
XFILLER_8_225 VPWR VGND sg13cmos5l_fill_2
XFILLER_8_214 VPWR VGND sg13cmos5l_decap_4
XFILLER_7_280 VPWR VGND sg13cmos5l_decap_4
XANTENNA__072__X FrameStrobe_O[1] VPWR VGND sg13cmos5l_antennanp
XFILLER_1_434 VPWR VGND sg13cmos5l_decap_4
XFILLER_5_217 VPWR VGND sg13cmos5l_fill_1
XFILLER_5_228 VPWR VGND sg13cmos5l_fill_2
XFILLER_4_283 VPWR VGND sg13cmos5l_fill_1
XANTENNA__067__X UIO_TOP_UOUT3 VPWR VGND sg13cmos5l_antennanp
XFILLER_9_364 VPWR VGND sg13cmos5l_decap_8
XANTENNA__063__A NN4END[2] VPWR VGND sg13cmos5l_antennanp
XFILLER_11_308 VPWR VGND sg13cmos5l_decap_8
XFILLER_11_35 VPWR VGND sg13cmos5l_decap_8
XFILLER_9_397 VPWR VGND sg13cmos5l_decap_8
XFILLER_6_367 VPWR VGND sg13cmos5l_decap_8
XFILLER_6_323 VPWR VGND sg13cmos5l_decap_8
XFILLER_6_301 VPWR VGND sg13cmos5l_decap_4
XFILLER_9_161 VPWR VGND sg13cmos5l_decap_8
XANTENNA__058__A NN4END[3] VPWR VGND sg13cmos5l_antennanp
XANTENNA__080__X FrameStrobe_O[9] VPWR VGND sg13cmos5l_antennanp
XFILLER_11_105 VPWR VGND sg13cmos5l_decap_8
XFILLER_3_348 VPWR VGND sg13cmos5l_decap_8
XFILLER_6_131 VPWR VGND sg13cmos5l_fill_2
X_088_ FrameStrobe_O[17] FrameStrobe[17] VPWR VGND sg13cmos5l_buf_1
XFILLER_8_69 VPWR VGND sg13cmos5l_decap_8
XANTENNA__075__X FrameStrobe_O[4] VPWR VGND sg13cmos5l_antennanp
XFILLER_3_101 VPWR VGND sg13cmos5l_decap_8
XFILLER_3_145 VPWR VGND sg13cmos5l_decap_8
X_011_ SS4BEG[5] N4END[10] VPWR VGND sg13cmos5l_buf_1
XFILLER_8_429 VPWR VGND sg13cmos5l_decap_8
XFILLER_0_81 VPWR VGND sg13cmos5l_decap_8
XANTENNA__071__A FrameStrobe[0] VPWR VGND sg13cmos5l_antennanp
XFILLER_0_137 VPWR VGND sg13cmos5l_decap_8
XFILLER_4_432 VPWR VGND sg13cmos5l_decap_4
XFILLER_8_237 VPWR VGND sg13cmos5l_decap_8
XFILLER_10_7 VPWR VGND sg13cmos5l_decap_8
XANTENNA__066__A NN4END[13] VPWR VGND sg13cmos5l_antennanp
XFILLER_5_207 VPWR VGND sg13cmos5l_decap_4
XANTENNA__083__X FrameStrobe_O[12] VPWR VGND sg13cmos5l_antennanp
XFILLER_2_49 VPWR VGND sg13cmos5l_decap_8
XFILLER_9_343 VPWR VGND sg13cmos5l_decap_8
XFILLER_9_321 VPWR VGND sg13cmos5l_decap_8
XANTENNA__078__X FrameStrobe_O[7] VPWR VGND sg13cmos5l_antennanp
XFILLER_10_353 VPWR VGND sg13cmos5l_decap_8
XFILLER_11_14 VPWR VGND sg13cmos5l_decap_8
XFILLER_6_335 VPWR VGND sg13cmos5l_decap_8
XANTENNA__074__A FrameStrobe[3] VPWR VGND sg13cmos5l_antennanp
XFILLER_3_70 VPWR VGND sg13cmos5l_fill_2
XFILLER_2_382 VPWR VGND sg13cmos5l_decap_8
XFILLER_6_143 VPWR VGND sg13cmos5l_decap_4
XFILLER_6_154 VPWR VGND sg13cmos5l_fill_1
X_087_ FrameStrobe_O[16] FrameStrobe[16] VPWR VGND sg13cmos5l_buf_1
XFILLER_8_48 VPWR VGND sg13cmos5l_decap_8
XANTENNA__069__A NN4END[10] VPWR VGND sg13cmos5l_antennanp
XANTENNA__091__X UIO_TOP_UOUT7 VPWR VGND sg13cmos5l_antennanp
XFILLER_3_124 VPWR VGND sg13cmos5l_decap_8
XFILLER_3_179 VPWR VGND sg13cmos5l_decap_8
X_010_ SS4BEG[4] N4END[11] VPWR VGND sg13cmos5l_buf_1
XANTENNA__086__X FrameStrobe_O[15] VPWR VGND sg13cmos5l_antennanp
XFILLER_0_116 VPWR VGND sg13cmos5l_decap_8
XFILLER_9_80 VPWR VGND sg13cmos5l_decap_8
XANTENNA__082__A FrameStrobe[11] VPWR VGND sg13cmos5l_antennanp
XFILLER_6_92 VPWR VGND sg13cmos5l_decap_4
XANTENNA__077__A FrameStrobe[6] VPWR VGND sg13cmos5l_antennanp
XFILLER_1_299 VPWR VGND sg13cmos5l_fill_1
XFILLER_2_28 VPWR VGND sg13cmos5l_decap_8
XFILLER_9_388 VPWR VGND sg13cmos5l_fill_1
XFILLER_9_300 VPWR VGND sg13cmos5l_fill_1
XANTENNA__094__X FrameData_O[1] VPWR VGND sg13cmos5l_antennanp
XFILLER_7_0 VPWR VGND sg13cmos5l_decap_4
XFILLER_5_380 VPWR VGND sg13cmos5l_decap_8
XFILLER_5_391 VPWR VGND sg13cmos5l_decap_4
XFILLER_9_196 VPWR VGND sg13cmos5l_decap_8
XANTENNA__089__X FrameStrobe_O[18] VPWR VGND sg13cmos5l_antennanp
XANTENNA__090__A FrameStrobe[19] VPWR VGND sg13cmos5l_antennanp
XFILLER_10_151 VPWR VGND sg13cmos5l_decap_8
XFILLER_3_317 VPWR VGND sg13cmos5l_fill_2
XFILLER_6_166 VPWR VGND sg13cmos5l_decap_8
XFILLER_6_188 VPWR VGND sg13cmos5l_decap_8
X_086_ FrameStrobe_O[15] FrameStrobe[15] VPWR VGND sg13cmos5l_buf_1
XFILLER_8_27 VPWR VGND sg13cmos5l_decap_8
XFILLER_2_361 VPWR VGND sg13cmos5l_decap_8
XANTENNA__085__A FrameStrobe[14] VPWR VGND sg13cmos5l_antennanp
XFILLER_3_158 VPWR VGND sg13cmos5l_decap_8
XFILLER_2_180 VPWR VGND sg13cmos5l_decap_8
X_069_ UIO_TOP_UOUT5 NN4END[10] VPWR VGND sg13cmos5l_buf_1
XFILLER_4_412 VPWR VGND sg13cmos5l_fill_2
XFILLER_5_39 VPWR VGND sg13cmos5l_decap_8
XFILLER_8_206 VPWR VGND sg13cmos5l_decap_4
XANTENNA__097__X FrameData_O[4] VPWR VGND sg13cmos5l_antennanp
XFILLER_4_253 VPWR VGND sg13cmos5l_fill_1
XFILLER_4_275 VPWR VGND sg13cmos5l_decap_4
XANTENNA__093__A FrameData[0] VPWR VGND sg13cmos5l_antennanp
XFILLER_1_256 VPWR VGND sg13cmos5l_decap_8
XFILLER_9_4 VPWR VGND sg13cmos5l_fill_2
XFILLER_1_289 VPWR VGND sg13cmos5l_fill_2
XFILLER_9_378 VPWR VGND sg13cmos5l_fill_2
XFILLER_9_312 VPWR VGND sg13cmos5l_decap_4
XANTENNA__088__A FrameStrobe[17] VPWR VGND sg13cmos5l_antennanp
XFILLER_11_49 VPWR VGND sg13cmos5l_decap_8
XFILLER_11_119 VPWR VGND sg13cmos5l_decap_8
XFILLER_3_72 VPWR VGND sg13cmos5l_fill_1
XFILLER_3_94 VPWR VGND sg13cmos5l_decap_8
XFILLER_9_175 VPWR VGND sg13cmos5l_decap_8
XFILLER_3_329 VPWR VGND sg13cmos5l_decap_8
XFILLER_8_39 VPWR VGND sg13cmos5l_decap_4
XFILLER_10_185 VPWR VGND sg13cmos5l_fill_2
XFILLER_2_340 VPWR VGND sg13cmos5l_decap_8
XFILLER_6_112 VPWR VGND sg13cmos5l_decap_8
X_085_ FrameStrobe_O[14] FrameStrobe[14] VPWR VGND sg13cmos5l_buf_1
XFILLER_3_115 VPWR VGND sg13cmos5l_decap_4
X_068_ UIO_TOP_UOUT4 NN4END[11] VPWR VGND sg13cmos5l_buf_1
XFILLER_7_421 VPWR VGND sg13cmos5l_decap_8
XFILLER_0_73 VPWR VGND sg13cmos5l_decap_4
XFILLER_0_95 VPWR VGND sg13cmos5l_decap_8
XANTENNA__096__A FrameData[3] VPWR VGND sg13cmos5l_antennanp
XFILLER_11_280 VPWR VGND sg13cmos5l_decap_8
XFILLER_7_295 VPWR VGND sg13cmos5l_decap_8
XFILLER_7_284 VPWR VGND sg13cmos5l_fill_1
XFILLER_7_262 VPWR VGND sg13cmos5l_fill_2
XFILLER_1_405 VPWR VGND sg13cmos5l_decap_8
XFILLER_1_416 VPWR VGND sg13cmos5l_fill_2
XFILLER_1_427 VPWR VGND sg13cmos5l_decap_8
XFILLER_4_232 VPWR VGND sg13cmos5l_decap_8
XFILLER_4_298 VPWR VGND sg13cmos5l_decap_8
XFILLER_6_83 VPWR VGND sg13cmos5l_fill_1
XFILLER_6_61 VPWR VGND sg13cmos5l_decap_4
XFILLER_9_357 VPWR VGND sg13cmos5l_decap_8
XFILLER_11_28 VPWR VGND sg13cmos5l_decap_8
XFILLER_6_349 VPWR VGND sg13cmos5l_fill_1
XFILLER_3_62 VPWR VGND sg13cmos5l_fill_2
XANTENNA__099__A FrameData[6] VPWR VGND sg13cmos5l_antennanp
XFILLER_10_175 VPWR VGND sg13cmos5l_decap_8
XFILLER_2_396 VPWR VGND sg13cmos5l_decap_4
XFILLER_6_102 VPWR VGND sg13cmos5l_decap_8
X_084_ FrameStrobe_O[13] FrameStrobe[13] VPWR VGND sg13cmos5l_buf_1
XFILLER_3_138 VPWR VGND sg13cmos5l_decap_4
XFILLER_7_411 VPWR VGND sg13cmos5l_decap_4
XFILLER_0_52 VPWR VGND sg13cmos5l_decap_8
X_067_ UIO_TOP_UOUT3 NN4END[12] VPWR VGND sg13cmos5l_buf_1
XFILLER_9_72 VPWR VGND sg13cmos5l_decap_4
XFILLER_4_403 VPWR VGND sg13cmos5l_decap_4
XFILLER_4_414 VPWR VGND sg13cmos5l_fill_1
XFILLER_4_425 VPWR VGND sg13cmos5l_decap_8
XFILLER_4_436 VPWR VGND sg13cmos5l_fill_2
XFILLER_5_19 VPWR VGND sg13cmos5l_fill_1
X_119_ FrameData_O[26] FrameData[26] VPWR VGND sg13cmos5l_buf_1
XFILLER_7_230 VPWR VGND sg13cmos5l_fill_1
XFILLER_4_211 VPWR VGND sg13cmos5l_decap_8
XFILLER_1_203 VPWR VGND sg13cmos5l_fill_2
XFILLER_9_336 VPWR VGND sg13cmos5l_decap_8
XFILLER_8_391 VPWR VGND sg13cmos5l_decap_8
XANTENNA__002__X S1BEG[0] VPWR VGND sg13cmos5l_antennanp
XFILLER_10_302 VPWR VGND sg13cmos5l_fill_2
XFILLER_10_313 VPWR VGND sg13cmos5l_fill_1
XFILLER_10_346 VPWR VGND sg13cmos5l_decap_8
XFILLER_10_379 VPWR VGND sg13cmos5l_fill_2
XFILLER_9_155 VPWR VGND sg13cmos5l_fill_2
XFILLER_10_121 VPWR VGND sg13cmos5l_fill_1
XFILLER_10_198 VPWR VGND sg13cmos5l_decap_4
XFILLER_2_375 VPWR VGND sg13cmos5l_decap_8
XFILLER_5_0 VPWR VGND sg13cmos5l_decap_8
XFILLER_6_136 VPWR VGND sg13cmos5l_decap_8
XFILLER_6_147 VPWR VGND sg13cmos5l_fill_2
X_083_ FrameStrobe_O[12] FrameStrobe[12] VPWR VGND sg13cmos5l_buf_1
XANTENNA__100__X FrameData_O[7] VPWR VGND sg13cmos5l_antennanp
XFILLER_0_31 VPWR VGND sg13cmos5l_decap_8
XFILLER_2_194 VPWR VGND sg13cmos5l_decap_8
X_066_ UIO_TOP_UOUT2 NN4END[13] VPWR VGND sg13cmos5l_buf_1
XFILLER_9_40 VPWR VGND sg13cmos5l_decap_4
XANTENNA__010__X SS4BEG[4] VPWR VGND sg13cmos5l_antennanp
XFILLER_0_109 VPWR VGND sg13cmos5l_decap_8
X_049_ S2BEG[3] N2MID[4] VPWR VGND sg13cmos5l_buf_1
X_118_ FrameData_O[25] FrameData[25] VPWR VGND sg13cmos5l_buf_1
XFILLER_7_275 VPWR VGND sg13cmos5l_fill_1
XFILLER_7_264 VPWR VGND sg13cmos5l_fill_1
XFILLER_7_242 VPWR VGND sg13cmos5l_fill_2
XANTENNA__005__X S1BEG[3] VPWR VGND sg13cmos5l_antennanp
XANTENNA__001__A clkload0/A VPWR VGND sg13cmos5l_antennanp
XFILLER_6_96 VPWR VGND sg13cmos5l_fill_2
XFILLER_0_292 VPWR VGND sg13cmos5l_decap_8
XFILLER_5_373 VPWR VGND sg13cmos5l_decap_8
XFILLER_9_189 VPWR VGND sg13cmos5l_decap_8
XFILLER_9_134 VPWR VGND sg13cmos5l_fill_2
XFILLER_9_112 VPWR VGND sg13cmos5l_decap_8
XFILLER_7_4 VPWR VGND sg13cmos5l_fill_1
XANTENNA__013__X SS4BEG[7] VPWR VGND sg13cmos5l_antennanp
XANTENNA__103__X FrameData_O[10] VPWR VGND sg13cmos5l_antennanp
XFILLER_10_111 VPWR VGND sg13cmos5l_fill_2
XFILLER_10_166 VPWR VGND sg13cmos5l_fill_1
XFILLER_2_354 VPWR VGND sg13cmos5l_decap_8
XFILLER_6_159 VPWR VGND sg13cmos5l_decap_4
X_082_ FrameStrobe_O[11] FrameStrobe[11] VPWR VGND sg13cmos5l_buf_1
XANTENNA__008__X SS4BEG[2] VPWR VGND sg13cmos5l_antennanp
XFILLER_11_420 VPWR VGND sg13cmos5l_decap_8
XFILLER_2_173 VPWR VGND sg13cmos5l_decap_8
X_065_ UIO_TOP_UOUT19 NN4END[0] VPWR VGND sg13cmos5l_buf_1
XFILLER_9_30 VPWR VGND sg13cmos5l_decap_4
XFILLER_7_435 VPWR VGND sg13cmos5l_fill_2
XFILLER_7_402 VPWR VGND sg13cmos5l_decap_4
XANTENNA__004__A N1END[1] VPWR VGND sg13cmos5l_antennanp
Xclkbuf_0_UserCLK clkbuf_0_UserCLK/X UserCLK VPWR VGND sg13cmos5l_buf_8
XFILLER_9_63 VPWR VGND sg13cmos5l_decap_4
XFILLER_11_294 VPWR VGND sg13cmos5l_decap_8
X_117_ FrameData_O[24] FrameData[24] VPWR VGND sg13cmos5l_buf_1
XFILLER_7_221 VPWR VGND sg13cmos5l_decap_8
XFILLER_7_210 VPWR VGND sg13cmos5l_fill_1
XANTENNA__111__X FrameData_O[18] VPWR VGND sg13cmos5l_antennanp
X_048_ S2BEG[2] N2MID[5] VPWR VGND sg13cmos5l_buf_1
XANTENNA__021__X SS4BEG[15] VPWR VGND sg13cmos5l_antennanp
XFILLER_4_246 VPWR VGND sg13cmos5l_decap_8
XFILLER_4_268 VPWR VGND sg13cmos5l_decap_8
XFILLER_4_279 VPWR VGND sg13cmos5l_fill_1
XANTENNA__106__X FrameData_O[13] VPWR VGND sg13cmos5l_antennanp
XFILLER_6_53 VPWR VGND sg13cmos5l_decap_4
XANTENNA__016__X SS4BEG[10] VPWR VGND sg13cmos5l_antennanp
XFILLER_1_249 VPWR VGND sg13cmos5l_decap_8
XANTENNA__102__A FrameData[9] VPWR VGND sg13cmos5l_antennanp
XFILLER_0_271 VPWR VGND sg13cmos5l_decap_8
XFILLER_9_316 VPWR VGND sg13cmos5l_fill_1
XFILLER_9_305 VPWR VGND sg13cmos5l_decap_8
XANTENNA__012__A N4END[9] VPWR VGND sg13cmos5l_antennanp
XFILLER_10_304 VPWR VGND sg13cmos5l_fill_1
XFILLER_9_157 VPWR VGND sg13cmos5l_fill_1
XFILLER_6_319 VPWR VGND sg13cmos5l_fill_1
XFILLER_6_308 VPWR VGND sg13cmos5l_decap_8
XANTENNA__007__A UIO_TOP_UIN18 VPWR VGND sg13cmos5l_antennanp
XFILLER_3_10 VPWR VGND sg13cmos5l_decap_8
XFILLER_3_54 VPWR VGND sg13cmos5l_decap_4
XFILLER_3_87 VPWR VGND sg13cmos5l_decap_8
XFILLER_5_341 VPWR VGND sg13cmos5l_fill_2
XFILLER_9_168 VPWR VGND sg13cmos5l_decap_8
XFILLER_8_190 VPWR VGND sg13cmos5l_fill_1
XFILLER_6_127 VPWR VGND sg13cmos5l_decap_4
X_081_ FrameStrobe_O[10] FrameStrobe[10] VPWR VGND sg13cmos5l_buf_1
XANTENNA__114__X FrameData_O[21] VPWR VGND sg13cmos5l_antennanp
XFILLER_5_171 VPWR VGND sg13cmos5l_decap_4
XANTENNA__024__X S4BEG[2] VPWR VGND sg13cmos5l_antennanp
XFILLER_3_108 VPWR VGND sg13cmos5l_decap_8
XFILLER_3_119 VPWR VGND sg13cmos5l_fill_1
XANTENNA__110__A FrameData[17] VPWR VGND sg13cmos5l_antennanp
XFILLER_2_152 VPWR VGND sg13cmos5l_decap_8
X_064_ UIO_TOP_UOUT18 NN4END[1] VPWR VGND sg13cmos5l_buf_1
XANTENNA__020__A N4END[1] VPWR VGND sg13cmos5l_antennanp
XANTENNA__109__X FrameData_O[16] VPWR VGND sg13cmos5l_antennanp
XFILLER_0_66 VPWR VGND sg13cmos5l_decap_8
XFILLER_0_77 VPWR VGND sg13cmos5l_fill_1
XFILLER_0_88 VPWR VGND sg13cmos5l_decap_8
XFILLER_9_97 VPWR VGND sg13cmos5l_decap_4
XANTENNA__019__X SS4BEG[13] VPWR VGND sg13cmos5l_antennanp
XANTENNA__105__A FrameData[12] VPWR VGND sg13cmos5l_antennanp
XFILLER_11_273 VPWR VGND sg13cmos5l_decap_8
X_047_ S2BEG[1] N2MID[6] VPWR VGND sg13cmos5l_buf_1
X_116_ FrameData_O[23] FrameData[23] VPWR VGND sg13cmos5l_buf_1
XFILLER_7_288 VPWR VGND sg13cmos5l_decap_8
XFILLER_7_255 VPWR VGND sg13cmos5l_decap_8
XANTENNA__015__A N4END[6] VPWR VGND sg13cmos5l_antennanp
XFILLER_4_225 VPWR VGND sg13cmos5l_decap_8
XFILLER_4_258 VPWR VGND sg13cmos5l_decap_8
XFILLER_6_76 VPWR VGND sg13cmos5l_decap_8
XFILLER_6_65 VPWR VGND sg13cmos5l_fill_1
XANTENNA__032__X S4BEG[10] VPWR VGND sg13cmos5l_antennanp
XANTENNA__122__X FrameData_O[29] VPWR VGND sg13cmos5l_antennanp
XFILLER_0_250 VPWR VGND sg13cmos5l_decap_8
XFILLER_9_328 VPWR VGND sg13cmos5l_decap_4
XANTENNA__117__X FrameData_O[24] VPWR VGND sg13cmos5l_antennanp
XFILLER_8_372 VPWR VGND sg13cmos5l_decap_4
XANTENNA__027__X S4BEG[5] VPWR VGND sg13cmos5l_antennanp
XANTENNA__113__A FrameData[20] VPWR VGND sg13cmos5l_antennanp
XFILLER_3_77 VPWR VGND sg13cmos5l_decap_8
XANTENNA__023__A UIO_TOP_UIN14 VPWR VGND sg13cmos5l_antennanp
X_080_ FrameStrobe_O[9] FrameStrobe[9] VPWR VGND sg13cmos5l_buf_1
XANTENNA__108__A FrameData[15] VPWR VGND sg13cmos5l_antennanp
XFILLER_2_323 VPWR VGND sg13cmos5l_fill_1
XFILLER_2_389 VPWR VGND sg13cmos5l_decap_8
XANTENNA__018__A N4END[3] VPWR VGND sg13cmos5l_antennanp
XFILLER_5_150 VPWR VGND sg13cmos5l_decap_8
XANTENNA__040__X S2BEGb[2] VPWR VGND sg13cmos5l_antennanp
XFILLER_2_131 VPWR VGND sg13cmos5l_decap_8
X_063_ UIO_TOP_UOUT17 NN4END[2] VPWR VGND sg13cmos5l_buf_1
XFILLER_7_437 VPWR VGND sg13cmos5l_fill_1
XFILLER_7_415 VPWR VGND sg13cmos5l_fill_2
XFILLER_0_23 VPWR VGND sg13cmos5l_decap_4
XFILLER_0_45 VPWR VGND sg13cmos5l_decap_8
XFILLER_9_87 VPWR VGND sg13cmos5l_decap_4
XANTENNA__035__X S4BEG[13] VPWR VGND sg13cmos5l_antennanp
XFILLER_4_407 VPWR VGND sg13cmos5l_fill_2
XFILLER_4_418 VPWR VGND sg13cmos5l_decap_8
XANTENNA__121__A FrameData[28] VPWR VGND sg13cmos5l_antennanp
XFILLER_11_252 VPWR VGND sg13cmos5l_decap_8
X_046_ S2BEG[0] N2MID[7] VPWR VGND sg13cmos5l_buf_1
X_115_ FrameData_O[22] FrameData[22] VPWR VGND sg13cmos5l_buf_1
XFILLER_7_201 VPWR VGND sg13cmos5l_decap_8
XANTENNA__031__A UIO_TOP_UIN6 VPWR VGND sg13cmos5l_antennanp
XANTENNA__116__A FrameData[23] VPWR VGND sg13cmos5l_antennanp
XFILLER_4_204 VPWR VGND sg13cmos5l_decap_8
XANTENNA__026__A UIO_TOP_UIN11 VPWR VGND sg13cmos5l_antennanp
XFILLER_3_281 VPWR VGND sg13cmos5l_fill_2
X_029_ S4BEG[7] UIO_TOP_UIN8 VPWR VGND sg13cmos5l_buf_1
XFILLER_6_88 VPWR VGND sg13cmos5l_fill_1
XFILLER_6_44 VPWR VGND sg13cmos5l_fill_2
XFILLER_1_229 VPWR VGND sg13cmos5l_fill_2
XFILLER_8_384 VPWR VGND sg13cmos5l_decap_8
XFILLER_8_351 VPWR VGND sg13cmos5l_decap_8
.ends
