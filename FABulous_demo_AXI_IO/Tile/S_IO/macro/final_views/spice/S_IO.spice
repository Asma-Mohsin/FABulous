* NGSPICE file created from S_IO.ext - technology: ihp-sg13cmos5l

* Black-box entry subcircuit for sg13cmos5l_antennanp abstract view
.subckt sg13cmos5l_antennanp A VDD VSS
.ends

* Black-box entry subcircuit for sg13cmos5l_fill_1 abstract view
.subckt sg13cmos5l_fill_1 VDD VSS
.ends

* Black-box entry subcircuit for sg13cmos5l_decap_8 abstract view
.subckt sg13cmos5l_decap_8 VDD VSS
.ends

* Black-box entry subcircuit for sg13cmos5l_decap_4 abstract view
.subckt sg13cmos5l_decap_4 VDD VSS
.ends

* Black-box entry subcircuit for sg13cmos5l_fill_2 abstract view
.subckt sg13cmos5l_fill_2 VDD VSS
.ends

* Black-box entry subcircuit for sg13cmos5l_buf_1 abstract view
.subckt sg13cmos5l_buf_1 X A VDD VSS
.ends

* Black-box entry subcircuit for sg13cmos5l_buf_8 abstract view
.subckt sg13cmos5l_buf_8 X A VDD VSS
.ends

* Black-box entry subcircuit for sg13cmos5l_tielo abstract view
.subckt sg13cmos5l_tielo L_LO VDD VSS
.ends

.subckt S_IO Co FrameData[0] FrameData[10] FrameData[11] FrameData[12] FrameData[13]
+ FrameData[14] FrameData[15] FrameData[16] FrameData[17] FrameData[18] FrameData[19]
+ FrameData[1] FrameData[20] FrameData[21] FrameData[22] FrameData[23] FrameData[24]
+ FrameData[25] FrameData[26] FrameData[27] FrameData[28] FrameData[29] FrameData[2]
+ FrameData[30] FrameData[31] FrameData[3] FrameData[4] FrameData[5] FrameData[6]
+ FrameData[7] FrameData[8] FrameData[9] FrameData_O[0] FrameData_O[10] FrameData_O[11]
+ FrameData_O[12] FrameData_O[13] FrameData_O[14] FrameData_O[15] FrameData_O[16]
+ FrameData_O[17] FrameData_O[18] FrameData_O[19] FrameData_O[1] FrameData_O[20] FrameData_O[21]
+ FrameData_O[22] FrameData_O[23] FrameData_O[24] FrameData_O[25] FrameData_O[26]
+ FrameData_O[27] FrameData_O[28] FrameData_O[29] FrameData_O[2] FrameData_O[30] FrameData_O[31]
+ FrameData_O[3] FrameData_O[4] FrameData_O[5] FrameData_O[6] FrameData_O[7] FrameData_O[8]
+ FrameData_O[9] FrameStrobe[0] FrameStrobe[10] FrameStrobe[11] FrameStrobe[12] FrameStrobe[13]
+ FrameStrobe[14] FrameStrobe[15] FrameStrobe[16] FrameStrobe[17] FrameStrobe[18]
+ FrameStrobe[19] FrameStrobe[1] FrameStrobe[2] FrameStrobe[3] FrameStrobe[4] FrameStrobe[5]
+ FrameStrobe[6] FrameStrobe[7] FrameStrobe[8] FrameStrobe[9] FrameStrobe_O[0] FrameStrobe_O[10]
+ FrameStrobe_O[11] FrameStrobe_O[12] FrameStrobe_O[13] FrameStrobe_O[14] FrameStrobe_O[15]
+ FrameStrobe_O[16] FrameStrobe_O[17] FrameStrobe_O[18] FrameStrobe_O[19] FrameStrobe_O[1]
+ FrameStrobe_O[2] FrameStrobe_O[3] FrameStrobe_O[4] FrameStrobe_O[5] FrameStrobe_O[6]
+ FrameStrobe_O[7] FrameStrobe_O[8] FrameStrobe_O[9] N1BEG[0] N1BEG[1] N1BEG[2] N1BEG[3]
+ N2BEG[0] N2BEG[1] N2BEG[2] N2BEG[3] N2BEG[4] N2BEG[5] N2BEG[6] N2BEG[7] N2BEGb[0]
+ N2BEGb[1] N2BEGb[2] N2BEGb[3] N2BEGb[4] N2BEGb[5] N2BEGb[6] N2BEGb[7] N4BEG[0] N4BEG[10]
+ N4BEG[11] N4BEG[12] N4BEG[13] N4BEG[14] N4BEG[15] N4BEG[1] N4BEG[2] N4BEG[3] N4BEG[4]
+ N4BEG[5] N4BEG[6] N4BEG[7] N4BEG[8] N4BEG[9] NN4BEG[0] NN4BEG[10] NN4BEG[11] NN4BEG[12]
+ NN4BEG[13] NN4BEG[14] NN4BEG[15] NN4BEG[1] NN4BEG[2] NN4BEG[3] NN4BEG[4] NN4BEG[5]
+ NN4BEG[6] NN4BEG[7] NN4BEG[8] NN4BEG[9] S1END[0] S1END[1] S1END[2] S1END[3] S2END[0]
+ S2END[1] S2END[2] S2END[3] S2END[4] S2END[5] S2END[6] S2END[7] S2MID[0] S2MID[1]
+ S2MID[2] S2MID[3] S2MID[4] S2MID[5] S2MID[6] S2MID[7] S4END[0] S4END[10] S4END[11]
+ S4END[12] S4END[13] S4END[14] S4END[15] S4END[1] S4END[2] S4END[3] S4END[4] S4END[5]
+ S4END[6] S4END[7] S4END[8] S4END[9] SS4END[0] SS4END[10] SS4END[11] SS4END[12] SS4END[13]
+ SS4END[14] SS4END[15] SS4END[1] SS4END[2] SS4END[3] SS4END[4] SS4END[5] SS4END[6]
+ SS4END[7] SS4END[8] SS4END[9] UIO_BOT_UIN0 UIO_BOT_UIN1 UIO_BOT_UIN10 UIO_BOT_UIN11
+ UIO_BOT_UIN12 UIO_BOT_UIN13 UIO_BOT_UIN14 UIO_BOT_UIN15 UIO_BOT_UIN16 UIO_BOT_UIN17
+ UIO_BOT_UIN18 UIO_BOT_UIN19 UIO_BOT_UIN2 UIO_BOT_UIN3 UIO_BOT_UIN4 UIO_BOT_UIN5
+ UIO_BOT_UIN6 UIO_BOT_UIN7 UIO_BOT_UIN8 UIO_BOT_UIN9 UIO_BOT_UOUT0 UIO_BOT_UOUT1
+ UIO_BOT_UOUT10 UIO_BOT_UOUT11 UIO_BOT_UOUT12 UIO_BOT_UOUT13 UIO_BOT_UOUT14 UIO_BOT_UOUT15
+ UIO_BOT_UOUT16 UIO_BOT_UOUT17 UIO_BOT_UOUT18 UIO_BOT_UOUT19 UIO_BOT_UOUT2 UIO_BOT_UOUT3
+ UIO_BOT_UOUT4 UIO_BOT_UOUT5 UIO_BOT_UOUT6 UIO_BOT_UOUT7 UIO_BOT_UOUT8 UIO_BOT_UOUT9
+ UserCLK UserCLKo VGND VPWR
XANTENNA__043__X N2BEG[0] VPWR VGND sg13cmos5l_antennanp
XFILLER_10_328 VPWR VGND sg13cmos5l_fill_1
XFILLER_7_7 VPWR VGND sg13cmos5l_decap_8
XFILLER_5_365 VPWR VGND sg13cmos5l_decap_8
XFILLER_5_376 VPWR VGND sg13cmos5l_fill_1
XFILLER_5_387 VPWR VGND sg13cmos5l_decap_8
XFILLER_9_148 VPWR VGND sg13cmos5l_decap_4
XANTENNA__038__X N2BEGb[3] VPWR VGND sg13cmos5l_antennanp
XFILLER_8_181 VPWR VGND sg13cmos5l_decap_8
XFILLER_2_313 VPWR VGND sg13cmos5l_decap_8
XFILLER_2_324 VPWR VGND sg13cmos5l_fill_2
XFILLER_2_379 VPWR VGND sg13cmos5l_fill_2
XFILLER_6_107 VPWR VGND sg13cmos5l_decap_8
XANTENNA__124__A FrameData[30] VPWR VGND sg13cmos5l_antennanp
XFILLER_5_140 VPWR VGND sg13cmos5l_fill_1
XFILLER_5_151 VPWR VGND sg13cmos5l_decap_8
XANTENNA__034__A UIO_BOT_UIN0 VPWR VGND sg13cmos5l_antennanp
XFILLER_11_412 VPWR VGND sg13cmos5l_decap_8
X_062_ UIO_BOT_UOUT15 SS4END[0] VPWR VGND sg13cmos5l_buf_1
XANTENNA__119__A FrameData[25] VPWR VGND sg13cmos5l_antennanp
XFILLER_0_79 VPWR VGND sg13cmos5l_decap_8
XFILLER_2_176 VPWR VGND sg13cmos5l_decap_8
XANTENNA__029__A UIO_BOT_UIN5 VPWR VGND sg13cmos5l_antennanp
XANTENNA__051__X N1BEG[0] VPWR VGND sg13cmos5l_antennanp
XFILLER_11_286 VPWR VGND sg13cmos5l_decap_8
X_045_ N2BEG[2] S2MID[5] VPWR VGND sg13cmos5l_buf_1
X_114_ FrameData_O[20] FrameData[20] VPWR VGND sg13cmos5l_buf_1
XFILLER_7_268 VPWR VGND sg13cmos5l_fill_2
XFILLER_7_257 VPWR VGND sg13cmos5l_decap_8
XFILLER_7_246 VPWR VGND sg13cmos5l_fill_1
XANTENNA__046__X N2BEG[3] VPWR VGND sg13cmos5l_antennanp
XFILLER_0_422 VPWR VGND sg13cmos5l_decap_8
XFILLER_4_227 VPWR VGND sg13cmos5l_decap_8
XFILLER_3_260 VPWR VGND sg13cmos5l_decap_8
XFILLER_3_293 VPWR VGND sg13cmos5l_decap_8
XFILLER_6_12 VPWR VGND sg13cmos5l_decap_8
X_028_ N4BEG[9] UIO_BOT_UIN6 VPWR VGND sg13cmos5l_buf_1
XANTENNA__042__A S2END[0] VPWR VGND sg13cmos5l_antennanp
XFILLER_9_319 VPWR VGND sg13cmos5l_decap_8
XFILLER_0_296 VPWR VGND sg13cmos5l_decap_8
XFILLER_8_341 VPWR VGND sg13cmos5l_decap_8
XFILLER_8_330 VPWR VGND sg13cmos5l_decap_8
XANTENNA__037__A S2END[5] VPWR VGND sg13cmos5l_antennanp
XFILLER_10_318 VPWR VGND sg13cmos5l_decap_8
XFILLER_11_0 VPWR VGND sg13cmos5l_decap_8
XFILLER_3_68 VPWR VGND sg13cmos5l_fill_2
XFILLER_5_344 VPWR VGND sg13cmos5l_decap_8
XFILLER_9_116 VPWR VGND sg13cmos5l_decap_8
XFILLER_8_160 VPWR VGND sg13cmos5l_decap_8
XANTENNA__054__X N1BEG[3] VPWR VGND sg13cmos5l_antennanp
XFILLER_2_303 VPWR VGND sg13cmos5l_decap_4
XFILLER_1_391 VPWR VGND sg13cmos5l_fill_1
XANTENNA__049__X N2BEG[6] VPWR VGND sg13cmos5l_antennanp
XANTENNA__050__A S2MID[0] VPWR VGND sg13cmos5l_antennanp
XFILLER_7_406 VPWR VGND sg13cmos5l_fill_1
XFILLER_0_14 VPWR VGND sg13cmos5l_fill_2
XFILLER_0_58 VPWR VGND sg13cmos5l_decap_8
XFILLER_2_155 VPWR VGND sg13cmos5l_decap_8
X_061_ UIO_BOT_UOUT14 SS4END[1] VPWR VGND sg13cmos5l_buf_1
XFILLER_9_67 VPWR VGND sg13cmos5l_fill_2
XFILLER_9_12 VPWR VGND sg13cmos5l_decap_8
XFILLER_7_417 VPWR VGND sg13cmos5l_decap_4
XANTENNA__045__A S2MID[5] VPWR VGND sg13cmos5l_antennanp
XFILLER_11_254 VPWR VGND sg13cmos5l_decap_8
X_044_ N2BEG[1] S2MID[6] VPWR VGND sg13cmos5l_buf_1
X_113_ FrameData_O[19] FrameData[19] VPWR VGND sg13cmos5l_buf_1
XFILLER_7_236 VPWR VGND sg13cmos5l_decap_4
XANTENNA__062__X UIO_BOT_UOUT15 VPWR VGND sg13cmos5l_antennanp
XFILLER_0_401 VPWR VGND sg13cmos5l_decap_8
XFILLER_1_90 VPWR VGND sg13cmos5l_decap_8
XFILLER_4_206 VPWR VGND sg13cmos5l_decap_8
XFILLER_3_250 VPWR VGND sg13cmos5l_fill_1
X_027_ N4BEG[8] UIO_BOT_UIN7 VPWR VGND sg13cmos5l_buf_1
XFILLER_6_79 VPWR VGND sg13cmos5l_decap_8
XFILLER_6_68 VPWR VGND sg13cmos5l_fill_1
XANTENNA__057__X UIO_BOT_UOUT10 VPWR VGND sg13cmos5l_antennanp
XFILLER_0_275 VPWR VGND sg13cmos5l_decap_8
XANTENNA__053__A S1END[1] VPWR VGND sg13cmos5l_antennanp
XFILLER_5_312 VPWR VGND sg13cmos5l_decap_8
XFILLER_5_323 VPWR VGND sg13cmos5l_fill_1
XFILLER_3_14 VPWR VGND sg13cmos5l_decap_8
XFILLER_3_25 VPWR VGND sg13cmos5l_fill_1
XANTENNA__048__A S2MID[2] VPWR VGND sg13cmos5l_antennanp
XANTENNA__070__X UIO_BOT_UOUT5 VPWR VGND sg13cmos5l_antennanp
XFILLER_10_105 VPWR VGND sg13cmos5l_fill_1
XFILLER_2_359 VPWR VGND sg13cmos5l_fill_2
XFILLER_5_186 VPWR VGND sg13cmos5l_decap_4
XANTENNA__065__X UIO_BOT_UOUT18 VPWR VGND sg13cmos5l_antennanp
XFILLER_0_48 VPWR VGND sg13cmos5l_decap_8
XFILLER_2_101 VPWR VGND sg13cmos5l_fill_1
XFILLER_2_134 VPWR VGND sg13cmos5l_decap_8
X_060_ UIO_BOT_UOUT13 SS4END[2] VPWR VGND sg13cmos5l_buf_1
XFILLER_9_46 VPWR VGND sg13cmos5l_decap_8
XANTENNA__061__A SS4END[1] VPWR VGND sg13cmos5l_antennanp
XFILLER_11_233 VPWR VGND sg13cmos5l_decap_8
X_043_ N2BEG[0] S2MID[7] VPWR VGND sg13cmos5l_buf_1
X_112_ FrameData_O[18] FrameData[18] VPWR VGND sg13cmos5l_buf_1
XFILLER_7_215 VPWR VGND sg13cmos5l_decap_8
XFILLER_6_292 VPWR VGND sg13cmos5l_decap_8
XANTENNA__056__A SS4END[14] VPWR VGND sg13cmos5l_antennanp
X_026_ N4BEG[7] UIO_BOT_UIN8 VPWR VGND sg13cmos5l_buf_1
XFILLER_6_47 VPWR VGND sg13cmos5l_decap_8
XANTENNA__073__X FrameStrobe_O[1] VPWR VGND sg13cmos5l_antennanp
XFILLER_0_254 VPWR VGND sg13cmos5l_decap_8
X_009_ NN4BEG[6] S4END[9] VPWR VGND sg13cmos5l_buf_1
XFILLER_8_376 VPWR VGND sg13cmos5l_decap_4
XFILLER_8_321 VPWR VGND sg13cmos5l_decap_4
XANTENNA__068__X UIO_BOT_UOUT3 VPWR VGND sg13cmos5l_antennanp
XFILLER_3_37 VPWR VGND sg13cmos5l_decap_8
XFILLER_3_48 VPWR VGND sg13cmos5l_fill_2
XFILLER_8_195 VPWR VGND sg13cmos5l_decap_8
XANTENNA__064__A S4END[2] VPWR VGND sg13cmos5l_antennanp
XFILLER_10_128 VPWR VGND sg13cmos5l_fill_1
XFILLER_10_139 VPWR VGND sg13cmos5l_fill_2
XFILLER_5_7 VPWR VGND sg13cmos5l_fill_1
XFILLER_1_360 VPWR VGND sg13cmos5l_fill_1
XFILLER_5_165 VPWR VGND sg13cmos5l_decap_8
XFILLER_4_80 VPWR VGND sg13cmos5l_fill_2
XANTENNA__059__A SS4END[3] VPWR VGND sg13cmos5l_antennanp
XANTENNA__081__X FrameStrobe_O[9] VPWR VGND sg13cmos5l_antennanp
XFILLER_0_16 VPWR VGND sg13cmos5l_fill_1
XFILLER_0_27 VPWR VGND sg13cmos5l_decap_8
XFILLER_11_426 VPWR VGND sg13cmos5l_decap_8
XFILLER_11_437 VPWR VGND sg13cmos5l_fill_1
XFILLER_3_4 VPWR VGND sg13cmos5l_fill_1
XANTENNA__076__X FrameStrobe_O[4] VPWR VGND sg13cmos5l_antennanp
XFILLER_11_212 VPWR VGND sg13cmos5l_decap_8
XFILLER_3_433 VPWR VGND sg13cmos5l_decap_4
X_042_ N2BEGb[7] S2END[0] VPWR VGND sg13cmos5l_buf_1
X_111_ FrameData_O[17] FrameData[17] VPWR VGND sg13cmos5l_buf_1
XANTENNA__072__A FrameStrobe[0] VPWR VGND sg13cmos5l_antennanp
XFILLER_6_271 VPWR VGND sg13cmos5l_decap_8
XFILLER_0_436 VPWR VGND sg13cmos5l_fill_2
X_025_ N4BEG[6] UIO_BOT_UIN9 VPWR VGND sg13cmos5l_buf_1
XFILLER_6_26 VPWR VGND sg13cmos5l_decap_8
XANTENNA__067__A SS4END[13] VPWR VGND sg13cmos5l_antennanp
XFILLER_0_233 VPWR VGND sg13cmos5l_decap_8
X_008_ NN4BEG[5] S4END[10] VPWR VGND sg13cmos5l_buf_1
XFILLER_8_399 VPWR VGND sg13cmos5l_fill_1
XFILLER_8_355 VPWR VGND sg13cmos5l_decap_8
XFILLER_7_80 VPWR VGND sg13cmos5l_fill_2
XANTENNA__084__X FrameStrobe_O[12] VPWR VGND sg13cmos5l_antennanp
XFILLER_5_358 VPWR VGND sg13cmos5l_decap_8
XFILLER_9_108 VPWR VGND sg13cmos5l_decap_4
XFILLER_10_118 VPWR VGND sg13cmos5l_fill_2
XFILLER_8_174 VPWR VGND sg13cmos5l_decap_8
XANTENNA__079__X FrameStrobe_O[7] VPWR VGND sg13cmos5l_antennanp
XANTENNA__080__A FrameStrobe[8] VPWR VGND sg13cmos5l_antennanp
XFILLER_5_133 VPWR VGND sg13cmos5l_decap_8
XFILLER_5_144 VPWR VGND sg13cmos5l_decap_8
XFILLER_1_383 VPWR VGND sg13cmos5l_fill_1
XANTENNA__075__A FrameStrobe[3] VPWR VGND sg13cmos5l_antennanp
XFILLER_11_405 VPWR VGND sg13cmos5l_decap_8
XFILLER_2_125 VPWR VGND sg13cmos5l_decap_4
XFILLER_2_169 VPWR VGND sg13cmos5l_decap_8
XFILLER_4_70 VPWR VGND sg13cmos5l_fill_2
XFILLER_1_191 VPWR VGND sg13cmos5l_fill_1
XFILLER_9_37 VPWR VGND sg13cmos5l_decap_4
XFILLER_9_26 VPWR VGND sg13cmos5l_fill_1
XFILLER_9_291 VPWR VGND sg13cmos5l_decap_8
XANTENNA__092__X UIO_BOT_UOUT7 VPWR VGND sg13cmos5l_antennanp
XFILLER_11_268 VPWR VGND sg13cmos5l_decap_4
XFILLER_11_279 VPWR VGND sg13cmos5l_decap_8
X_041_ N2BEGb[6] S2END[1] VPWR VGND sg13cmos5l_buf_1
X_110_ FrameData_O[16] FrameData[16] VPWR VGND sg13cmos5l_buf_1
Xclkload0 clkload0/X clkload0/A VPWR VGND sg13cmos5l_buf_1
XFILLER_10_290 VPWR VGND sg13cmos5l_decap_8
XANTENNA__087__X FrameStrobe_O[15] VPWR VGND sg13cmos5l_antennanp
XFILLER_0_415 VPWR VGND sg13cmos5l_decap_8
XFILLER_10_80 VPWR VGND sg13cmos5l_fill_1
XFILLER_10_91 VPWR VGND sg13cmos5l_fill_1
XFILLER_3_286 VPWR VGND sg13cmos5l_decap_8
X_024_ N4BEG[5] UIO_BOT_UIN10 VPWR VGND sg13cmos5l_buf_1
XANTENNA__083__A FrameStrobe[11] VPWR VGND sg13cmos5l_antennanp
XFILLER_0_212 VPWR VGND sg13cmos5l_decap_8
XFILLER_0_289 VPWR VGND sg13cmos5l_decap_8
X_007_ NN4BEG[4] S4END[11] VPWR VGND sg13cmos5l_buf_1
XFILLER_7_92 VPWR VGND sg13cmos5l_decap_4
XANTENNA__078__A FrameStrobe[6] VPWR VGND sg13cmos5l_antennanp
XFILLER_5_337 VPWR VGND sg13cmos5l_decap_4
XFILLER_8_153 VPWR VGND sg13cmos5l_decap_8
XANTENNA__095__X FrameData_O[1] VPWR VGND sg13cmos5l_antennanp
XFILLER_2_307 VPWR VGND sg13cmos5l_fill_2
XFILLER_5_112 VPWR VGND sg13cmos5l_decap_4
XANTENNA__091__A FrameStrobe[19] VPWR VGND sg13cmos5l_antennanp
XFILLER_4_82 VPWR VGND sg13cmos5l_fill_1
XFILLER_4_93 VPWR VGND sg13cmos5l_decap_8
XFILLER_2_148 VPWR VGND sg13cmos5l_decap_8
XANTENNA__086__A FrameStrobe[14] VPWR VGND sg13cmos5l_antennanp
XFILLER_11_247 VPWR VGND sg13cmos5l_decap_8
XFILLER_3_413 VPWR VGND sg13cmos5l_fill_2
X_040_ N2BEGb[5] S2END[2] VPWR VGND sg13cmos5l_buf_1
XFILLER_7_229 VPWR VGND sg13cmos5l_decap_8
XFILLER_1_83 VPWR VGND sg13cmos5l_decap_8
XFILLER_6_251 VPWR VGND sg13cmos5l_fill_1
XFILLER_6_240 VPWR VGND sg13cmos5l_decap_8
XFILLER_3_232 VPWR VGND sg13cmos5l_decap_8
XFILLER_3_243 VPWR VGND sg13cmos5l_decap_8
XFILLER_3_254 VPWR VGND sg13cmos5l_fill_2
X_023_ N4BEG[4] UIO_BOT_UIN11 VPWR VGND sg13cmos5l_buf_1
XANTENNA__098__X FrameData_O[4] VPWR VGND sg13cmos5l_antennanp
XFILLER_0_268 VPWR VGND sg13cmos5l_decap_8
X_006_ NN4BEG[3] UIO_BOT_UIN16 VPWR VGND sg13cmos5l_buf_1
XANTENNA__094__A FrameData[0] VPWR VGND sg13cmos5l_antennanp
XFILLER_5_305 VPWR VGND sg13cmos5l_decap_8
XFILLER_5_327 VPWR VGND sg13cmos5l_decap_4
XFILLER_4_393 VPWR VGND sg13cmos5l_decap_8
XFILLER_8_132 VPWR VGND sg13cmos5l_decap_8
XANTENNA__089__A FrameStrobe[17] VPWR VGND sg13cmos5l_antennanp
XFILLER_10_109 VPWR VGND sg13cmos5l_fill_2
XFILLER_1_374 VPWR VGND sg13cmos5l_fill_2
XFILLER_1_396 VPWR VGND sg13cmos5l_fill_1
XFILLER_5_179 VPWR VGND sg13cmos5l_decap_8
XFILLER_4_50 VPWR VGND sg13cmos5l_fill_2
XFILLER_2_105 VPWR VGND sg13cmos5l_fill_1
XFILLER_2_116 VPWR VGND sg13cmos5l_decap_4
XFILLER_6_422 VPWR VGND sg13cmos5l_decap_8
XFILLER_9_271 VPWR VGND sg13cmos5l_fill_1
XFILLER_9_260 VPWR VGND sg13cmos5l_fill_2
XFILLER_11_226 VPWR VGND sg13cmos5l_decap_8
XFILLER_1_4 VPWR VGND sg13cmos5l_fill_1
XFILLER_7_208 VPWR VGND sg13cmos5l_decap_8
X_099_ FrameData_O[5] FrameData[5] VPWR VGND sg13cmos5l_buf_1
XFILLER_6_285 VPWR VGND sg13cmos5l_decap_8
XFILLER_6_263 VPWR VGND sg13cmos5l_decap_4
XANTENNA__097__A FrameData[3] VPWR VGND sg13cmos5l_antennanp
XFILLER_10_60 VPWR VGND sg13cmos5l_fill_1
X_022_ N4BEG[3] UIO_BOT_UIN12 VPWR VGND sg13cmos5l_buf_1
XFILLER_0_247 VPWR VGND sg13cmos5l_decap_8
XFILLER_8_325 VPWR VGND sg13cmos5l_fill_2
X_005_ NN4BEG[2] UIO_BOT_UIN17 VPWR VGND sg13cmos5l_buf_1
XFILLER_8_369 VPWR VGND sg13cmos5l_decap_8
XFILLER_4_372 VPWR VGND sg13cmos5l_decap_8
XFILLER_8_188 VPWR VGND sg13cmos5l_decap_8
XFILLER_1_331 VPWR VGND sg13cmos5l_fill_2
XFILLER_1_353 VPWR VGND sg13cmos5l_decap_8
XFILLER_5_158 VPWR VGND sg13cmos5l_decap_8
XFILLER_9_431 VPWR VGND sg13cmos5l_decap_8
XFILLER_11_419 VPWR VGND sg13cmos5l_decap_8
XFILLER_1_161 VPWR VGND sg13cmos5l_fill_1
XFILLER_1_183 VPWR VGND sg13cmos5l_fill_1
XFILLER_6_412 VPWR VGND sg13cmos5l_fill_1
XFILLER_11_205 VPWR VGND sg13cmos5l_decap_8
XFILLER_3_426 VPWR VGND sg13cmos5l_decap_8
XFILLER_3_437 VPWR VGND sg13cmos5l_fill_1
X_098_ FrameData_O[4] FrameData[4] VPWR VGND sg13cmos5l_buf_1
XFILLER_6_231 VPWR VGND sg13cmos5l_decap_4
XFILLER_0_429 VPWR VGND sg13cmos5l_decap_8
XFILLER_1_63 VPWR VGND sg13cmos5l_fill_2
XFILLER_3_256 VPWR VGND sg13cmos5l_fill_1
XFILLER_3_267 VPWR VGND sg13cmos5l_decap_4
XFILLER_6_19 VPWR VGND sg13cmos5l_decap_8
X_021_ N4BEG[2] UIO_BOT_UIN13 VPWR VGND sg13cmos5l_buf_1
XFILLER_0_226 VPWR VGND sg13cmos5l_decap_8
XFILLER_11_7 VPWR VGND sg13cmos5l_fill_1
X_004_ NN4BEG[1] UIO_BOT_UIN18 VPWR VGND sg13cmos5l_buf_1
XFILLER_8_348 VPWR VGND sg13cmos5l_decap_8
XFILLER_8_337 VPWR VGND sg13cmos5l_fill_1
XFILLER_8_315 VPWR VGND sg13cmos5l_fill_2
XFILLER_7_73 VPWR VGND sg13cmos5l_decap_8
XFILLER_8_167 VPWR VGND sg13cmos5l_decap_8
XANTENNA__003__X NN4BEG[0] VPWR VGND sg13cmos5l_antennanp
XFILLER_5_104 VPWR VGND sg13cmos5l_decap_4
XFILLER_5_126 VPWR VGND sg13cmos5l_decap_8
XFILLER_4_192 VPWR VGND sg13cmos5l_decap_8
XFILLER_4_52 VPWR VGND sg13cmos5l_fill_1
XFILLER_4_63 VPWR VGND sg13cmos5l_decap_8
XFILLER_2_129 VPWR VGND sg13cmos5l_fill_1
XANTENNA__000__L_LO Co VPWR VGND sg13cmos5l_antennanp
XFILLER_1_151 VPWR VGND sg13cmos5l_fill_2
XFILLER_9_19 VPWR VGND sg13cmos5l_decap_8
XFILLER_9_284 VPWR VGND sg13cmos5l_decap_8
XFILLER_10_250 VPWR VGND sg13cmos5l_fill_2
XANTENNA__101__X FrameData_O[7] VPWR VGND sg13cmos5l_antennanp
XFILLER_1_97 VPWR VGND sg13cmos5l_decap_4
X_097_ FrameData_O[3] FrameData[3] VPWR VGND sg13cmos5l_buf_1
XANTENNA__011__X NN4BEG[8] VPWR VGND sg13cmos5l_antennanp
XFILLER_0_408 VPWR VGND sg13cmos5l_decap_8
XFILLER_10_73 VPWR VGND sg13cmos5l_fill_2
XFILLER_3_213 VPWR VGND sg13cmos5l_decap_8
XFILLER_3_224 VPWR VGND sg13cmos5l_decap_4
X_020_ N4BEG[1] UIO_BOT_UIN14 VPWR VGND sg13cmos5l_buf_1
XFILLER_3_279 VPWR VGND sg13cmos5l_decap_8
XANTENNA__006__X NN4BEG[3] VPWR VGND sg13cmos5l_antennanp
XFILLER_0_205 VPWR VGND sg13cmos5l_decap_8
X_003_ NN4BEG[0] UIO_BOT_UIN19 VPWR VGND sg13cmos5l_buf_1
XFILLER_8_305 VPWR VGND sg13cmos5l_fill_1
XANTENNA__002__A clkload0/A VPWR VGND sg13cmos5l_antennanp
XFILLER_7_96 VPWR VGND sg13cmos5l_fill_1
XFILLER_7_85 VPWR VGND sg13cmos5l_decap_8
XFILLER_8_102 VPWR VGND sg13cmos5l_decap_8
XFILLER_8_146 VPWR VGND sg13cmos5l_decap_8
XFILLER_8_113 VPWR VGND sg13cmos5l_fill_1
XFILLER_5_116 VPWR VGND sg13cmos5l_fill_1
XANTENNA__104__X FrameData_O[10] VPWR VGND sg13cmos5l_antennanp
XFILLER_4_171 VPWR VGND sg13cmos5l_decap_8
XFILLER_4_42 VPWR VGND sg13cmos5l_fill_1
XANTENNA__014__X NN4BEG[11] VPWR VGND sg13cmos5l_antennanp
XFILLER_10_432 VPWR VGND sg13cmos5l_decap_4
XFILLER_1_141 VPWR VGND sg13cmos5l_decap_4
XFILLER_8_0 VPWR VGND sg13cmos5l_decap_8
XFILLER_6_436 VPWR VGND sg13cmos5l_fill_2
XANTENNA__010__A S4END[8] VPWR VGND sg13cmos5l_antennanp
XANTENNA__100__A FrameData[6] VPWR VGND sg13cmos5l_antennanp
XANTENNA__009__X NN4BEG[6] VPWR VGND sg13cmos5l_antennanp
XFILLER_3_406 VPWR VGND sg13cmos5l_decap_8
X_096_ FrameData_O[2] FrameData[2] VPWR VGND sg13cmos5l_buf_1
XFILLER_6_299 VPWR VGND sg13cmos5l_decap_8
XFILLER_6_255 VPWR VGND sg13cmos5l_decap_4
XANTENNA__005__A UIO_BOT_UIN17 VPWR VGND sg13cmos5l_antennanp
Xclkbuf_1_1__f_UserCLK _002_/A clkbuf_0_UserCLK/X VPWR VGND sg13cmos5l_buf_8
XFILLER_10_96 VPWR VGND sg13cmos5l_fill_2
XANTENNA__112__X FrameData_O[18] VPWR VGND sg13cmos5l_antennanp
X_079_ FrameStrobe_O[7] FrameStrobe[7] VPWR VGND sg13cmos5l_buf_1
XANTENNA__022__X N4BEG[3] VPWR VGND sg13cmos5l_antennanp
X_002_ UserCLKo _002_/A VPWR VGND sg13cmos5l_buf_1
XFILLER_8_317 VPWR VGND sg13cmos5l_fill_1
XANTENNA__107__X FrameData_O[13] VPWR VGND sg13cmos5l_antennanp
XFILLER_7_42 VPWR VGND sg13cmos5l_decap_8
XFILLER_7_394 VPWR VGND sg13cmos5l_fill_2
XFILLER_7_350 VPWR VGND sg13cmos5l_decap_4
XANTENNA__017__X NN4BEG[14] VPWR VGND sg13cmos5l_antennanp
XANTENNA__103__A FrameData[9] VPWR VGND sg13cmos5l_antennanp
XFILLER_4_342 VPWR VGND sg13cmos5l_decap_8
XFILLER_4_353 VPWR VGND sg13cmos5l_fill_1
XFILLER_4_386 VPWR VGND sg13cmos5l_decap_8
XFILLER_8_125 VPWR VGND sg13cmos5l_decap_4
XANTENNA__013__A S4END[5] VPWR VGND sg13cmos5l_antennanp
XFILLER_7_191 VPWR VGND sg13cmos5l_decap_8
XFILLER_1_345 VPWR VGND sg13cmos5l_fill_1
XFILLER_1_367 VPWR VGND sg13cmos5l_fill_2
XFILLER_9_412 VPWR VGND sg13cmos5l_fill_2
XANTENNA__008__A S4END[10] VPWR VGND sg13cmos5l_antennanp
XANTENNA__120__X FrameData_O[26] VPWR VGND sg13cmos5l_antennanp
XFILLER_2_109 VPWR VGND sg13cmos5l_decap_8
XFILLER_4_76 VPWR VGND sg13cmos5l_fill_1
XFILLER_4_87 VPWR VGND sg13cmos5l_fill_2
XANTENNA__030__X N4BEG[11] VPWR VGND sg13cmos5l_antennanp
XANTENNA__115__X FrameData_O[21] VPWR VGND sg13cmos5l_antennanp
XFILLER_9_253 VPWR VGND sg13cmos5l_decap_8
XFILLER_9_220 VPWR VGND sg13cmos5l_fill_1
XANTENNA__025__X N4BEG[6] VPWR VGND sg13cmos5l_antennanp
XFILLER_11_219 VPWR VGND sg13cmos5l_decap_8
XANTENNA__111__A FrameData[17] VPWR VGND sg13cmos5l_antennanp
XFILLER_10_252 VPWR VGND sg13cmos5l_fill_1
XFILLER_1_77 VPWR VGND sg13cmos5l_fill_2
X_095_ FrameData_O[1] FrameData[1] VPWR VGND sg13cmos5l_buf_1
XFILLER_6_278 VPWR VGND sg13cmos5l_decap_8
XFILLER_6_267 VPWR VGND sg13cmos5l_fill_1
XANTENNA__021__A UIO_BOT_UIN13 VPWR VGND sg13cmos5l_antennanp
XFILLER_10_75 VPWR VGND sg13cmos5l_fill_1
XFILLER_3_204 VPWR VGND sg13cmos5l_decap_4
XANTENNA__016__A S4END[2] VPWR VGND sg13cmos5l_antennanp
XANTENNA__106__A FrameData[12] VPWR VGND sg13cmos5l_antennanp
X_078_ FrameStrobe_O[6] FrameStrobe[6] VPWR VGND sg13cmos5l_buf_1
X_001_ UIO_BOT_UOUT9 SS4END[6] VPWR VGND sg13cmos5l_buf_1
XANTENNA__123__X FrameData_O[29] VPWR VGND sg13cmos5l_antennanp
XFILLER_11_391 VPWR VGND sg13cmos5l_decap_8
XFILLER_7_21 VPWR VGND sg13cmos5l_decap_8
XANTENNA__033__X N4BEG[14] VPWR VGND sg13cmos5l_antennanp
XFILLER_4_365 VPWR VGND sg13cmos5l_decap_8
XANTENNA__118__X FrameData_O[24] VPWR VGND sg13cmos5l_antennanp
XFILLER_7_170 VPWR VGND sg13cmos5l_decap_8
XANTENNA__028__X N4BEG[9] VPWR VGND sg13cmos5l_antennanp
XFILLER_1_302 VPWR VGND sg13cmos5l_fill_2
XFILLER_1_313 VPWR VGND sg13cmos5l_fill_2
XFILLER_1_379 VPWR VGND sg13cmos5l_decap_4
XANTENNA__114__A FrameData[20] VPWR VGND sg13cmos5l_antennanp
XFILLER_4_22 VPWR VGND sg13cmos5l_decap_8
XFILLER_4_33 VPWR VGND sg13cmos5l_fill_2
XFILLER_9_424 VPWR VGND sg13cmos5l_decap_8
XANTENNA__024__A UIO_BOT_UIN10 VPWR VGND sg13cmos5l_antennanp
XFILLER_6_416 VPWR VGND sg13cmos5l_fill_2
XANTENNA__109__A FrameData[15] VPWR VGND sg13cmos5l_antennanp
XFILLER_1_121 VPWR VGND sg13cmos5l_decap_8
XFILLER_1_176 VPWR VGND sg13cmos5l_decap_8
XFILLER_9_298 VPWR VGND sg13cmos5l_decap_8
XFILLER_9_265 VPWR VGND sg13cmos5l_fill_2
XFILLER_9_232 VPWR VGND sg13cmos5l_decap_8
XANTENNA__019__A UIO_BOT_UIN15 VPWR VGND sg13cmos5l_antennanp
XANTENNA__041__X N2BEGb[6] VPWR VGND sg13cmos5l_antennanp
XFILLER_3_419 VPWR VGND sg13cmos5l_decap_8
XFILLER_10_231 VPWR VGND sg13cmos5l_fill_2
XFILLER_10_297 VPWR VGND sg13cmos5l_decap_8
XFILLER_6_213 VPWR VGND sg13cmos5l_fill_2
X_094_ FrameData_O[0] FrameData[0] VPWR VGND sg13cmos5l_buf_1
XFILLER_6_235 VPWR VGND sg13cmos5l_fill_2
XANTENNA__036__X N2BEGb[1] VPWR VGND sg13cmos5l_antennanp
XANTENNA__122__A FrameData[28] VPWR VGND sg13cmos5l_antennanp
XFILLER_2_271 VPWR VGND sg13cmos5l_decap_8
XFILLER_2_282 VPWR VGND sg13cmos5l_decap_8
X_077_ FrameStrobe_O[5] FrameStrobe[5] VPWR VGND sg13cmos5l_buf_1
XANTENNA__032__A UIO_BOT_UIN2 VPWR VGND sg13cmos5l_antennanp
XFILLER_0_219 VPWR VGND sg13cmos5l_decap_8
XANTENNA__117__A FrameData[23] VPWR VGND sg13cmos5l_antennanp
XFILLER_11_370 VPWR VGND sg13cmos5l_decap_8
X_000_ Co VPWR VGND sg13cmos5l_tielo
XFILLER_7_66 VPWR VGND sg13cmos5l_decap_8
XFILLER_7_374 VPWR VGND sg13cmos5l_decap_8
XANTENNA__027__A UIO_BOT_UIN7 VPWR VGND sg13cmos5l_antennanp
XFILLER_4_300 VPWR VGND sg13cmos5l_decap_4
XFILLER_4_333 VPWR VGND sg13cmos5l_fill_2
XANTENNA__044__X N2BEG[1] VPWR VGND sg13cmos5l_antennanp
XFILLER_1_325 VPWR VGND sg13cmos5l_fill_2
XFILLER_1_336 VPWR VGND sg13cmos5l_fill_2
XFILLER_1_369 VPWR VGND sg13cmos5l_fill_1
XFILLER_0_380 VPWR VGND sg13cmos5l_decap_8
XFILLER_4_130 VPWR VGND sg13cmos5l_decap_8
XFILLER_4_152 VPWR VGND sg13cmos5l_fill_2
XFILLER_4_185 VPWR VGND sg13cmos5l_decap_8
XFILLER_4_56 VPWR VGND sg13cmos5l_decap_8
XFILLER_4_89 VPWR VGND sg13cmos5l_fill_1
XANTENNA__039__X N2BEGb[4] VPWR VGND sg13cmos5l_antennanp
XANTENNA__040__A S2END[2] VPWR VGND sg13cmos5l_antennanp
XFILLER_1_199 VPWR VGND sg13cmos5l_fill_2
XANTENNA__035__A S2END[7] VPWR VGND sg13cmos5l_antennanp
XANTENNA__125__A FrameData[31] VPWR VGND sg13cmos5l_antennanp
XFILLER_10_243 VPWR VGND sg13cmos5l_fill_1
XFILLER_10_265 VPWR VGND sg13cmos5l_fill_2
XFILLER_2_420 VPWR VGND sg13cmos5l_decap_8
XFILLER_6_0 VPWR VGND sg13cmos5l_decap_8
X_093_ UIO_BOT_UOUT8 SS4END[7] VPWR VGND sg13cmos5l_buf_1
XFILLER_6_247 VPWR VGND sg13cmos5l_decap_4
XFILLER_1_68 VPWR VGND sg13cmos5l_fill_2
XFILLER_1_79 VPWR VGND sg13cmos5l_fill_1
XFILLER_5_291 VPWR VGND sg13cmos5l_decap_8
XANTENNA__052__X N1BEG[1] VPWR VGND sg13cmos5l_antennanp
XFILLER_3_228 VPWR VGND sg13cmos5l_fill_1
XFILLER_3_239 VPWR VGND sg13cmos5l_fill_1
XFILLER_2_250 VPWR VGND sg13cmos5l_decap_8
X_076_ FrameStrobe_O[4] FrameStrobe[4] VPWR VGND sg13cmos5l_buf_1
XANTENNA__047__X N2BEG[4] VPWR VGND sg13cmos5l_antennanp
Xclkbuf_1_0__f_UserCLK clkload0/A clkbuf_0_UserCLK/X VPWR VGND sg13cmos5l_buf_8
XFILLER_8_309 VPWR VGND sg13cmos5l_fill_2
X_059_ UIO_BOT_UOUT12 SS4END[3] VPWR VGND sg13cmos5l_buf_1
XFILLER_7_331 VPWR VGND sg13cmos5l_fill_1
XANTENNA__043__A S2MID[7] VPWR VGND sg13cmos5l_antennanp
XFILLER_8_139 VPWR VGND sg13cmos5l_decap_8
XFILLER_8_117 VPWR VGND sg13cmos5l_decap_4
XANTENNA__038__A S2END[4] VPWR VGND sg13cmos5l_antennanp
XANTENNA__060__X UIO_BOT_UOUT13 VPWR VGND sg13cmos5l_antennanp
XFILLER_1_304 VPWR VGND sg13cmos5l_fill_1
XFILLER_4_164 VPWR VGND sg13cmos5l_decap_8
XANTENNA__055__X UIO_BOT_UOUT0 VPWR VGND sg13cmos5l_antennanp
XFILLER_10_425 VPWR VGND sg13cmos5l_decap_8
XFILLER_10_436 VPWR VGND sg13cmos5l_fill_2
XFILLER_1_101 VPWR VGND sg13cmos5l_fill_1
XFILLER_1_145 VPWR VGND sg13cmos5l_fill_2
XFILLER_6_429 VPWR VGND sg13cmos5l_decap_8
XFILLER_9_267 VPWR VGND sg13cmos5l_fill_1
XANTENNA__051__A S1END[3] VPWR VGND sg13cmos5l_antennanp
XFILLER_10_200 VPWR VGND sg13cmos5l_fill_1
XFILLER_10_211 VPWR VGND sg13cmos5l_decap_8
XFILLER_6_226 VPWR VGND sg13cmos5l_fill_1
XFILLER_1_36 VPWR VGND sg13cmos5l_fill_2
XFILLER_1_58 VPWR VGND sg13cmos5l_fill_1
X_092_ UIO_BOT_UOUT7 SS4END[8] VPWR VGND sg13cmos5l_buf_1
XANTENNA__046__A S2MID[4] VPWR VGND sg13cmos5l_antennanp
XFILLER_10_67 VPWR VGND sg13cmos5l_fill_2
XFILLER_5_270 VPWR VGND sg13cmos5l_decap_8
X_075_ FrameStrobe_O[3] FrameStrobe[3] VPWR VGND sg13cmos5l_buf_1
XANTENNA__063__X UIO_BOT_UOUT16 VPWR VGND sg13cmos5l_antennanp
XFILLER_2_90 VPWR VGND sg13cmos5l_decap_8
X_058_ UIO_BOT_UOUT11 SS4END[4] VPWR VGND sg13cmos5l_buf_1
XFILLER_7_387 VPWR VGND sg13cmos5l_decap_8
XFILLER_7_35 VPWR VGND sg13cmos5l_decap_8
XFILLER_7_343 VPWR VGND sg13cmos5l_decap_8
XFILLER_7_310 VPWR VGND sg13cmos5l_decap_8
XANTENNA__058__X UIO_BOT_UOUT11 VPWR VGND sg13cmos5l_antennanp
XFILLER_11_180 VPWR VGND sg13cmos5l_decap_8
XFILLER_4_335 VPWR VGND sg13cmos5l_fill_1
XFILLER_4_379 VPWR VGND sg13cmos5l_decap_8
XANTENNA__054__A S1END[0] VPWR VGND sg13cmos5l_antennanp
XFILLER_7_184 VPWR VGND sg13cmos5l_fill_2
XFILLER_1_327 VPWR VGND sg13cmos5l_fill_1
XFILLER_1_349 VPWR VGND sg13cmos5l_fill_1
XFILLER_4_14 VPWR VGND sg13cmos5l_decap_4
XFILLER_9_405 VPWR VGND sg13cmos5l_decap_8
XANTENNA__049__A S2MID[1] VPWR VGND sg13cmos5l_antennanp
XANTENNA__071__X UIO_BOT_UOUT6 VPWR VGND sg13cmos5l_antennanp
XFILLER_1_113 VPWR VGND sg13cmos5l_fill_2
XFILLER_1_135 VPWR VGND sg13cmos5l_fill_2
XFILLER_6_408 VPWR VGND sg13cmos5l_decap_4
XFILLER_9_246 VPWR VGND sg13cmos5l_decap_8
XANTENNA__066__X UIO_BOT_UOUT19 VPWR VGND sg13cmos5l_antennanp
XFILLER_8_290 VPWR VGND sg13cmos5l_fill_1
XFILLER_10_223 VPWR VGND sg13cmos5l_fill_1
X_091_ FrameStrobe_O[19] FrameStrobe[19] VPWR VGND sg13cmos5l_buf_1
XANTENNA__062__A SS4END[0] VPWR VGND sg13cmos5l_antennanp
XFILLER_3_208 VPWR VGND sg13cmos5l_fill_2
X_074_ FrameStrobe_O[2] FrameStrobe[2] VPWR VGND sg13cmos5l_buf_1
XFILLER_2_296 VPWR VGND sg13cmos5l_decap_8
XANTENNA__057__A SS4END[5] VPWR VGND sg13cmos5l_antennanp
XFILLER_11_384 VPWR VGND sg13cmos5l_decap_8
X_057_ UIO_BOT_UOUT10 SS4END[5] VPWR VGND sg13cmos5l_buf_1
XFILLER_7_14 VPWR VGND sg13cmos5l_decap_8
XANTENNA__074__X FrameStrobe_O[2] VPWR VGND sg13cmos5l_antennanp
XFILLER_4_358 VPWR VGND sg13cmos5l_decap_8
X_109_ FrameData_O[15] FrameData[15] VPWR VGND sg13cmos5l_buf_1
XFILLER_7_163 VPWR VGND sg13cmos5l_decap_8
XANTENNA__069__X UIO_BOT_UOUT4 VPWR VGND sg13cmos5l_antennanp
XANTENNA__070__A SS4END[10] VPWR VGND sg13cmos5l_antennanp
XFILLER_9_417 VPWR VGND sg13cmos5l_decap_8
XFILLER_0_394 VPWR VGND sg13cmos5l_decap_8
XFILLER_4_100 VPWR VGND sg13cmos5l_decap_4
XFILLER_4_122 VPWR VGND sg13cmos5l_decap_4
XFILLER_4_199 VPWR VGND sg13cmos5l_decap_8
XANTENNA__065__A S4END[1] VPWR VGND sg13cmos5l_antennanp
XFILLER_9_225 VPWR VGND sg13cmos5l_decap_4
XFILLER_0_191 VPWR VGND sg13cmos5l_decap_8
XANTENNA__082__X FrameStrobe_O[10] VPWR VGND sg13cmos5l_antennanp
XFILLER_10_257 VPWR VGND sg13cmos5l_fill_2
XFILLER_2_434 VPWR VGND sg13cmos5l_decap_4
XFILLER_6_206 VPWR VGND sg13cmos5l_decap_8
X_090_ FrameStrobe_O[18] FrameStrobe[18] VPWR VGND sg13cmos5l_buf_1
XANTENNA__077__X FrameStrobe_O[5] VPWR VGND sg13cmos5l_antennanp
XFILLER_10_69 VPWR VGND sg13cmos5l_fill_1
XFILLER_2_264 VPWR VGND sg13cmos5l_decap_8
XFILLER_4_0 VPWR VGND sg13cmos5l_decap_8
X_073_ FrameStrobe_O[1] FrameStrobe[1] VPWR VGND sg13cmos5l_buf_1
XANTENNA__073__A FrameStrobe[1] VPWR VGND sg13cmos5l_antennanp
XFILLER_11_363 VPWR VGND sg13cmos5l_decap_8
X_056_ UIO_BOT_UOUT1 SS4END[14] VPWR VGND sg13cmos5l_buf_1
X_125_ FrameData_O[31] FrameData[31] VPWR VGND sg13cmos5l_buf_1
XFILLER_7_59 VPWR VGND sg13cmos5l_decap_4
XFILLER_7_367 VPWR VGND sg13cmos5l_decap_8
XANTENNA__068__A SS4END[12] VPWR VGND sg13cmos5l_antennanp
XANTENNA__090__X FrameStrobe_O[18] VPWR VGND sg13cmos5l_antennanp
XFILLER_4_304 VPWR VGND sg13cmos5l_fill_1
XFILLER_4_315 VPWR VGND sg13cmos5l_fill_1
XFILLER_4_326 VPWR VGND sg13cmos5l_decap_8
XFILLER_8_109 VPWR VGND sg13cmos5l_decap_4
XFILLER_3_381 VPWR VGND sg13cmos5l_decap_4
X_039_ N2BEGb[4] S2END[3] VPWR VGND sg13cmos5l_buf_1
X_108_ FrameData_O[14] FrameData[14] VPWR VGND sg13cmos5l_buf_1
XFILLER_7_186 VPWR VGND sg13cmos5l_fill_1
XFILLER_7_142 VPWR VGND sg13cmos5l_decap_8
XANTENNA__085__X FrameStrobe_O[13] VPWR VGND sg13cmos5l_antennanp
XFILLER_1_318 VPWR VGND sg13cmos5l_decap_4
XFILLER_0_373 VPWR VGND sg13cmos5l_decap_8
XFILLER_4_145 VPWR VGND sg13cmos5l_decap_8
XFILLER_4_178 VPWR VGND sg13cmos5l_decap_8
XANTENNA__081__A FrameStrobe[9] VPWR VGND sg13cmos5l_antennanp
XFILLER_1_137 VPWR VGND sg13cmos5l_fill_1
XFILLER_1_159 VPWR VGND sg13cmos5l_fill_2
XFILLER_5_410 VPWR VGND sg13cmos5l_fill_1
XFILLER_8_7 VPWR VGND sg13cmos5l_fill_1
XFILLER_0_170 VPWR VGND sg13cmos5l_decap_8
XANTENNA__076__A FrameStrobe[4] VPWR VGND sg13cmos5l_antennanp
XFILLER_2_413 VPWR VGND sg13cmos5l_decap_8
XFILLER_5_284 VPWR VGND sg13cmos5l_decap_8
XANTENNA__093__X UIO_BOT_UOUT8 VPWR VGND sg13cmos5l_antennanp
XFILLER_2_232 VPWR VGND sg13cmos5l_fill_2
X_072_ FrameStrobe_O[0] FrameStrobe[0] VPWR VGND sg13cmos5l_buf_1
XANTENNA__088__X FrameStrobe_O[16] VPWR VGND sg13cmos5l_antennanp
XFILLER_11_342 VPWR VGND sg13cmos5l_decap_8
X_055_ UIO_BOT_UOUT0 SS4END[15] VPWR VGND sg13cmos5l_buf_1
X_124_ FrameData_O[30] FrameData[30] VPWR VGND sg13cmos5l_buf_1
XFILLER_7_49 VPWR VGND sg13cmos5l_decap_8
XFILLER_7_324 VPWR VGND sg13cmos5l_decap_8
XFILLER_11_80 VPWR VGND sg13cmos5l_fill_2
XANTENNA__084__A FrameStrobe[12] VPWR VGND sg13cmos5l_antennanp
XFILLER_4_349 VPWR VGND sg13cmos5l_decap_4
XFILLER_11_194 VPWR VGND sg13cmos5l_fill_1
X_038_ N2BEGb[3] S2END[4] VPWR VGND sg13cmos5l_buf_1
X_107_ FrameData_O[13] FrameData[13] VPWR VGND sg13cmos5l_buf_1
XFILLER_7_121 VPWR VGND sg13cmos5l_decap_8
XANTENNA__079__A FrameStrobe[7] VPWR VGND sg13cmos5l_antennanp
XFILLER_1_308 VPWR VGND sg13cmos5l_fill_2
XFILLER_8_81 VPWR VGND sg13cmos5l_decap_8
XFILLER_0_352 VPWR VGND sg13cmos5l_decap_8
XFILLER_4_157 VPWR VGND sg13cmos5l_decap_8
XFILLER_10_407 VPWR VGND sg13cmos5l_fill_1
XFILLER_3_190 VPWR VGND sg13cmos5l_decap_8
XANTENNA__096__X FrameData_O[2] VPWR VGND sg13cmos5l_antennanp
XFILLER_10_418 VPWR VGND sg13cmos5l_fill_1
XFILLER_9_216 VPWR VGND sg13cmos5l_decap_4
XFILLER_5_433 VPWR VGND sg13cmos5l_decap_4
XANTENNA__092__A SS4END[8] VPWR VGND sg13cmos5l_antennanp
XFILLER_5_82 VPWR VGND sg13cmos5l_decap_8
XFILLER_6_219 VPWR VGND sg13cmos5l_decap_4
XFILLER_1_29 VPWR VGND sg13cmos5l_decap_4
XFILLER_5_263 VPWR VGND sg13cmos5l_decap_8
XANTENNA__087__A FrameStrobe[15] VPWR VGND sg13cmos5l_antennanp
XFILLER_2_211 VPWR VGND sg13cmos5l_fill_1
X_071_ UIO_BOT_UOUT6 SS4END[9] VPWR VGND sg13cmos5l_buf_1
XFILLER_2_83 VPWR VGND sg13cmos5l_decap_8
XFILLER_11_321 VPWR VGND sg13cmos5l_decap_8
XFILLER_11_398 VPWR VGND sg13cmos5l_decap_8
XFILLER_11_92 VPWR VGND sg13cmos5l_decap_8
X_054_ N1BEG[3] S1END[0] VPWR VGND sg13cmos5l_buf_1
X_123_ FrameData_O[29] FrameData[29] VPWR VGND sg13cmos5l_buf_1
XFILLER_7_303 VPWR VGND sg13cmos5l_decap_8
XFILLER_7_28 VPWR VGND sg13cmos5l_decap_8
XANTENNA__099__X FrameData_O[5] VPWR VGND sg13cmos5l_antennanp
XFILLER_11_173 VPWR VGND sg13cmos5l_decap_8
X_037_ N2BEGb[2] S2END[5] VPWR VGND sg13cmos5l_buf_1
X_106_ FrameData_O[12] FrameData[12] VPWR VGND sg13cmos5l_buf_1
XFILLER_7_177 VPWR VGND sg13cmos5l_decap_8
XFILLER_7_100 VPWR VGND sg13cmos5l_decap_8
XFILLER_8_60 VPWR VGND sg13cmos5l_decap_8
XANTENNA__095__A FrameData[1] VPWR VGND sg13cmos5l_antennanp
XFILLER_0_331 VPWR VGND sg13cmos5l_decap_8
XFILLER_4_29 VPWR VGND sg13cmos5l_decap_4
XFILLER_1_128 VPWR VGND sg13cmos5l_fill_1
XFILLER_5_401 VPWR VGND sg13cmos5l_decap_8
XFILLER_9_239 VPWR VGND sg13cmos5l_decap_8
XFILLER_9_206 VPWR VGND sg13cmos5l_decap_8
XFILLER_8_283 VPWR VGND sg13cmos5l_fill_2
XFILLER_2_404 VPWR VGND sg13cmos5l_fill_2
XFILLER_5_242 VPWR VGND sg13cmos5l_decap_8
XFILLER_2_234 VPWR VGND sg13cmos5l_fill_1
XFILLER_2_245 VPWR VGND sg13cmos5l_fill_1
XFILLER_2_278 VPWR VGND sg13cmos5l_fill_1
XFILLER_2_289 VPWR VGND sg13cmos5l_decap_8
X_070_ UIO_BOT_UOUT5 SS4END[10] VPWR VGND sg13cmos5l_buf_1
XFILLER_2_62 VPWR VGND sg13cmos5l_decap_8
XANTENNA__098__A FrameData[4] VPWR VGND sg13cmos5l_antennanp
XFILLER_11_300 VPWR VGND sg13cmos5l_decap_8
XFILLER_11_377 VPWR VGND sg13cmos5l_decap_8
X_053_ N1BEG[2] S1END[1] VPWR VGND sg13cmos5l_buf_1
X_122_ FrameData_O[28] FrameData[28] VPWR VGND sg13cmos5l_buf_1
XFILLER_6_381 VPWR VGND sg13cmos5l_decap_8
XFILLER_11_141 VPWR VGND sg13cmos5l_decap_8
XFILLER_11_152 VPWR VGND sg13cmos5l_fill_2
X_105_ FrameData_O[11] FrameData[11] VPWR VGND sg13cmos5l_buf_1
XFILLER_7_156 VPWR VGND sg13cmos5l_decap_8
XFILLER_3_395 VPWR VGND sg13cmos5l_decap_4
X_036_ N2BEGb[1] S2END[6] VPWR VGND sg13cmos5l_buf_1
XFILLER_0_310 VPWR VGND sg13cmos5l_decap_8
XFILLER_4_115 VPWR VGND sg13cmos5l_decap_8
XFILLER_4_137 VPWR VGND sg13cmos5l_fill_2
XFILLER_0_387 VPWR VGND sg13cmos5l_decap_8
X_019_ N4BEG[0] UIO_BOT_UIN15 VPWR VGND sg13cmos5l_buf_1
XFILLER_8_421 VPWR VGND sg13cmos5l_decap_8
XFILLER_0_184 VPWR VGND sg13cmos5l_decap_8
XFILLER_8_262 VPWR VGND sg13cmos5l_decap_8
XFILLER_8_251 VPWR VGND sg13cmos5l_fill_1
XFILLER_2_427 VPWR VGND sg13cmos5l_decap_8
XFILLER_6_7 VPWR VGND sg13cmos5l_fill_2
XFILLER_5_221 VPWR VGND sg13cmos5l_decap_8
XFILLER_5_298 VPWR VGND sg13cmos5l_decap_8
XANTENNA__001__X UIO_BOT_UOUT9 VPWR VGND sg13cmos5l_antennanp
XFILLER_2_257 VPWR VGND sg13cmos5l_decap_8
XFILLER_2_41 VPWR VGND sg13cmos5l_decap_8
XFILLER_11_356 VPWR VGND sg13cmos5l_decap_8
X_052_ N1BEG[1] S1END[2] VPWR VGND sg13cmos5l_buf_1
X_121_ FrameData_O[27] FrameData[27] VPWR VGND sg13cmos5l_buf_1
XFILLER_4_308 VPWR VGND sg13cmos5l_decap_8
XFILLER_4_319 VPWR VGND sg13cmos5l_decap_8
XFILLER_11_120 VPWR VGND sg13cmos5l_decap_8
XFILLER_11_164 VPWR VGND sg13cmos5l_fill_2
XFILLER_3_330 VPWR VGND sg13cmos5l_fill_1
XFILLER_3_363 VPWR VGND sg13cmos5l_fill_1
XFILLER_3_374 VPWR VGND sg13cmos5l_decap_8
X_035_ N2BEGb[0] S2END[7] VPWR VGND sg13cmos5l_buf_1
X_104_ FrameData_O[10] FrameData[10] VPWR VGND sg13cmos5l_buf_1
XFILLER_7_135 VPWR VGND sg13cmos5l_decap_8
XFILLER_8_95 VPWR VGND sg13cmos5l_decap_8
XFILLER_0_366 VPWR VGND sg13cmos5l_decap_8
X_018_ NN4BEG[15] S4END[0] VPWR VGND sg13cmos5l_buf_1
XANTENNA__004__X NN4BEG[1] VPWR VGND sg13cmos5l_antennanp
XFILLER_0_163 VPWR VGND sg13cmos5l_decap_8
XFILLER_5_414 VPWR VGND sg13cmos5l_fill_2
XFILLER_10_0 VPWR VGND sg13cmos5l_fill_1
XFILLER_5_63 VPWR VGND sg13cmos5l_fill_2
XFILLER_5_96 VPWR VGND sg13cmos5l_fill_2
XFILLER_8_230 VPWR VGND sg13cmos5l_decap_4
XFILLER_10_207 VPWR VGND sg13cmos5l_fill_1
XFILLER_10_218 VPWR VGND sg13cmos5l_fill_1
XFILLER_5_277 VPWR VGND sg13cmos5l_decap_8
XFILLER_2_225 VPWR VGND sg13cmos5l_decap_8
XANTENNA__102__X FrameData_O[8] VPWR VGND sg13cmos5l_antennanp
XFILLER_1_280 VPWR VGND sg13cmos5l_fill_1
XFILLER_1_291 VPWR VGND sg13cmos5l_decap_8
XFILLER_2_20 VPWR VGND sg13cmos5l_decap_8
XFILLER_2_97 VPWR VGND sg13cmos5l_decap_4
XANTENNA__012__X NN4BEG[9] VPWR VGND sg13cmos5l_antennanp
XFILLER_11_335 VPWR VGND sg13cmos5l_decap_8
XFILLER_11_73 VPWR VGND sg13cmos5l_decap_8
X_051_ N1BEG[0] S1END[3] VPWR VGND sg13cmos5l_buf_1
X_120_ FrameData_O[26] FrameData[26] VPWR VGND sg13cmos5l_buf_1
XFILLER_7_317 VPWR VGND sg13cmos5l_decap_8
XFILLER_6_350 VPWR VGND sg13cmos5l_decap_4
XANTENNA__007__X NN4BEG[4] VPWR VGND sg13cmos5l_antennanp
XFILLER_11_187 VPWR VGND sg13cmos5l_decap_8
XFILLER_11_198 VPWR VGND sg13cmos5l_decap_8
XFILLER_3_342 VPWR VGND sg13cmos5l_decap_8
X_034_ N4BEG[15] UIO_BOT_UIN0 VPWR VGND sg13cmos5l_buf_1
X_103_ FrameData_O[9] FrameData[9] VPWR VGND sg13cmos5l_buf_1
XFILLER_7_114 VPWR VGND sg13cmos5l_decap_8
XANTENNA__003__A UIO_BOT_UIN19 VPWR VGND sg13cmos5l_antennanp
XFILLER_8_74 VPWR VGND sg13cmos5l_decap_8
XFILLER_0_345 VPWR VGND sg13cmos5l_decap_8
XANTENNA__110__X FrameData_O[16] VPWR VGND sg13cmos5l_antennanp
XFILLER_3_183 VPWR VGND sg13cmos5l_decap_4
X_017_ NN4BEG[14] S4END[1] VPWR VGND sg13cmos5l_buf_1
XANTENNA__020__X N4BEG[1] VPWR VGND sg13cmos5l_antennanp
XFILLER_5_426 VPWR VGND sg13cmos5l_decap_8
XFILLER_5_437 VPWR VGND sg13cmos5l_fill_1
XANTENNA__105__X FrameData_O[11] VPWR VGND sg13cmos5l_antennanp
XFILLER_0_142 VPWR VGND sg13cmos5l_decap_8
XFILLER_5_20 VPWR VGND sg13cmos5l_decap_4
XFILLER_5_42 VPWR VGND sg13cmos5l_decap_8
XANTENNA__015__X NN4BEG[12] VPWR VGND sg13cmos5l_antennanp
XANTENNA__101__A FrameData[7] VPWR VGND sg13cmos5l_antennanp
XFILLER_5_256 VPWR VGND sg13cmos5l_decap_8
XANTENNA__011__A S4END[7] VPWR VGND sg13cmos5l_antennanp
XFILLER_2_204 VPWR VGND sg13cmos5l_decap_8
XFILLER_2_76 VPWR VGND sg13cmos5l_decap_8
XANTENNA__006__A UIO_BOT_UIN16 VPWR VGND sg13cmos5l_antennanp
XFILLER_11_314 VPWR VGND sg13cmos5l_decap_8
XFILLER_11_41 VPWR VGND sg13cmos5l_fill_1
X_050_ N2BEG[7] S2MID[0] VPWR VGND sg13cmos5l_buf_1
XANTENNA__113__X FrameData_O[19] VPWR VGND sg13cmos5l_antennanp
XFILLER_11_52 VPWR VGND sg13cmos5l_decap_8
XFILLER_11_85 VPWR VGND sg13cmos5l_decap_8
XANTENNA__023__X N4BEG[4] VPWR VGND sg13cmos5l_antennanp
XFILLER_0_0 VPWR VGND sg13cmos5l_decap_8
X_102_ FrameData_O[8] FrameData[8] VPWR VGND sg13cmos5l_buf_1
X_033_ N4BEG[14] UIO_BOT_UIN1 VPWR VGND sg13cmos5l_buf_1
XANTENNA__108__X FrameData_O[14] VPWR VGND sg13cmos5l_antennanp
XFILLER_6_192 VPWR VGND sg13cmos5l_decap_8
XFILLER_8_53 VPWR VGND sg13cmos5l_decap_8
XANTENNA__018__X NN4BEG[15] VPWR VGND sg13cmos5l_antennanp
XFILLER_0_324 VPWR VGND sg13cmos5l_decap_8
XANTENNA__104__A FrameData[10] VPWR VGND sg13cmos5l_antennanp
X_016_ NN4BEG[13] S4END[2] VPWR VGND sg13cmos5l_buf_1
XFILLER_8_435 VPWR VGND sg13cmos5l_fill_2
XANTENNA__014__A S4END[4] VPWR VGND sg13cmos5l_antennanp
XFILLER_0_121 VPWR VGND sg13cmos5l_decap_8
XFILLER_0_198 VPWR VGND sg13cmos5l_decap_8
XFILLER_8_276 VPWR VGND sg13cmos5l_decap_8
XFILLER_8_243 VPWR VGND sg13cmos5l_fill_2
XANTENNA__009__A S4END[9] VPWR VGND sg13cmos5l_antennanp
XANTENNA__121__X FrameData_O[27] VPWR VGND sg13cmos5l_antennanp
XFILLER_5_65 VPWR VGND sg13cmos5l_fill_1
XFILLER_5_76 VPWR VGND sg13cmos5l_fill_2
XANTENNA__031__X N4BEG[12] VPWR VGND sg13cmos5l_antennanp
XFILLER_5_235 VPWR VGND sg13cmos5l_decap_8
XANTENNA__116__X FrameData_O[22] VPWR VGND sg13cmos5l_antennanp
XANTENNA__026__X N4BEG[7] VPWR VGND sg13cmos5l_antennanp
XFILLER_2_238 VPWR VGND sg13cmos5l_decap_8
XFILLER_4_7 VPWR VGND sg13cmos5l_fill_1
XANTENNA__112__A FrameData[18] VPWR VGND sg13cmos5l_antennanp
XFILLER_1_260 VPWR VGND sg13cmos5l_fill_1
XFILLER_2_55 VPWR VGND sg13cmos5l_decap_8
XANTENNA__022__A UIO_BOT_UIN12 VPWR VGND sg13cmos5l_antennanp
XFILLER_9_393 VPWR VGND sg13cmos5l_fill_2
XANTENNA__107__A FrameData[13] VPWR VGND sg13cmos5l_antennanp
XANTENNA__017__A S4END[1] VPWR VGND sg13cmos5l_antennanp
XFILLER_6_374 VPWR VGND sg13cmos5l_decap_8
XFILLER_11_134 VPWR VGND sg13cmos5l_decap_8
XFILLER_3_311 VPWR VGND sg13cmos5l_fill_1
XFILLER_3_388 VPWR VGND sg13cmos5l_decap_8
X_101_ FrameData_O[7] FrameData[7] VPWR VGND sg13cmos5l_buf_1
X_032_ N4BEG[13] UIO_BOT_UIN2 VPWR VGND sg13cmos5l_buf_1
XFILLER_7_149 VPWR VGND sg13cmos5l_decap_8
XANTENNA__124__X FrameData_O[30] VPWR VGND sg13cmos5l_antennanp
XFILLER_3_399 VPWR VGND sg13cmos5l_fill_1
XFILLER_6_160 VPWR VGND sg13cmos5l_decap_8
XFILLER_8_32 VPWR VGND sg13cmos5l_decap_8
XANTENNA__034__X N4BEG[15] VPWR VGND sg13cmos5l_antennanp
XFILLER_0_303 VPWR VGND sg13cmos5l_decap_8
XFILLER_4_108 VPWR VGND sg13cmos5l_decap_8
XANTENNA__120__A FrameData[26] VPWR VGND sg13cmos5l_antennanp
XFILLER_3_163 VPWR VGND sg13cmos5l_fill_1
X_015_ NN4BEG[12] S4END[3] VPWR VGND sg13cmos5l_buf_1
XFILLER_8_414 VPWR VGND sg13cmos5l_decap_8
XANTENNA__029__X N4BEG[10] VPWR VGND sg13cmos5l_antennanp
XANTENNA__030__A UIO_BOT_UIN4 VPWR VGND sg13cmos5l_antennanp
XANTENNA__119__X FrameData_O[25] VPWR VGND sg13cmos5l_antennanp
XFILLER_0_100 VPWR VGND sg13cmos5l_decap_8
XFILLER_0_177 VPWR VGND sg13cmos5l_decap_8
XANTENNA__115__A FrameData[21] VPWR VGND sg13cmos5l_antennanp
XFILLER_5_11 VPWR VGND sg13cmos5l_decap_4
XFILLER_8_288 VPWR VGND sg13cmos5l_fill_2
XFILLER_8_255 VPWR VGND sg13cmos5l_decap_8
XANTENNA__025__A UIO_BOT_UIN9 VPWR VGND sg13cmos5l_antennanp
XFILLER_2_409 VPWR VGND sg13cmos5l_fill_1
XFILLER_5_214 VPWR VGND sg13cmos5l_decap_8
XFILLER_1_420 VPWR VGND sg13cmos5l_decap_8
XANTENNA__042__X N2BEGb[7] VPWR VGND sg13cmos5l_antennanp
XFILLER_2_34 VPWR VGND sg13cmos5l_decap_8
XFILLER_9_372 VPWR VGND sg13cmos5l_fill_2
XANTENNA__037__X N2BEGb[2] VPWR VGND sg13cmos5l_antennanp
XFILLER_11_32 VPWR VGND sg13cmos5l_decap_8
XFILLER_11_349 VPWR VGND sg13cmos5l_decap_8
XANTENNA__123__A FrameData[29] VPWR VGND sg13cmos5l_antennanp
XFILLER_10_360 VPWR VGND sg13cmos5l_fill_1
XFILLER_10_382 VPWR VGND sg13cmos5l_fill_2
XFILLER_10_393 VPWR VGND sg13cmos5l_decap_8
XFILLER_6_364 VPWR VGND sg13cmos5l_fill_2
XFILLER_6_320 VPWR VGND sg13cmos5l_decap_8
XANTENNA__033__A UIO_BOT_UIN1 VPWR VGND sg13cmos5l_antennanp
XFILLER_11_113 VPWR VGND sg13cmos5l_decap_8
XFILLER_11_157 VPWR VGND sg13cmos5l_decap_8
X_100_ FrameData_O[6] FrameData[6] VPWR VGND sg13cmos5l_buf_1
X_031_ N4BEG[12] UIO_BOT_UIN3 VPWR VGND sg13cmos5l_buf_1
XFILLER_7_128 VPWR VGND sg13cmos5l_decap_8
XANTENNA__118__A FrameData[24] VPWR VGND sg13cmos5l_antennanp
XFILLER_3_356 VPWR VGND sg13cmos5l_decap_8
XFILLER_3_367 VPWR VGND sg13cmos5l_decap_8
XFILLER_6_183 VPWR VGND sg13cmos5l_decap_4
XFILLER_8_88 VPWR VGND sg13cmos5l_decap_8
XFILLER_8_11 VPWR VGND sg13cmos5l_decap_8
XANTENNA__028__A UIO_BOT_UIN6 VPWR VGND sg13cmos5l_antennanp
XANTENNA__050__X N2BEG[7] VPWR VGND sg13cmos5l_antennanp
XFILLER_0_359 VPWR VGND sg13cmos5l_decap_8
XFILLER_3_131 VPWR VGND sg13cmos5l_decap_8
XFILLER_3_175 VPWR VGND sg13cmos5l_decap_4
XFILLER_3_197 VPWR VGND sg13cmos5l_decap_8
X_014_ NN4BEG[11] S4END[4] VPWR VGND sg13cmos5l_buf_1
XFILLER_8_437 VPWR VGND sg13cmos5l_fill_1
XANTENNA__045__X N2BEG[2] VPWR VGND sg13cmos5l_antennanp
XFILLER_0_156 VPWR VGND sg13cmos5l_decap_8
XFILLER_5_56 VPWR VGND sg13cmos5l_decap_8
XFILLER_5_78 VPWR VGND sg13cmos5l_fill_1
XFILLER_5_89 VPWR VGND sg13cmos5l_decap_8
XFILLER_8_234 VPWR VGND sg13cmos5l_fill_2
XFILLER_8_223 VPWR VGND sg13cmos5l_decap_8
XANTENNA__041__A S2END[1] VPWR VGND sg13cmos5l_antennanp
XANTENNA__036__A S2END[6] VPWR VGND sg13cmos5l_antennanp
XFILLER_2_218 VPWR VGND sg13cmos5l_decap_8
XFILLER_1_284 VPWR VGND sg13cmos5l_decap_8
XFILLER_2_13 VPWR VGND sg13cmos5l_decap_8
XANTENNA__053__X N1BEG[2] VPWR VGND sg13cmos5l_antennanp
XFILLER_11_11 VPWR VGND sg13cmos5l_decap_8
XFILLER_11_328 VPWR VGND sg13cmos5l_decap_8
XFILLER_11_66 VPWR VGND sg13cmos5l_decap_8
XFILLER_11_99 VPWR VGND sg13cmos5l_decap_8
XFILLER_6_343 VPWR VGND sg13cmos5l_decap_8
XANTENNA__048__X N2BEG[5] VPWR VGND sg13cmos5l_antennanp
XFILLER_9_170 VPWR VGND sg13cmos5l_fill_2
XFILLER_11_169 VPWR VGND sg13cmos5l_fill_1
XFILLER_3_335 VPWR VGND sg13cmos5l_decap_8
X_030_ N4BEG[11] UIO_BOT_UIN4 VPWR VGND sg13cmos5l_buf_1
XFILLER_8_67 VPWR VGND sg13cmos5l_decap_8
XFILLER_7_107 VPWR VGND sg13cmos5l_decap_8
XANTENNA__044__A S2MID[6] VPWR VGND sg13cmos5l_antennanp
XFILLER_0_338 VPWR VGND sg13cmos5l_decap_8
X_013_ NN4BEG[10] S4END[5] VPWR VGND sg13cmos5l_buf_1
XANTENNA__039__A S2END[3] VPWR VGND sg13cmos5l_antennanp
XANTENNA__061__X UIO_BOT_UOUT14 VPWR VGND sg13cmos5l_antennanp
XFILLER_0_135 VPWR VGND sg13cmos5l_decap_8
XFILLER_5_408 VPWR VGND sg13cmos5l_fill_2
XFILLER_5_419 VPWR VGND sg13cmos5l_decap_8
XFILLER_4_430 VPWR VGND sg13cmos5l_decap_8
XFILLER_5_24 VPWR VGND sg13cmos5l_fill_1
XFILLER_5_35 VPWR VGND sg13cmos5l_decap_8
XFILLER_8_202 VPWR VGND sg13cmos5l_decap_8
XANTENNA__056__X UIO_BOT_UOUT1 VPWR VGND sg13cmos5l_antennanp
XFILLER_5_249 VPWR VGND sg13cmos5l_decap_8
XFILLER_4_293 VPWR VGND sg13cmos5l_decap_8
XANTENNA__052__A S1END[2] VPWR VGND sg13cmos5l_antennanp
XFILLER_1_230 VPWR VGND sg13cmos5l_fill_1
XFILLER_1_241 VPWR VGND sg13cmos5l_fill_1
XFILLER_2_69 VPWR VGND sg13cmos5l_decap_8
XFILLER_9_374 VPWR VGND sg13cmos5l_fill_1
XFILLER_9_341 VPWR VGND sg13cmos5l_decap_8
XFILLER_9_0 VPWR VGND sg13cmos5l_decap_4
XANTENNA__047__A S2MID[3] VPWR VGND sg13cmos5l_antennanp
XFILLER_11_307 VPWR VGND sg13cmos5l_decap_8
XFILLER_11_45 VPWR VGND sg13cmos5l_decap_8
XFILLER_6_399 VPWR VGND sg13cmos5l_fill_2
XFILLER_6_388 VPWR VGND sg13cmos5l_decap_4
XFILLER_6_366 VPWR VGND sg13cmos5l_fill_1
XFILLER_9_182 VPWR VGND sg13cmos5l_decap_8
XANTENNA__064__X UIO_BOT_UOUT17 VPWR VGND sg13cmos5l_antennanp
XFILLER_11_148 VPWR VGND sg13cmos5l_decap_4
XFILLER_6_174 VPWR VGND sg13cmos5l_decap_4
X_089_ FrameStrobe_O[17] FrameStrobe[17] VPWR VGND sg13cmos5l_buf_1
XFILLER_8_46 VPWR VGND sg13cmos5l_decap_8
XANTENNA__059__X UIO_BOT_UOUT12 VPWR VGND sg13cmos5l_antennanp
XANTENNA__060__A SS4END[2] VPWR VGND sg13cmos5l_antennanp
XFILLER_0_317 VPWR VGND sg13cmos5l_decap_8
XFILLER_8_428 VPWR VGND sg13cmos5l_decap_8
XFILLER_8_406 VPWR VGND sg13cmos5l_decap_4
XFILLER_3_100 VPWR VGND sg13cmos5l_decap_8
X_012_ NN4BEG[9] S4END[6] VPWR VGND sg13cmos5l_buf_1
XANTENNA__055__A SS4END[15] VPWR VGND sg13cmos5l_antennanp
XFILLER_0_114 VPWR VGND sg13cmos5l_decap_8
XFILLER_5_69 VPWR VGND sg13cmos5l_decap_8
XFILLER_8_269 VPWR VGND sg13cmos5l_decap_8
XANTENNA__072__X FrameStrobe_O[0] VPWR VGND sg13cmos5l_antennanp
XFILLER_1_434 VPWR VGND sg13cmos5l_decap_4
XFILLER_5_206 VPWR VGND sg13cmos5l_fill_2
XFILLER_5_228 VPWR VGND sg13cmos5l_decap_8
XFILLER_4_272 VPWR VGND sg13cmos5l_decap_8
XANTENNA__067__X UIO_BOT_UOUT2 VPWR VGND sg13cmos5l_antennanp
XFILLER_2_48 VPWR VGND sg13cmos5l_decap_8
XANTENNA__063__A S4END[3] VPWR VGND sg13cmos5l_antennanp
XFILLER_10_374 VPWR VGND sg13cmos5l_decap_4
XFILLER_6_334 VPWR VGND sg13cmos5l_decap_4
XFILLER_9_161 VPWR VGND sg13cmos5l_fill_1
XANTENNA__058__A SS4END[4] VPWR VGND sg13cmos5l_antennanp
XANTENNA__080__X FrameStrobe_O[8] VPWR VGND sg13cmos5l_antennanp
XFILLER_11_127 VPWR VGND sg13cmos5l_decap_8
XFILLER_3_304 VPWR VGND sg13cmos5l_decap_8
XFILLER_3_326 VPWR VGND sg13cmos5l_decap_4
XFILLER_2_381 VPWR VGND sg13cmos5l_fill_1
XFILLER_2_392 VPWR VGND sg13cmos5l_fill_2
XFILLER_6_142 VPWR VGND sg13cmos5l_fill_1
XFILLER_6_153 VPWR VGND sg13cmos5l_decap_8
X_088_ FrameStrobe_O[16] FrameStrobe[16] VPWR VGND sg13cmos5l_buf_1
XFILLER_8_25 VPWR VGND sg13cmos5l_decap_8
XANTENNA__075__X FrameStrobe_O[3] VPWR VGND sg13cmos5l_antennanp
X_011_ NN4BEG[8] S4END[7] VPWR VGND sg13cmos5l_buf_1
XANTENNA__071__A SS4END[9] VPWR VGND sg13cmos5l_antennanp
XFILLER_4_410 VPWR VGND sg13cmos5l_fill_2
XFILLER_5_15 VPWR VGND sg13cmos5l_fill_1
XANTENNA__066__A S4END[0] VPWR VGND sg13cmos5l_antennanp
XFILLER_1_413 VPWR VGND sg13cmos5l_fill_2
XANTENNA__083__X FrameStrobe_O[11] VPWR VGND sg13cmos5l_antennanp
XFILLER_1_265 VPWR VGND sg13cmos5l_fill_1
XFILLER_1_276 VPWR VGND sg13cmos5l_decap_4
XFILLER_1_298 VPWR VGND sg13cmos5l_fill_1
XFILLER_2_27 VPWR VGND sg13cmos5l_decap_8
XFILLER_9_398 VPWR VGND sg13cmos5l_decap_8
XFILLER_9_365 VPWR VGND sg13cmos5l_decap_8
XANTENNA__078__X FrameStrobe_O[6] VPWR VGND sg13cmos5l_antennanp
XFILLER_10_353 VPWR VGND sg13cmos5l_fill_1
XFILLER_11_25 VPWR VGND sg13cmos5l_decap_8
XFILLER_6_313 VPWR VGND sg13cmos5l_decap_8
XFILLER_6_357 VPWR VGND sg13cmos5l_decap_8
XANTENNA__074__A FrameStrobe[2] VPWR VGND sg13cmos5l_antennanp
XFILLER_11_106 VPWR VGND sg13cmos5l_decap_8
XFILLER_3_349 VPWR VGND sg13cmos5l_decap_8
XFILLER_3_70 VPWR VGND sg13cmos5l_fill_1
XFILLER_3_81 VPWR VGND sg13cmos5l_decap_8
XFILLER_6_121 VPWR VGND sg13cmos5l_decap_8
XFILLER_6_187 VPWR VGND sg13cmos5l_fill_2
X_087_ FrameStrobe_O[15] FrameStrobe[15] VPWR VGND sg13cmos5l_buf_1
XANTENNA__069__A SS4END[11] VPWR VGND sg13cmos5l_antennanp
XANTENNA__091__X FrameStrobe_O[19] VPWR VGND sg13cmos5l_antennanp
XFILLER_3_124 VPWR VGND sg13cmos5l_decap_8
XFILLER_3_168 VPWR VGND sg13cmos5l_decap_4
XFILLER_3_179 VPWR VGND sg13cmos5l_fill_1
X_010_ NN4BEG[7] S4END[8] VPWR VGND sg13cmos5l_buf_1
XFILLER_0_93 VPWR VGND sg13cmos5l_decap_8
XFILLER_2_190 VPWR VGND sg13cmos5l_fill_2
XANTENNA__086__X FrameStrobe_O[14] VPWR VGND sg13cmos5l_antennanp
XFILLER_0_149 VPWR VGND sg13cmos5l_decap_8
XFILLER_9_80 VPWR VGND sg13cmos5l_fill_2
XFILLER_8_216 VPWR VGND sg13cmos5l_decap_8
XFILLER_4_400 VPWR VGND sg13cmos5l_decap_4
XFILLER_5_49 VPWR VGND sg13cmos5l_decap_8
XFILLER_8_249 VPWR VGND sg13cmos5l_fill_2
XANTENNA__082__A FrameStrobe[10] VPWR VGND sg13cmos5l_antennanp
XFILLER_7_282 VPWR VGND sg13cmos5l_decap_8
XFILLER_4_241 VPWR VGND sg13cmos5l_decap_8
XANTENNA__077__A FrameStrobe[5] VPWR VGND sg13cmos5l_antennanp
XANTENNA__094__X FrameData_O[0] VPWR VGND sg13cmos5l_antennanp
XFILLER_11_59 VPWR VGND sg13cmos5l_decap_8
XFILLER_10_343 VPWR VGND sg13cmos5l_fill_2
XFILLER_9_152 VPWR VGND sg13cmos5l_fill_2
XFILLER_9_141 VPWR VGND sg13cmos5l_decap_4
XFILLER_9_130 VPWR VGND sg13cmos5l_decap_8
XFILLER_7_0 VPWR VGND sg13cmos5l_decap_8
XFILLER_3_93 VPWR VGND sg13cmos5l_decap_8
XFILLER_5_380 VPWR VGND sg13cmos5l_decap_8
XANTENNA__089__X FrameStrobe_O[17] VPWR VGND sg13cmos5l_antennanp
XANTENNA__090__A FrameStrobe[18] VPWR VGND sg13cmos5l_antennanp
XFILLER_0_7 VPWR VGND sg13cmos5l_decap_8
XFILLER_6_100 VPWR VGND sg13cmos5l_decap_8
XFILLER_6_199 VPWR VGND sg13cmos5l_decap_8
X_086_ FrameStrobe_O[14] FrameStrobe[14] VPWR VGND sg13cmos5l_buf_1
XFILLER_2_361 VPWR VGND sg13cmos5l_fill_1
XFILLER_2_372 VPWR VGND sg13cmos5l_decap_8
XANTENNA__085__A FrameStrobe[13] VPWR VGND sg13cmos5l_antennanp
X_069_ UIO_BOT_UOUT4 SS4END[11] VPWR VGND sg13cmos5l_buf_1
XFILLER_0_128 VPWR VGND sg13cmos5l_decap_8
XFILLER_0_72 VPWR VGND sg13cmos5l_decap_8
XFILLER_9_92 VPWR VGND sg13cmos5l_fill_2
XFILLER_4_423 VPWR VGND sg13cmos5l_decap_8
XFILLER_5_28 VPWR VGND sg13cmos5l_decap_8
XFILLER_8_239 VPWR VGND sg13cmos5l_decap_4
XFILLER_7_250 VPWR VGND sg13cmos5l_decap_8
XANTENNA__097__X FrameData_O[3] VPWR VGND sg13cmos5l_antennanp
XFILLER_1_415 VPWR VGND sg13cmos5l_fill_1
XFILLER_4_220 VPWR VGND sg13cmos5l_decap_8
XFILLER_4_264 VPWR VGND sg13cmos5l_decap_4
XFILLER_4_286 VPWR VGND sg13cmos5l_decap_8
XFILLER_6_93 VPWR VGND sg13cmos5l_decap_8
XANTENNA__093__A SS4END[7] VPWR VGND sg13cmos5l_antennanp
XFILLER_1_201 VPWR VGND sg13cmos5l_fill_1
XFILLER_1_212 VPWR VGND sg13cmos5l_decap_4
XFILLER_1_234 VPWR VGND sg13cmos5l_decap_8
XFILLER_1_256 VPWR VGND sg13cmos5l_decap_4
XFILLER_9_4 VPWR VGND sg13cmos5l_fill_2
XFILLER_9_389 VPWR VGND sg13cmos5l_decap_4
XFILLER_9_334 VPWR VGND sg13cmos5l_decap_8
XFILLER_9_312 VPWR VGND sg13cmos5l_decap_8
XANTENNA__088__A FrameStrobe[16] VPWR VGND sg13cmos5l_antennanp
XFILLER_10_311 VPWR VGND sg13cmos5l_decap_8
XFILLER_3_50 VPWR VGND sg13cmos5l_fill_1
XFILLER_3_61 VPWR VGND sg13cmos5l_fill_2
XFILLER_9_175 VPWR VGND sg13cmos5l_decap_8
XFILLER_10_152 VPWR VGND sg13cmos5l_fill_2
XFILLER_8_39 VPWR VGND sg13cmos5l_decap_8
XFILLER_6_167 VPWR VGND sg13cmos5l_decap_8
XFILLER_6_178 VPWR VGND sg13cmos5l_fill_1
X_085_ FrameStrobe_O[13] FrameStrobe[13] VPWR VGND sg13cmos5l_buf_1
XFILLER_3_159 VPWR VGND sg13cmos5l_fill_1
XFILLER_2_192 VPWR VGND sg13cmos5l_fill_1
X_068_ UIO_BOT_UOUT3 SS4END[12] VPWR VGND sg13cmos5l_buf_1
XFILLER_7_432 VPWR VGND sg13cmos5l_decap_4
XFILLER_7_421 VPWR VGND sg13cmos5l_fill_1
XFILLER_7_410 VPWR VGND sg13cmos5l_decap_8
XFILLER_0_107 VPWR VGND sg13cmos5l_decap_8
XFILLER_9_60 VPWR VGND sg13cmos5l_decap_4
XANTENNA__096__A FrameData[2] VPWR VGND sg13cmos5l_antennanp
XFILLER_1_427 VPWR VGND sg13cmos5l_decap_8
XFILLER_6_72 VPWR VGND sg13cmos5l_decap_8
XFILLER_6_61 VPWR VGND sg13cmos5l_decap_8
XFILLER_1_246 VPWR VGND sg13cmos5l_decap_4
XFILLER_9_379 VPWR VGND sg13cmos5l_decap_8
XFILLER_11_39 VPWR VGND sg13cmos5l_fill_2
XFILLER_10_378 VPWR VGND sg13cmos5l_fill_1
XFILLER_6_338 VPWR VGND sg13cmos5l_fill_1
XFILLER_6_327 VPWR VGND sg13cmos5l_decap_8
XFILLER_9_165 VPWR VGND sg13cmos5l_fill_2
XANTENNA__099__A FrameData[5] VPWR VGND sg13cmos5l_antennanp
XFILLER_3_319 VPWR VGND sg13cmos5l_decap_8
XFILLER_10_186 VPWR VGND sg13cmos5l_fill_2
XFILLER_2_330 VPWR VGND sg13cmos5l_decap_8
XFILLER_2_352 VPWR VGND sg13cmos5l_decap_8
XFILLER_2_385 VPWR VGND sg13cmos5l_decap_8
XFILLER_6_135 VPWR VGND sg13cmos5l_decap_8
XFILLER_6_146 VPWR VGND sg13cmos5l_decap_8
X_084_ FrameStrobe_O[12] FrameStrobe[12] VPWR VGND sg13cmos5l_buf_1
XFILLER_8_18 VPWR VGND sg13cmos5l_decap_8
XFILLER_3_138 VPWR VGND sg13cmos5l_decap_8
XFILLER_3_149 VPWR VGND sg13cmos5l_decap_8
XFILLER_0_41 VPWR VGND sg13cmos5l_decap_8
X_067_ UIO_BOT_UOUT2 SS4END[13] VPWR VGND sg13cmos5l_buf_1
XFILLER_9_94 VPWR VGND sg13cmos5l_fill_1
X_119_ FrameData_O[25] FrameData[25] VPWR VGND sg13cmos5l_buf_1
XFILLER_7_296 VPWR VGND sg13cmos5l_decap_8
XFILLER_7_274 VPWR VGND sg13cmos5l_decap_4
XFILLER_4_255 VPWR VGND sg13cmos5l_decap_4
XFILLER_6_40 VPWR VGND sg13cmos5l_decap_8
XFILLER_1_225 VPWR VGND sg13cmos5l_fill_2
XFILLER_9_358 VPWR VGND sg13cmos5l_decap_8
XFILLER_11_18 VPWR VGND sg13cmos5l_decap_8
XFILLER_8_380 VPWR VGND sg13cmos5l_fill_1
XANTENNA__002__X UserCLKo VPWR VGND sg13cmos5l_antennanp
XFILLER_10_335 VPWR VGND sg13cmos5l_fill_2
XFILLER_6_306 VPWR VGND sg13cmos5l_decap_8
XFILLER_3_30 VPWR VGND sg13cmos5l_decap_8
XFILLER_3_63 VPWR VGND sg13cmos5l_fill_1
XFILLER_3_74 VPWR VGND sg13cmos5l_decap_8
XFILLER_5_372 VPWR VGND sg13cmos5l_decap_4
XFILLER_5_394 VPWR VGND sg13cmos5l_decap_8
XFILLER_9_199 VPWR VGND sg13cmos5l_decap_8
XFILLER_2_320 VPWR VGND sg13cmos5l_decap_4
XFILLER_2_397 VPWR VGND sg13cmos5l_decap_8
XFILLER_5_0 VPWR VGND sg13cmos5l_decap_8
XFILLER_6_114 VPWR VGND sg13cmos5l_decap_8
X_083_ FrameStrobe_O[11] FrameStrobe[11] VPWR VGND sg13cmos5l_buf_1
XFILLER_3_117 VPWR VGND sg13cmos5l_decap_8
XANTENNA__100__X FrameData_O[6] VPWR VGND sg13cmos5l_antennanp
XFILLER_0_20 VPWR VGND sg13cmos5l_decap_8
XFILLER_0_86 VPWR VGND sg13cmos5l_decap_8
XFILLER_2_183 VPWR VGND sg13cmos5l_decap_8
X_066_ UIO_BOT_UOUT19 S4END[0] VPWR VGND sg13cmos5l_buf_1
XANTENNA__010__X NN4BEG[7] VPWR VGND sg13cmos5l_antennanp
XFILLER_4_404 VPWR VGND sg13cmos5l_fill_2
XFILLER_4_437 VPWR VGND sg13cmos5l_fill_1
XFILLER_8_209 VPWR VGND sg13cmos5l_decap_8
XFILLER_11_293 VPWR VGND sg13cmos5l_decap_8
X_049_ N2BEG[6] S2MID[1] VPWR VGND sg13cmos5l_buf_1
X_118_ FrameData_O[24] FrameData[24] VPWR VGND sg13cmos5l_buf_1
XFILLER_7_264 VPWR VGND sg13cmos5l_decap_4
XANTENNA__005__X NN4BEG[2] VPWR VGND sg13cmos5l_antennanp
XFILLER_4_234 VPWR VGND sg13cmos5l_decap_8
XANTENNA__001__A SS4END[6] VPWR VGND sg13cmos5l_antennanp
XFILLER_9_348 VPWR VGND sg13cmos5l_decap_8
XFILLER_9_326 VPWR VGND sg13cmos5l_decap_4
XFILLER_10_358 VPWR VGND sg13cmos5l_fill_2
XFILLER_8_392 VPWR VGND sg13cmos5l_decap_8
XFILLER_5_351 VPWR VGND sg13cmos5l_decap_8
XFILLER_9_189 VPWR VGND sg13cmos5l_decap_8
XFILLER_9_123 VPWR VGND sg13cmos5l_decap_8
XFILLER_9_112 VPWR VGND sg13cmos5l_fill_1
XANTENNA__013__X NN4BEG[10] VPWR VGND sg13cmos5l_antennanp
XANTENNA__103__X FrameData_O[9] VPWR VGND sg13cmos5l_antennanp
XFILLER_10_111 VPWR VGND sg13cmos5l_fill_1
XFILLER_2_365 VPWR VGND sg13cmos5l_decap_8
X_082_ FrameStrobe_O[10] FrameStrobe[10] VPWR VGND sg13cmos5l_buf_1
XANTENNA__008__X NN4BEG[5] VPWR VGND sg13cmos5l_antennanp
XFILLER_3_107 VPWR VGND sg13cmos5l_decap_8
XFILLER_0_65 VPWR VGND sg13cmos5l_decap_8
XFILLER_2_162 VPWR VGND sg13cmos5l_decap_8
X_065_ UIO_BOT_UOUT18 S4END[1] VPWR VGND sg13cmos5l_buf_1
XFILLER_9_30 VPWR VGND sg13cmos5l_decap_4
XANTENNA__004__A UIO_BOT_UIN18 VPWR VGND sg13cmos5l_antennanp
Xclkbuf_0_UserCLK clkbuf_0_UserCLK/X UserCLK VPWR VGND sg13cmos5l_buf_8
XFILLER_9_85 VPWR VGND sg13cmos5l_decap_8
XFILLER_9_41 VPWR VGND sg13cmos5l_fill_2
XFILLER_11_261 VPWR VGND sg13cmos5l_decap_8
XFILLER_11_272 VPWR VGND sg13cmos5l_fill_1
XFILLER_4_416 VPWR VGND sg13cmos5l_decap_8
X_117_ FrameData_O[23] FrameData[23] VPWR VGND sg13cmos5l_buf_1
XANTENNA__111__X FrameData_O[17] VPWR VGND sg13cmos5l_antennanp
X_048_ N2BEG[5] S2MID[2] VPWR VGND sg13cmos5l_buf_1
XANTENNA__021__X N4BEG[2] VPWR VGND sg13cmos5l_antennanp
XFILLER_4_213 VPWR VGND sg13cmos5l_decap_8
XFILLER_4_268 VPWR VGND sg13cmos5l_fill_1
XFILLER_4_279 VPWR VGND sg13cmos5l_decap_8
XANTENNA__106__X FrameData_O[12] VPWR VGND sg13cmos5l_antennanp
XFILLER_6_86 VPWR VGND sg13cmos5l_decap_8
XANTENNA__016__X NN4BEG[13] VPWR VGND sg13cmos5l_antennanp
XFILLER_1_205 VPWR VGND sg13cmos5l_decap_8
XFILLER_1_216 VPWR VGND sg13cmos5l_fill_1
XANTENNA__102__A FrameData[8] VPWR VGND sg13cmos5l_antennanp
XFILLER_0_282 VPWR VGND sg13cmos5l_decap_8
XFILLER_9_305 VPWR VGND sg13cmos5l_decap_8
XANTENNA__012__A S4END[6] VPWR VGND sg13cmos5l_antennanp
XFILLER_10_304 VPWR VGND sg13cmos5l_decap_8
XFILLER_9_157 VPWR VGND sg13cmos5l_decap_4
XFILLER_9_102 VPWR VGND sg13cmos5l_fill_2
XANTENNA__007__A S4END[11] VPWR VGND sg13cmos5l_antennanp
XFILLER_3_21 VPWR VGND sg13cmos5l_decap_4
XFILLER_3_54 VPWR VGND sg13cmos5l_decap_8
X_081_ FrameStrobe_O[9] FrameStrobe[9] VPWR VGND sg13cmos5l_buf_1
XANTENNA__114__X FrameData_O[20] VPWR VGND sg13cmos5l_antennanp
XFILLER_5_193 VPWR VGND sg13cmos5l_fill_2
XANTENNA__024__X N4BEG[5] VPWR VGND sg13cmos5l_antennanp
XANTENNA__110__A FrameData[16] VPWR VGND sg13cmos5l_antennanp
XFILLER_2_141 VPWR VGND sg13cmos5l_decap_8
X_064_ UIO_BOT_UOUT17 S4END[2] VPWR VGND sg13cmos5l_buf_1
XFILLER_7_436 VPWR VGND sg13cmos5l_fill_2
XFILLER_7_425 VPWR VGND sg13cmos5l_decap_8
XANTENNA__020__A UIO_BOT_UIN14 VPWR VGND sg13cmos5l_antennanp
XANTENNA__109__X FrameData_O[15] VPWR VGND sg13cmos5l_antennanp
XFILLER_9_53 VPWR VGND sg13cmos5l_decap_8
XANTENNA__019__X N4BEG[0] VPWR VGND sg13cmos5l_antennanp
XANTENNA__105__A FrameData[11] VPWR VGND sg13cmos5l_antennanp
XFILLER_11_240 VPWR VGND sg13cmos5l_decap_8
X_047_ N2BEG[4] S2MID[3] VPWR VGND sg13cmos5l_buf_1
X_116_ FrameData_O[22] FrameData[22] VPWR VGND sg13cmos5l_buf_1
XFILLER_7_244 VPWR VGND sg13cmos5l_fill_2
XFILLER_7_222 VPWR VGND sg13cmos5l_decap_8
XANTENNA__015__A S4END[3] VPWR VGND sg13cmos5l_antennanp
XFILLER_6_54 VPWR VGND sg13cmos5l_decap_8
XANTENNA__032__X N4BEG[13] VPWR VGND sg13cmos5l_antennanp
XANTENNA__122__X FrameData_O[28] VPWR VGND sg13cmos5l_antennanp
XFILLER_0_261 VPWR VGND sg13cmos5l_decap_8
XANTENNA__117__X FrameData_O[23] VPWR VGND sg13cmos5l_antennanp
XANTENNA__027__X N4BEG[8] VPWR VGND sg13cmos5l_antennanp
XFILLER_10_349 VPWR VGND sg13cmos5l_decap_4
XANTENNA__113__A FrameData[19] VPWR VGND sg13cmos5l_antennanp
XFILLER_3_88 VPWR VGND sg13cmos5l_fill_2
XANTENNA__023__A UIO_BOT_UIN11 VPWR VGND sg13cmos5l_antennanp
XFILLER_10_135 VPWR VGND sg13cmos5l_fill_1
X_080_ FrameStrobe_O[8] FrameStrobe[8] VPWR VGND sg13cmos5l_buf_1
XANTENNA__108__A FrameData[14] VPWR VGND sg13cmos5l_antennanp
XFILLER_2_345 VPWR VGND sg13cmos5l_decap_8
XFILLER_6_128 VPWR VGND sg13cmos5l_decap_8
XANTENNA__018__A S4END[0] VPWR VGND sg13cmos5l_antennanp
XFILLER_5_172 VPWR VGND sg13cmos5l_decap_8
XANTENNA__040__X N2BEGb[5] VPWR VGND sg13cmos5l_antennanp
XFILLER_11_433 VPWR VGND sg13cmos5l_decap_4
XFILLER_2_120 VPWR VGND sg13cmos5l_fill_1
XFILLER_2_197 VPWR VGND sg13cmos5l_decap_8
XFILLER_3_0 VPWR VGND sg13cmos5l_decap_4
X_063_ UIO_BOT_UOUT16 S4END[3] VPWR VGND sg13cmos5l_buf_1
XFILLER_7_404 VPWR VGND sg13cmos5l_fill_2
XANTENNA__125__X FrameData_O[31] VPWR VGND sg13cmos5l_antennanp
XFILLER_0_34 VPWR VGND sg13cmos5l_decap_8
XFILLER_9_98 VPWR VGND sg13cmos5l_decap_4
XFILLER_9_76 VPWR VGND sg13cmos5l_decap_4
XANTENNA__035__X N2BEGb[0] VPWR VGND sg13cmos5l_antennanp
XANTENNA__121__A FrameData[27] VPWR VGND sg13cmos5l_antennanp
X_046_ N2BEG[3] S2MID[4] VPWR VGND sg13cmos5l_buf_1
X_115_ FrameData_O[21] FrameData[21] VPWR VGND sg13cmos5l_buf_1
XFILLER_7_289 VPWR VGND sg13cmos5l_decap_8
XFILLER_7_278 VPWR VGND sg13cmos5l_fill_1
XFILLER_7_201 VPWR VGND sg13cmos5l_decap_8
XANTENNA__031__A UIO_BOT_UIN3 VPWR VGND sg13cmos5l_antennanp
XANTENNA__116__A FrameData[22] VPWR VGND sg13cmos5l_antennanp
XFILLER_4_248 VPWR VGND sg13cmos5l_decap_8
XFILLER_4_259 VPWR VGND sg13cmos5l_fill_2
XANTENNA__026__A UIO_BOT_UIN8 VPWR VGND sg13cmos5l_antennanp
X_029_ N4BEG[10] UIO_BOT_UIN5 VPWR VGND sg13cmos5l_buf_1
XFILLER_6_33 VPWR VGND sg13cmos5l_decap_8
XFILLER_0_240 VPWR VGND sg13cmos5l_decap_8
XFILLER_8_384 VPWR VGND sg13cmos5l_fill_1
XFILLER_8_362 VPWR VGND sg13cmos5l_decap_8
.ends
