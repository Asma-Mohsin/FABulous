* NGSPICE file created from LUT4AB.ext - technology: ihp-sg13cmos5l

* Black-box entry subcircuit for sg13cmos5l_buf_1 abstract view
.subckt sg13cmos5l_buf_1 X A VDD VSS
.ends

* Black-box entry subcircuit for sg13cmos5l_a21oi_1 abstract view
.subckt sg13cmos5l_a21oi_1 Y A1 A2 B1 VDD VSS
.ends

* Black-box entry subcircuit for sg13cmos5l_nand2_1 abstract view
.subckt sg13cmos5l_nand2_1 Y A B VDD VSS
.ends

* Black-box entry subcircuit for sg13cmos5l_o21ai_1 abstract view
.subckt sg13cmos5l_o21ai_1 Y A1 A2 B1 VDD VSS
.ends

* Black-box entry subcircuit for sg13cmos5l_dlhq_1 abstract view
.subckt sg13cmos5l_dlhq_1 Q D GATE VDD VSS
.ends

* Black-box entry subcircuit for sg13cmos5l_nor2b_1 abstract view
.subckt sg13cmos5l_nor2b_1 Y A B_N VDD VSS
.ends

* Black-box entry subcircuit for sg13cmos5l_mux4_1 abstract view
.subckt sg13cmos5l_mux4_1 X A0 A1 A2 A3 S0 S1 VDD VSS
.ends

* Black-box entry subcircuit for sg13cmos5l_fill_1 abstract view
.subckt sg13cmos5l_fill_1 VDD VSS
.ends

* Black-box entry subcircuit for sg13cmos5l_fill_2 abstract view
.subckt sg13cmos5l_fill_2 VDD VSS
.ends

* Black-box entry subcircuit for sg13cmos5l_nand3_1 abstract view
.subckt sg13cmos5l_nand3_1 Y A B C VDD VSS
.ends

* Black-box entry subcircuit for sg13cmos5l_a22oi_1 abstract view
.subckt sg13cmos5l_a22oi_1 Y A1 A2 B1 B2 VDD VSS
.ends

* Black-box entry subcircuit for sg13cmos5l_mux2_1 abstract view
.subckt sg13cmos5l_mux2_1 X A0 A1 S VDD VSS
.ends

* Black-box entry subcircuit for sg13cmos5l_antennanp abstract view
.subckt sg13cmos5l_antennanp A VDD VSS
.ends

* Black-box entry subcircuit for sg13cmos5l_or2_1 abstract view
.subckt sg13cmos5l_or2_1 X A B VDD VSS
.ends

* Black-box entry subcircuit for sg13cmos5l_nand2b_1 abstract view
.subckt sg13cmos5l_nand2b_1 Y A_N B VDD VSS
.ends

* Black-box entry subcircuit for sg13cmos5l_nor2_1 abstract view
.subckt sg13cmos5l_nor2_1 Y A B VDD VSS
.ends

* Black-box entry subcircuit for sg13cmos5l_nor3_1 abstract view
.subckt sg13cmos5l_nor3_1 Y A B C VDD VSS
.ends

* Black-box entry subcircuit for sg13cmos5l_inv_1 abstract view
.subckt sg13cmos5l_inv_1 Y A VDD VSS
.ends

* Black-box entry subcircuit for sg13cmos5l_tiehi abstract view
.subckt sg13cmos5l_tiehi L_HI VDD VSS
.ends

* Black-box entry subcircuit for sg13cmos5l_decap_8 abstract view
.subckt sg13cmos5l_decap_8 VDD VSS
.ends

* Black-box entry subcircuit for sg13cmos5l_nand3b_1 abstract view
.subckt sg13cmos5l_nand3b_1 Y A_N B C VDD VSS
.ends

* Black-box entry subcircuit for sg13cmos5l_a221oi_1 abstract view
.subckt sg13cmos5l_a221oi_1 Y A1 A2 B1 B2 C1 VDD VSS
.ends

* Black-box entry subcircuit for sg13cmos5l_nand4_1 abstract view
.subckt sg13cmos5l_nand4_1 Y A B C D VDD VSS
.ends

* Black-box entry subcircuit for sg13cmos5l_or4_1 abstract view
.subckt sg13cmos5l_or4_1 X A B C D VDD VSS
.ends

* Black-box entry subcircuit for sg13cmos5l_a21o_1 abstract view
.subckt sg13cmos5l_a21o_1 X A1 A2 B1 VDD VSS
.ends

* Black-box entry subcircuit for sg13cmos5l_decap_4 abstract view
.subckt sg13cmos5l_decap_4 VDD VSS
.ends

* Black-box entry subcircuit for sg13cmos5l_and2_1 abstract view
.subckt sg13cmos5l_and2_1 X A B VDD VSS
.ends

* Black-box entry subcircuit for sg13cmos5l_buf_8 abstract view
.subckt sg13cmos5l_buf_8 X A VDD VSS
.ends

* Black-box entry subcircuit for sg13cmos5l_or3_1 abstract view
.subckt sg13cmos5l_or3_1 X A B C VDD VSS
.ends

* Black-box entry subcircuit for sg13cmos5l_dfrbpq_1 abstract view
.subckt sg13cmos5l_dfrbpq_1 Q CLK D RESET_B VDD VSS
.ends

* Black-box entry subcircuit for sg13cmos5l_and3_1 abstract view
.subckt sg13cmos5l_and3_1 X A B C VDD VSS
.ends

.subckt LUT4AB Ci Co E1BEG[0] E1BEG[1] E1BEG[2] E1BEG[3] E1END[0] E1END[1] E1END[2]
+ E1END[3] E2BEG[0] E2BEG[1] E2BEG[2] E2BEG[3] E2BEG[4] E2BEG[5] E2BEG[6] E2BEG[7]
+ E2BEGb[0] E2BEGb[1] E2BEGb[2] E2BEGb[3] E2BEGb[4] E2BEGb[5] E2BEGb[6] E2BEGb[7]
+ E2END[0] E2END[1] E2END[2] E2END[3] E2END[4] E2END[5] E2END[6] E2END[7] E2MID[0]
+ E2MID[1] E2MID[2] E2MID[3] E2MID[4] E2MID[5] E2MID[6] E2MID[7] E6BEG[0] E6BEG[10]
+ E6BEG[11] E6BEG[1] E6BEG[2] E6BEG[3] E6BEG[4] E6BEG[5] E6BEG[6] E6BEG[7] E6BEG[8]
+ E6BEG[9] E6END[0] E6END[10] E6END[11] E6END[1] E6END[2] E6END[3] E6END[4] E6END[5]
+ E6END[6] E6END[7] E6END[8] E6END[9] EE4BEG[0] EE4BEG[10] EE4BEG[11] EE4BEG[12] EE4BEG[13]
+ EE4BEG[14] EE4BEG[15] EE4BEG[1] EE4BEG[2] EE4BEG[3] EE4BEG[4] EE4BEG[5] EE4BEG[6]
+ EE4BEG[7] EE4BEG[8] EE4BEG[9] EE4END[0] EE4END[10] EE4END[11] EE4END[12] EE4END[13]
+ EE4END[14] EE4END[15] EE4END[1] EE4END[2] EE4END[3] EE4END[4] EE4END[5] EE4END[6]
+ EE4END[7] EE4END[8] EE4END[9] FrameData[0] FrameData[10] FrameData[11] FrameData[12]
+ FrameData[13] FrameData[14] FrameData[15] FrameData[16] FrameData[17] FrameData[18]
+ FrameData[19] FrameData[1] FrameData[20] FrameData[21] FrameData[22] FrameData[23]
+ FrameData[24] FrameData[25] FrameData[26] FrameData[27] FrameData[28] FrameData[29]
+ FrameData[2] FrameData[30] FrameData[31] FrameData[3] FrameData[4] FrameData[5]
+ FrameData[6] FrameData[7] FrameData[8] FrameData[9] FrameData_O[0] FrameData_O[10]
+ FrameData_O[11] FrameData_O[12] FrameData_O[13] FrameData_O[14] FrameData_O[15]
+ FrameData_O[16] FrameData_O[17] FrameData_O[18] FrameData_O[19] FrameData_O[1] FrameData_O[20]
+ FrameData_O[21] FrameData_O[22] FrameData_O[23] FrameData_O[24] FrameData_O[25]
+ FrameData_O[26] FrameData_O[27] FrameData_O[28] FrameData_O[29] FrameData_O[2] FrameData_O[30]
+ FrameData_O[31] FrameData_O[3] FrameData_O[4] FrameData_O[5] FrameData_O[6] FrameData_O[7]
+ FrameData_O[8] FrameData_O[9] FrameStrobe[0] FrameStrobe[10] FrameStrobe[11] FrameStrobe[12]
+ FrameStrobe[13] FrameStrobe[14] FrameStrobe[15] FrameStrobe[16] FrameStrobe[17]
+ FrameStrobe[18] FrameStrobe[19] FrameStrobe[1] FrameStrobe[2] FrameStrobe[3] FrameStrobe[4]
+ FrameStrobe[5] FrameStrobe[6] FrameStrobe[7] FrameStrobe[8] FrameStrobe[9] FrameStrobe_O[0]
+ FrameStrobe_O[10] FrameStrobe_O[11] FrameStrobe_O[12] FrameStrobe_O[13] FrameStrobe_O[14]
+ FrameStrobe_O[15] FrameStrobe_O[16] FrameStrobe_O[17] FrameStrobe_O[18] FrameStrobe_O[19]
+ FrameStrobe_O[1] FrameStrobe_O[2] FrameStrobe_O[3] FrameStrobe_O[4] FrameStrobe_O[5]
+ FrameStrobe_O[6] FrameStrobe_O[7] FrameStrobe_O[8] FrameStrobe_O[9] N1BEG[0] N1BEG[1]
+ N1BEG[2] N1BEG[3] N1END[0] N1END[1] N1END[2] N1END[3] N2BEG[0] N2BEG[1] N2BEG[2]
+ N2BEG[3] N2BEG[4] N2BEG[5] N2BEG[6] N2BEG[7] N2BEGb[0] N2BEGb[1] N2BEGb[2] N2BEGb[3]
+ N2BEGb[4] N2BEGb[5] N2BEGb[6] N2BEGb[7] N2END[0] N2END[1] N2END[2] N2END[3] N2END[4]
+ N2END[5] N2END[6] N2END[7] N2MID[0] N2MID[1] N2MID[2] N2MID[3] N2MID[4] N2MID[5]
+ N2MID[6] N2MID[7] N4BEG[0] N4BEG[10] N4BEG[11] N4BEG[12] N4BEG[13] N4BEG[14] N4BEG[15]
+ N4BEG[1] N4BEG[2] N4BEG[3] N4BEG[4] N4BEG[5] N4BEG[6] N4BEG[7] N4BEG[8] N4BEG[9]
+ N4END[0] N4END[10] N4END[11] N4END[12] N4END[13] N4END[14] N4END[15] N4END[1] N4END[2]
+ N4END[3] N4END[4] N4END[5] N4END[6] N4END[7] N4END[8] N4END[9] NN4BEG[0] NN4BEG[10]
+ NN4BEG[11] NN4BEG[12] NN4BEG[13] NN4BEG[14] NN4BEG[15] NN4BEG[1] NN4BEG[2] NN4BEG[3]
+ NN4BEG[4] NN4BEG[5] NN4BEG[6] NN4BEG[7] NN4BEG[8] NN4BEG[9] NN4END[0] NN4END[10]
+ NN4END[11] NN4END[12] NN4END[13] NN4END[14] NN4END[15] NN4END[1] NN4END[2] NN4END[3]
+ NN4END[4] NN4END[5] NN4END[6] NN4END[7] NN4END[8] NN4END[9] S1BEG[0] S1BEG[1] S1BEG[2]
+ S1BEG[3] S1END[0] S1END[1] S1END[2] S1END[3] S2BEG[0] S2BEG[1] S2BEG[2] S2BEG[3]
+ S2BEG[4] S2BEG[5] S2BEG[6] S2BEG[7] S2BEGb[0] S2BEGb[1] S2BEGb[2] S2BEGb[3] S2BEGb[4]
+ S2BEGb[5] S2BEGb[6] S2BEGb[7] S2END[0] S2END[1] S2END[2] S2END[3] S2END[4] S2END[5]
+ S2END[6] S2END[7] S2MID[0] S2MID[1] S2MID[2] S2MID[3] S2MID[4] S2MID[5] S2MID[6]
+ S2MID[7] S4BEG[0] S4BEG[10] S4BEG[11] S4BEG[12] S4BEG[13] S4BEG[14] S4BEG[15] S4BEG[1]
+ S4BEG[2] S4BEG[3] S4BEG[4] S4BEG[5] S4BEG[6] S4BEG[7] S4BEG[8] S4BEG[9] S4END[0]
+ S4END[10] S4END[11] S4END[12] S4END[13] S4END[14] S4END[15] S4END[1] S4END[2] S4END[3]
+ S4END[4] S4END[5] S4END[6] S4END[7] S4END[8] S4END[9] SS4BEG[0] SS4BEG[10] SS4BEG[11]
+ SS4BEG[12] SS4BEG[13] SS4BEG[14] SS4BEG[15] SS4BEG[1] SS4BEG[2] SS4BEG[3] SS4BEG[4]
+ SS4BEG[5] SS4BEG[6] SS4BEG[7] SS4BEG[8] SS4BEG[9] SS4END[0] SS4END[10] SS4END[11]
+ SS4END[12] SS4END[13] SS4END[14] SS4END[15] SS4END[1] SS4END[2] SS4END[3] SS4END[4]
+ SS4END[5] SS4END[6] SS4END[7] SS4END[8] SS4END[9] UserCLK UserCLKo VGND VPWR W1BEG[0]
+ W1BEG[1] W1BEG[2] W1BEG[3] W1END[0] W1END[1] W1END[2] W1END[3] W2BEG[0] W2BEG[1]
+ W2BEG[2] W2BEG[3] W2BEG[4] W2BEG[5] W2BEG[6] W2BEG[7] W2BEGb[0] W2BEGb[1] W2BEGb[2]
+ W2BEGb[3] W2BEGb[4] W2BEGb[5] W2BEGb[6] W2BEGb[7] W2END[0] W2END[1] W2END[2] W2END[3]
+ W2END[4] W2END[5] W2END[6] W2END[7] W2MID[0] W2MID[1] W2MID[2] W2MID[3] W2MID[4]
+ W2MID[5] W2MID[6] W2MID[7] W6BEG[0] W6BEG[10] W6BEG[11] W6BEG[1] W6BEG[2] W6BEG[3]
+ W6BEG[4] W6BEG[5] W6BEG[6] W6BEG[7] W6BEG[8] W6BEG[9] W6END[0] W6END[10] W6END[11]
+ W6END[1] W6END[2] W6END[3] W6END[4] W6END[5] W6END[6] W6END[7] W6END[8] W6END[9]
+ WW4BEG[0] WW4BEG[10] WW4BEG[11] WW4BEG[12] WW4BEG[13] WW4BEG[14] WW4BEG[15] WW4BEG[1]
+ WW4BEG[2] WW4BEG[3] WW4BEG[4] WW4BEG[5] WW4BEG[6] WW4BEG[7] WW4BEG[8] WW4BEG[9]
+ WW4END[0] WW4END[10] WW4END[11] WW4END[12] WW4END[13] WW4END[14] WW4END[15] WW4END[1]
+ WW4END[2] WW4END[3] WW4END[4] WW4END[5] WW4END[6] WW4END[7] WW4END[8] WW4END[9]
X_3086_ FrameData_O[23] FrameData[23] VPWR VGND sg13cmos5l_buf_1
X_3155_ W6BEG[3] W6END[5] VPWR VGND sg13cmos5l_buf_1
X_2106_ _2106_/Y _2610_/Q _2105_/X _2577_/Q VPWR VGND sg13cmos5l_a21oi_1
X_2037_ _2037_/Y _2037_/A _2037_/B VPWR VGND sg13cmos5l_nand2_1
X_2939_ E2BEGb[0] E2MID[0] VPWR VGND sg13cmos5l_buf_1
X_1270_ _1270_/Y _2851_/Q _1268_/Y _1269_/Y VPWR VGND sg13cmos5l_o21ai_1
X_1606_ _1607_/B _2313_/Q _1604_/Y _1605_/Y VPWR VGND sg13cmos5l_a21oi_1
X_2724_ _2724_/Q FrameData[13] FrameStrobe[6] VPWR VGND sg13cmos5l_dlhq_1
X_2655_ _2655_/Q FrameData[8] FrameStrobe[8] VPWR VGND sg13cmos5l_dlhq_1
X_1399_ _1399_/Y _2549_/Q E2END[3] VPWR VGND sg13cmos5l_nor2b_1
X_1468_ _1468_/X _2060_/B _1896_/X _1802_/X _1981_/Y _2873_/Q _2853_/Q VPWR VGND sg13cmos5l_mux4_1
X_1537_ _1538_/B _2471_/Q _2405_/Q _2406_/Q _2729_/Q _1531_/B _1528_/Y VPWR VGND sg13cmos5l_mux4_1
X_2586_ _2586_/Q FrameData[3] FrameStrobe[10] VPWR VGND sg13cmos5l_dlhq_1
XFILLER_27_214 VPWR VGND sg13cmos5l_fill_1
X_3069_ FrameData_O[6] FrameData[6] VPWR VGND sg13cmos5l_buf_1
X_3138_ W2BEG[2] _3138_/A VPWR VGND sg13cmos5l_buf_1
XFILLER_53_61 VPWR VGND sg13cmos5l_fill_2
X_2440_ _2440_/Q FrameData[17] FrameStrobe[15] VPWR VGND sg13cmos5l_dlhq_1
X_1253_ _1254_/C _2311_/Q _1253_/B _1253_/C VPWR VGND sg13cmos5l_nand3_1
X_1322_ _1516_/A _1318_/Y _1320_/Y _1321_/X _2483_/Q VPWR VGND sg13cmos5l_a22oi_1
X_2371_ _2371_/Q FrameData[12] FrameStrobe[17] VPWR VGND sg13cmos5l_dlhq_1
X_1184_ _1185_/A _1182_/X _1183_/X _1184_/S VPWR VGND sg13cmos5l_mux2_1
XFILLER_20_434 VPWR VGND sg13cmos5l_fill_2
X_2707_ _2707_/Q FrameData[28] FrameStrobe[7] VPWR VGND sg13cmos5l_dlhq_1
X_2638_ _2638_/Q FrameData[23] FrameStrobe[9] VPWR VGND sg13cmos5l_dlhq_1
X_2569_ _2569_/Q FrameData[18] FrameStrobe[11] VPWR VGND sg13cmos5l_dlhq_1
XANTENNA__2930__X E1BEG[3] VPWR VGND sg13cmos5l_antennanp
XFILLER_0_13 VPWR VGND sg13cmos5l_fill_2
XFILLER_0_35 VPWR VGND sg13cmos5l_fill_2
XANTENNA__3001__X N4BEG[6] VPWR VGND sg13cmos5l_antennanp
X_1940_ _1940_/Y _1148_/Y _1930_/X _2492_/Q VPWR VGND sg13cmos5l_a21oi_1
X_1871_ _1871_/X _1869_/X _1870_/X _1871_/S VPWR VGND sg13cmos5l_mux2_1
X_2423_ _2423_/Q FrameData[0] FrameStrobe[15] VPWR VGND sg13cmos5l_dlhq_1
XFILLER_29_0 VPWR VGND sg13cmos5l_fill_1
XFILLER_29_309 VPWR VGND sg13cmos5l_fill_2
X_1236_ _1236_/Y _2878_/Q _1232_/Y _1235_/Y VPWR VGND sg13cmos5l_o21ai_1
X_1305_ _1305_/X _1305_/A _1305_/B VPWR VGND sg13cmos5l_or2_1
X_2354_ _2354_/Q FrameData[27] FrameStrobe[18] VPWR VGND sg13cmos5l_dlhq_1
X_2285_ _2289_/S _2277_/A _2389_/Q VPWR VGND sg13cmos5l_nand2b_1
X_1167_ _1167_/Y _2690_/Q _1155_/Y _1149_/Y VPWR VGND sg13cmos5l_a21oi_1
XFILLER_50_95 VPWR VGND sg13cmos5l_fill_1
X_2070_ _2070_/Y _2324_/Q _1700_/X _2325_/Q VPWR VGND sg13cmos5l_o21ai_1
XFILLER_19_375 VPWR VGND sg13cmos5l_fill_1
XFILLER_34_389 VPWR VGND sg13cmos5l_fill_1
X_2972_ EE4BEG[13] _2972_/A VPWR VGND sg13cmos5l_buf_1
X_1923_ _1923_/Y _1926_/A _1926_/B VPWR VGND sg13cmos5l_nor2_1
X_1854_ _1854_/X N4END[0] E6END[0] S4END[0] _3137_/A _2582_/Q _2581_/Q VPWR VGND sg13cmos5l_mux4_1
X_1785_ _1786_/B _1785_/A _1785_/B _1785_/C VPWR VGND sg13cmos5l_nor3_1
X_2406_ _2406_/Q FrameData[15] FrameStrobe[16] VPWR VGND sg13cmos5l_dlhq_1
X_1219_ _1219_/Y _2316_/Q E2END[5] _1218_/Y VPWR VGND sg13cmos5l_a21oi_1
X_2337_ _2337_/Q FrameData[10] FrameStrobe[18] VPWR VGND sg13cmos5l_dlhq_1
X_2268_ _2268_/Y _2448_/Q _2266_/Y _2264_/Y VPWR VGND sg13cmos5l_o21ai_1
X_2199_ _2200_/B N1END[1] E1END[1] W1END[1] _2031_/B _2802_/Q _2702_/Q VPWR VGND sg13cmos5l_mux4_1
XANTENNA_5 E2MID[6] VPWR VGND sg13cmos5l_antennanp
XFILLER_6_45 VPWR VGND sg13cmos5l_fill_2
X_1570_ _1570_/Y SS4END[0] _2689_/Q _1569_/Y VPWR VGND sg13cmos5l_a21oi_1
X_3171_ WW4BEG[7] WW4END[11] VPWR VGND sg13cmos5l_buf_1
X_2122_ _3060_/A E6END[0] S2END[3] S4END[2] _1896_/X _2608_/Q _2607_/Q VPWR VGND sg13cmos5l_mux4_1
X_2053_ _2053_/Y _2912_/Q _2049_/X _2052_/Y VPWR VGND sg13cmos5l_o21ai_1
XFILLER_34_175 VPWR VGND sg13cmos5l_fill_1
X_2955_ E6BEG[8] E6END[10] VPWR VGND sg13cmos5l_buf_1
X_2886_ _2886_/Q FrameData[23] FrameStrobe[1] VPWR VGND sg13cmos5l_dlhq_1
X_1906_ _1961_/A _1904_/X _1905_/X _1903_/X _1902_/X _2618_/Q _2648_/Q VPWR VGND sg13cmos5l_mux4_1
X_1837_ _1837_/Y _2696_/Q _1837_/B VPWR VGND sg13cmos5l_nand2b_1
X_1768_ _1785_/C _1769_/A _1769_/B VPWR VGND sg13cmos5l_nor2_1
X_1699_ _1699_/X N2MID[2] S2MID[2] E2MID[2] _2936_/A _2494_/Q _2525_/Q VPWR VGND sg13cmos5l_mux4_1
XFILLER_31_20 VPWR VGND sg13cmos5l_fill_2
X_1622_ _1622_/X N1END[2] N2END[6] S1END[0] S1END[2] _2315_/Q _2906_/Q VPWR VGND sg13cmos5l_mux4_1
X_2740_ _2740_/Q FrameData[29] FrameStrobe[6] VPWR VGND sg13cmos5l_dlhq_1
X_2671_ _2671_/Q FrameData[24] FrameStrobe[8] VPWR VGND sg13cmos5l_dlhq_1
X_1484_ _1484_/X N2MID[4] E2MID[4] W2MID[4] _3034_/A _2775_/Q _2743_/Q VPWR VGND sg13cmos5l_mux4_1
X_1553_ _1553_/Y _2308_/Q _1549_/Y _1552_/Y VPWR VGND sg13cmos5l_o21ai_1
XFILLER_11_0 VPWR VGND sg13cmos5l_fill_1
X_3085_ FrameData_O[22] FrameData[22] VPWR VGND sg13cmos5l_buf_1
X_3154_ W6BEG[2] W6END[4] VPWR VGND sg13cmos5l_buf_1
X_2105_ _2105_/X E1END[0] _1896_/X _2578_/Q VPWR VGND sg13cmos5l_mux2_1
X_2036_ _2037_/B N2END[1] N4END[1] E6END[1] SS4END[1] _2814_/Q _2783_/Q VPWR VGND
+ sg13cmos5l_mux4_1
X_2938_ E2BEG[7] _2938_/A VPWR VGND sg13cmos5l_buf_1
X_2869_ _2869_/Q FrameData[5] FrameStrobe[1] VPWR VGND sg13cmos5l_dlhq_1
XFILLER_45_215 VPWR VGND sg13cmos5l_fill_1
XANTENNA__2933__X E2BEG[2] VPWR VGND sg13cmos5l_antennanp
XANTENNA__3004__X N4BEG[9] VPWR VGND sg13cmos5l_antennanp
X_2723_ _2723_/Q FrameData[12] FrameStrobe[6] VPWR VGND sg13cmos5l_dlhq_1
X_1536_ _1536_/X _2831_/Q _2403_/Q _2436_/Q _2417_/Q _1531_/B _1528_/Y VPWR VGND sg13cmos5l_mux4_1
X_1605_ _1605_/Y _2313_/Q _1602_/X _2312_/Q VPWR VGND sg13cmos5l_o21ai_1
X_2654_ _2654_/Q FrameData[7] FrameStrobe[8] VPWR VGND sg13cmos5l_dlhq_1
X_2585_ _2585_/Q FrameData[2] FrameStrobe[10] VPWR VGND sg13cmos5l_dlhq_1
XFILLER_47_19 VPWR VGND sg13cmos5l_fill_2
X_1398_ _2981_/A _1396_/Y _1397_/Y _1390_/Y VPWR VGND sg13cmos5l_o21ai_1
X_1467_ _1467_/X N2MID[5] E2MID[5] S2MID[5] W2MID[5] _2586_/Q _2585_/Q VPWR VGND sg13cmos5l_mux4_1
X_3137_ W2BEG[1] _3137_/A VPWR VGND sg13cmos5l_buf_1
X_3068_ FrameData_O[5] FrameData[5] VPWR VGND sg13cmos5l_buf_1
X_2019_ _2019_/Y _2721_/Q EE4END[1] VPWR VGND sg13cmos5l_nor2b_1
XANTENNA__2928__X E1BEG[1] VPWR VGND sg13cmos5l_antennanp
XFILLER_53_84 VPWR VGND sg13cmos5l_fill_2
X_1252_ _1253_/C _2789_/Q _1252_/B VPWR VGND sg13cmos5l_nand2_1
X_1321_ _1321_/X _1310_/Y _1305_/X _2642_/Q VPWR VGND sg13cmos5l_mux2_1
X_2370_ _2370_/Q FrameData[11] FrameStrobe[17] VPWR VGND sg13cmos5l_dlhq_1
X_1183_ _1183_/X _2060_/B _1896_/X _1784_/X _1802_/X _2885_/Q _2883_/Q VPWR VGND sg13cmos5l_mux4_1
XFILLER_32_284 VPWR VGND sg13cmos5l_fill_1
X_2706_ _2706_/Q FrameData[27] FrameStrobe[7] VPWR VGND sg13cmos5l_dlhq_1
X_1519_ _1740_/B _2342_/Q _1517_/Y _1518_/Y VPWR VGND sg13cmos5l_o21ai_1
X_2637_ _2637_/Q FrameData[22] FrameStrobe[9] VPWR VGND sg13cmos5l_dlhq_1
X_2568_ _2568_/Q FrameData[17] FrameStrobe[11] VPWR VGND sg13cmos5l_dlhq_1
X_2499_ _2499_/Q FrameData[12] FrameStrobe[13] VPWR VGND sg13cmos5l_dlhq_1
X_1870_ _1870_/X _2363_/Q _2362_/Q _1870_/S VPWR VGND sg13cmos5l_mux2_1
XFILLER_50_4 VPWR VGND sg13cmos5l_fill_1
X_2422_ _2422_/Q FrameData[31] FrameStrobe[16] VPWR VGND sg13cmos5l_dlhq_1
X_2353_ _2353_/Q FrameData[26] FrameStrobe[18] VPWR VGND sg13cmos5l_dlhq_1
X_1166_ _1166_/X _2690_/Q _1896_/X VPWR VGND sg13cmos5l_or2_1
X_1235_ _1235_/Y _2878_/Q _1234_/Y _1240_/A VPWR VGND sg13cmos5l_a21oi_1
X_1304_ _1305_/B _2515_/Q _3138_/A _1303_/Y VPWR VGND sg13cmos5l_a21oi_1
X_2284_ _2296_/D _2296_/Q _2283_/X _2284_/S VPWR VGND sg13cmos5l_mux2_1
X_1999_ _2000_/C _2828_/Q _1997_/Y _1998_/Y VPWR VGND sg13cmos5l_o21ai_1
XANTENNA__3102__X FrameStrobe_O[7] VPWR VGND sg13cmos5l_antennanp
XANTENNA__2941__X E2BEGb[2] VPWR VGND sg13cmos5l_antennanp
XFILLER_11_232 VPWR VGND sg13cmos5l_fill_1
XFILLER_50_52 VPWR VGND sg13cmos5l_fill_2
XFILLER_46_151 VPWR VGND sg13cmos5l_fill_2
XANTENNA__3012__X NN4BEG[1] VPWR VGND sg13cmos5l_antennanp
X_2971_ EE4BEG[12] _2971_/A VPWR VGND sg13cmos5l_buf_1
X_1922_ _1922_/Y _1926_/A _1926_/B VPWR VGND sg13cmos5l_nor2b_1
X_1853_ _3137_/A _1851_/Y _1852_/Y _1845_/Y VPWR VGND sg13cmos5l_o21ai_1
X_1784_ _1784_/X _1783_/Y _2299_/Q _2383_/Q VPWR VGND sg13cmos5l_mux2_1
X_2405_ _2405_/Q FrameData[14] FrameStrobe[16] VPWR VGND sg13cmos5l_dlhq_1
X_2336_ _2336_/Q FrameData[9] FrameStrobe[18] VPWR VGND sg13cmos5l_dlhq_1
XFILLER_37_162 VPWR VGND sg13cmos5l_fill_1
X_1149_ _1149_/Y _2760_/Q VPWR VGND sg13cmos5l_inv_1
X_1218_ _1218_/Y _2316_/Q E1END[1] VPWR VGND sg13cmos5l_nor2b_1
X_2267_ _2267_/Y _1971_/Y _1979_/Y _2291_/B _2464_/Q VPWR VGND sg13cmos5l_a22oi_1
X_2198_ _2927_/A _2031_/B _1318_/B _2982_/A _1368_/X _2480_/Q _2479_/Q VPWR VGND sg13cmos5l_mux4_1
XANTENNA__2936__X E2BEG[5] VPWR VGND sg13cmos5l_antennanp
XFILLER_0_434 VPWR VGND sg13cmos5l_fill_2
XFILLER_29_53 VPWR VGND sg13cmos5l_fill_2
XFILLER_16_335 VPWR VGND sg13cmos5l_fill_1
XANTENNA_6 E2MID[6] VPWR VGND sg13cmos5l_antennanp
XANTENNA__3007__X N4BEG[12] VPWR VGND sg13cmos5l_antennanp
X_3170_ WW4BEG[6] WW4END[10] VPWR VGND sg13cmos5l_buf_1
X_2121_ _3061_/A S2END[0] S4END[3] W6END[1] _1740_/B _2606_/Q _2543_/Q VPWR VGND sg13cmos5l_mux4_1
X_2052_ _2052_/Y _2912_/Q _2051_/Y _2864_/Q VPWR VGND sg13cmos5l_a21oi_1
XFILLER_22_349 VPWR VGND sg13cmos5l_fill_2
XFILLER_34_154 VPWR VGND sg13cmos5l_fill_2
XFILLER_34_198 VPWR VGND sg13cmos5l_fill_1
X_2885_ _2885_/Q FrameData[22] FrameStrobe[1] VPWR VGND sg13cmos5l_dlhq_1
X_2954_ E6BEG[7] E6END[9] VPWR VGND sg13cmos5l_buf_1
X_1905_ _1905_/X N2MID[3] E2MID[3] S2MID[3] W2MID[3] _2304_/Q _2897_/Q VPWR VGND sg13cmos5l_mux4_1
X_1836_ _1837_/B N1END[0] N2END[2] _2795_/Q VPWR VGND sg13cmos5l_mux2_1
X_1767_ _1780_/A _1769_/A _1769_/B VPWR VGND sg13cmos5l_nor2b_1
X_1698_ _1698_/X _1694_/X _1695_/X _2799_/Q VPWR VGND sg13cmos5l_mux2_1
X_2319_ _2319_/Q FrameData[18] FrameStrobe[19] VPWR VGND sg13cmos5l_dlhq_1
XFILLER_31_76 VPWR VGND sg13cmos5l_fill_2
XFILLER_0_275 VPWR VGND sg13cmos5l_fill_2
XFILLER_0_297 VPWR VGND sg13cmos5l_fill_2
XFILLER_16_121 VPWR VGND sg13cmos5l_fill_1
XFILLER_12_360 VPWR VGND sg13cmos5l_fill_2
X_1552_ _1552_/Y _2308_/Q _1551_/Y _1544_/A VPWR VGND sg13cmos5l_a21oi_1
X_1621_ _1621_/Y _2886_/Q _1614_/X _1620_/Y VPWR VGND sg13cmos5l_o21ai_1
X_2670_ _2670_/Q FrameData[23] FrameStrobe[8] VPWR VGND sg13cmos5l_dlhq_1
X_1483_ _3034_/A _2852_/Q _1482_/Y _1475_/Y VPWR VGND sg13cmos5l_o21ai_1
X_3153_ W6BEG[1] W6END[3] VPWR VGND sg13cmos5l_buf_1
X_2104_ _2104_/Y N1END[0] _2578_/Q _2103_/Y VPWR VGND sg13cmos5l_o21ai_1
X_3084_ FrameData_O[21] FrameData[21] VPWR VGND sg13cmos5l_buf_1
X_2035_ _2035_/Y _2037_/A _2028_/X _2034_/Y VPWR VGND sg13cmos5l_a21oi_1
X_2868_ _2868_/Q FrameData[4] FrameStrobe[1] VPWR VGND sg13cmos5l_dlhq_1
X_2937_ E2BEG[6] _2937_/A VPWR VGND sg13cmos5l_buf_1
X_2799_ _2799_/Q FrameData[24] FrameStrobe[4] VPWR VGND sg13cmos5l_dlhq_1
X_1819_ _1819_/Y _2722_/Q W2END[2] _1818_/Y VPWR VGND sg13cmos5l_a21oi_1
XANTENNA__3110__X FrameStrobe_O[15] VPWR VGND sg13cmos5l_antennanp
XFILLER_5_301 VPWR VGND sg13cmos5l_fill_1
XANTENNA__3020__X NN4BEG[9] VPWR VGND sg13cmos5l_antennanp
X_2722_ _2722_/Q FrameData[11] FrameStrobe[6] VPWR VGND sg13cmos5l_dlhq_1
X_1535_ _1535_/Y _1531_/A _1534_/X _1521_/Y VPWR VGND sg13cmos5l_a21oi_1
X_1604_ _1604_/Y E2END[0] _2905_/Q _1603_/Y VPWR VGND sg13cmos5l_o21ai_1
X_2653_ _2653_/Q FrameData[6] FrameStrobe[8] VPWR VGND sg13cmos5l_dlhq_1
X_2584_ _2584_/Q FrameData[1] FrameStrobe[10] VPWR VGND sg13cmos5l_dlhq_1
X_1397_ _1397_/Y _2719_/Q _1391_/X _2844_/Q VPWR VGND sg13cmos5l_o21ai_1
X_1466_ _1466_/X N4END[1] E6END[1] W6END[1] _3032_/A _2694_/Q _2634_/Q VPWR VGND sg13cmos5l_mux4_1
X_3067_ FrameData_O[4] FrameData[4] VPWR VGND sg13cmos5l_buf_1
X_3136_ W2BEG[0] _3136_/A VPWR VGND sg13cmos5l_buf_1
X_2018_ _2018_/Y _2845_/Q _2017_/X _2016_/Y VPWR VGND sg13cmos5l_a21oi_1
XANTENNA__3105__X FrameStrobe_O[10] VPWR VGND sg13cmos5l_antennanp
XANTENNA__2944__X E2BEGb[5] VPWR VGND sg13cmos5l_antennanp
X_1320_ _1320_/Y _2483_/Q _1320_/B VPWR VGND sg13cmos5l_nor2_1
XANTENNA__3015__X NN4BEG[4] VPWR VGND sg13cmos5l_antennanp
X_1182_ _1182_/X _1740_/B _1957_/Y _2031_/B _1283_/Y _2883_/Q _2885_/Q VPWR VGND sg13cmos5l_mux4_1
X_1251_ _1252_/B _2031_/B _1542_/X _2788_/Q VPWR VGND sg13cmos5l_mux2_1
XFILLER_24_208 VPWR VGND sg13cmos5l_fill_2
X_2705_ _2705_/Q FrameData[26] FrameStrobe[7] VPWR VGND sg13cmos5l_dlhq_1
X_2636_ _2636_/Q FrameData[21] FrameStrobe[9] VPWR VGND sg13cmos5l_dlhq_1
X_1449_ _1882_/A _1446_/X _1448_/Y _1430_/Y _1425_/X _2485_/Q _2453_/Q VPWR VGND sg13cmos5l_mux4_1
X_1518_ _1518_/Y _2297_/Q _2342_/Q VPWR VGND sg13cmos5l_nand2_1
X_2567_ _2567_/Q FrameData[16] FrameStrobe[11] VPWR VGND sg13cmos5l_dlhq_1
X_2498_ _2498_/Q FrameData[11] FrameStrobe[13] VPWR VGND sg13cmos5l_dlhq_1
X_3119_ SS4BEG[4] SS4END[8] VPWR VGND sg13cmos5l_buf_1
XFILLER_23_55 VPWR VGND sg13cmos5l_fill_2
XANTENNA__2939__X E2BEGb[0] VPWR VGND sg13cmos5l_antennanp
X_1303_ _1303_/Y _1113_/Y _2515_/Q _2546_/Q VPWR VGND sg13cmos5l_o21ai_1
X_2421_ _2421_/Q FrameData[30] FrameStrobe[16] VPWR VGND sg13cmos5l_dlhq_1
X_2352_ _2352_/Q FrameData[25] FrameStrobe[18] VPWR VGND sg13cmos5l_dlhq_1
X_2283_ _2283_/X _2335_/Q _1895_/X _2283_/S VPWR VGND sg13cmos5l_mux2_1
X_1165_ _1165_/Y _2726_/Q _1158_/X _1164_/Y VPWR VGND sg13cmos5l_o21ai_1
X_1234_ _1234_/Y _2797_/Q _2031_/B _1233_/Y VPWR VGND sg13cmos5l_o21ai_1
X_2619_ _2619_/Q FrameData[4] FrameStrobe[9] VPWR VGND sg13cmos5l_dlhq_1
X_1998_ _1998_/Y _2828_/Q _1995_/X _2827_/Q VPWR VGND sg13cmos5l_a21oi_1
XFILLER_18_44 VPWR VGND sg13cmos5l_fill_1
XFILLER_1_0 VPWR VGND sg13cmos5l_fill_2
X_2970_ EE4BEG[11] EE4END[15] VPWR VGND sg13cmos5l_buf_1
X_1921_ _1926_/B _1904_/X _1905_/X _1903_/X _1902_/X _2584_/Q _2557_/Q VPWR VGND sg13cmos5l_mux4_1
X_1852_ _1852_/Y _2761_/Q _1846_/X _2727_/Q VPWR VGND sg13cmos5l_o21ai_1
X_1783_ _1783_/Y _1782_/A _1781_/Y _1782_/Y VPWR VGND sg13cmos5l_a21oi_1
XFILLER_34_0 VPWR VGND sg13cmos5l_fill_1
X_2404_ _2404_/Q FrameData[13] FrameStrobe[16] VPWR VGND sg13cmos5l_dlhq_1
X_2335_ _2335_/Q FrameData[8] FrameStrobe[18] VPWR VGND sg13cmos5l_dlhq_1
X_2266_ _2266_/Y _2464_/Q _2291_/B VPWR VGND sg13cmos5l_nand2_1
X_1148_ _1148_/Y _2523_/Q VPWR VGND sg13cmos5l_inv_1
X_1217_ _1217_/Y _1110_/Y _2316_/Q _1216_/Y VPWR VGND sg13cmos5l_a21oi_1
X_2197_ _2928_/A _1784_/X _1724_/X _2979_/A _1727_/X _2801_/Q _2768_/Q VPWR VGND sg13cmos5l_mux4_1
XFILLER_20_45 VPWR VGND sg13cmos5l_fill_2
XANTENNA__3113__X FrameStrobe_O[18] VPWR VGND sg13cmos5l_antennanp
XFILLER_48_417 VPWR VGND sg13cmos5l_fill_2
XANTENNA__2952__X E6BEG[5] VPWR VGND sg13cmos5l_antennanp
XANTENNA_7 E2MID[6] VPWR VGND sg13cmos5l_antennanp
X_2120_ _3062_/A S2END[1] W6END[0] S4END[0] _2031_/B _2541_/Q _2542_/Q VPWR VGND sg13cmos5l_mux4_1
XANTENNA__3023__X NN4BEG[12] VPWR VGND sg13cmos5l_antennanp
X_2051_ _2051_/Y _2051_/A VPWR VGND sg13cmos5l_inv_1
X_2884_ _2884_/Q FrameData[21] FrameStrobe[1] VPWR VGND sg13cmos5l_dlhq_1
X_2953_ E6BEG[6] E6END[8] VPWR VGND sg13cmos5l_buf_1
X_1904_ _1904_/X N2MID[2] W2MID[2] S2MID[2] _2937_/A _2587_/Q _2588_/Q VPWR VGND sg13cmos5l_mux4_1
X_1835_ _1835_/X S2END[2] S4END[2] _2795_/Q VPWR VGND sg13cmos5l_mux2_1
X_1766_ _1777_/A _1769_/B _1769_/A VPWR VGND sg13cmos5l_nor2b_1
X_1697_ _1697_/X _1691_/X _1696_/X _2835_/Q VPWR VGND sg13cmos5l_mux2_1
X_2318_ _2318_/Q FrameData[17] FrameStrobe[19] VPWR VGND sg13cmos5l_dlhq_1
X_2249_ _2259_/S _2277_/A _2328_/Q VPWR VGND sg13cmos5l_nand2b_1
XFILLER_15_45 VPWR VGND sg13cmos5l_fill_2
XANTENNA__2947__X E6BEG[0] VPWR VGND sg13cmos5l_antennanp
XANTENNA__3108__X FrameStrobe_O[13] VPWR VGND sg13cmos5l_antennanp
XFILLER_48_214 VPWR VGND sg13cmos5l_fill_1
XFILLER_12_372 VPWR VGND sg13cmos5l_fill_2
XANTENNA__3018__X NN4BEG[7] VPWR VGND sg13cmos5l_antennanp
X_1482_ _1482_/Y _2872_/Q _1476_/X _1481_/Y VPWR VGND sg13cmos5l_o21ai_1
X_1551_ _1551_/Y W1END[2] _2870_/Q _1550_/Y VPWR VGND sg13cmos5l_a21oi_1
X_1620_ _1620_/Y _1620_/A _2314_/Q VPWR VGND sg13cmos5l_nor2b_1
X_3083_ FrameData_O[20] FrameData[20] VPWR VGND sg13cmos5l_buf_1
X_3152_ W6BEG[0] W6END[2] VPWR VGND sg13cmos5l_buf_1
X_2103_ _2103_/Y _1603_/A _2578_/Q _2610_/Q VPWR VGND sg13cmos5l_a21oi_1
XFILLER_22_125 VPWR VGND sg13cmos5l_fill_1
X_2034_ _2034_/Y _2814_/Q _2030_/Y _2033_/Y VPWR VGND sg13cmos5l_a21oi_1
X_2867_ _2867_/Q FrameData[3] FrameStrobe[1] VPWR VGND sg13cmos5l_dlhq_1
X_2936_ E2BEG[5] _2936_/A VPWR VGND sg13cmos5l_buf_1
X_2798_ _2798_/Q FrameData[23] FrameStrobe[4] VPWR VGND sg13cmos5l_dlhq_1
X_1818_ _1818_/Y _2722_/Q E1END[0] VPWR VGND sg13cmos5l_nor2b_1
X_1749_ _1749_/Y _2903_/Q _1747_/X _1748_/Y VPWR VGND sg13cmos5l_o21ai_1
XFILLER_42_65 VPWR VGND sg13cmos5l_fill_2
X_2721_ _2721_/Q FrameData[10] FrameStrobe[6] VPWR VGND sg13cmos5l_dlhq_1
X_2652_ _2652_/Q FrameData[5] FrameStrobe[8] VPWR VGND sg13cmos5l_dlhq_1
X_1465_ _3032_/A _1127_/Y _1460_/Y _1462_/Y _1464_/Y VPWR VGND sg13cmos5l_a22oi_1
X_1534_ _1534_/X _2375_/Q _2374_/Q _2597_/Q _2437_/Q _1528_/Y _1531_/B VPWR VGND sg13cmos5l_mux4_1
X_1603_ _1603_/Y _1603_/A _2905_/Q VPWR VGND sg13cmos5l_nand2_1
X_2583_ _2583_/Q FrameData[0] FrameStrobe[10] VPWR VGND sg13cmos5l_dlhq_1
X_1396_ _1396_/Y _2755_/Q _1392_/X _1395_/Y VPWR VGND sg13cmos5l_a21oi_1
X_3066_ FrameData_O[3] FrameData[3] VPWR VGND sg13cmos5l_buf_1
X_3135_ W1BEG[3] _3135_/A VPWR VGND sg13cmos5l_buf_1
X_2017_ _2017_/X _2031_/B _1957_/Y _1784_/X _1283_/Y _2721_/Q _2786_/Q VPWR VGND sg13cmos5l_mux4_1
X_2919_ _2919_/L_HI VPWR VGND sg13cmos5l_tiehi
XANTENNA__3121__X SS4BEG[6] VPWR VGND sg13cmos5l_antennanp
XFILLER_18_239 VPWR VGND sg13cmos5l_fill_2
XFILLER_37_76 VPWR VGND sg13cmos5l_fill_2
XFILLER_53_53 VPWR VGND sg13cmos5l_fill_1
XANTENNA__2960__X EE4BEG[1] VPWR VGND sg13cmos5l_antennanp
X_1181_ _2985_/A _1179_/X _1180_/X _1178_/X _1177_/X _2846_/Q _2818_/Q VPWR VGND sg13cmos5l_mux4_1
X_1250_ _1253_/B _2788_/Q _1740_/B _1249_/Y VPWR VGND sg13cmos5l_o21ai_1
XANTENNA__3031__X S2BEG[0] VPWR VGND sg13cmos5l_antennanp
X_2704_ _2704_/Q FrameData[25] FrameStrobe[7] VPWR VGND sg13cmos5l_dlhq_1
X_2635_ _2635_/Q FrameData[20] FrameStrobe[9] VPWR VGND sg13cmos5l_dlhq_1
X_1448_ _1448_/Y _1448_/A VPWR VGND sg13cmos5l_inv_1
X_1517_ _1517_/Y _1516_/A _1508_/Y _1516_/Y VPWR VGND sg13cmos5l_o21ai_1
X_2566_ _2566_/Q FrameData[15] FrameStrobe[11] VPWR VGND sg13cmos5l_dlhq_1
X_2497_ _2497_/Q FrameData[10] FrameStrobe[13] VPWR VGND sg13cmos5l_dlhq_1
X_1379_ _1408_/B _2512_/Q _1378_/X VPWR VGND sg13cmos5l_nor2b_1
X_3049_ S4BEG[2] S4END[6] VPWR VGND sg13cmos5l_buf_1
X_3118_ SS4BEG[3] SS4END[7] VPWR VGND sg13cmos5l_buf_1
XFILLER_23_78 VPWR VGND sg13cmos5l_fill_1
XANTENNA__3116__X SS4BEG[1] VPWR VGND sg13cmos5l_antennanp
XANTENNA__2955__X E6BEG[8] VPWR VGND sg13cmos5l_antennanp
X_2420_ _2420_/Q FrameData[29] FrameStrobe[16] VPWR VGND sg13cmos5l_dlhq_1
XANTENNA__3026__X NN4BEG[15] VPWR VGND sg13cmos5l_antennanp
X_1233_ _1233_/Y _1697_/X _2797_/Q VPWR VGND sg13cmos5l_nand2b_1
X_1302_ _1305_/A _2546_/Q _1302_/B VPWR VGND sg13cmos5l_nor2_1
X_2351_ _2351_/Q FrameData[24] FrameStrobe[18] VPWR VGND sg13cmos5l_dlhq_1
X_2282_ _2283_/S _2358_/Q _2291_/B VPWR VGND sg13cmos5l_nand2_1
X_1164_ _1164_/Y _2793_/Q _1164_/B VPWR VGND sg13cmos5l_nor2_1
XFILLER_20_212 VPWR VGND sg13cmos5l_decap_8
X_1997_ _1997_/Y _2762_/Q _1802_/X _1996_/Y VPWR VGND sg13cmos5l_a21oi_1
X_2618_ _2618_/Q FrameData[3] FrameStrobe[9] VPWR VGND sg13cmos5l_dlhq_1
X_2549_ _2549_/Q FrameData[30] FrameStrobe[12] VPWR VGND sg13cmos5l_dlhq_1
X_1920_ _1926_/A _1899_/X _1900_/X _1898_/X _1897_/X _2679_/Q _2617_/Q VPWR VGND sg13cmos5l_mux4_1
X_1851_ _1851_/Y _2795_/Q _1847_/X _1850_/Y VPWR VGND sg13cmos5l_a21oi_1
XFILLER_6_271 VPWR VGND sg13cmos5l_fill_1
X_2403_ _2403_/Q FrameData[12] FrameStrobe[16] VPWR VGND sg13cmos5l_dlhq_1
X_1782_ _1782_/Y _1782_/A _1782_/B VPWR VGND sg13cmos5l_nor2_1
XFILLER_27_0 VPWR VGND sg13cmos5l_fill_2
X_1216_ _1216_/Y S2END[5] _2316_/Q _2859_/Q VPWR VGND sg13cmos5l_o21ai_1
X_2334_ _2334_/Q FrameData[7] FrameStrobe[18] VPWR VGND sg13cmos5l_dlhq_1
X_2265_ _2265_/Y _2277_/A _2301_/Q _2391_/Q VPWR VGND sg13cmos5l_nand3b_1
X_2196_ _2929_/A _1802_/X _2980_/A _1905_/X _1932_/X _2575_/Q _2836_/Q VPWR VGND sg13cmos5l_mux4_1
XFILLER_25_315 VPWR VGND sg13cmos5l_fill_2
X_1147_ _1916_/A _2537_/Q VPWR VGND sg13cmos5l_inv_1
XFILLER_45_21 VPWR VGND sg13cmos5l_fill_1
XFILLER_45_43 VPWR VGND sg13cmos5l_fill_2
XANTENNA_8 E2MID[6] VPWR VGND sg13cmos5l_antennanp
X_2050_ _2051_/A _2060_/B _1896_/X _1784_/X _1802_/X _2889_/Q _2865_/Q VPWR VGND sg13cmos5l_mux4_1
X_2952_ E6BEG[5] E6END[7] VPWR VGND sg13cmos5l_buf_1
X_2883_ _2883_/Q FrameData[20] FrameStrobe[1] VPWR VGND sg13cmos5l_dlhq_1
X_1903_ _1903_/X N2END[3] E2END[3] SS4END[0] W2END[3] _2750_/Q _2629_/Q VPWR VGND
+ sg13cmos5l_mux4_1
X_1834_ _1834_/Y _1871_/S _1831_/Y _1832_/Y _1833_/Y _1862_/A VPWR VGND sg13cmos5l_a221oi_1
X_1765_ _1782_/B _1764_/X _1734_/X _1769_/A VPWR VGND sg13cmos5l_mux2_1
X_1696_ _1696_/X _1690_/X _1695_/X _1696_/S VPWR VGND sg13cmos5l_mux2_1
X_2317_ _2317_/Q FrameData[16] FrameStrobe[19] VPWR VGND sg13cmos5l_dlhq_1
X_2248_ _2277_/A _2239_/Y _2242_/Y _2247_/Y _2613_/Q VPWR VGND sg13cmos5l_a22oi_1
X_2179_ _2179_/X _1346_/X _1722_/X _2665_/Q VPWR VGND sg13cmos5l_mux2_1
XANTENNA__3124__X SS4BEG[9] VPWR VGND sg13cmos5l_antennanp
XANTENNA__2963__X EE4BEG[4] VPWR VGND sg13cmos5l_antennanp
X_1481_ _1481_/Y _2873_/Q _1479_/Y _1480_/Y VPWR VGND sg13cmos5l_o21ai_1
X_1550_ _1550_/Y _2870_/Q EE4END[0] VPWR VGND sg13cmos5l_nor2b_1
XANTENNA__3034__X S2BEG[3] VPWR VGND sg13cmos5l_antennanp
XFILLER_39_226 VPWR VGND sg13cmos5l_fill_2
X_3082_ FrameData_O[19] FrameData[19] VPWR VGND sg13cmos5l_buf_1
X_3151_ W2BEGb[7] W2MID[7] VPWR VGND sg13cmos5l_buf_1
X_2102_ _2102_/Y _2102_/A _2577_/Q VPWR VGND sg13cmos5l_nor2b_1
X_2033_ _2033_/Y _2814_/Q _2032_/Y _2813_/Q VPWR VGND sg13cmos5l_o21ai_1
XFILLER_50_435 VPWR VGND sg13cmos5l_fill_1
X_2935_ E2BEG[4] _2935_/A VPWR VGND sg13cmos5l_buf_1
X_2866_ _2866_/Q FrameData[2] FrameStrobe[1] VPWR VGND sg13cmos5l_dlhq_1
X_2797_ _2797_/Q FrameData[22] FrameStrobe[4] VPWR VGND sg13cmos5l_dlhq_1
X_1817_ _1817_/X E2END[2] W6END[0] _2722_/Q VPWR VGND sg13cmos5l_mux2_1
X_1748_ _1748_/Y _2903_/Q _1746_/Y _2880_/Q VPWR VGND sg13cmos5l_a21oi_1
X_1679_ _2936_/A _1677_/Y _1678_/Y _1671_/Y VPWR VGND sg13cmos5l_o21ai_1
XANTENNA__2958__X E6BEG[11] VPWR VGND sg13cmos5l_antennanp
XANTENNA__3119__X SS4BEG[4] VPWR VGND sg13cmos5l_antennanp
XFILLER_32_435 VPWR VGND sg13cmos5l_fill_1
XANTENNA__3029__X S1BEG[2] VPWR VGND sg13cmos5l_antennanp
X_1602_ _1602_/X E1END[0] S2END[0] _2905_/Q VPWR VGND sg13cmos5l_mux2_1
X_2720_ _2720_/Q FrameData[9] FrameStrobe[6] VPWR VGND sg13cmos5l_dlhq_1
X_2651_ _2651_/Q FrameData[4] FrameStrobe[8] VPWR VGND sg13cmos5l_dlhq_1
X_2582_ _2582_/Q FrameData[31] FrameStrobe[11] VPWR VGND sg13cmos5l_dlhq_1
X_1395_ _1395_/Y _2755_/Q _1394_/Y _2719_/Q VPWR VGND sg13cmos5l_o21ai_1
X_1464_ _1464_/Y _2688_/Q _1463_/X _1127_/Y VPWR VGND sg13cmos5l_a21oi_1
X_1533_ _1533_/Y _1531_/A _1533_/B VPWR VGND sg13cmos5l_nand2b_1
X_3065_ FrameData_O[2] FrameData[2] VPWR VGND sg13cmos5l_buf_1
X_3134_ W1BEG[2] _3134_/A VPWR VGND sg13cmos5l_buf_1
X_2016_ _2016_/Y _2845_/Q _2015_/X VPWR VGND sg13cmos5l_nor2b_1
XFILLER_23_435 VPWR VGND sg13cmos5l_fill_1
X_2918_ _2918_/Q FrameData[24] FrameStrobe[0] VPWR VGND sg13cmos5l_dlhq_1
X_2849_ _2849_/Q FrameData[14] FrameStrobe[2] VPWR VGND sg13cmos5l_dlhq_1
XFILLER_1_361 VPWR VGND sg13cmos5l_fill_2
XFILLER_5_177 VPWR VGND sg13cmos5l_fill_1
X_1180_ _1180_/X E1END[3] W1END[1] E2END[7] W1END[3] _2819_/Q _2847_/Q VPWR VGND sg13cmos5l_mux4_1
X_1516_ _1516_/Y _1516_/A _1516_/B _1516_/C _1516_/D VPWR VGND sg13cmos5l_nand4_1
X_2703_ _2703_/Q FrameData[24] FrameStrobe[7] VPWR VGND sg13cmos5l_dlhq_1
X_2634_ _2634_/Q FrameData[19] FrameStrobe[9] VPWR VGND sg13cmos5l_dlhq_1
X_2565_ _2565_/Q FrameData[14] FrameStrobe[11] VPWR VGND sg13cmos5l_dlhq_1
X_1378_ _1378_/X _1376_/X _1377_/X _2674_/Q VPWR VGND sg13cmos5l_mux2_1
X_1447_ _1448_/A N2MID[3] E2MID[3] S2MID[3] W2MID[3] _2866_/Q _2895_/Q VPWR VGND sg13cmos5l_mux4_1
X_3117_ SS4BEG[2] SS4END[6] VPWR VGND sg13cmos5l_buf_1
X_2496_ _2496_/Q FrameData[9] FrameStrobe[13] VPWR VGND sg13cmos5l_dlhq_1
X_3048_ S4BEG[1] S4END[5] VPWR VGND sg13cmos5l_buf_1
XANTENNA__3132__X W1BEG[0] VPWR VGND sg13cmos5l_antennanp
XANTENNA__2971__X EE4BEG[12] VPWR VGND sg13cmos5l_antennanp
X_1232_ _1232_/Y _2797_/Q _1156_/Y _1231_/Y VPWR VGND sg13cmos5l_a21oi_1
X_1301_ _1302_/B N4END[0] SS4END[0] _2515_/Q VPWR VGND sg13cmos5l_mux2_1
X_2350_ _2350_/Q FrameData[23] FrameStrobe[18] VPWR VGND sg13cmos5l_dlhq_1
X_2281_ _2284_/S _2277_/A _2390_/Q VPWR VGND sg13cmos5l_nand2b_1
XANTENNA__3042__X S2BEGb[3] VPWR VGND sg13cmos5l_antennanp
XFILLER_37_368 VPWR VGND sg13cmos5l_fill_1
X_1163_ _1164_/B _2690_/Q _1159_/X _1162_/Y VPWR VGND sg13cmos5l_a21oi_1
X_1996_ _1996_/Y _2762_/Q _1896_/X VPWR VGND sg13cmos5l_nor2b_1
X_2617_ _2617_/Q FrameData[2] FrameStrobe[9] VPWR VGND sg13cmos5l_dlhq_1
X_2548_ _2548_/Q FrameData[29] FrameStrobe[12] VPWR VGND sg13cmos5l_dlhq_1
X_2479_ _2479_/Q FrameData[24] FrameStrobe[14] VPWR VGND sg13cmos5l_dlhq_1
XFILLER_43_349 VPWR VGND sg13cmos5l_fill_1
XANTENNA__3127__X SS4BEG[12] VPWR VGND sg13cmos5l_antennanp
XFILLER_7_239 VPWR VGND sg13cmos5l_fill_2
XANTENNA__2966__X EE4BEG[7] VPWR VGND sg13cmos5l_antennanp
X_1850_ _1850_/Y _2795_/Q _1849_/Y _2761_/Q VPWR VGND sg13cmos5l_o21ai_1
X_1781_ _1781_/Y _1781_/A _1781_/B _1781_/C VPWR VGND sg13cmos5l_nand3_1
XANTENNA__3037__X S2BEG[6] VPWR VGND sg13cmos5l_antennanp
X_2402_ _2402_/Q FrameData[11] FrameStrobe[16] VPWR VGND sg13cmos5l_dlhq_1
X_2333_ _2333_/Q FrameData[6] FrameStrobe[18] VPWR VGND sg13cmos5l_dlhq_1
X_1146_ _1653_/A _2309_/Q VPWR VGND sg13cmos5l_inv_1
X_1215_ _1215_/Y _2859_/Q _1212_/X _2888_/Q VPWR VGND sg13cmos5l_a21oi_1
X_2264_ _2264_/Y _2277_/A _2391_/Q VPWR VGND sg13cmos5l_nand2b_1
X_2195_ _2930_/A _1981_/Y _2981_/A _1467_/X _1825_/X _2508_/Q _2574_/Q VPWR VGND sg13cmos5l_mux4_1
X_1979_ _1979_/Y _1971_/B _1979_/B _1979_/C VPWR VGND sg13cmos5l_nand3b_1
XFILLER_0_426 VPWR VGND sg13cmos5l_fill_2
XFILLER_51_190 VPWR VGND sg13cmos5l_fill_2
XANTENNA_9 E2MID[6] VPWR VGND sg13cmos5l_antennanp
X_2951_ E6BEG[4] E6END[6] VPWR VGND sg13cmos5l_buf_1
X_1902_ _1902_/X N4END[2] W2END[2] SS4END[2] _2935_/A _2742_/Q _2806_/Q VPWR VGND
+ sg13cmos5l_mux4_1
X_2882_ _2882_/Q FrameData[19] FrameStrobe[1] VPWR VGND sg13cmos5l_dlhq_1
X_1833_ _1833_/Y _2334_/Q _1870_/S _1871_/S VPWR VGND sg13cmos5l_a21oi_1
X_1764_ _1764_/X _2412_/Q _2381_/Q _2411_/Q _2439_/Q _1778_/B _1769_/B VPWR VGND sg13cmos5l_mux4_1
X_2316_ _2316_/Q FrameData[15] FrameStrobe[19] VPWR VGND sg13cmos5l_dlhq_1
X_1695_ _1695_/X _1694_/X _1542_/X _1695_/S VPWR VGND sg13cmos5l_mux2_1
X_1129_ _1129_/Y E2MID[2] VPWR VGND sg13cmos5l_inv_1
X_2247_ _2247_/Y _2486_/Q _2243_/X _2245_/Y _2246_/Y VPWR VGND sg13cmos5l_a22oi_1
X_2178_ _2178_/Y _2665_/Q _1957_/Y _2177_/Y VPWR VGND sg13cmos5l_o21ai_1
XFILLER_25_168 VPWR VGND sg13cmos5l_fill_1
XANTENNA__3140__X W2BEG[4] VPWR VGND sg13cmos5l_antennanp
X_1480_ _1480_/Y _2873_/Q _1477_/X _1469_/B VPWR VGND sg13cmos5l_a21oi_1
X_3150_ W2BEGb[6] W2MID[6] VPWR VGND sg13cmos5l_buf_1
XANTENNA__3050__X S4BEG[3] VPWR VGND sg13cmos5l_antennanp
X_3081_ FrameData_O[18] FrameData[18] VPWR VGND sg13cmos5l_buf_1
X_2101_ _2101_/Y _2610_/Q _2101_/B VPWR VGND sg13cmos5l_nand2b_1
X_2032_ _2032_/Y _2783_/Q _1156_/Y _2031_/Y VPWR VGND sg13cmos5l_a21oi_1
XFILLER_50_403 VPWR VGND sg13cmos5l_fill_2
X_2865_ _2865_/Q FrameData[31] FrameStrobe[2] VPWR VGND sg13cmos5l_dlhq_1
X_2934_ E2BEG[3] _2934_/A VPWR VGND sg13cmos5l_buf_1
X_2796_ _2796_/Q FrameData[21] FrameStrobe[4] VPWR VGND sg13cmos5l_dlhq_1
X_1816_ _1816_/X N2END[2] N4END[2] E6END[0] S2END[2] _2747_/Q _2722_/Q VPWR VGND sg13cmos5l_mux4_1
X_1747_ _1747_/X N1END[2] S2END[4] _2879_/Q VPWR VGND sg13cmos5l_mux2_1
X_1678_ _1678_/Y _2849_/Q _1672_/X _2824_/Q VPWR VGND sg13cmos5l_o21ai_1
XFILLER_38_293 VPWR VGND sg13cmos5l_fill_1
XANTENNA__3135__X W1BEG[3] VPWR VGND sg13cmos5l_antennanp
XFILLER_5_348 VPWR VGND sg13cmos5l_fill_1
XANTENNA__2974__X EE4BEG[15] VPWR VGND sg13cmos5l_antennanp
X_1532_ _1533_/B _2409_/Q _2408_/Q _2438_/Q _2472_/Q _1528_/Y _1531_/B VPWR VGND sg13cmos5l_mux4_1
X_1601_ _1601_/Y _2312_/Q _1601_/B VPWR VGND sg13cmos5l_nand2b_1
X_2650_ _2650_/Q FrameData[3] FrameStrobe[8] VPWR VGND sg13cmos5l_dlhq_1
X_2581_ _2581_/Q FrameData[30] FrameStrobe[11] VPWR VGND sg13cmos5l_dlhq_1
XANTENNA__3045__X S2BEGb[6] VPWR VGND sg13cmos5l_antennanp
X_1394_ _1394_/Y _2686_/Q _1957_/Y _1393_/Y VPWR VGND sg13cmos5l_a21oi_1
X_1463_ _1463_/X _2031_/B _1957_/Y _1784_/X _1283_/Y _2658_/Q _2654_/Q VPWR VGND sg13cmos5l_mux4_1
X_3133_ W1BEG[1] _3133_/A VPWR VGND sg13cmos5l_buf_1
X_3064_ FrameData_O[1] FrameData[1] VPWR VGND sg13cmos5l_buf_1
X_2015_ _2015_/X _1896_/X _1740_/B _1802_/X _1981_/Y _2786_/Q _2721_/Q VPWR VGND sg13cmos5l_mux4_1
X_2848_ _2848_/Q FrameData[13] FrameStrobe[2] VPWR VGND sg13cmos5l_dlhq_1
X_2917_ _2917_/Q FrameData[23] FrameStrobe[0] VPWR VGND sg13cmos5l_dlhq_1
X_2779_ _2779_/Q FrameData[4] FrameStrobe[4] VPWR VGND sg13cmos5l_dlhq_1
XANTENNA__2969__X EE4BEG[10] VPWR VGND sg13cmos5l_antennanp
XFILLER_32_211 VPWR VGND sg13cmos5l_fill_1
XFILLER_32_288 VPWR VGND sg13cmos5l_fill_1
X_2702_ _2702_/Q FrameData[23] FrameStrobe[7] VPWR VGND sg13cmos5l_dlhq_1
X_1515_ _1516_/D _1515_/A _1515_/B _1515_/C _1515_/D VPWR VGND sg13cmos5l_or4_1
X_2633_ _2633_/Q FrameData[18] FrameStrobe[9] VPWR VGND sg13cmos5l_dlhq_1
X_2564_ _2564_/Q FrameData[13] FrameStrobe[11] VPWR VGND sg13cmos5l_dlhq_1
X_2495_ _2495_/Q FrameData[8] FrameStrobe[13] VPWR VGND sg13cmos5l_dlhq_1
X_1377_ _1377_/X N2MID[7] E2MID[7] S2MID[7] W2MID[7] _2562_/Q _2593_/Q VPWR VGND sg13cmos5l_mux4_1
X_1446_ _1446_/X _1129_/Y _1130_/Y _1131_/Y _1445_/A _2466_/Q _2465_/Q VPWR VGND sg13cmos5l_mux4_1
X_3116_ SS4BEG[1] SS4END[5] VPWR VGND sg13cmos5l_buf_1
XFILLER_11_428 VPWR VGND sg13cmos5l_fill_1
XFILLER_23_14 VPWR VGND sg13cmos5l_fill_2
XFILLER_23_277 VPWR VGND sg13cmos5l_fill_2
X_3047_ S4BEG[0] S4END[4] VPWR VGND sg13cmos5l_buf_1
XFILLER_48_22 VPWR VGND sg13cmos5l_fill_1
XFILLER_9_38 VPWR VGND sg13cmos5l_fill_1
X_1162_ _1162_/Y _2690_/Q _1161_/Y _2726_/Q VPWR VGND sg13cmos5l_o21ai_1
X_1231_ _1231_/Y _2797_/Q _1740_/B VPWR VGND sg13cmos5l_nor2_1
X_1300_ _3138_/A _2595_/Q _1288_/Y _1299_/Y VPWR VGND sg13cmos5l_a21oi_1
X_2280_ _2295_/D _1119_/Y _2279_/B _2279_/Y VPWR VGND sg13cmos5l_a21oi_1
X_2616_ _2616_/Q FrameData[1] FrameStrobe[9] VPWR VGND sg13cmos5l_dlhq_1
X_1995_ _1995_/X _1740_/B _1981_/Y _2762_/Q VPWR VGND sg13cmos5l_mux2_1
X_1429_ _1429_/X NN4END[0] E2END[2] _2713_/Q VPWR VGND sg13cmos5l_mux2_1
X_2547_ _2547_/Q FrameData[28] FrameStrobe[12] VPWR VGND sg13cmos5l_dlhq_1
X_2478_ _2478_/Q FrameData[23] FrameStrobe[14] VPWR VGND sg13cmos5l_dlhq_1
XFILLER_34_57 VPWR VGND sg13cmos5l_fill_2
XFILLER_3_435 VPWR VGND sg13cmos5l_fill_1
XANTENNA__3143__X W2BEG[7] VPWR VGND sg13cmos5l_antennanp
XANTENNA__2982__X N2BEG[3] VPWR VGND sg13cmos5l_antennanp
X_1780_ _1781_/C _1780_/A _1780_/B _1780_/C VPWR VGND sg13cmos5l_nand3_1
X_2401_ _2401_/Q FrameData[10] FrameStrobe[16] VPWR VGND sg13cmos5l_dlhq_1
X_2332_ _2332_/Q FrameData[5] FrameStrobe[18] VPWR VGND sg13cmos5l_dlhq_1
XANTENNA__3053__X S4BEG[6] VPWR VGND sg13cmos5l_antennanp
XFILLER_18_380 VPWR VGND sg13cmos5l_fill_1
XFILLER_37_133 VPWR VGND sg13cmos5l_fill_1
X_1145_ _1145_/Y _2901_/Q VPWR VGND sg13cmos5l_inv_1
X_1214_ _1214_/Y _2859_/Q _1214_/B VPWR VGND sg13cmos5l_nand2b_1
X_2263_ _2300_/D _2300_/Q _2262_/X _2263_/S VPWR VGND sg13cmos5l_mux2_1
X_2194_ _2971_/A _2190_/Y _2193_/Y _2188_/Y VPWR VGND sg13cmos5l_a21oi_1
X_1978_ _1979_/C _1976_/Y _1977_/Y _1975_/A VPWR VGND sg13cmos5l_a21o_1
XFILLER_24_350 VPWR VGND sg13cmos5l_fill_2
XANTENNA__3138__X W2BEG[2] VPWR VGND sg13cmos5l_antennanp
XANTENNA__2977__X N1BEG[2] VPWR VGND sg13cmos5l_antennanp
XFILLER_10_92 VPWR VGND sg13cmos5l_fill_1
XFILLER_3_243 VPWR VGND sg13cmos5l_fill_1
XFILLER_34_136 VPWR VGND sg13cmos5l_fill_1
XFILLER_34_169 VPWR VGND sg13cmos5l_fill_1
X_2881_ _2881_/Q FrameData[18] FrameStrobe[1] VPWR VGND sg13cmos5l_dlhq_1
X_2950_ E6BEG[3] E6END[5] VPWR VGND sg13cmos5l_buf_1
X_1901_ _1962_/A _1899_/X _1900_/X _1898_/X _1897_/X _2583_/Q _2555_/Q VPWR VGND sg13cmos5l_mux4_1
X_1832_ _1832_/Y _1870_/S _2336_/Q VPWR VGND sg13cmos5l_nand2b_1
XANTENNA__3048__X S4BEG[1] VPWR VGND sg13cmos5l_antennanp
X_1763_ _1782_/A _1735_/X _2240_/B _1762_/X _1761_/Y _2460_/Q _2490_/Q VPWR VGND sg13cmos5l_mux4_1
X_1694_ _1694_/X _1740_/B _2031_/B _1694_/S VPWR VGND sg13cmos5l_mux2_1
XFILLER_32_0 VPWR VGND sg13cmos5l_fill_1
X_2315_ _2315_/Q FrameData[14] FrameStrobe[19] VPWR VGND sg13cmos5l_dlhq_1
X_2246_ _2246_/Y _2486_/Q _2246_/B VPWR VGND sg13cmos5l_nor2_1
XFILLER_53_434 VPWR VGND sg13cmos5l_fill_2
X_1128_ _1128_/Y W2END[7] VPWR VGND sg13cmos5l_inv_1
X_2177_ _2177_/Y _1484_/X _2665_/Q VPWR VGND sg13cmos5l_nand2b_1
XFILLER_0_224 VPWR VGND sg13cmos5l_fill_1
XFILLER_44_434 VPWR VGND sg13cmos5l_fill_2
X_3080_ FrameData_O[17] FrameData[17] VPWR VGND sg13cmos5l_buf_1
X_2100_ _2101_/B _1740_/B _1905_/X _2578_/Q VPWR VGND sg13cmos5l_mux2_1
X_2031_ _2031_/Y _2783_/Q _2031_/B VPWR VGND sg13cmos5l_nor2_1
X_2864_ _2864_/Q FrameData[30] FrameStrobe[2] VPWR VGND sg13cmos5l_dlhq_1
X_2933_ E2BEG[2] _2933_/A VPWR VGND sg13cmos5l_buf_1
X_2795_ _2795_/Q FrameData[20] FrameStrobe[4] VPWR VGND sg13cmos5l_dlhq_1
X_1815_ _1815_/Y _2756_/Q _1815_/B VPWR VGND sg13cmos5l_nand2_1
XFILLER_7_60 VPWR VGND sg13cmos5l_fill_1
X_1746_ _1746_/Y N2END[4] _2879_/Q _1745_/Y VPWR VGND sg13cmos5l_o21ai_1
X_1677_ _1677_/Y _2902_/Q _1673_/X _1676_/Y VPWR VGND sg13cmos5l_a21oi_1
X_2229_ _3010_/A N2END[1] W6END[0] N4END[0] _1957_/Y _2803_/Q _2837_/Q VPWR VGND sg13cmos5l_mux4_1
XFILLER_21_150 VPWR VGND sg13cmos5l_fill_1
XANTENNA__2990__X N2BEGb[3] VPWR VGND sg13cmos5l_antennanp
XANTENNA__3151__X W2BEGb[7] VPWR VGND sg13cmos5l_antennanp
XFILLER_29_272 VPWR VGND sg13cmos5l_decap_4
XFILLER_44_231 VPWR VGND sg13cmos5l_fill_2
X_1462_ _1462_/Y _2688_/Q _1462_/B VPWR VGND sg13cmos5l_nand2b_1
X_1531_ _1785_/A _1531_/A _1531_/B VPWR VGND sg13cmos5l_nor2_1
X_1600_ _1601_/B N1END[0] NN4END[0] S1END[0] S1END[2] _2313_/Q _2905_/Q VPWR VGND
+ sg13cmos5l_mux4_1
X_2580_ _2580_/Q FrameData[29] FrameStrobe[11] VPWR VGND sg13cmos5l_dlhq_1
XANTENNA__3061__X S4BEG[14] VPWR VGND sg13cmos5l_antennanp
X_1393_ _1393_/Y _2686_/Q _2031_/B VPWR VGND sg13cmos5l_nor2b_1
X_3063_ FrameData_O[0] FrameData[0] VPWR VGND sg13cmos5l_buf_1
X_3132_ W1BEG[0] _3132_/A VPWR VGND sg13cmos5l_buf_1
X_2014_ _3031_/A _2790_/Q _2005_/Y _2007_/Y _2013_/Y VPWR VGND sg13cmos5l_a22oi_1
X_2847_ _2847_/Q FrameData[12] FrameStrobe[2] VPWR VGND sg13cmos5l_dlhq_1
X_2916_ _2916_/Q FrameData[22] FrameStrobe[0] VPWR VGND sg13cmos5l_dlhq_1
X_2778_ _2778_/Q FrameData[3] FrameStrobe[4] VPWR VGND sg13cmos5l_dlhq_1
X_1729_ _1729_/Y _1729_/A VPWR VGND sg13cmos5l_inv_1
XANTENNA__3146__X W2BEGb[2] VPWR VGND sg13cmos5l_antennanp
XANTENNA__2985__X N2BEG[6] VPWR VGND sg13cmos5l_antennanp
X_2701_ _2701_/Q FrameData[22] FrameStrobe[7] VPWR VGND sg13cmos5l_dlhq_1
X_2632_ _2632_/Q FrameData[17] FrameStrobe[9] VPWR VGND sg13cmos5l_dlhq_1
XANTENNA__3056__X S4BEG[9] VPWR VGND sg13cmos5l_antennanp
XFILLER_4_190 VPWR VGND sg13cmos5l_fill_2
X_1445_ _2934_/A _1445_/A VPWR VGND sg13cmos5l_inv_1
X_1514_ _1515_/D _2371_/Q _1513_/B VPWR VGND sg13cmos5l_nor2b_1
X_2563_ _2563_/Q FrameData[12] FrameStrobe[11] VPWR VGND sg13cmos5l_dlhq_1
X_2494_ _2494_/Q FrameData[7] FrameStrobe[13] VPWR VGND sg13cmos5l_dlhq_1
X_1376_ _1376_/X E2MID[6] S2MID[6] W2MID[6] _2983_/A _2524_/Q _2777_/Q VPWR VGND sg13cmos5l_mux4_1
X_3046_ S2BEGb[7] S2MID[7] VPWR VGND sg13cmos5l_buf_1
X_3115_ SS4BEG[0] SS4END[4] VPWR VGND sg13cmos5l_buf_1
XFILLER_37_337 VPWR VGND sg13cmos5l_fill_1
X_1161_ _1161_/Y E1END[3] _1149_/Y _1160_/X VPWR VGND sg13cmos5l_a21oi_1
X_1230_ _3140_/A _1228_/Y _1229_/Y _1222_/Y VPWR VGND sg13cmos5l_o21ai_1
X_1994_ _2000_/B _2827_/Q _1994_/B _1994_/C VPWR VGND sg13cmos5l_nand3_1
X_2615_ _2615_/Q FrameData[0] FrameStrobe[9] VPWR VGND sg13cmos5l_dlhq_1
XFILLER_18_26 VPWR VGND sg13cmos5l_fill_2
X_1428_ _1428_/Y _2745_/Q _1428_/B _1428_/C VPWR VGND sg13cmos5l_nand3_1
X_2546_ _2546_/Q FrameData[27] FrameStrobe[12] VPWR VGND sg13cmos5l_dlhq_1
X_2477_ _2477_/Q FrameData[22] FrameStrobe[14] VPWR VGND sg13cmos5l_dlhq_1
XFILLER_28_337 VPWR VGND sg13cmos5l_fill_2
X_1359_ _1359_/Y N1END[1] _1136_/Y _2723_/Q VPWR VGND sg13cmos5l_a21oi_1
X_3029_ S1BEG[2] _3029_/A VPWR VGND sg13cmos5l_buf_1
XFILLER_50_35 VPWR VGND sg13cmos5l_fill_1
XFILLER_46_145 VPWR VGND sg13cmos5l_fill_1
XFILLER_6_230 VPWR VGND sg13cmos5l_fill_2
X_2400_ _2400_/Q FrameData[9] FrameStrobe[16] VPWR VGND sg13cmos5l_dlhq_1
X_1213_ _1214_/B N1END[1] N2END[5] _2316_/Q VPWR VGND sg13cmos5l_mux2_1
X_2331_ _2331_/Q FrameData[4] FrameStrobe[18] VPWR VGND sg13cmos5l_dlhq_1
X_2262_ _2262_/X _2386_/Q _1801_/X _2262_/S VPWR VGND sg13cmos5l_mux2_1
X_1144_ _1184_/S _2884_/Q VPWR VGND sg13cmos5l_inv_1
X_2193_ _2193_/Y _2478_/Q _2193_/B VPWR VGND sg13cmos5l_nor2_1
X_1977_ _1977_/Y _2602_/Q _1907_/Y _1916_/B _2697_/Q VPWR VGND sg13cmos5l_a22oi_1
X_2529_ _2529_/Q FrameData[10] FrameStrobe[12] VPWR VGND sg13cmos5l_dlhq_1
XFILLER_28_156 VPWR VGND sg13cmos5l_fill_1
XANTENNA__3154__X W6BEG[2] VPWR VGND sg13cmos5l_antennanp
XANTENNA__2993__X N2BEGb[6] VPWR VGND sg13cmos5l_antennanp
X_2880_ _2880_/Q FrameData[17] FrameStrobe[1] VPWR VGND sg13cmos5l_dlhq_1
X_1900_ _1900_/X N2MID[5] E2MID[5] S2MID[5] W2MID[5] _2628_/Q _2681_/Q VPWR VGND sg13cmos5l_mux4_1
X_1831_ _1831_/Y _2330_/Q _1870_/S _1830_/Y VPWR VGND sg13cmos5l_a21oi_1
X_1762_ _1762_/X NN4END[2] S2END[1] E2END[1] W2END[1] _2751_/Q _2752_/Q VPWR VGND
+ sg13cmos5l_mux4_1
X_1693_ _1694_/S _2799_/Q _1695_/S _1692_/Y VPWR VGND sg13cmos5l_o21ai_1
XANTENNA__3064__X FrameData_O[1] VPWR VGND sg13cmos5l_antennanp
XFILLER_25_0 VPWR VGND sg13cmos5l_fill_2
X_2314_ _2314_/Q FrameData[13] FrameStrobe[19] VPWR VGND sg13cmos5l_dlhq_1
X_2245_ _2245_/Y _2933_/A _2516_/Q VPWR VGND sg13cmos5l_nand2b_1
X_2176_ _2182_/A _2638_/Q _2176_/B VPWR VGND sg13cmos5l_nor2_1
X_1127_ _1127_/Y _2565_/Q VPWR VGND sg13cmos5l_inv_1
XANTENNA__3149__X W2BEGb[5] VPWR VGND sg13cmos5l_antennanp
XANTENNA__2988__X N2BEGb[1] VPWR VGND sg13cmos5l_antennanp
XFILLER_39_207 VPWR VGND sg13cmos5l_fill_2
X_2030_ _2030_/Y _2783_/Q _1784_/X _2029_/Y VPWR VGND sg13cmos5l_o21ai_1
X_2932_ E2BEG[1] _2932_/A VPWR VGND sg13cmos5l_buf_1
XANTENNA__3059__X S4BEG[12] VPWR VGND sg13cmos5l_antennanp
X_2863_ _2863_/Q FrameData[28] FrameStrobe[2] VPWR VGND sg13cmos5l_dlhq_1
X_2794_ _2794_/Q FrameData[19] FrameStrobe[4] VPWR VGND sg13cmos5l_dlhq_1
X_1814_ _1815_/B _2747_/Q _1812_/Y _1813_/Y VPWR VGND sg13cmos5l_o21ai_1
X_1745_ _1745_/Y S4END[0] _2879_/Q VPWR VGND sg13cmos5l_nand2b_1
X_1676_ _1676_/Y _2902_/Q _1675_/Y _2849_/Q VPWR VGND sg13cmos5l_o21ai_1
XFILLER_53_210 VPWR VGND sg13cmos5l_fill_2
X_2228_ _3023_/A _2227_/X _2226_/X _2700_/Q VPWR VGND sg13cmos5l_mux2_1
X_2159_ _2159_/Y _2576_/Q _2159_/B VPWR VGND sg13cmos5l_nor2_1
XFILLER_53_287 VPWR VGND sg13cmos5l_fill_1
XFILLER_17_435 VPWR VGND sg13cmos5l_fill_1
X_1392_ _1392_/X _1784_/X _1697_/X _2686_/Q VPWR VGND sg13cmos5l_mux2_1
X_1461_ _1462_/B _2060_/B _1740_/B _1802_/X _1981_/Y _2654_/Q _2658_/Q VPWR VGND sg13cmos5l_mux4_1
X_1530_ _1531_/B _1346_/X _1347_/X _1345_/A _1343_/X _2424_/Q _2423_/Q VPWR VGND sg13cmos5l_mux4_1
X_3062_ S4BEG[15] _3062_/A VPWR VGND sg13cmos5l_buf_1
X_3131_ UserCLKo _3131_/A VPWR VGND sg13cmos5l_buf_1
X_2013_ _2013_/Y _2790_/Q _2013_/B VPWR VGND sg13cmos5l_nor2_1
X_2915_ _2915_/Q FrameData[21] FrameStrobe[0] VPWR VGND sg13cmos5l_dlhq_1
X_2846_ _2846_/Q FrameData[11] FrameStrobe[2] VPWR VGND sg13cmos5l_dlhq_1
X_2777_ _2777_/Q FrameData[2] FrameStrobe[4] VPWR VGND sg13cmos5l_dlhq_1
X_1728_ _1729_/A N2END[5] E2END[5] SS4END[1] W2END[5] _2816_/Q _2842_/Q VPWR VGND
+ sg13cmos5l_mux4_1
X_1659_ _1659_/Y _2310_/Q _1656_/Y _2309_/Q VPWR VGND sg13cmos5l_o21ai_1
XFILLER_26_221 VPWR VGND sg13cmos5l_fill_1
XFILLER_26_243 VPWR VGND sg13cmos5l_fill_1
XANTENNA__3162__X W6BEG[10] VPWR VGND sg13cmos5l_antennanp
XFILLER_17_243 VPWR VGND sg13cmos5l_fill_1
XFILLER_32_257 VPWR VGND sg13cmos5l_fill_1
X_2700_ _2700_/Q FrameData[21] FrameStrobe[7] VPWR VGND sg13cmos5l_dlhq_1
X_2631_ _2631_/Q FrameData[16] FrameStrobe[9] VPWR VGND sg13cmos5l_dlhq_1
X_2562_ _2562_/Q FrameData[11] FrameStrobe[11] VPWR VGND sg13cmos5l_dlhq_1
XANTENNA__3072__X FrameData_O[9] VPWR VGND sg13cmos5l_antennanp
X_1375_ _1375_/Y _1515_/A _1515_/B VPWR VGND sg13cmos5l_nand2b_1
X_1444_ _1445_/A _1435_/Y _1438_/Y _1443_/Y VPWR VGND sg13cmos5l_o21ai_1
X_1513_ _1515_/C _2339_/Q _1513_/B VPWR VGND sg13cmos5l_nor2_1
X_2493_ _2493_/Q FrameData[6] FrameStrobe[13] VPWR VGND sg13cmos5l_dlhq_1
X_3045_ S2BEGb[6] S2MID[6] VPWR VGND sg13cmos5l_buf_1
X_3114_ FrameStrobe_O[19] FrameStrobe[19] VPWR VGND sg13cmos5l_buf_1
X_2829_ _2829_/Q FrameData[23] FrameStrobe[3] VPWR VGND sg13cmos5l_dlhq_1
XANTENNA__3157__X W6BEG[5] VPWR VGND sg13cmos5l_antennanp
XANTENNA__2996__X N4BEG[1] VPWR VGND sg13cmos5l_antennanp
X_1160_ _1160_/X E2END[7] _2760_/Q VPWR VGND sg13cmos5l_and2_1
X_1993_ _1994_/C _2762_/Q _1649_/B _1992_/Y VPWR VGND sg13cmos5l_a21o_1
XANTENNA__3067__X FrameData_O[4] VPWR VGND sg13cmos5l_antennanp
X_2614_ _2614_/Q FrameData[31] FrameStrobe[10] VPWR VGND sg13cmos5l_dlhq_1
X_2545_ _2545_/Q FrameData[26] FrameStrobe[12] VPWR VGND sg13cmos5l_dlhq_1
X_1358_ _1358_/Y N2END[3] _2725_/Q VPWR VGND sg13cmos5l_nand2_1
X_1427_ _1428_/C W2END[2] _2713_/Q VPWR VGND sg13cmos5l_nand2_1
X_2476_ _2476_/Q FrameData[21] FrameStrobe[14] VPWR VGND sg13cmos5l_dlhq_1
X_1289_ _1289_/X EE4END[3] E6END[1] _2660_/Q VPWR VGND sg13cmos5l_mux2_1
X_3028_ S1BEG[1] _3028_/A VPWR VGND sg13cmos5l_buf_1
XFILLER_19_316 VPWR VGND sg13cmos5l_fill_1
XFILLER_34_5 VPWR VGND sg13cmos5l_fill_2
X_1212_ _1212_/X S1END[1] S1END[3] _2316_/Q VPWR VGND sg13cmos5l_mux2_1
X_2330_ _2330_/Q FrameData[3] FrameStrobe[18] VPWR VGND sg13cmos5l_dlhq_1
X_2261_ _2262_/S _2327_/Q _2291_/B VPWR VGND sg13cmos5l_nand2_1
X_2192_ _2193_/B _2539_/Q _1155_/Y _2191_/Y VPWR VGND sg13cmos5l_a21oi_1
XFILLER_52_127 VPWR VGND sg13cmos5l_fill_2
X_1143_ _1143_/Y _2354_/Q VPWR VGND sg13cmos5l_inv_1
X_1976_ _1976_/Y _2730_/Q _1961_/Y _1962_/Y _2601_/Q VPWR VGND sg13cmos5l_a22oi_1
XFILLER_0_407 VPWR VGND sg13cmos5l_fill_1
X_2528_ _2528_/Q FrameData[9] FrameStrobe[12] VPWR VGND sg13cmos5l_dlhq_1
X_2459_ _2459_/Q FrameData[4] FrameStrobe[14] VPWR VGND sg13cmos5l_dlhq_1
XANTENNA__3170__X WW4BEG[6] VPWR VGND sg13cmos5l_antennanp
X_1830_ _1830_/Y _1870_/S _2331_/Q VPWR VGND sg13cmos5l_nor2b_1
X_1761_ _1761_/Y _1761_/A VPWR VGND sg13cmos5l_inv_1
X_2313_ _2313_/Q FrameData[12] FrameStrobe[19] VPWR VGND sg13cmos5l_dlhq_1
X_1692_ _1692_/Y _2799_/Q _1692_/B VPWR VGND sg13cmos5l_nand2_1
XANTENNA__3080__X FrameData_O[17] VPWR VGND sg13cmos5l_antennanp
XFILLER_18_0 VPWR VGND sg13cmos5l_fill_1
XFILLER_38_411 VPWR VGND sg13cmos5l_fill_2
X_1126_ _1126_/Y _2654_/Q VPWR VGND sg13cmos5l_inv_1
X_2244_ _2246_/B _2516_/Q _2981_/A VPWR VGND sg13cmos5l_nor2_1
X_2175_ _2176_/B N1END[3] E1END[3] S1END[3] _2060_/B _2665_/Q _2664_/Q VPWR VGND sg13cmos5l_mux4_1
X_1959_ _1959_/X _1912_/X _1913_/X _2183_/B _1914_/X _2488_/Q _2519_/Q VPWR VGND sg13cmos5l_mux4_1
XFILLER_0_237 VPWR VGND sg13cmos5l_fill_1
XFILLER_8_359 VPWR VGND sg13cmos5l_fill_1
XANTENNA__3165__X WW4BEG[1] VPWR VGND sg13cmos5l_antennanp
X_2931_ E2BEG[0] _2931_/A VPWR VGND sg13cmos5l_buf_1
XFILLER_30_141 VPWR VGND sg13cmos5l_fill_2
X_2862_ _2862_/Q FrameData[27] FrameStrobe[2] VPWR VGND sg13cmos5l_dlhq_1
X_2793_ _2793_/Q FrameData[18] FrameStrobe[4] VPWR VGND sg13cmos5l_dlhq_1
X_1813_ _1813_/Y _2747_/Q _1810_/X _2782_/Q VPWR VGND sg13cmos5l_a21oi_1
X_1744_ _1744_/Y _1139_/Y _1737_/X _1743_/Y VPWR VGND sg13cmos5l_a21oi_1
XANTENNA__3075__X FrameData_O[12] VPWR VGND sg13cmos5l_antennanp
X_1675_ _1675_/Y _2871_/Q _1957_/Y _1674_/Y VPWR VGND sg13cmos5l_a21oi_1
X_1109_ _1109_/Y _2913_/Q VPWR VGND sg13cmos5l_inv_1
X_2227_ _2227_/X N1END[2] W1END[2] E1END[2] _1802_/X _2701_/Q _2731_/Q VPWR VGND sg13cmos5l_mux4_1
X_2158_ _2159_/B N1END[1] S1END[1] E1END[1] _2031_/B _2609_/Q _2604_/Q VPWR VGND sg13cmos5l_mux4_1
X_2089_ _2089_/X N1END[2] S1END[2] W1END[2] _1802_/X _2326_/Q _2916_/Q VPWR VGND sg13cmos5l_mux4_1
XFILLER_29_263 VPWR VGND sg13cmos5l_fill_1
XANTENNA__2999__X N4BEG[4] VPWR VGND sg13cmos5l_antennanp
XFILLER_8_145 VPWR VGND sg13cmos5l_fill_2
X_1391_ _1391_/X _2060_/B _1896_/X _1802_/X _1981_/Y _2755_/Q _2686_/Q VPWR VGND sg13cmos5l_mux4_1
X_1460_ _1460_/Y _1460_/A _1460_/B VPWR VGND sg13cmos5l_nor2_1
X_3130_ SS4BEG[15] _3130_/A VPWR VGND sg13cmos5l_buf_1
X_3061_ S4BEG[14] _3061_/A VPWR VGND sg13cmos5l_buf_1
X_2012_ _2013_/B _2792_/Q _2009_/Y _2011_/Y VPWR VGND sg13cmos5l_a21oi_1
XFILLER_50_236 VPWR VGND sg13cmos5l_fill_1
X_2845_ _2845_/Q FrameData[10] FrameStrobe[2] VPWR VGND sg13cmos5l_dlhq_1
X_2914_ _2914_/Q FrameData[20] FrameStrobe[0] VPWR VGND sg13cmos5l_dlhq_1
X_2776_ _2776_/Q FrameData[1] FrameStrobe[4] VPWR VGND sg13cmos5l_dlhq_1
X_1727_ _1727_/X N4END[1] SS4END[1] W2END[4] _3034_/A _2677_/Q _2646_/Q VPWR VGND
+ sg13cmos5l_mux4_1
X_1658_ _1658_/Y E2END[6] _2901_/Q _1657_/Y VPWR VGND sg13cmos5l_o21ai_1
X_1589_ _1589_/X _2875_/Q _1585_/X _1588_/Y VPWR VGND sg13cmos5l_a21o_1
XFILLER_9_410 VPWR VGND sg13cmos5l_fill_1
X_1512_ _1516_/C _2343_/Q _1513_/B _1511_/Y VPWR VGND sg13cmos5l_o21ai_1
X_2630_ _2630_/Q FrameData[15] FrameStrobe[9] VPWR VGND sg13cmos5l_dlhq_1
X_2561_ _2561_/Q FrameData[10] FrameStrobe[11] VPWR VGND sg13cmos5l_dlhq_1
X_2492_ _2492_/Q FrameData[5] FrameStrobe[13] VPWR VGND sg13cmos5l_dlhq_1
XFILLER_4_41 VPWR VGND sg13cmos5l_fill_2
X_1374_ _1515_/B _2451_/Q _1371_/X _1372_/X _1373_/Y VPWR VGND sg13cmos5l_a22oi_1
X_1443_ _1443_/Y _1443_/A _1443_/B VPWR VGND sg13cmos5l_nand2_1
X_3113_ FrameStrobe_O[18] FrameStrobe[18] VPWR VGND sg13cmos5l_buf_1
X_3044_ S2BEGb[5] S2MID[5] VPWR VGND sg13cmos5l_buf_1
X_2828_ _2828_/Q FrameData[22] FrameStrobe[3] VPWR VGND sg13cmos5l_dlhq_1
X_2759_ _2759_/Q FrameData[16] FrameStrobe[5] VPWR VGND sg13cmos5l_dlhq_1
XFILLER_10_431 VPWR VGND sg13cmos5l_fill_1
XFILLER_13_94 VPWR VGND sg13cmos5l_fill_1
XFILLER_22_280 VPWR VGND sg13cmos5l_fill_2
XFILLER_6_435 VPWR VGND sg13cmos5l_fill_1
XANTENNA__3173__X WW4BEG[9] VPWR VGND sg13cmos5l_antennanp
X_1992_ _1992_/Y _2762_/Q _1784_/X _2828_/Q VPWR VGND sg13cmos5l_o21ai_1
XANTENNA__3083__X FrameData_O[20] VPWR VGND sg13cmos5l_antennanp
XFILLER_48_0 VPWR VGND sg13cmos5l_fill_2
X_2613_ _2613_/Q FrameData[30] FrameStrobe[10] VPWR VGND sg13cmos5l_dlhq_1
X_2544_ _2544_/Q FrameData[25] FrameStrobe[12] VPWR VGND sg13cmos5l_dlhq_1
X_2475_ _2475_/Q FrameData[20] FrameStrobe[14] VPWR VGND sg13cmos5l_dlhq_1
X_1288_ _1288_/Y _2695_/Q _1287_/X _1286_/Y VPWR VGND sg13cmos5l_o21ai_1
X_1357_ _1357_/Y E6END[1] _1136_/Y _1356_/X VPWR VGND sg13cmos5l_a21oi_1
X_1426_ _1428_/B _2713_/Q S2END[2] VPWR VGND sg13cmos5l_nand2b_1
X_3027_ S1BEG[0] _3027_/A VPWR VGND sg13cmos5l_buf_1
XFILLER_3_427 VPWR VGND sg13cmos5l_fill_1
XANTENNA__3168__X WW4BEG[4] VPWR VGND sg13cmos5l_antennanp
XFILLER_10_261 VPWR VGND sg13cmos5l_fill_1
X_1142_ _1142_/Y _2355_/Q VPWR VGND sg13cmos5l_inv_1
X_1211_ _1211_/X _2985_/A _3037_/A _2937_/A _3142_/A _2647_/Q _2616_/Q VPWR VGND sg13cmos5l_mux4_1
X_2260_ _2263_/S _2277_/A _2361_/Q VPWR VGND sg13cmos5l_nand2b_1
X_2191_ _2191_/Y E1END[2] _2539_/Q _2507_/Q VPWR VGND sg13cmos5l_o21ai_1
XANTENNA__3078__X FrameData_O[15] VPWR VGND sg13cmos5l_antennanp
X_1975_ _1979_/B _1975_/A _1975_/B VPWR VGND sg13cmos5l_nand2_1
X_1409_ _1409_/X _2060_/B _1740_/B _1802_/X _1981_/Y _2785_/Q _2691_/Q VPWR VGND sg13cmos5l_mux4_1
X_2527_ _2527_/Q FrameData[8] FrameStrobe[12] VPWR VGND sg13cmos5l_dlhq_1
X_2458_ _2458_/Q FrameData[3] FrameStrobe[14] VPWR VGND sg13cmos5l_dlhq_1
X_2389_ _2389_/Q FrameData[30] FrameStrobe[17] VPWR VGND sg13cmos5l_dlhq_1
XFILLER_3_213 VPWR VGND sg13cmos5l_fill_1
XFILLER_47_423 VPWR VGND sg13cmos5l_fill_1
XFILLER_15_342 VPWR VGND sg13cmos5l_fill_1
XFILLER_15_353 VPWR VGND sg13cmos5l_fill_1
X_1760_ _1761_/A _2614_/Q _1757_/X _1759_/X VPWR VGND sg13cmos5l_o21ai_1
X_1691_ _1691_/X _1689_/Y _1690_/X _2799_/Q VPWR VGND sg13cmos5l_mux2_1
X_2312_ _2312_/Q FrameData[11] FrameStrobe[19] VPWR VGND sg13cmos5l_dlhq_1
X_1125_ _1125_/Y _2548_/Q VPWR VGND sg13cmos5l_inv_1
X_2243_ _2243_/X _3138_/A _3033_/A _2243_/S VPWR VGND sg13cmos5l_mux2_1
X_2174_ _2973_/A _2174_/A _2174_/B VPWR VGND sg13cmos5l_nor2_1
XFILLER_21_301 VPWR VGND sg13cmos5l_fill_1
X_1958_ _1958_/Y _2532_/Q _1958_/B _1958_/C VPWR VGND sg13cmos5l_nand3_1
X_1889_ _1889_/Y _2499_/Q _1488_/Y _1883_/B _2369_/Q VPWR VGND sg13cmos5l_a22oi_1
XANTENNA_90 W2MID[3] VPWR VGND sg13cmos5l_antennanp
XFILLER_47_253 VPWR VGND sg13cmos5l_fill_2
X_2861_ _2861_/Q FrameData[26] FrameStrobe[2] VPWR VGND sg13cmos5l_dlhq_1
X_2930_ E1BEG[3] _2930_/A VPWR VGND sg13cmos5l_buf_1
XFILLER_7_41 VPWR VGND sg13cmos5l_fill_2
X_2792_ _2792_/Q FrameData[17] FrameStrobe[4] VPWR VGND sg13cmos5l_dlhq_1
X_1812_ _1812_/Y _2722_/Q _1802_/X _1811_/Y VPWR VGND sg13cmos5l_a21oi_1
X_1743_ _1743_/Y _2903_/Q _1739_/Y _1742_/Y VPWR VGND sg13cmos5l_a21oi_1
X_1674_ _1674_/Y _2871_/Q _1740_/B VPWR VGND sg13cmos5l_nor2b_1
XANTENNA__3091__X FrameData_O[28] VPWR VGND sg13cmos5l_antennanp
X_2226_ _2226_/X _1981_/Y _1351_/A _1448_/A _1903_/X _2701_/Q _2731_/Q VPWR VGND sg13cmos5l_mux4_1
XFILLER_26_404 VPWR VGND sg13cmos5l_fill_1
X_1108_ _1108_/Y _2914_/Q VPWR VGND sg13cmos5l_inv_1
X_2157_ _2957_/A _2154_/Y _2156_/Y _2149_/Y VPWR VGND sg13cmos5l_o21ai_1
X_2088_ _2088_/X _1981_/Y _1351_/A _1448_/A _1898_/X _2916_/Q _2326_/Q VPWR VGND sg13cmos5l_mux4_1
XANTENNA__3176__X WW4BEG[12] VPWR VGND sg13cmos5l_antennanp
XFILLER_12_164 VPWR VGND sg13cmos5l_fill_2
X_1390_ _1390_/Y _1385_/Y _1388_/Y _1389_/Y VPWR VGND sg13cmos5l_o21ai_1
X_3060_ S4BEG[13] _3060_/A VPWR VGND sg13cmos5l_buf_1
X_2011_ _2011_/Y _2792_/Q _2010_/X _2791_/Q VPWR VGND sg13cmos5l_o21ai_1
X_2844_ _2844_/Q FrameData[9] FrameStrobe[2] VPWR VGND sg13cmos5l_dlhq_1
X_2913_ _2913_/Q FrameData[19] FrameStrobe[0] VPWR VGND sg13cmos5l_dlhq_1
XANTENNA__3086__X FrameData_O[23] VPWR VGND sg13cmos5l_antennanp
X_1588_ _1588_/Y _2875_/Q _1587_/Y _2874_/Q VPWR VGND sg13cmos5l_o21ai_1
X_2775_ _2775_/Q FrameData[0] FrameStrobe[4] VPWR VGND sg13cmos5l_dlhq_1
X_1726_ _1778_/B _1725_/X _1705_/Y _2416_/Q VPWR VGND sg13cmos5l_mux2_1
X_1657_ _1657_/Y W1END[2] _2901_/Q VPWR VGND sg13cmos5l_nand2b_1
X_2209_ _2212_/A _2764_/Q _1370_/Y _2208_/Y VPWR VGND sg13cmos5l_a21oi_1
X_1442_ _1443_/B _2822_/Q _1441_/X _2820_/Q VPWR VGND sg13cmos5l_a21oi_1
X_1511_ _1511_/Y _1124_/Y _1513_/B _1503_/Y VPWR VGND sg13cmos5l_a21oi_1
X_2560_ _2560_/Q FrameData[9] FrameStrobe[11] VPWR VGND sg13cmos5l_dlhq_1
X_2491_ _2491_/Q FrameData[4] FrameStrobe[13] VPWR VGND sg13cmos5l_dlhq_1
X_1373_ _1373_/Y _2511_/Q _2185_/B _2451_/Q VPWR VGND sg13cmos5l_a21oi_1
X_3043_ S2BEGb[4] S2MID[4] VPWR VGND sg13cmos5l_buf_1
X_3112_ FrameStrobe_O[17] FrameStrobe[17] VPWR VGND sg13cmos5l_buf_1
XFILLER_23_259 VPWR VGND sg13cmos5l_fill_1
X_2827_ _2827_/Q FrameData[21] FrameStrobe[3] VPWR VGND sg13cmos5l_dlhq_1
X_2758_ _2758_/Q FrameData[15] FrameStrobe[5] VPWR VGND sg13cmos5l_dlhq_1
X_2689_ _2689_/Q FrameData[10] FrameStrobe[7] VPWR VGND sg13cmos5l_dlhq_1
X_1709_ _1709_/Y _2843_/Q _1709_/B VPWR VGND sg13cmos5l_nand2b_1
XFILLER_8_0 VPWR VGND sg13cmos5l_fill_2
XFILLER_38_70 VPWR VGND sg13cmos5l_fill_2
XFILLER_9_263 VPWR VGND sg13cmos5l_fill_2
XFILLER_9_285 VPWR VGND sg13cmos5l_fill_2
X_2612_ _2612_/Q FrameData[29] FrameStrobe[10] VPWR VGND sg13cmos5l_dlhq_1
X_1991_ _1994_/B _2762_/Q _2031_/B _1990_/Y VPWR VGND sg13cmos5l_o21ai_1
X_1425_ _1425_/X _1132_/Y _1128_/Y _1114_/Y _1424_/A _2596_/Q _2659_/Q VPWR VGND sg13cmos5l_mux4_1
X_2543_ _2543_/Q FrameData[24] FrameStrobe[12] VPWR VGND sg13cmos5l_dlhq_1
X_2474_ _2474_/Q FrameData[19] FrameStrobe[14] VPWR VGND sg13cmos5l_dlhq_1
X_1287_ _1287_/X _2060_/B _1896_/X _1802_/X _1981_/Y _2660_/Q _2633_/Q VPWR VGND sg13cmos5l_mux4_1
X_1356_ _1356_/X S2END[3] _2725_/Q VPWR VGND sg13cmos5l_and2_1
X_3026_ NN4BEG[15] _3026_/A VPWR VGND sg13cmos5l_buf_1
X_1141_ _1788_/A _2445_/Q VPWR VGND sg13cmos5l_inv_1
X_1210_ _3037_/A _1208_/Y _1209_/Y _1202_/Y VPWR VGND sg13cmos5l_o21ai_1
X_2190_ _2190_/Y N1END[2] _2539_/Q _2189_/Y VPWR VGND sg13cmos5l_o21ai_1
X_1974_ _1975_/B _1974_/A _1974_/B VPWR VGND sg13cmos5l_nand2_1
XANTENNA__3094__X FrameData_O[31] VPWR VGND sg13cmos5l_antennanp
X_1408_ _1408_/Y _2500_/Q _1408_/B _1408_/C VPWR VGND sg13cmos5l_nor3_1
X_2526_ _2526_/Q FrameData[7] FrameStrobe[12] VPWR VGND sg13cmos5l_dlhq_1
X_2457_ _2457_/Q FrameData[2] FrameStrobe[14] VPWR VGND sg13cmos5l_dlhq_1
X_2388_ _2388_/Q FrameData[29] FrameStrobe[17] VPWR VGND sg13cmos5l_dlhq_1
XFILLER_24_332 VPWR VGND sg13cmos5l_fill_1
X_1339_ _1339_/Y _2693_/Q _1338_/Y _2655_/Q VPWR VGND sg13cmos5l_o21ai_1
X_3009_ N4BEG[14] _3009_/A VPWR VGND sg13cmos5l_buf_1
XANTENNA__3179__X WW4BEG[15] VPWR VGND sg13cmos5l_antennanp
XFILLER_15_398 VPWR VGND sg13cmos5l_fill_2
X_1690_ _1690_/X _1689_/Y _1283_/Y _1690_/S VPWR VGND sg13cmos5l_mux2_1
XFILLER_32_4 VPWR VGND sg13cmos5l_fill_1
X_2311_ _2311_/Q FrameData[10] FrameStrobe[19] VPWR VGND sg13cmos5l_dlhq_1
X_2242_ _2242_/Y _2486_/Q _2241_/Y _2613_/Q VPWR VGND sg13cmos5l_a21oi_1
XFILLER_25_129 VPWR VGND sg13cmos5l_fill_1
XFILLER_38_435 VPWR VGND sg13cmos5l_fill_1
X_1124_ _1124_/Y _2344_/Q VPWR VGND sg13cmos5l_inv_1
X_2173_ _2174_/B _2573_/Q _2173_/B VPWR VGND sg13cmos5l_nor2_1
XANTENNA__3089__X FrameData_O[26] VPWR VGND sg13cmos5l_antennanp
X_1957_ _1957_/Y _2271_/A _2506_/Q _1956_/Y VPWR VGND sg13cmos5l_a21oi_1
X_2509_ _2509_/Q FrameData[22] FrameStrobe[13] VPWR VGND sg13cmos5l_dlhq_1
X_1888_ _1888_/Y _1884_/Y _1885_/Y _1886_/Y _1887_/Y _1878_/Y VPWR VGND sg13cmos5l_a221oi_1
XFILLER_29_435 VPWR VGND sg13cmos5l_fill_1
XANTENNA_80 W2MID[3] VPWR VGND sg13cmos5l_antennanp
XANTENNA_91 W2MID[3] VPWR VGND sg13cmos5l_antennanp
X_2860_ _2860_/Q FrameData[25] FrameStrobe[2] VPWR VGND sg13cmos5l_dlhq_1
X_2791_ _2791_/Q FrameData[16] FrameStrobe[4] VPWR VGND sg13cmos5l_dlhq_1
X_1811_ _1811_/Y _2722_/Q _2060_/B VPWR VGND sg13cmos5l_nor2b_1
X_1742_ _1742_/Y _2903_/Q _1741_/Y _2880_/Q VPWR VGND sg13cmos5l_o21ai_1
X_1673_ _1673_/X _2031_/B _1542_/X _2871_/Q VPWR VGND sg13cmos5l_mux2_1
X_2225_ _3024_/A _2225_/A _2225_/B VPWR VGND sg13cmos5l_nor2_1
X_1107_ _2037_/A _2813_/Q VPWR VGND sg13cmos5l_inv_1
X_2156_ _2156_/Y _2804_/Q _2155_/X _2770_/Q VPWR VGND sg13cmos5l_o21ai_1
X_2087_ _3177_/A _2087_/A _2087_/B VPWR VGND sg13cmos5l_nor2_1
X_2989_ N2BEGb[2] N2MID[2] VPWR VGND sg13cmos5l_buf_1
X_2010_ _2010_/X E2END[1] W2END[1] _2757_/Q VPWR VGND sg13cmos5l_mux2_1
XFILLER_50_205 VPWR VGND sg13cmos5l_fill_2
X_2912_ _2912_/Q FrameData[18] FrameStrobe[0] VPWR VGND sg13cmos5l_dlhq_1
X_2843_ _2843_/Q FrameData[8] FrameStrobe[2] VPWR VGND sg13cmos5l_dlhq_1
X_2774_ _2774_/Q FrameData[31] FrameStrobe[5] VPWR VGND sg13cmos5l_dlhq_1
X_1725_ _1725_/X _1723_/X _1724_/X _1722_/X _1721_/X _2491_/Q _2463_/Q VPWR VGND sg13cmos5l_mux4_1
X_1587_ _1587_/Y W1END[0] _2854_/Q _1586_/Y VPWR VGND sg13cmos5l_a21oi_1
X_1656_ _1656_/Y _1603_/A _2901_/Q _1655_/Y VPWR VGND sg13cmos5l_a21oi_1
X_2208_ _2208_/Y _2764_/Q _1700_/X _2800_/Q VPWR VGND sg13cmos5l_o21ai_1
X_2139_ _2139_/Y _2772_/Q _1155_/Y _2138_/Y VPWR VGND sg13cmos5l_a21oi_1
XFILLER_53_16 VPWR VGND sg13cmos5l_fill_2
XFILLER_9_434 VPWR VGND sg13cmos5l_fill_2
X_1441_ _1441_/X N4END[0] E2END[4] W2END[4] W6END[0] _2848_/Q _2821_/Q VPWR VGND sg13cmos5l_mux4_1
X_1510_ _1516_/B _1515_/B _1510_/B VPWR VGND sg13cmos5l_nand2_1
X_2490_ _2490_/Q FrameData[3] FrameStrobe[13] VPWR VGND sg13cmos5l_dlhq_1
X_1372_ _1372_/X _2511_/Q _1372_/B VPWR VGND sg13cmos5l_or2_1
X_3042_ S2BEGb[3] S2MID[3] VPWR VGND sg13cmos5l_buf_1
X_3111_ FrameStrobe_O[16] FrameStrobe[16] VPWR VGND sg13cmos5l_buf_1
XFILLER_23_205 VPWR VGND sg13cmos5l_fill_1
XANTENNA__3097__X FrameStrobe_O[2] VPWR VGND sg13cmos5l_antennanp
X_2826_ _2826_/Q FrameData[20] FrameStrobe[3] VPWR VGND sg13cmos5l_dlhq_1
X_2757_ _2757_/Q FrameData[14] FrameStrobe[5] VPWR VGND sg13cmos5l_dlhq_1
X_2688_ _2688_/Q FrameData[9] FrameStrobe[7] VPWR VGND sg13cmos5l_dlhq_1
X_1708_ _1709_/B E1END[2] E2END[4] _2898_/Q VPWR VGND sg13cmos5l_mux2_1
X_1639_ _1639_/Y _2855_/Q E2END[6] _1638_/Y VPWR VGND sg13cmos5l_o21ai_1
XFILLER_20_219 VPWR VGND sg13cmos5l_fill_1
X_1990_ _1990_/Y _2762_/Q _1156_/Y _2828_/Q VPWR VGND sg13cmos5l_a21oi_1
X_2611_ _2611_/Q FrameData[28] FrameStrobe[10] VPWR VGND sg13cmos5l_dlhq_1
X_2542_ _2542_/Q FrameData[23] FrameStrobe[12] VPWR VGND sg13cmos5l_dlhq_1
X_1355_ _1355_/Y _1355_/A VPWR VGND sg13cmos5l_inv_1
X_1424_ _2932_/A _1424_/A VPWR VGND sg13cmos5l_inv_1
X_2473_ _2473_/Q FrameData[18] FrameStrobe[14] VPWR VGND sg13cmos5l_dlhq_1
X_1286_ _1286_/Y _2695_/Q _1286_/B VPWR VGND sg13cmos5l_nand2_1
X_3025_ NN4BEG[14] _3025_/A VPWR VGND sg13cmos5l_buf_1
XFILLER_50_28 VPWR VGND sg13cmos5l_fill_2
X_2809_ _2809_/Q FrameData[3] FrameStrobe[3] VPWR VGND sg13cmos5l_dlhq_1
XFILLER_46_127 VPWR VGND sg13cmos5l_fill_1
XFILLER_42_311 VPWR VGND sg13cmos5l_fill_1
XFILLER_49_81 VPWR VGND sg13cmos5l_fill_1
X_1140_ _1544_/A _2307_/Q VPWR VGND sg13cmos5l_inv_1
X_1973_ _1974_/B _2569_/Q _1907_/Y _1962_/Y _2535_/Q VPWR VGND sg13cmos5l_a22oi_1
X_2525_ _2525_/Q FrameData[6] FrameStrobe[12] VPWR VGND sg13cmos5l_dlhq_1
X_1338_ _1338_/Y _2631_/Q _1957_/Y _1337_/Y VPWR VGND sg13cmos5l_a21oi_1
X_1407_ _1408_/C _2674_/Q _1403_/X _1406_/Y VPWR VGND sg13cmos5l_a21oi_1
X_2456_ _2456_/Q FrameData[1] FrameStrobe[14] VPWR VGND sg13cmos5l_dlhq_1
X_2387_ _2387_/Q FrameData[28] FrameStrobe[17] VPWR VGND sg13cmos5l_dlhq_1
X_1269_ _1269_/Y _2851_/Q _1266_/X _1153_/Y VPWR VGND sg13cmos5l_a21oi_1
X_3008_ N4BEG[13] _3008_/A VPWR VGND sg13cmos5l_buf_1
XFILLER_3_259 VPWR VGND sg13cmos5l_fill_1
XFILLER_27_171 VPWR VGND sg13cmos5l_fill_2
XFILLER_15_366 VPWR VGND sg13cmos5l_fill_2
XFILLER_15_388 VPWR VGND sg13cmos5l_fill_1
X_2310_ _2310_/Q FrameData[9] FrameStrobe[19] VPWR VGND sg13cmos5l_dlhq_1
X_2241_ _2241_/Y _2516_/Q _1317_/Y _2240_/Y VPWR VGND sg13cmos5l_o21ai_1
X_2172_ _2173_/B N1END[0] E1END[0] S1END[0] _1896_/X _2605_/Q _2637_/Q VPWR VGND sg13cmos5l_mux4_1
X_1123_ _1123_/Y _2876_/Q VPWR VGND sg13cmos5l_inv_1
X_1956_ _1956_/Y _1948_/Y _1955_/X _2506_/Q VPWR VGND sg13cmos5l_a21oi_1
X_1887_ _1887_/Y _2399_/Q _1487_/Y _1891_/B _2397_/Q _1880_/Y VPWR VGND sg13cmos5l_a221oi_1
X_2508_ _2508_/Q FrameData[21] FrameStrobe[13] VPWR VGND sg13cmos5l_dlhq_1
X_2439_ _2439_/Q FrameData[16] FrameStrobe[15] VPWR VGND sg13cmos5l_dlhq_1
XANTENNA_70 W1END[0] VPWR VGND sg13cmos5l_antennanp
XANTENNA_81 W2MID[3] VPWR VGND sg13cmos5l_antennanp
XANTENNA_92 W2MID[3] VPWR VGND sg13cmos5l_antennanp
X_2790_ _2790_/Q FrameData[15] FrameStrobe[4] VPWR VGND sg13cmos5l_dlhq_1
X_1810_ _1810_/X _1740_/B _1981_/Y _2722_/Q VPWR VGND sg13cmos5l_mux2_1
X_1741_ _1741_/Y _2879_/Q _1156_/Y _1740_/Y VPWR VGND sg13cmos5l_a21oi_1
X_1672_ _1672_/X _2060_/B _1896_/X _1784_/X _1981_/Y _2902_/Q _2871_/Q VPWR VGND sg13cmos5l_mux4_1
X_2224_ _2225_/B _2766_/Q _2222_/X _2223_/Y VPWR VGND sg13cmos5l_a21oi_1
X_2155_ _2155_/X _1981_/Y _1957_/Y _1448_/A _1351_/A _2772_/Q _2735_/Q VPWR VGND sg13cmos5l_mux4_1
Xclkbuf_1_0__f_UserCLK_regs _2300_/CLK clkbuf_0_UserCLK_regs/X VPWR VGND sg13cmos5l_buf_8
X_2086_ _2087_/B _2086_/A _2086_/B VPWR VGND sg13cmos5l_nor2_1
X_2988_ N2BEGb[1] N2MID[1] VPWR VGND sg13cmos5l_buf_1
X_1939_ _1939_/Y _2523_/Q _1939_/B VPWR VGND sg13cmos5l_nand2_1
XFILLER_17_428 VPWR VGND sg13cmos5l_fill_1
XFILLER_12_166 VPWR VGND sg13cmos5l_fill_1
XFILLER_8_126 VPWR VGND sg13cmos5l_fill_2
XFILLER_35_269 VPWR VGND sg13cmos5l_fill_1
X_2911_ _2911_/Q FrameData[17] FrameStrobe[0] VPWR VGND sg13cmos5l_dlhq_1
X_2842_ _2842_/Q FrameData[7] FrameStrobe[2] VPWR VGND sg13cmos5l_dlhq_1
X_2773_ _2773_/Q FrameData[30] FrameStrobe[5] VPWR VGND sg13cmos5l_dlhq_1
X_1724_ _1724_/X N2MID[7] E2MID[7] S2MID[7] W2MID[7] _2682_/Q _2564_/Q VPWR VGND sg13cmos5l_mux4_1
X_1586_ _1586_/Y _2854_/Q E1END[0] VPWR VGND sg13cmos5l_nor2b_1
X_1655_ _1655_/Y E1END[2] _2901_/Q VPWR VGND sg13cmos5l_nor2_1
XFILLER_37_29 VPWR VGND sg13cmos5l_fill_1
X_2207_ _3026_/A _2204_/Y _2206_/Y _2200_/Y VPWR VGND sg13cmos5l_a21oi_1
X_2138_ _2138_/Y _2772_/Q _1784_/X _2735_/Q VPWR VGND sg13cmos5l_o21ai_1
X_2069_ _3179_/A _2067_/X _2068_/X _2862_/Q VPWR VGND sg13cmos5l_mux2_1
XFILLER_34_291 VPWR VGND sg13cmos5l_fill_2
X_1371_ _1371_/X _1370_/A _1368_/X _2511_/Q VPWR VGND sg13cmos5l_mux2_1
X_1440_ _1443_/A _2822_/Q _1440_/B VPWR VGND sg13cmos5l_nand2b_1
X_3110_ FrameStrobe_O[15] FrameStrobe[15] VPWR VGND sg13cmos5l_buf_1
X_3041_ S2BEGb[2] S2MID[2] VPWR VGND sg13cmos5l_buf_1
X_2825_ _2825_/Q FrameData[19] FrameStrobe[3] VPWR VGND sg13cmos5l_dlhq_1
X_1638_ _1638_/Y W1END[2] _2855_/Q VPWR VGND sg13cmos5l_nand2b_1
X_2756_ _2756_/Q FrameData[13] FrameStrobe[5] VPWR VGND sg13cmos5l_dlhq_1
X_2687_ _2687_/Q FrameData[8] FrameStrobe[7] VPWR VGND sg13cmos5l_dlhq_1
X_1707_ _1707_/X W2END[4] W6END[0] _2898_/Q VPWR VGND sg13cmos5l_mux2_1
X_1569_ _1569_/Y _2689_/Q E1END[0] VPWR VGND sg13cmos5l_nor2b_1
X_2610_ _2610_/Q FrameData[27] FrameStrobe[10] VPWR VGND sg13cmos5l_dlhq_1
X_2541_ _2541_/Q FrameData[22] FrameStrobe[12] VPWR VGND sg13cmos5l_dlhq_1
X_2472_ _2472_/Q FrameData[17] FrameStrobe[14] VPWR VGND sg13cmos5l_dlhq_1
X_1285_ _1286_/B _1285_/A VPWR VGND sg13cmos5l_inv_1
X_1354_ _1355_/A _1353_/X _1352_/X _2823_/Q VPWR VGND sg13cmos5l_mux2_1
X_1423_ _1424_/A _2794_/Q _1422_/Y _1415_/Y VPWR VGND sg13cmos5l_o21ai_1
X_3024_ NN4BEG[13] _3024_/A VPWR VGND sg13cmos5l_buf_1
X_2808_ _2808_/Q FrameData[2] FrameStrobe[3] VPWR VGND sg13cmos5l_dlhq_1
X_2739_ _2739_/Q FrameData[28] FrameStrobe[6] VPWR VGND sg13cmos5l_dlhq_1
XFILLER_27_320 VPWR VGND sg13cmos5l_fill_1
XFILLER_33_378 VPWR VGND sg13cmos5l_fill_2
X_1972_ _1974_/A _2568_/Q _1916_/B _1961_/Y _2600_/Q VPWR VGND sg13cmos5l_a22oi_1
X_2524_ _2524_/Q FrameData[5] FrameStrobe[12] VPWR VGND sg13cmos5l_dlhq_1
X_2455_ _2455_/Q FrameData[0] FrameStrobe[14] VPWR VGND sg13cmos5l_dlhq_1
XFILLER_28_117 VPWR VGND sg13cmos5l_fill_2
X_1268_ _1268_/Y _2826_/Q _1957_/Y _1267_/Y VPWR VGND sg13cmos5l_a21oi_1
X_1337_ _1337_/Y _2631_/Q _2031_/B VPWR VGND sg13cmos5l_nor2b_1
X_1406_ _1406_/Y _2674_/Q _1405_/A _2512_/Q VPWR VGND sg13cmos5l_o21ai_1
X_2386_ _2386_/Q FrameData[27] FrameStrobe[17] VPWR VGND sg13cmos5l_dlhq_1
X_1199_ _1199_/Y _2692_/Q _1198_/Y _2656_/Q VPWR VGND sg13cmos5l_o21ai_1
X_3007_ N4BEG[12] _3007_/A VPWR VGND sg13cmos5l_buf_1
XFILLER_30_337 VPWR VGND sg13cmos5l_fill_1
X_1122_ _1122_/Y _2856_/Q VPWR VGND sg13cmos5l_inv_1
X_2240_ _2240_/Y _2516_/Q _2240_/B VPWR VGND sg13cmos5l_nand2_1
X_2171_ _2174_/A _2171_/A _2171_/B VPWR VGND sg13cmos5l_nor2_1
XFILLER_53_429 VPWR VGND sg13cmos5l_fill_1
X_1955_ _1955_/X _1955_/A _1955_/B _1955_/C VPWR VGND sg13cmos5l_or3_1
X_1886_ _1886_/Y _2368_/Q _1488_/Y _1883_/B _2398_/Q VPWR VGND sg13cmos5l_a22oi_1
X_2507_ _2507_/Q FrameData[20] FrameStrobe[13] VPWR VGND sg13cmos5l_dlhq_1
X_2438_ _2438_/Q FrameData[15] FrameStrobe[15] VPWR VGND sg13cmos5l_dlhq_1
X_2369_ _2369_/Q FrameData[10] FrameStrobe[17] VPWR VGND sg13cmos5l_dlhq_1
XANTENNA_60 S1END[0] VPWR VGND sg13cmos5l_antennanp
XANTENNA_71 W1END[0] VPWR VGND sg13cmos5l_antennanp
XANTENNA_82 W2MID[3] VPWR VGND sg13cmos5l_antennanp
XANTENNA_93 W2MID[3] VPWR VGND sg13cmos5l_antennanp
X_1740_ _1740_/Y _2879_/Q _1740_/B VPWR VGND sg13cmos5l_nor2_1
X_1671_ _1671_/Y _2849_/Q _1664_/X _1670_/Y VPWR VGND sg13cmos5l_o21ai_1
X_2223_ _2223_/Y _2766_/Q _2221_/Y _2765_/Q VPWR VGND sg13cmos5l_o21ai_1
X_2154_ _2154_/Y _2735_/Q _2150_/X _2153_/Y VPWR VGND sg13cmos5l_a21oi_1
X_2085_ _2086_/B _2893_/Q _2082_/Y _2863_/Q VPWR VGND sg13cmos5l_o21ai_1
X_2987_ N2BEGb[0] N2MID[0] VPWR VGND sg13cmos5l_buf_1
X_1938_ _1938_/Y _1938_/A VPWR VGND sg13cmos5l_inv_1
X_1869_ _1869_/X _2366_/Q _2365_/Q _1870_/S VPWR VGND sg13cmos5l_mux2_1
X_2841_ _2841_/Q FrameData[6] FrameStrobe[2] VPWR VGND sg13cmos5l_dlhq_1
X_2910_ _2910_/Q FrameData[16] FrameStrobe[0] VPWR VGND sg13cmos5l_dlhq_1
X_2772_ _2772_/Q FrameData[29] FrameStrobe[5] VPWR VGND sg13cmos5l_dlhq_1
X_1723_ _1723_/X N2MID[6] W2MID[6] E2MID[6] _2984_/A _2779_/Q _2780_/Q VPWR VGND sg13cmos5l_mux4_1
X_1654_ _1654_/X N1END[2] S1END[2] N2END[6] S2END[6] _2901_/Q _2310_/Q VPWR VGND sg13cmos5l_mux4_1
X_1585_ _1585_/X E2END[0] W1END[2] _2854_/Q VPWR VGND sg13cmos5l_mux2_1
X_2206_ _2206_/Y _2206_/A VPWR VGND sg13cmos5l_inv_1
X_2137_ _2958_/A _2134_/Y _2136_/Y _2132_/Y VPWR VGND sg13cmos5l_o21ai_1
X_2068_ _2068_/X _1784_/X _1731_/A _1899_/X _1485_/X _2892_/Q _2891_/Q VPWR VGND sg13cmos5l_mux4_1
XFILLER_13_432 VPWR VGND sg13cmos5l_fill_1
XFILLER_32_229 VPWR VGND sg13cmos5l_fill_2
X_1370_ _1370_/Y _1370_/A VPWR VGND sg13cmos5l_inv_1
X_3040_ S2BEGb[1] S2MID[1] VPWR VGND sg13cmos5l_buf_1
X_2824_ _2824_/Q FrameData[18] FrameStrobe[3] VPWR VGND sg13cmos5l_dlhq_1
X_1637_ _1637_/Y _1122_/Y _1636_/X _1123_/Y VPWR VGND sg13cmos5l_a21oi_1
X_2755_ _2755_/Q FrameData[12] FrameStrobe[5] VPWR VGND sg13cmos5l_dlhq_1
X_2686_ _2686_/Q FrameData[7] FrameStrobe[7] VPWR VGND sg13cmos5l_dlhq_1
X_1706_ _1706_/X N2END[4] N4END[0] E6END[0] S2END[4] _2898_/Q _2843_/Q VPWR VGND sg13cmos5l_mux4_1
X_1499_ _1499_/X _2404_/Q _2407_/Q _1513_/B VPWR VGND sg13cmos5l_mux2_1
X_1568_ _1568_/X E2END[0] WW4END[0] _2689_/Q VPWR VGND sg13cmos5l_mux2_1
X_3169_ WW4BEG[5] WW4END[9] VPWR VGND sg13cmos5l_buf_1
XFILLER_14_218 VPWR VGND sg13cmos5l_fill_1
XFILLER_10_435 VPWR VGND sg13cmos5l_fill_1
X_1422_ _1422_/Y _1419_/Y _1421_/Y _1417_/Y VPWR VGND sg13cmos5l_o21ai_1
X_2540_ _2540_/Q FrameData[21] FrameStrobe[12] VPWR VGND sg13cmos5l_dlhq_1
X_2471_ _2471_/Q FrameData[16] FrameStrobe[14] VPWR VGND sg13cmos5l_dlhq_1
X_1284_ _1285_/A _2031_/B _1957_/Y _1784_/X _1283_/Y _2633_/Q _2660_/Q VPWR VGND sg13cmos5l_mux4_1
X_1353_ _1353_/X _2060_/B _1896_/X _1802_/X _1981_/Y _2725_/Q _2723_/Q VPWR VGND sg13cmos5l_mux4_1
X_3023_ NN4BEG[12] _3023_/A VPWR VGND sg13cmos5l_buf_1
XFILLER_51_379 VPWR VGND sg13cmos5l_fill_1
X_2807_ _2807_/Q FrameData[1] FrameStrobe[3] VPWR VGND sg13cmos5l_dlhq_1
X_2738_ _2738_/Q FrameData[27] FrameStrobe[6] VPWR VGND sg13cmos5l_dlhq_1
X_2669_ _2669_/Q FrameData[22] FrameStrobe[8] VPWR VGND sg13cmos5l_dlhq_1
XANTENNA__2931__X E2BEG[0] VPWR VGND sg13cmos5l_antennanp
XANTENNA__3002__X N4BEG[7] VPWR VGND sg13cmos5l_antennanp
XFILLER_33_313 VPWR VGND sg13cmos5l_fill_2
X_1971_ _1971_/Y _1971_/A _1971_/B _1971_/C VPWR VGND sg13cmos5l_nand3_1
XFILLER_39_0 VPWR VGND sg13cmos5l_fill_2
X_1405_ _1405_/Y _1405_/A VPWR VGND sg13cmos5l_inv_1
X_2523_ _2523_/Q FrameData[4] FrameStrobe[12] VPWR VGND sg13cmos5l_dlhq_1
X_2454_ _2454_/Q FrameData[31] FrameStrobe[15] VPWR VGND sg13cmos5l_dlhq_1
X_2385_ _2385_/Q FrameData[26] FrameStrobe[17] VPWR VGND sg13cmos5l_dlhq_1
X_1198_ _1198_/Y E2END[7] _2657_/Q _1197_/Y VPWR VGND sg13cmos5l_a21oi_1
X_1267_ _1267_/Y _2826_/Q _1740_/B VPWR VGND sg13cmos5l_nor2b_1
X_1336_ _1336_/X _1784_/X _1542_/X _2631_/Q VPWR VGND sg13cmos5l_mux2_1
X_3006_ N4BEG[11] N4END[15] VPWR VGND sg13cmos5l_buf_1
X_1121_ _1121_/Y _2660_/Q VPWR VGND sg13cmos5l_inv_1
X_2170_ _2171_/B _2605_/Q _2169_/Y _2573_/Q VPWR VGND sg13cmos5l_o21ai_1
X_1954_ _1955_/C _2537_/Q _1911_/Y _1952_/Y _1953_/Y _1918_/Y VPWR VGND sg13cmos5l_a221oi_1
X_1885_ _1885_/Y _2401_/Q _1487_/Y _1891_/B _2435_/Q _1883_/X VPWR VGND sg13cmos5l_a221oi_1
X_2506_ _2506_/Q FrameData[19] FrameStrobe[13] VPWR VGND sg13cmos5l_dlhq_1
X_2437_ _2437_/Q FrameData[14] FrameStrobe[15] VPWR VGND sg13cmos5l_dlhq_1
X_2368_ _2368_/Q FrameData[9] FrameStrobe[17] VPWR VGND sg13cmos5l_dlhq_1
X_1319_ _1320_/B _2642_/Q _1319_/B VPWR VGND sg13cmos5l_nor2_1
X_2299_ _2299_/Q _2300_/CLK _2299_/D _2919_/L_HI VPWR VGND sg13cmos5l_dfrbpq_1
XANTENNA_50 N2MID[6] VPWR VGND sg13cmos5l_antennanp
XANTENNA_61 S1END[0] VPWR VGND sg13cmos5l_antennanp
XANTENNA_72 W2END[5] VPWR VGND sg13cmos5l_antennanp
XANTENNA_83 W2MID[3] VPWR VGND sg13cmos5l_antennanp
XANTENNA_94 W2MID[3] VPWR VGND sg13cmos5l_antennanp
XFILLER_15_143 VPWR VGND sg13cmos5l_fill_2
Xclkbuf_1_0__f_UserCLK _3131_/A clkbuf_0_UserCLK/X VPWR VGND sg13cmos5l_buf_8
X_1670_ _1670_/Y _2824_/Q _1670_/B VPWR VGND sg13cmos5l_nor2_1
X_2222_ _2222_/X _1346_/X _1702_/X _2767_/Q VPWR VGND sg13cmos5l_mux2_1
X_2153_ _2153_/Y _2735_/Q _2152_/Y _2804_/Q VPWR VGND sg13cmos5l_o21ai_1
X_2084_ _2086_/A _2894_/Q _1729_/Y _2083_/Y VPWR VGND sg13cmos5l_a21oi_1
X_2986_ N2BEG[7] _2986_/A VPWR VGND sg13cmos5l_buf_1
X_1937_ _1938_/A _2715_/Q _1936_/X _1935_/Y VPWR VGND sg13cmos5l_o21ai_1
X_1868_ _1868_/Y _1871_/S _1865_/Y _1866_/Y _1867_/Y _1862_/A VPWR VGND sg13cmos5l_a221oi_1
X_1799_ _1799_/X _2388_/Q _2387_/Q _2419_/Q _2446_/Q _1797_/S _1793_/B VPWR VGND sg13cmos5l_mux4_1
XFILLER_29_224 VPWR VGND sg13cmos5l_fill_1
XANTENNA__3100__X FrameStrobe_O[5] VPWR VGND sg13cmos5l_antennanp
XANTENNA__3010__X N4BEG[15] VPWR VGND sg13cmos5l_antennanp
X_2840_ _2840_/Q FrameData[5] FrameStrobe[2] VPWR VGND sg13cmos5l_dlhq_1
X_2771_ _2771_/Q FrameData[28] FrameStrobe[5] VPWR VGND sg13cmos5l_dlhq_1
X_1584_ _1584_/X N1END[0] N2END[0] S1END[0] S2END[0] _2875_/Q _2854_/Q VPWR VGND sg13cmos5l_mux4_1
X_1722_ _1722_/X N2END[7] S2END[7] EE4END[2] W2END[7] _2684_/Q _2685_/Q VPWR VGND
+ sg13cmos5l_mux4_1
X_1653_ _1653_/X _1653_/A _1653_/B VPWR VGND sg13cmos5l_and2_1
XFILLER_21_0 VPWR VGND sg13cmos5l_fill_2
X_2205_ _2206_/A _2702_/Q _2202_/Y _2732_/Q VPWR VGND sg13cmos5l_o21ai_1
X_2136_ _2136_/Y _2733_/Q _2135_/X _2666_/Q VPWR VGND sg13cmos5l_o21ai_1
X_2067_ _2067_/X N1END[1] S1END[1] W1END[1] _2031_/B _2892_/Q _2891_/Q VPWR VGND sg13cmos5l_mux4_1
X_2969_ EE4BEG[10] EE4END[14] VPWR VGND sg13cmos5l_buf_1
XANTENNA__2934__X E2BEG[3] VPWR VGND sg13cmos5l_antennanp
XANTENNA__3005__X N4BEG[10] VPWR VGND sg13cmos5l_antennanp
X_2823_ _2823_/Q FrameData[17] FrameStrobe[3] VPWR VGND sg13cmos5l_dlhq_1
X_2754_ _2754_/Q FrameData[11] FrameStrobe[5] VPWR VGND sg13cmos5l_dlhq_1
X_1705_ _1705_/Y _1785_/A _1785_/B VPWR VGND sg13cmos5l_nor2_1
X_1567_ _1567_/X N1END[0] N2END[0] S1END[0] S1END[2] _2759_/Q _2689_/Q VPWR VGND sg13cmos5l_mux4_1
X_1636_ _1636_/X _2060_/B _1896_/X _1784_/X _1981_/Y _2877_/Q _2855_/Q VPWR VGND sg13cmos5l_mux4_1
X_2685_ _2685_/Q FrameData[6] FrameStrobe[7] VPWR VGND sg13cmos5l_dlhq_1
X_1498_ _1498_/X _2378_/Q _2410_/Q _1513_/B VPWR VGND sg13cmos5l_mux2_1
X_3168_ WW4BEG[4] WW4END[8] VPWR VGND sg13cmos5l_buf_1
X_2119_ _3127_/A _2119_/A _2119_/B VPWR VGND sg13cmos5l_nor2_1
XFILLER_22_241 VPWR VGND sg13cmos5l_fill_1
X_3099_ FrameStrobe_O[4] FrameStrobe[4] VPWR VGND sg13cmos5l_buf_1
XANTENNA__2929__X E1BEG[2] VPWR VGND sg13cmos5l_antennanp
X_1421_ _1421_/Y _1411_/A _1420_/X _2718_/Q VPWR VGND sg13cmos5l_o21ai_1
X_2470_ _2470_/Q FrameData[15] FrameStrobe[14] VPWR VGND sg13cmos5l_dlhq_1
X_1283_ _1283_/Y _1155_/Y _1686_/B _1282_/Y VPWR VGND sg13cmos5l_a21oi_1
X_1352_ _1352_/X _2031_/B _1957_/Y _1784_/X _1698_/X _2723_/Q _2725_/Q VPWR VGND sg13cmos5l_mux4_1
X_3022_ NN4BEG[11] NN4END[15] VPWR VGND sg13cmos5l_buf_1
X_2806_ _2806_/Q FrameData[31] FrameStrobe[4] VPWR VGND sg13cmos5l_dlhq_1
X_2737_ _2737_/Q FrameData[26] FrameStrobe[6] VPWR VGND sg13cmos5l_dlhq_1
X_2668_ _2668_/Q FrameData[21] FrameStrobe[8] VPWR VGND sg13cmos5l_dlhq_1
X_1619_ _1620_/A _2315_/Q _1617_/X _1618_/Y VPWR VGND sg13cmos5l_a21oi_1
X_2599_ _2599_/Q FrameData[16] FrameStrobe[10] VPWR VGND sg13cmos5l_dlhq_1
XFILLER_45_174 VPWR VGND sg13cmos5l_fill_2
X_1970_ _1971_/C _1968_/Y _1969_/Y _1975_/A VPWR VGND sg13cmos5l_a21o_1
X_2522_ _2522_/Q FrameData[3] FrameStrobe[12] VPWR VGND sg13cmos5l_dlhq_1
X_1335_ _1335_/X _2060_/B _1896_/X _1802_/X _1981_/Y _2693_/Q _2631_/Q VPWR VGND sg13cmos5l_mux4_1
X_1404_ _1405_/A NN4END[3] E2END[6] S2END[6] W2END[6] _2652_/Q _2651_/Q VPWR VGND
+ sg13cmos5l_mux4_1
X_2453_ _2453_/Q FrameData[30] FrameStrobe[15] VPWR VGND sg13cmos5l_dlhq_1
X_2384_ _2384_/Q FrameData[25] FrameStrobe[17] VPWR VGND sg13cmos5l_dlhq_1
X_1197_ _1197_/Y _2657_/Q E1END[3] VPWR VGND sg13cmos5l_nor2b_1
X_1266_ _1266_/X _2031_/B _1283_/Y _2826_/Q VPWR VGND sg13cmos5l_mux2_1
X_3005_ N4BEG[10] N4END[14] VPWR VGND sg13cmos5l_buf_1
XANTENNA__2942__X E2BEGb[3] VPWR VGND sg13cmos5l_antennanp
XANTENNA__3103__X FrameStrobe_O[8] VPWR VGND sg13cmos5l_antennanp
XANTENNA__3013__X NN4BEG[2] VPWR VGND sg13cmos5l_antennanp
XFILLER_18_141 VPWR VGND sg13cmos5l_fill_2
X_1120_ _1120_/Y WW4END[1] VPWR VGND sg13cmos5l_inv_1
X_1953_ _1953_/Y _2476_/Q _1922_/Y _1925_/Y _2699_/Q VPWR VGND sg13cmos5l_a22oi_1
X_1884_ _1884_/Y _2433_/Q _1488_/Y _1880_/A VPWR VGND sg13cmos5l_a21oi_1
XFILLER_51_0 VPWR VGND sg13cmos5l_fill_2
X_2505_ _2505_/Q FrameData[18] FrameStrobe[13] VPWR VGND sg13cmos5l_dlhq_1
XFILLER_29_406 VPWR VGND sg13cmos5l_fill_2
X_1318_ _1318_/Y _2642_/Q _1318_/B VPWR VGND sg13cmos5l_nand2_1
X_2436_ _2436_/Q FrameData[13] FrameStrobe[15] VPWR VGND sg13cmos5l_dlhq_1
X_2367_ _2367_/Q FrameData[8] FrameStrobe[17] VPWR VGND sg13cmos5l_dlhq_1
X_2298_ _2298_/Q _2302_/CLK _2298_/D _2920_/L_HI VPWR VGND sg13cmos5l_dfrbpq_1
X_1249_ _1249_/Y _2788_/Q _1156_/Y _2789_/Q VPWR VGND sg13cmos5l_a21oi_1
XANTENNA_40 N2MID[2] VPWR VGND sg13cmos5l_antennanp
XANTENNA_51 N2MID[6] VPWR VGND sg13cmos5l_antennanp
XANTENNA_62 S1END[0] VPWR VGND sg13cmos5l_antennanp
XANTENNA_73 W2END[5] VPWR VGND sg13cmos5l_antennanp
XANTENNA_84 W2MID[3] VPWR VGND sg13cmos5l_antennanp
XANTENNA_95 W2MID[3] VPWR VGND sg13cmos5l_antennanp
XFILLER_20_394 VPWR VGND sg13cmos5l_fill_1
XFILLER_21_99 VPWR VGND sg13cmos5l_fill_1
XANTENNA__2937__X E2BEG[6] VPWR VGND sg13cmos5l_antennanp
XFILLER_7_387 VPWR VGND sg13cmos5l_fill_2
XANTENNA__3008__X N4BEG[13] VPWR VGND sg13cmos5l_antennanp
X_2221_ _2221_/Y _2767_/Q _1957_/Y _2220_/Y VPWR VGND sg13cmos5l_o21ai_1
X_2152_ _2152_/Y _2772_/Q _1697_/X _2151_/Y VPWR VGND sg13cmos5l_a21oi_1
X_2083_ _2083_/Y _2894_/Q _1346_/X _2893_/Q VPWR VGND sg13cmos5l_o21ai_1
X_2985_ N2BEG[6] _2985_/A VPWR VGND sg13cmos5l_buf_1
X_1936_ _1936_/X N2END[1] EE4END[3] _2749_/Q VPWR VGND sg13cmos5l_mux2_1
X_1867_ _1867_/Y _2429_/Q _1870_/S _1871_/S VPWR VGND sg13cmos5l_a21oi_1
X_1798_ _1798_/X _2413_/Q _2474_/Q _2420_/Q _2447_/Q _1793_/B _1797_/S VPWR VGND sg13cmos5l_mux4_1
XFILLER_17_409 VPWR VGND sg13cmos5l_fill_2
X_2419_ _2419_/Q FrameData[28] FrameStrobe[16] VPWR VGND sg13cmos5l_dlhq_1
XFILLER_40_401 VPWR VGND sg13cmos5l_fill_2
X_2770_ _2770_/Q FrameData[27] FrameStrobe[5] VPWR VGND sg13cmos5l_dlhq_1
X_1721_ _1721_/X N4END[3] E2END[3] W2END[3] _2982_/A _2550_/Q _2518_/Q VPWR VGND sg13cmos5l_mux4_1
X_1583_ _1583_/Y _2874_/Q _1576_/X _1582_/Y VPWR VGND sg13cmos5l_o21ai_1
X_1652_ _1653_/B _2060_/B _1896_/X _1784_/X _1981_/Y _2310_/Q _2901_/Q VPWR VGND sg13cmos5l_mux4_1
XFILLER_14_0 VPWR VGND sg13cmos5l_fill_2
X_2204_ _2204_/Y _2802_/Q _1899_/X _2203_/Y VPWR VGND sg13cmos5l_o21ai_1
X_2135_ _2135_/X _1981_/Y _1957_/Y _1698_/X _1283_/Y _2734_/Q _2667_/Q VPWR VGND sg13cmos5l_mux4_1
X_2066_ _3162_/A _2057_/Y _2058_/Y _2065_/Y _1109_/Y VPWR VGND sg13cmos5l_a22oi_1
X_2899_ _2899_/Q FrameData[5] FrameStrobe[0] VPWR VGND sg13cmos5l_dlhq_1
X_2968_ EE4BEG[9] EE4END[13] VPWR VGND sg13cmos5l_buf_1
X_1919_ _1919_/X _2537_/Q _1919_/B VPWR VGND sg13cmos5l_or2_1
XFILLER_1_338 VPWR VGND sg13cmos5l_fill_2
XFILLER_25_250 VPWR VGND sg13cmos5l_fill_1
XANTENNA__2950__X E6BEG[3] VPWR VGND sg13cmos5l_antennanp
XANTENNA__3111__X FrameStrobe_O[16] VPWR VGND sg13cmos5l_antennanp
XANTENNA__3021__X NN4BEG[10] VPWR VGND sg13cmos5l_antennanp
X_2822_ _2822_/Q FrameData[16] FrameStrobe[3] VPWR VGND sg13cmos5l_dlhq_1
X_2753_ _2753_/Q FrameData[10] FrameStrobe[5] VPWR VGND sg13cmos5l_dlhq_1
X_2684_ _2684_/Q FrameData[5] FrameStrobe[7] VPWR VGND sg13cmos5l_dlhq_1
X_1704_ _1785_/B _1375_/Y _1495_/Y _1531_/A _1531_/B _1502_/Y VPWR VGND sg13cmos5l_a221oi_1
X_1497_ _1513_/B _1408_/Y _1497_/B VPWR VGND sg13cmos5l_nand2b_1
X_1566_ _1566_/Y _2724_/Q _1566_/B VPWR VGND sg13cmos5l_nand2_1
X_1635_ _1635_/Y _2877_/Q _1631_/Y _1634_/Y VPWR VGND sg13cmos5l_o21ai_1
X_3167_ WW4BEG[3] WW4END[7] VPWR VGND sg13cmos5l_buf_1
X_3098_ FrameStrobe_O[3] FrameStrobe[3] VPWR VGND sg13cmos5l_buf_1
X_2118_ _2119_/B _2481_/Q _2118_/B VPWR VGND sg13cmos5l_nor2_1
X_2049_ _2049_/X E1END[2] W1END[2] _1740_/B _2031_/B _2889_/Q _2865_/Q VPWR VGND sg13cmos5l_mux4_1
XANTENNA__2945__X E2BEGb[6] VPWR VGND sg13cmos5l_antennanp
XANTENNA__3106__X FrameStrobe_O[11] VPWR VGND sg13cmos5l_antennanp
XANTENNA__3016__X NN4BEG[5] VPWR VGND sg13cmos5l_antennanp
X_1351_ _2185_/B _1351_/A VPWR VGND sg13cmos5l_inv_1
X_1420_ _1420_/X E2END[2] WW4END[3] _2691_/Q VPWR VGND sg13cmos5l_mux2_1
XFILLER_36_378 VPWR VGND sg13cmos5l_fill_1
X_1282_ _1282_/Y _1784_/X _1686_/B VPWR VGND sg13cmos5l_nor2_1
X_3021_ NN4BEG[10] NN4END[14] VPWR VGND sg13cmos5l_buf_1
X_2805_ _2805_/Q FrameData[30] FrameStrobe[4] VPWR VGND sg13cmos5l_dlhq_1
X_1618_ _1618_/Y _2315_/Q _1616_/Y _2886_/Q VPWR VGND sg13cmos5l_o21ai_1
X_2736_ _2736_/Q FrameData[25] FrameStrobe[6] VPWR VGND sg13cmos5l_dlhq_1
X_2667_ _2667_/Q FrameData[20] FrameStrobe[8] VPWR VGND sg13cmos5l_dlhq_1
X_1549_ _1549_/Y _1603_/A _2870_/Q _1548_/Y VPWR VGND sg13cmos5l_a21oi_1
X_2598_ _2598_/Q FrameData[15] FrameStrobe[10] VPWR VGND sg13cmos5l_dlhq_1
Xclkbuf_regs_0_UserCLK clkbuf_regs_0_UserCLK/X UserCLK VPWR VGND sg13cmos5l_buf_8
X_2521_ _2521_/Q FrameData[2] FrameStrobe[12] VPWR VGND sg13cmos5l_dlhq_1
X_1265_ _1265_/X _2060_/B _1896_/X _1802_/X _1981_/Y _2851_/Q _2826_/Q VPWR VGND sg13cmos5l_mux4_1
X_1334_ _1334_/Y _1325_/Y _1328_/Y _1333_/Y VPWR VGND sg13cmos5l_o21ai_1
X_1403_ _1403_/X _1400_/Y _1402_/Y _2547_/Q VPWR VGND sg13cmos5l_mux2_1
X_2452_ _2452_/Q FrameData[29] FrameStrobe[15] VPWR VGND sg13cmos5l_dlhq_1
X_2383_ _2383_/Q FrameData[24] FrameStrobe[17] VPWR VGND sg13cmos5l_dlhq_1
X_1196_ _1196_/Y _1110_/Y _2657_/Q _1195_/Y VPWR VGND sg13cmos5l_o21ai_1
X_3004_ N4BEG[9] N4END[13] VPWR VGND sg13cmos5l_buf_1
X_2719_ _2719_/Q FrameData[8] FrameStrobe[6] VPWR VGND sg13cmos5l_dlhq_1
XFILLER_35_65 VPWR VGND sg13cmos5l_fill_1
X_1952_ _1952_/Y _2504_/Q _1923_/Y _1927_/A _2538_/Q VPWR VGND sg13cmos5l_a22oi_1
X_1883_ _1883_/X _2370_/Q _1883_/B VPWR VGND sg13cmos5l_and2_1
XFILLER_44_0 VPWR VGND sg13cmos5l_fill_1
X_2504_ _2504_/Q FrameData[17] FrameStrobe[13] VPWR VGND sg13cmos5l_dlhq_1
X_2435_ _2435_/Q FrameData[12] FrameStrobe[15] VPWR VGND sg13cmos5l_dlhq_1
X_1248_ _1254_/B _2789_/Q _1246_/Y _1247_/Y VPWR VGND sg13cmos5l_o21ai_1
X_1317_ _1317_/Y _1318_/B VPWR VGND sg13cmos5l_inv_1
X_2366_ _2366_/Q FrameData[7] FrameStrobe[17] VPWR VGND sg13cmos5l_dlhq_1
X_2297_ _2297_/Q _2302_/CLK _2297_/D _2921_/L_HI VPWR VGND sg13cmos5l_dfrbpq_1
X_1179_ _1179_/X N1END[3] S1END[3] N2END[7] S2END[7] _2819_/Q _2847_/Q VPWR VGND sg13cmos5l_mux4_1
XANTENNA_30 N2MID[2] VPWR VGND sg13cmos5l_antennanp
XANTENNA_41 N2MID[2] VPWR VGND sg13cmos5l_antennanp
XANTENNA_52 N2MID[6] VPWR VGND sg13cmos5l_antennanp
XANTENNA_63 W1END[0] VPWR VGND sg13cmos5l_antennanp
XANTENNA_74 W2END[5] VPWR VGND sg13cmos5l_antennanp
XANTENNA_85 W2MID[3] VPWR VGND sg13cmos5l_antennanp
XANTENNA_96 W2MID[3] VPWR VGND sg13cmos5l_antennanp
XANTENNA__2953__X E6BEG[6] VPWR VGND sg13cmos5l_antennanp
XANTENNA__3114__X FrameStrobe_O[19] VPWR VGND sg13cmos5l_antennanp
XFILLER_46_20 VPWR VGND sg13cmos5l_fill_1
XFILLER_15_145 VPWR VGND sg13cmos5l_fill_1
XFILLER_15_167 VPWR VGND sg13cmos5l_fill_1
XANTENNA__3024__X NN4BEG[13] VPWR VGND sg13cmos5l_antennanp
X_2220_ _2220_/Y _1484_/X _2767_/Q VPWR VGND sg13cmos5l_nand2b_1
X_2151_ _2151_/Y _2772_/Q _1542_/X VPWR VGND sg13cmos5l_nor2b_1
X_2082_ _2082_/Y _2894_/Q _1957_/Y _2081_/Y VPWR VGND sg13cmos5l_o21ai_1
X_2984_ N2BEG[5] _2984_/A VPWR VGND sg13cmos5l_buf_1
X_1935_ _1935_/Y _2715_/Q _1935_/B _1935_/C VPWR VGND sg13cmos5l_nand3_1
X_1866_ _1866_/Y _1870_/S _2364_/Q VPWR VGND sg13cmos5l_nand2b_1
X_1797_ _1797_/X _1794_/X _1796_/X _1797_/S VPWR VGND sg13cmos5l_mux2_1
X_2418_ _2418_/Q FrameData[27] FrameStrobe[16] VPWR VGND sg13cmos5l_dlhq_1
X_2349_ _2349_/Q FrameData[22] FrameStrobe[18] VPWR VGND sg13cmos5l_dlhq_1
XFILLER_52_284 VPWR VGND sg13cmos5l_fill_1
XANTENNA__3109__X FrameStrobe_O[14] VPWR VGND sg13cmos5l_antennanp
XFILLER_4_325 VPWR VGND sg13cmos5l_fill_2
XANTENNA__2948__X E6BEG[1] VPWR VGND sg13cmos5l_antennanp
XFILLER_28_281 VPWR VGND sg13cmos5l_fill_1
XFILLER_35_229 VPWR VGND sg13cmos5l_fill_2
X_1720_ _2982_/A _1718_/Y _1719_/Y _1712_/Y VPWR VGND sg13cmos5l_o21ai_1
X_1651_ _1651_/Y _1647_/Y _1648_/Y _1650_/Y _2310_/Q _1653_/A VPWR VGND sg13cmos5l_a221oi_1
XANTENNA__3019__X NN4BEG[8] VPWR VGND sg13cmos5l_antennanp
X_1582_ _1582_/Y _1582_/A _2829_/Q VPWR VGND sg13cmos5l_nor2b_1
X_2203_ _2203_/Y _2802_/Q _1430_/Y _1115_/Y VPWR VGND sg13cmos5l_a21oi_1
X_2134_ _2134_/Y _2134_/A _2733_/Q VPWR VGND sg13cmos5l_nor2b_1
X_2065_ _2065_/Y _1108_/Y _2059_/X _2064_/Y VPWR VGND sg13cmos5l_a21oi_1
XFILLER_22_435 VPWR VGND sg13cmos5l_fill_1
X_2967_ EE4BEG[8] EE4END[12] VPWR VGND sg13cmos5l_buf_1
X_2898_ _2898_/Q FrameData[4] FrameStrobe[0] VPWR VGND sg13cmos5l_dlhq_1
X_1918_ _1918_/Y _2537_/Q _1919_/B VPWR VGND sg13cmos5l_nor2_1
X_1849_ _1849_/Y _2696_/Q _1957_/Y _1848_/Y VPWR VGND sg13cmos5l_a21oi_1
XFILLER_40_232 VPWR VGND sg13cmos5l_fill_2
XFILLER_0_372 VPWR VGND sg13cmos5l_fill_1
X_2821_ _2821_/Q FrameData[15] FrameStrobe[3] VPWR VGND sg13cmos5l_dlhq_1
X_1634_ _1634_/Y _2877_/Q _1633_/Y _1122_/Y VPWR VGND sg13cmos5l_a21oi_1
X_2752_ _2752_/Q FrameData[9] FrameStrobe[5] VPWR VGND sg13cmos5l_dlhq_1
X_2683_ _2683_/Q FrameData[4] FrameStrobe[7] VPWR VGND sg13cmos5l_dlhq_1
X_1703_ _1769_/A _1699_/X _1700_/X _1702_/X _1701_/X _2462_/Q _2428_/Q VPWR VGND sg13cmos5l_mux4_1
X_1496_ _1497_/B _1495_/Y _2500_/Q VPWR VGND sg13cmos5l_nand2b_1
X_1565_ _1566_/B _2759_/Q _1563_/Y _1564_/Y VPWR VGND sg13cmos5l_o21ai_1
X_3166_ WW4BEG[2] WW4END[6] VPWR VGND sg13cmos5l_buf_1
X_3097_ FrameStrobe_O[2] FrameStrobe[2] VPWR VGND sg13cmos5l_buf_1
X_2117_ _2118_/B N1END[2] W1END[2] E1END[2] _1802_/X _2540_/Q _2509_/Q VPWR VGND sg13cmos5l_mux4_1
X_2048_ _2048_/Y _2865_/Q _2047_/X _2864_/Q VPWR VGND sg13cmos5l_o21ai_1
XANTENNA__2961__X EE4BEG[2] VPWR VGND sg13cmos5l_antennanp
XANTENNA__3122__X SS4BEG[7] VPWR VGND sg13cmos5l_antennanp
XFILLER_45_357 VPWR VGND sg13cmos5l_fill_2
X_1281_ _1686_/B _1211_/X _1692_/B _2835_/Q VPWR VGND sg13cmos5l_mux2_1
X_1350_ _1351_/A N2MID[3] E2MID[3] S2MID[3] W2MID[3] _2303_/Q _2896_/Q VPWR VGND sg13cmos5l_mux4_1
XANTENNA__3032__X S2BEG[1] VPWR VGND sg13cmos5l_antennanp
X_3020_ NN4BEG[9] NN4END[13] VPWR VGND sg13cmos5l_buf_1
X_2804_ _2804_/Q FrameData[29] FrameStrobe[4] VPWR VGND sg13cmos5l_dlhq_1
X_1617_ _1617_/X _2031_/B _1697_/X _2906_/Q VPWR VGND sg13cmos5l_mux2_1
X_2735_ _2735_/Q FrameData[24] FrameStrobe[6] VPWR VGND sg13cmos5l_dlhq_1
X_2666_ _2666_/Q FrameData[19] FrameStrobe[8] VPWR VGND sg13cmos5l_dlhq_1
X_2597_ _2597_/Q FrameData[14] FrameStrobe[10] VPWR VGND sg13cmos5l_dlhq_1
X_1479_ _1479_/Y W2END[4] _2853_/Q _1478_/Y VPWR VGND sg13cmos5l_a21oi_1
X_1548_ _1548_/Y E1END[0] _2870_/Q VPWR VGND sg13cmos5l_nor2_1
X_3149_ W2BEGb[5] W2MID[5] VPWR VGND sg13cmos5l_buf_1
XFILLER_10_279 VPWR VGND sg13cmos5l_fill_1
Xclkbuf_0_UserCLK_regs clkbuf_0_UserCLK_regs/X clkbuf_regs_0_UserCLK/X VPWR VGND sg13cmos5l_buf_8
XANTENNA__2956__X E6BEG[9] VPWR VGND sg13cmos5l_antennanp
XANTENNA__3117__X SS4BEG[2] VPWR VGND sg13cmos5l_antennanp
XFILLER_2_434 VPWR VGND sg13cmos5l_fill_2
XANTENNA__3027__X S1BEG[0] VPWR VGND sg13cmos5l_antennanp
X_1402_ _1402_/Y _2549_/Q _2981_/A _1401_/Y VPWR VGND sg13cmos5l_a21oi_1
X_2520_ _2520_/Q FrameData[1] FrameStrobe[12] VPWR VGND sg13cmos5l_dlhq_1
X_2451_ _2451_/Q FrameData[28] FrameStrobe[15] VPWR VGND sg13cmos5l_dlhq_1
X_1264_ _2983_/A _2787_/Q _1263_/X _1254_/Y VPWR VGND sg13cmos5l_o21ai_1
X_1333_ _1333_/Y _1331_/Y _1332_/Y _2630_/Q VPWR VGND sg13cmos5l_a21oi_1
X_3003_ N4BEG[8] N4END[12] VPWR VGND sg13cmos5l_buf_1
X_2382_ _2382_/Q FrameData[23] FrameStrobe[17] VPWR VGND sg13cmos5l_dlhq_1
XFILLER_17_390 VPWR VGND sg13cmos5l_fill_2
X_1195_ _1195_/Y W1END[3] _2657_/Q VPWR VGND sg13cmos5l_nand2_1
X_2718_ _2718_/Q FrameData[7] FrameStrobe[6] VPWR VGND sg13cmos5l_dlhq_1
X_2649_ _2649_/Q FrameData[2] FrameStrobe[8] VPWR VGND sg13cmos5l_dlhq_1
XFILLER_19_89 VPWR VGND sg13cmos5l_fill_1
XFILLER_27_121 VPWR VGND sg13cmos5l_fill_2
XFILLER_4_0 VPWR VGND sg13cmos5l_fill_1
XFILLER_25_9 VPWR VGND sg13cmos5l_fill_1
XFILLER_18_165 VPWR VGND sg13cmos5l_fill_1
X_1951_ _1955_/B _1916_/X _1919_/X _1949_/Y _1950_/Y VPWR VGND sg13cmos5l_a22oi_1
X_1882_ _1883_/B _1882_/A _1882_/B VPWR VGND sg13cmos5l_nor2_1
XFILLER_37_0 VPWR VGND sg13cmos5l_fill_2
X_2503_ _2503_/Q FrameData[16] FrameStrobe[13] VPWR VGND sg13cmos5l_dlhq_1
X_2434_ _2434_/Q FrameData[11] FrameStrobe[15] VPWR VGND sg13cmos5l_dlhq_1
X_2365_ _2365_/Q FrameData[6] FrameStrobe[17] VPWR VGND sg13cmos5l_dlhq_1
X_1178_ _1178_/X _2060_/B _1896_/X _1784_/X _1802_/X _2847_/Q _2819_/Q VPWR VGND sg13cmos5l_mux4_1
X_1247_ _1247_/Y _2789_/Q _1244_/X _2311_/Q VPWR VGND sg13cmos5l_a21oi_1
X_1316_ _1318_/B N2MID[1] E2MID[1] S2MID[1] W2MID[1] _2559_/Q _2526_/Q VPWR VGND sg13cmos5l_mux4_1
X_2296_ _2296_/Q _2300_/CLK _2296_/D _2922_/L_HI VPWR VGND sg13cmos5l_dfrbpq_1
XANTENNA_20 EE4END[2] VPWR VGND sg13cmos5l_antennanp
XANTENNA_31 N2MID[2] VPWR VGND sg13cmos5l_antennanp
XANTENNA_42 N2MID[2] VPWR VGND sg13cmos5l_antennanp
XANTENNA_53 N2MID[6] VPWR VGND sg13cmos5l_antennanp
XANTENNA_64 W1END[0] VPWR VGND sg13cmos5l_antennanp
XANTENNA_75 W2END[5] VPWR VGND sg13cmos5l_antennanp
XANTENNA_86 W2MID[3] VPWR VGND sg13cmos5l_antennanp
XANTENNA_97 W2MID[3] VPWR VGND sg13cmos5l_antennanp
XANTENNA__3130__X SS4BEG[15] VPWR VGND sg13cmos5l_antennanp
XFILLER_7_301 VPWR VGND sg13cmos5l_fill_2
XFILLER_38_227 VPWR VGND sg13cmos5l_fill_1
X_2150_ _2150_/X _1700_/X _1905_/X _2772_/Q VPWR VGND sg13cmos5l_mux2_1
X_2081_ _2081_/Y _1484_/X _2894_/Q VPWR VGND sg13cmos5l_nand2b_1
XANTENNA__3040__X S2BEGb[1] VPWR VGND sg13cmos5l_antennanp
X_2983_ N2BEG[4] _2983_/A VPWR VGND sg13cmos5l_buf_1
X_1934_ _1935_/C _2749_/Q S2END[1] VPWR VGND sg13cmos5l_nand2b_1
X_1865_ _1865_/Y _2470_/Q _1870_/S _1864_/Y VPWR VGND sg13cmos5l_a21oi_1
X_1796_ _1796_/X _2415_/Q _2473_/Q _2414_/Q _2440_/Q _1793_/B _1800_/S VPWR VGND sg13cmos5l_mux4_1
X_2417_ _2417_/Q FrameData[26] FrameStrobe[16] VPWR VGND sg13cmos5l_dlhq_1
X_2348_ _2348_/Q FrameData[21] FrameStrobe[18] VPWR VGND sg13cmos5l_dlhq_1
XFILLER_44_208 VPWR VGND sg13cmos5l_fill_2
X_2279_ _2279_/Y _2279_/A _2279_/B _2279_/C VPWR VGND sg13cmos5l_nor3_1
XANTENNA__2964__X EE4BEG[5] VPWR VGND sg13cmos5l_antennanp
XANTENNA__3125__X SS4BEG[10] VPWR VGND sg13cmos5l_antennanp
X_1581_ _1582_/A _2875_/Q _1579_/X _1580_/Y VPWR VGND sg13cmos5l_a21oi_1
X_1650_ _1650_/Y _2901_/Q _2031_/B _1649_/Y VPWR VGND sg13cmos5l_o21ai_1
XANTENNA__3035__X S2BEG[4] VPWR VGND sg13cmos5l_antennanp
X_2202_ _2202_/Y _2802_/Q _1731_/A _2201_/Y VPWR VGND sg13cmos5l_a21oi_1
X_2133_ _2134_/A _1484_/X _1731_/A _1346_/X _1899_/X _2667_/Q _2734_/Q VPWR VGND sg13cmos5l_mux4_1
X_2064_ _2064_/Y _2060_/Y _2061_/Y _2063_/Y _2322_/Q _1108_/Y VPWR VGND sg13cmos5l_a221oi_1
X_2897_ _2897_/Q FrameData[3] FrameStrobe[0] VPWR VGND sg13cmos5l_dlhq_1
X_2966_ EE4BEG[7] EE4END[11] VPWR VGND sg13cmos5l_buf_1
X_1917_ _1919_/B _1912_/X _1913_/X _2183_/B _1914_/X _2807_/Q _2521_/Q VPWR VGND sg13cmos5l_mux4_1
X_1848_ _1848_/Y _2696_/Q _2031_/B VPWR VGND sg13cmos5l_nor2b_1
X_1779_ _1780_/C _1778_/B _2351_/Q VPWR VGND sg13cmos5l_nand2b_1
XFILLER_17_208 VPWR VGND sg13cmos5l_decap_4
XANTENNA__2959__X EE4BEG[0] VPWR VGND sg13cmos5l_antennanp
XFILLER_31_255 VPWR VGND sg13cmos5l_decap_8
X_2820_ _2820_/Q FrameData[14] FrameStrobe[3] VPWR VGND sg13cmos5l_dlhq_1
X_2751_ _2751_/Q FrameData[8] FrameStrobe[5] VPWR VGND sg13cmos5l_dlhq_1
X_1564_ _1564_/Y _2759_/Q _1561_/X _2758_/Q VPWR VGND sg13cmos5l_a21oi_1
X_1633_ _1633_/Y _2855_/Q _2031_/B _1632_/Y VPWR VGND sg13cmos5l_o21ai_1
X_2682_ _2682_/Q FrameData[3] FrameStrobe[7] VPWR VGND sg13cmos5l_dlhq_1
X_1702_ _1702_/X N2END[3] E2END[3] S2END[3] WW4END[1] _2754_/Q _2753_/Q VPWR VGND
+ sg13cmos5l_mux4_1
X_1495_ _1495_/Y _1487_/Y _1494_/Y _1489_/Y VPWR VGND sg13cmos5l_o21ai_1
X_3165_ WW4BEG[1] WW4END[5] VPWR VGND sg13cmos5l_buf_1
X_3096_ FrameStrobe_O[1] FrameStrobe[1] VPWR VGND sg13cmos5l_buf_1
X_2116_ _2119_/A _2116_/A _2116_/B VPWR VGND sg13cmos5l_nor2_1
X_2047_ _2047_/X _1981_/Y _1957_/Y _1698_/X _1283_/Y _2889_/Q _2912_/Q VPWR VGND sg13cmos5l_mux4_1
X_2949_ E6BEG[2] E6END[4] VPWR VGND sg13cmos5l_buf_1
XFILLER_49_119 VPWR VGND sg13cmos5l_fill_2
X_1280_ _1692_/B _2983_/A _2935_/A _3035_/A _3140_/A _2744_/Q _2712_/Q VPWR VGND sg13cmos5l_mux4_1
X_2803_ _2803_/Q FrameData[28] FrameStrobe[4] VPWR VGND sg13cmos5l_dlhq_1
X_2734_ _2734_/Q FrameData[23] FrameStrobe[6] VPWR VGND sg13cmos5l_dlhq_1
X_1547_ _1547_/X N1END[0] N2END[0] S1END[0] S2END[0] _2308_/Q _2870_/Q VPWR VGND sg13cmos5l_mux4_1
X_1616_ _1616_/Y _2906_/Q _1957_/Y _1615_/Y VPWR VGND sg13cmos5l_a21oi_1
X_2665_ _2665_/Q FrameData[18] FrameStrobe[8] VPWR VGND sg13cmos5l_dlhq_1
X_2596_ _2596_/Q FrameData[13] FrameStrobe[10] VPWR VGND sg13cmos5l_dlhq_1
X_1478_ _1478_/Y _2853_/Q E2END[4] VPWR VGND sg13cmos5l_nor2b_1
X_3148_ W2BEGb[4] W2MID[4] VPWR VGND sg13cmos5l_buf_1
X_3079_ FrameData_O[16] FrameData[16] VPWR VGND sg13cmos5l_buf_1
XFILLER_6_207 VPWR VGND sg13cmos5l_fill_1
XANTENNA__3133__X W1BEG[1] VPWR VGND sg13cmos5l_antennanp
XANTENNA_110 E2MID[5] VPWR VGND sg13cmos5l_antennanp
XANTENNA__2972__X EE4BEG[13] VPWR VGND sg13cmos5l_antennanp
XFILLER_18_369 VPWR VGND sg13cmos5l_fill_1
XFILLER_33_339 VPWR VGND sg13cmos5l_fill_1
X_1401_ _1401_/Y _2549_/Q WW4END[2] VPWR VGND sg13cmos5l_nor2b_1
X_2450_ _2450_/Q FrameData[27] FrameStrobe[15] VPWR VGND sg13cmos5l_dlhq_1
X_2381_ _2381_/Q FrameData[22] FrameStrobe[17] VPWR VGND sg13cmos5l_dlhq_1
XANTENNA__3043__X S2BEGb[4] VPWR VGND sg13cmos5l_antennanp
X_1194_ _1194_/X N1END[3] S1END[3] N2END[7] S2END[7] _2692_/Q _2657_/Q VPWR VGND sg13cmos5l_mux4_1
X_1263_ _1263_/X _1258_/Y _1262_/Y _1256_/Y _1260_/Y _2311_/Q _2789_/Q VPWR VGND sg13cmos5l_mux4_1
X_1332_ _1332_/Y _2631_/Q _1329_/X _2655_/Q VPWR VGND sg13cmos5l_a21oi_1
X_3002_ N4BEG[7] N4END[11] VPWR VGND sg13cmos5l_buf_1
XFILLER_51_147 VPWR VGND sg13cmos5l_fill_2
X_2717_ _2717_/Q FrameData[6] FrameStrobe[6] VPWR VGND sg13cmos5l_dlhq_1
X_2648_ _2648_/Q FrameData[1] FrameStrobe[8] VPWR VGND sg13cmos5l_dlhq_1
X_2579_ _2579_/Q FrameData[28] FrameStrobe[11] VPWR VGND sg13cmos5l_dlhq_1
XFILLER_27_100 VPWR VGND sg13cmos5l_fill_1
XANTENNA__2967__X EE4BEG[8] VPWR VGND sg13cmos5l_antennanp
XANTENNA__3128__X SS4BEG[13] VPWR VGND sg13cmos5l_antennanp
X_1950_ _1950_/Y _2503_/Q _1925_/Y _1927_/A _2477_/Q VPWR VGND sg13cmos5l_a22oi_1
XANTENNA__3038__X S2BEG[7] VPWR VGND sg13cmos5l_antennanp
X_2502_ _2502_/Q FrameData[15] FrameStrobe[13] VPWR VGND sg13cmos5l_dlhq_1
X_1881_ _1891_/B _1882_/A _1882_/B VPWR VGND sg13cmos5l_and2_1
X_1315_ _1319_/B _2649_/Q _1311_/X _1314_/Y VPWR VGND sg13cmos5l_o21ai_1
X_2433_ _2433_/Q FrameData[10] FrameStrobe[15] VPWR VGND sg13cmos5l_dlhq_1
X_2364_ _2364_/Q FrameData[5] FrameStrobe[17] VPWR VGND sg13cmos5l_dlhq_1
X_1177_ _1177_/X _1740_/B _1957_/Y _2031_/B _1697_/X _2819_/Q _2847_/Q VPWR VGND sg13cmos5l_mux4_1
X_1246_ _1246_/Y _2788_/Q _1802_/X _1245_/Y VPWR VGND sg13cmos5l_a21oi_1
X_2295_ _2295_/Q _2300_/CLK _2295_/D _2923_/L_HI VPWR VGND sg13cmos5l_dfrbpq_1
XANTENNA_10 E2MID[6] VPWR VGND sg13cmos5l_antennanp
XANTENNA_21 EE4END[2] VPWR VGND sg13cmos5l_antennanp
XANTENNA_32 N2MID[2] VPWR VGND sg13cmos5l_antennanp
XANTENNA_43 N2MID[2] VPWR VGND sg13cmos5l_antennanp
XANTENNA_54 N2MID[6] VPWR VGND sg13cmos5l_antennanp
XANTENNA_65 W1END[0] VPWR VGND sg13cmos5l_antennanp
XANTENNA_76 W2MID[3] VPWR VGND sg13cmos5l_antennanp
XANTENNA_87 W2MID[3] VPWR VGND sg13cmos5l_antennanp
XANTENNA_98 W2MID[3] VPWR VGND sg13cmos5l_antennanp
XFILLER_46_99 VPWR VGND sg13cmos5l_fill_1
X_2080_ _2087_/A _2863_/Q _2080_/B VPWR VGND sg13cmos5l_nor2_1
XFILLER_21_117 VPWR VGND sg13cmos5l_fill_1
X_2982_ N2BEG[3] _2982_/A VPWR VGND sg13cmos5l_buf_1
X_1933_ _1935_/B W2END[1] _2749_/Q VPWR VGND sg13cmos5l_nand2_1
X_1864_ _1864_/Y _1870_/S _2393_/Q VPWR VGND sg13cmos5l_nor2b_1
X_1795_ _1801_/S _1735_/X _2240_/B _1762_/X _1761_/Y _2551_/Q _2457_/Q VPWR VGND sg13cmos5l_mux4_1
X_2416_ _2416_/Q FrameData[25] FrameStrobe[16] VPWR VGND sg13cmos5l_dlhq_1
X_2347_ _2347_/Q FrameData[20] FrameStrobe[18] VPWR VGND sg13cmos5l_dlhq_1
X_2278_ _2279_/C _2402_/Q _2422_/Q _2291_/B VPWR VGND sg13cmos5l_and3_1
XFILLER_25_401 VPWR VGND sg13cmos5l_fill_2
XFILLER_37_272 VPWR VGND sg13cmos5l_fill_1
X_1229_ _1229_/Y _2888_/Q _1223_/X _2887_/Q VPWR VGND sg13cmos5l_o21ai_1
XANTENNA__3141__X W2BEG[5] VPWR VGND sg13cmos5l_antennanp
XANTENNA__2980__X N2BEG[1] VPWR VGND sg13cmos5l_antennanp
X_1580_ _1580_/Y _2875_/Q _1578_/Y _2874_/Q VPWR VGND sg13cmos5l_o21ai_1
X_2201_ _2201_/Y _2802_/Q _1784_/X VPWR VGND sg13cmos5l_nor2b_1
X_2132_ _2132_/Y _2667_/Q _2128_/X _2131_/Y VPWR VGND sg13cmos5l_o21ai_1
XANTENNA__3051__X S4BEG[4] VPWR VGND sg13cmos5l_antennanp
X_2063_ _2063_/Y _2890_/Q _1802_/X _2062_/Y VPWR VGND sg13cmos5l_a21oi_1
X_2896_ _2896_/Q FrameData[1] FrameStrobe[0] VPWR VGND sg13cmos5l_dlhq_1
X_2965_ EE4BEG[6] EE4END[10] VPWR VGND sg13cmos5l_buf_1
X_1916_ _1916_/X _1916_/A _1916_/B _1916_/C VPWR VGND sg13cmos5l_or3_1
X_1847_ _1847_/X _1784_/X _1697_/X _2696_/Q VPWR VGND sg13cmos5l_mux2_1
X_1778_ _1780_/B _2350_/Q _1778_/B VPWR VGND sg13cmos5l_nand2_1
XFILLER_40_278 VPWR VGND sg13cmos5l_fill_1
XANTENNA__2975__X N1BEG[0] VPWR VGND sg13cmos5l_antennanp
XANTENNA__3136__X W2BEG[0] VPWR VGND sg13cmos5l_antennanp
X_2750_ _2750_/Q FrameData[7] FrameStrobe[5] VPWR VGND sg13cmos5l_dlhq_1
X_2681_ _2681_/Q FrameData[2] FrameStrobe[7] VPWR VGND sg13cmos5l_dlhq_1
X_1701_ _1701_/X NN4END[2] E2END[2] S4END[2] _2934_/A _2710_/Q _2678_/Q VPWR VGND
+ sg13cmos5l_mux4_1
XANTENNA__3046__X S2BEGb[7] VPWR VGND sg13cmos5l_antennanp
X_1494_ _1494_/Y _1871_/S _1492_/Y _1493_/Y VPWR VGND sg13cmos5l_a21oi_1
X_1563_ _1563_/Y _2689_/Q _1784_/X _1562_/Y VPWR VGND sg13cmos5l_a21oi_1
X_1632_ _1632_/Y _1283_/Y _2855_/Q VPWR VGND sg13cmos5l_nand2b_1
X_3164_ WW4BEG[0] WW4END[4] VPWR VGND sg13cmos5l_buf_1
X_3095_ FrameStrobe_O[0] FrameStrobe[0] VPWR VGND sg13cmos5l_buf_1
X_2115_ _2116_/B _2509_/Q _2114_/Y _2481_/Q VPWR VGND sg13cmos5l_o21ai_1
X_2046_ _2046_/Y _2046_/A _2865_/Q VPWR VGND sg13cmos5l_nor2b_1
X_2879_ _2879_/Q FrameData[16] FrameStrobe[1] VPWR VGND sg13cmos5l_dlhq_1
X_2948_ E6BEG[1] E6END[3] VPWR VGND sg13cmos5l_buf_1
X_2802_ _2802_/Q FrameData[27] FrameStrobe[4] VPWR VGND sg13cmos5l_dlhq_1
X_2733_ _2733_/Q FrameData[22] FrameStrobe[6] VPWR VGND sg13cmos5l_dlhq_1
X_2664_ _2664_/Q FrameData[17] FrameStrobe[8] VPWR VGND sg13cmos5l_dlhq_1
X_1477_ _1477_/X E6END[0] WW4END[2] _2853_/Q VPWR VGND sg13cmos5l_mux2_1
X_1546_ _1546_/Y _2307_/Q _1545_/X _1544_/X VPWR VGND sg13cmos5l_a21oi_1
X_1615_ _1615_/Y _2906_/Q _1740_/B VPWR VGND sg13cmos5l_nor2b_1
X_2595_ _2595_/Q FrameData[12] FrameStrobe[10] VPWR VGND sg13cmos5l_dlhq_1
X_3078_ FrameData_O[15] FrameData[15] VPWR VGND sg13cmos5l_buf_1
X_3147_ W2BEGb[3] W2MID[3] VPWR VGND sg13cmos5l_buf_1
XFILLER_24_25 VPWR VGND sg13cmos5l_fill_1
XFILLER_35_370 VPWR VGND sg13cmos5l_fill_1
X_2029_ _2029_/Y _1542_/X _2783_/Q VPWR VGND sg13cmos5l_nand2b_1
XANTENNA_100 W2MID[3] VPWR VGND sg13cmos5l_antennanp
XANTENNA_111 E2MID[5] VPWR VGND sg13cmos5l_antennanp
XFILLER_45_156 VPWR VGND sg13cmos5l_fill_1
X_1331_ _1331_/Y _2631_/Q _1331_/B VPWR VGND sg13cmos5l_nand2b_1
X_1400_ _1400_/Y SS4END[3] _2549_/Q _1399_/Y VPWR VGND sg13cmos5l_a21oi_1
X_2380_ _2380_/Q FrameData[21] FrameStrobe[17] VPWR VGND sg13cmos5l_dlhq_1
XFILLER_36_167 VPWR VGND sg13cmos5l_fill_1
XFILLER_36_178 VPWR VGND sg13cmos5l_fill_1
X_1193_ _3142_/A _1190_/Y _1192_/Y _1185_/Y VPWR VGND sg13cmos5l_a21oi_1
X_1262_ _1262_/Y W1END[1] _2788_/Q _1261_/Y VPWR VGND sg13cmos5l_a21oi_1
X_3001_ N4BEG[6] N4END[10] VPWR VGND sg13cmos5l_buf_1
XFILLER_32_395 VPWR VGND sg13cmos5l_fill_1
X_2716_ _2716_/Q FrameData[5] FrameStrobe[6] VPWR VGND sg13cmos5l_dlhq_1
X_2647_ _2647_/Q FrameData[0] FrameStrobe[8] VPWR VGND sg13cmos5l_dlhq_1
XFILLER_19_14 VPWR VGND sg13cmos5l_fill_1
X_1529_ _1531_/A _1372_/B _1351_/A _1370_/A _1368_/X _2427_/Q _2360_/Q VPWR VGND sg13cmos5l_mux4_1
X_2578_ _2578_/Q FrameData[27] FrameStrobe[11] VPWR VGND sg13cmos5l_dlhq_1
XANTENNA__3144__X W2BEGb[0] VPWR VGND sg13cmos5l_antennanp
XANTENNA__2983__X N2BEG[4] VPWR VGND sg13cmos5l_antennanp
X_1880_ _1880_/Y _1880_/A VPWR VGND sg13cmos5l_inv_1
X_2501_ _2501_/Q FrameData[14] FrameStrobe[13] VPWR VGND sg13cmos5l_dlhq_1
XANTENNA__3054__X S4BEG[7] VPWR VGND sg13cmos5l_antennanp
X_1314_ _1314_/Y _2649_/Q _1314_/B VPWR VGND sg13cmos5l_nand2_1
X_2432_ _2432_/Q FrameData[9] FrameStrobe[15] VPWR VGND sg13cmos5l_dlhq_1
X_2363_ _2363_/Q FrameData[4] FrameStrobe[17] VPWR VGND sg13cmos5l_dlhq_1
X_2294_ Co _1911_/Y _1923_/Y _1927_/Y VPWR VGND sg13cmos5l_o21ai_1
XFILLER_52_435 VPWR VGND sg13cmos5l_fill_1
X_1176_ _2937_/A _1169_/Y _1175_/Y _1165_/Y VPWR VGND sg13cmos5l_o21ai_1
X_1245_ _1245_/Y _2788_/Q _2060_/B VPWR VGND sg13cmos5l_nor2b_1
Xclkbuf_1_1__f_UserCLK_regs _2302_/CLK clkbuf_0_UserCLK_regs/X VPWR VGND sg13cmos5l_buf_8
XANTENNA_11 E2MID[6] VPWR VGND sg13cmos5l_antennanp
XANTENNA_22 EE4END[2] VPWR VGND sg13cmos5l_antennanp
XANTENNA_33 N2MID[2] VPWR VGND sg13cmos5l_antennanp
XANTENNA_44 N2MID[5] VPWR VGND sg13cmos5l_antennanp
XANTENNA_55 S1END[0] VPWR VGND sg13cmos5l_antennanp
XANTENNA_66 W1END[0] VPWR VGND sg13cmos5l_antennanp
XANTENNA_77 W2MID[3] VPWR VGND sg13cmos5l_antennanp
XANTENNA_88 W2MID[3] VPWR VGND sg13cmos5l_antennanp
XANTENNA_99 W2MID[3] VPWR VGND sg13cmos5l_antennanp
XFILLER_43_435 VPWR VGND sg13cmos5l_fill_1
XANTENNA__2978__X N1BEG[3] VPWR VGND sg13cmos5l_antennanp
XANTENNA__3139__X W2BEG[3] VPWR VGND sg13cmos5l_antennanp
XFILLER_34_435 VPWR VGND sg13cmos5l_fill_1
XANTENNA__3049__X S4BEG[2] VPWR VGND sg13cmos5l_antennanp
X_2981_ N2BEG[2] _2981_/A VPWR VGND sg13cmos5l_buf_1
X_1932_ _1932_/X NN4END[0] W2END[0] E6END[0] _3140_/A _2708_/Q _2709_/Q VPWR VGND
+ sg13cmos5l_mux4_1
X_1863_ _1863_/Y _1834_/Y _1863_/B _1863_/C VPWR VGND sg13cmos5l_nand3b_1
XFILLER_42_0 VPWR VGND sg13cmos5l_fill_2
X_2415_ _2415_/Q FrameData[24] FrameStrobe[16] VPWR VGND sg13cmos5l_dlhq_1
X_1794_ _1794_/X _2443_/Q _2442_/Q _2382_/Q _2441_/Q _1793_/B _1800_/S VPWR VGND sg13cmos5l_mux4_1
X_1228_ _1228_/Y _2316_/Q _1224_/X _1227_/Y VPWR VGND sg13cmos5l_a21oi_1
X_2346_ _2346_/Q FrameData[19] FrameStrobe[18] VPWR VGND sg13cmos5l_dlhq_1
X_2277_ _2279_/B _2277_/A _2454_/Q VPWR VGND sg13cmos5l_nor2b_1
XFILLER_12_129 VPWR VGND sg13cmos5l_fill_1
XFILLER_25_435 VPWR VGND sg13cmos5l_fill_1
X_1159_ _1159_/X S2END[7] W1END[3] _2760_/Q VPWR VGND sg13cmos5l_mux2_1
XFILLER_11_162 VPWR VGND sg13cmos5l_fill_2
X_2200_ _2200_/Y _2732_/Q _2200_/B VPWR VGND sg13cmos5l_nor2_1
X_2131_ _2131_/Y _2667_/Q _2130_/Y _2666_/Q VPWR VGND sg13cmos5l_a21oi_1
X_2062_ _2062_/Y _2890_/Q _1896_/X VPWR VGND sg13cmos5l_nor2b_1
X_2964_ EE4BEG[5] EE4END[9] VPWR VGND sg13cmos5l_buf_1
XFILLER_8_93 VPWR VGND sg13cmos5l_fill_1
X_2895_ _2895_/Q FrameData[0] FrameStrobe[0] VPWR VGND sg13cmos5l_dlhq_1
X_1915_ _2183_/B N2END[7] S2END[7] E2END[7] WW4END[0] _2653_/Q _2683_/Q VPWR VGND
+ sg13cmos5l_mux4_1
X_1846_ _1846_/X _2060_/B _1740_/B _1802_/X _1981_/Y _2795_/Q _2696_/Q VPWR VGND sg13cmos5l_mux4_1
X_1777_ _1781_/B _1777_/A _1777_/B _1777_/C VPWR VGND sg13cmos5l_nand3_1
X_2329_ _2329_/Q FrameData[2] FrameStrobe[18] VPWR VGND sg13cmos5l_dlhq_1
XANTENNA__3152__X W6BEG[0] VPWR VGND sg13cmos5l_antennanp
XANTENNA__2991__X N2BEGb[4] VPWR VGND sg13cmos5l_antennanp
X_1631_ _1631_/Y _2855_/Q _1156_/Y _1630_/Y VPWR VGND sg13cmos5l_a21oi_1
X_2680_ _2680_/Q FrameData[1] FrameStrobe[7] VPWR VGND sg13cmos5l_dlhq_1
X_1700_ _1700_/X N2MID[3] E2MID[3] S2MID[3] W2MID[3] _2306_/Q _2305_/Q VPWR VGND sg13cmos5l_mux4_1
X_1493_ _1493_/Y _1862_/A Ci VPWR VGND sg13cmos5l_nor2b_1
X_1562_ _1562_/Y _2689_/Q _2060_/B VPWR VGND sg13cmos5l_nor2b_1
XANTENNA__3062__X S4BEG[15] VPWR VGND sg13cmos5l_antennanp
XFILLER_39_346 VPWR VGND sg13cmos5l_fill_2
X_3163_ W6BEG[11] _3163_/A VPWR VGND sg13cmos5l_buf_1
X_3094_ FrameData_O[31] FrameData[31] VPWR VGND sg13cmos5l_buf_1
X_2114_ _2114_/Y _2540_/Q _1351_/A _2113_/Y VPWR VGND sg13cmos5l_a21oi_1
X_2045_ _2046_/A _1484_/X _1731_/A _1346_/X _1899_/X _2912_/Q _2889_/Q VPWR VGND sg13cmos5l_mux4_1
X_2947_ E6BEG[0] E6END[2] VPWR VGND sg13cmos5l_buf_1
X_2878_ _2878_/Q FrameData[15] FrameStrobe[1] VPWR VGND sg13cmos5l_dlhq_1
X_1829_ _1870_/S _1828_/X Ci _2394_/Q VPWR VGND sg13cmos5l_mux2_1
XANTENNA__2986__X N2BEG[7] VPWR VGND sg13cmos5l_antennanp
XANTENNA__3147__X W2BEGb[3] VPWR VGND sg13cmos5l_antennanp
XFILLER_5_434 VPWR VGND sg13cmos5l_fill_2
X_2801_ _2801_/Q FrameData[26] FrameStrobe[4] VPWR VGND sg13cmos5l_dlhq_1
XANTENNA__3057__X S4BEG[10] VPWR VGND sg13cmos5l_antennanp
XFILLER_8_294 VPWR VGND sg13cmos5l_fill_2
X_1614_ _1614_/X E1END[2] S2END[6] E2END[6] W1END[2] _2906_/Q _2315_/Q VPWR VGND sg13cmos5l_mux4_1
X_2732_ _2732_/Q FrameData[21] FrameStrobe[6] VPWR VGND sg13cmos5l_dlhq_1
X_2663_ _2663_/Q FrameData[16] FrameStrobe[8] VPWR VGND sg13cmos5l_dlhq_1
X_2594_ _2594_/Q FrameData[11] FrameStrobe[10] VPWR VGND sg13cmos5l_dlhq_1
X_1476_ _1476_/X N2END[4] S2END[4] E1END[2] S4END[0] _2853_/Q _2873_/Q VPWR VGND sg13cmos5l_mux4_1
X_1545_ _1545_/X _1740_/B _2031_/B _1981_/Y _1283_/Y _2308_/Q _2870_/Q VPWR VGND sg13cmos5l_mux4_1
XFILLER_27_338 VPWR VGND sg13cmos5l_fill_1
X_3077_ FrameData_O[14] FrameData[14] VPWR VGND sg13cmos5l_buf_1
X_3146_ W2BEGb[2] W2MID[2] VPWR VGND sg13cmos5l_buf_1
X_2028_ _2028_/X _1896_/X _1740_/B _1802_/X _1981_/Y _2814_/Q _2783_/Q VPWR VGND sg13cmos5l_mux4_1
XFILLER_1_19 VPWR VGND sg13cmos5l_fill_1
XANTENNA_101 W2MID[4] VPWR VGND sg13cmos5l_antennanp
XANTENNA_112 E2MID[5] VPWR VGND sg13cmos5l_antennanp
XFILLER_45_146 VPWR VGND sg13cmos5l_fill_1
XFILLER_39_6 VPWR VGND sg13cmos5l_fill_2
X_1261_ _1261_/Y _2788_/Q E1END[1] VPWR VGND sg13cmos5l_nor2b_1
X_1330_ _1331_/B NN4END[3] E1END[1] _2693_/Q VPWR VGND sg13cmos5l_mux2_1
X_1192_ _1192_/Y _1184_/S _1191_/X _2882_/Q VPWR VGND sg13cmos5l_a21oi_1
X_3000_ N4BEG[5] N4END[9] VPWR VGND sg13cmos5l_buf_1
X_2715_ _2715_/Q FrameData[4] FrameStrobe[6] VPWR VGND sg13cmos5l_dlhq_1
X_2646_ _2646_/Q FrameData[31] FrameStrobe[9] VPWR VGND sg13cmos5l_dlhq_1
X_2577_ _2577_/Q FrameData[26] FrameStrobe[11] VPWR VGND sg13cmos5l_dlhq_1
X_1459_ _1460_/B _2658_/Q _1456_/Y _1458_/Y VPWR VGND sg13cmos5l_a21oi_1
X_1528_ _1528_/Y _2444_/Q _1527_/Y _1526_/Y VPWR VGND sg13cmos5l_a21oi_1
X_3129_ SS4BEG[14] _3129_/A VPWR VGND sg13cmos5l_buf_1
XANTENNA__3160__X W6BEG[8] VPWR VGND sg13cmos5l_antennanp
XFILLER_14_374 VPWR VGND sg13cmos5l_fill_1
X_2500_ _2500_/Q FrameData[13] FrameStrobe[13] VPWR VGND sg13cmos5l_dlhq_1
X_2431_ _2431_/Q FrameData[8] FrameStrobe[15] VPWR VGND sg13cmos5l_dlhq_1
X_1244_ _1244_/X _1896_/X _1981_/Y _2788_/Q VPWR VGND sg13cmos5l_mux2_1
X_1313_ _1314_/B _2619_/Q _3140_/A _1312_/Y VPWR VGND sg13cmos5l_a21oi_1
X_2362_ _2362_/Q FrameData[3] FrameStrobe[17] VPWR VGND sg13cmos5l_dlhq_1
X_2293_ _2298_/D _2298_/Q _2292_/X _2293_/S VPWR VGND sg13cmos5l_mux2_1
XANTENNA__3070__X FrameData_O[7] VPWR VGND sg13cmos5l_antennanp
XFILLER_52_414 VPWR VGND sg13cmos5l_fill_1
X_1175_ _1175_/Y _1171_/Y _1174_/Y _2793_/Q VPWR VGND sg13cmos5l_o21ai_1
XANTENNA_12 E2MID[6] VPWR VGND sg13cmos5l_antennanp
XANTENNA_23 EE4END[2] VPWR VGND sg13cmos5l_antennanp
XANTENNA_34 N2MID[2] VPWR VGND sg13cmos5l_antennanp
XANTENNA_45 N2MID[5] VPWR VGND sg13cmos5l_antennanp
XANTENNA_56 S1END[0] VPWR VGND sg13cmos5l_antennanp
XANTENNA_67 W1END[0] VPWR VGND sg13cmos5l_antennanp
XANTENNA_78 W2MID[3] VPWR VGND sg13cmos5l_antennanp
XANTENNA_89 W2MID[3] VPWR VGND sg13cmos5l_antennanp
XFILLER_32_171 VPWR VGND sg13cmos5l_fill_2
X_2629_ _2629_/Q FrameData[14] FrameStrobe[9] VPWR VGND sg13cmos5l_dlhq_1
XANTENNA__3155__X W6BEG[3] VPWR VGND sg13cmos5l_antennanp
XFILLER_11_377 VPWR VGND sg13cmos5l_fill_2
XANTENNA__2994__X N2BEGb[7] VPWR VGND sg13cmos5l_antennanp
X_2980_ N2BEG[1] _2980_/A VPWR VGND sg13cmos5l_buf_1
X_1931_ _1939_/B N2MID[1] E2MID[1] S2MID[1] W2MID[1] _2561_/Q _2560_/Q VPWR VGND sg13cmos5l_mux4_1
X_1862_ _1863_/C _1862_/A _1862_/B VPWR VGND sg13cmos5l_nand2_1
X_1793_ _1793_/X _1800_/S _1793_/B VPWR VGND sg13cmos5l_or2_1
XANTENNA__3065__X FrameData_O[2] VPWR VGND sg13cmos5l_antennanp
XFILLER_6_392 VPWR VGND sg13cmos5l_fill_1
X_2414_ _2414_/Q FrameData[23] FrameStrobe[16] VPWR VGND sg13cmos5l_dlhq_1
X_1158_ _1158_/X N1END[3] S1END[1] N2END[7] S1END[3] _2690_/Q _2760_/Q VPWR VGND sg13cmos5l_mux4_1
X_1227_ _1227_/Y _2316_/Q _1226_/Y _2888_/Q VPWR VGND sg13cmos5l_o21ai_1
X_2345_ _2345_/Q FrameData[18] FrameStrobe[18] VPWR VGND sg13cmos5l_dlhq_1
X_2276_ _2279_/A _2422_/Q _2291_/B _1873_/Y VPWR VGND sg13cmos5l_a21oi_1
XFILLER_4_307 VPWR VGND sg13cmos5l_fill_1
XANTENNA__2989__X N2BEGb[2] VPWR VGND sg13cmos5l_antennanp
XFILLER_19_230 VPWR VGND sg13cmos5l_fill_2
X_2130_ _2130_/Y _2130_/A VPWR VGND sg13cmos5l_inv_1
X_2061_ _2061_/Y _2890_/Q _1784_/X _2322_/Q VPWR VGND sg13cmos5l_a21oi_1
X_2963_ EE4BEG[4] EE4END[8] VPWR VGND sg13cmos5l_buf_1
X_1914_ _1914_/X N4END[3] EE4END[0] S4END[3] _2983_/A _2580_/Q _2645_/Q VPWR VGND
+ sg13cmos5l_mux4_1
X_2894_ _2894_/Q FrameData[31] FrameStrobe[1] VPWR VGND sg13cmos5l_dlhq_1
X_1845_ _1845_/Y _1840_/Y _1843_/Y _1844_/Y VPWR VGND sg13cmos5l_o21ai_1
X_1776_ _1777_/C _1778_/B _2353_/Q VPWR VGND sg13cmos5l_nand2b_1
X_2328_ _2328_/Q FrameData[1] FrameStrobe[18] VPWR VGND sg13cmos5l_dlhq_1
X_2259_ _2299_/D _2299_/Q _2258_/X _2259_/S VPWR VGND sg13cmos5l_mux2_1
X_1630_ _1630_/Y _2855_/Q _1740_/B VPWR VGND sg13cmos5l_nor2_1
X_1492_ _1492_/Y Ci _1862_/A VPWR VGND sg13cmos5l_nand2b_1
X_1561_ _1561_/X _1896_/X _1802_/X _2689_/Q VPWR VGND sg13cmos5l_mux2_1
X_3162_ W6BEG[10] _3162_/A VPWR VGND sg13cmos5l_buf_1
X_3093_ FrameData_O[30] FrameData[30] VPWR VGND sg13cmos5l_buf_1
X_2113_ _2113_/Y _2540_/Q _1981_/Y VPWR VGND sg13cmos5l_nor2b_1
X_2044_ _2979_/A _2748_/Q _2035_/Y _2037_/Y _2043_/Y VPWR VGND sg13cmos5l_a22oi_1
X_2877_ _2877_/Q FrameData[14] FrameStrobe[1] VPWR VGND sg13cmos5l_dlhq_1
X_2946_ E2BEGb[7] E2MID[7] VPWR VGND sg13cmos5l_buf_1
X_1828_ _1828_/X _1803_/X _1804_/X _1827_/A _1825_/X _2545_/Q _2510_/Q VPWR VGND sg13cmos5l_mux4_1
X_1759_ _1759_/X _2676_/Q _3139_/A _1758_/Y VPWR VGND sg13cmos5l_a21o_1
XFILLER_9_218 VPWR VGND sg13cmos5l_fill_1
XANTENNA__3163__X W6BEG[11] VPWR VGND sg13cmos5l_antennanp
X_2800_ _2800_/Q FrameData[25] FrameStrobe[4] VPWR VGND sg13cmos5l_dlhq_1
X_2731_ _2731_/Q FrameData[20] FrameStrobe[6] VPWR VGND sg13cmos5l_dlhq_1
X_1544_ _1544_/X _1544_/A _1544_/B VPWR VGND sg13cmos5l_and2_1
X_1613_ _1696_/S _2808_/Q _1612_/X _1611_/Y VPWR VGND sg13cmos5l_o21ai_1
X_2662_ _2662_/Q FrameData[15] FrameStrobe[8] VPWR VGND sg13cmos5l_dlhq_1
X_2593_ _2593_/Q FrameData[10] FrameStrobe[10] VPWR VGND sg13cmos5l_dlhq_1
XANTENNA__3073__X FrameData_O[10] VPWR VGND sg13cmos5l_antennanp
X_1475_ _1475_/Y _2852_/Q _1475_/B _1475_/C VPWR VGND sg13cmos5l_nand3_1
X_3145_ W2BEGb[1] W2MID[1] VPWR VGND sg13cmos5l_buf_1
X_3076_ FrameData_O[13] FrameData[13] VPWR VGND sg13cmos5l_buf_1
X_2027_ _2931_/A _2720_/Q _2018_/Y _2026_/Y VPWR VGND sg13cmos5l_a21oi_1
XFILLER_40_48 VPWR VGND sg13cmos5l_fill_2
X_2929_ E1BEG[2] _2929_/A VPWR VGND sg13cmos5l_buf_1
XANTENNA_102 W2MID[4] VPWR VGND sg13cmos5l_antennanp
XANTENNA_113 E2MID[5] VPWR VGND sg13cmos5l_antennanp
XANTENNA__2997__X N4BEG[2] VPWR VGND sg13cmos5l_antennanp
XANTENNA__3158__X W6BEG[6] VPWR VGND sg13cmos5l_antennanp
X_1191_ _1191_/X N1END[3] S1END[1] N2END[7] S1END[3] _2883_/Q _2885_/Q VPWR VGND sg13cmos5l_mux4_1
X_1260_ _1260_/Y W1END[3] _2788_/Q _1259_/Y VPWR VGND sg13cmos5l_a21oi_1
XANTENNA__3068__X FrameData_O[5] VPWR VGND sg13cmos5l_antennanp
X_2714_ _2714_/Q FrameData[3] FrameStrobe[6] VPWR VGND sg13cmos5l_dlhq_1
X_1527_ _1527_/Y _1375_/Y _1495_/Y _1502_/Y VPWR VGND sg13cmos5l_a21oi_1
X_2645_ _2645_/Q FrameData[30] FrameStrobe[9] VPWR VGND sg13cmos5l_dlhq_1
X_2576_ _2576_/Q FrameData[25] FrameStrobe[11] VPWR VGND sg13cmos5l_dlhq_1
X_1389_ _1389_/Y _1382_/Y _1383_/Y _2844_/Q VPWR VGND sg13cmos5l_a21oi_1
X_1458_ _1458_/Y _2658_/Q _1457_/X _2688_/Q VPWR VGND sg13cmos5l_o21ai_1
X_3128_ SS4BEG[13] _3128_/A VPWR VGND sg13cmos5l_buf_1
X_3059_ S4BEG[12] _3059_/A VPWR VGND sg13cmos5l_buf_1
XFILLER_51_58 VPWR VGND sg13cmos5l_fill_2
X_2430_ _2430_/Q FrameData[7] FrameStrobe[15] VPWR VGND sg13cmos5l_dlhq_1
X_2361_ _2361_/Q FrameData[2] FrameStrobe[17] VPWR VGND sg13cmos5l_dlhq_1
XFILLER_49_272 VPWR VGND sg13cmos5l_fill_1
X_1174_ _1174_/Y _2726_/Q _1174_/B VPWR VGND sg13cmos5l_nand2_1
X_1243_ _3035_/A _1236_/Y _1238_/Y _1240_/Y _1242_/Y VPWR VGND sg13cmos5l_a22oi_1
X_1312_ _1312_/Y _2619_/Q W2MID[0] VPWR VGND sg13cmos5l_nor2b_1
X_2292_ _2292_/X _2346_/Q _1540_/Y _2292_/S VPWR VGND sg13cmos5l_mux2_1
XANTENNA_13 EE4END[0] VPWR VGND sg13cmos5l_antennanp
XANTENNA_24 EE4END[2] VPWR VGND sg13cmos5l_antennanp
XANTENNA_35 N2MID[2] VPWR VGND sg13cmos5l_antennanp
XANTENNA_46 N2MID[5] VPWR VGND sg13cmos5l_antennanp
XANTENNA_57 S1END[0] VPWR VGND sg13cmos5l_antennanp
XANTENNA_68 W1END[0] VPWR VGND sg13cmos5l_antennanp
XANTENNA_79 W2MID[3] VPWR VGND sg13cmos5l_antennanp
XFILLER_20_356 VPWR VGND sg13cmos5l_fill_1
X_2628_ _2628_/Q FrameData[13] FrameStrobe[9] VPWR VGND sg13cmos5l_dlhq_1
X_2559_ _2559_/Q FrameData[8] FrameStrobe[11] VPWR VGND sg13cmos5l_dlhq_1
XANTENNA__3171__X WW4BEG[7] VPWR VGND sg13cmos5l_antennanp
X_1930_ _1930_/X N2MID[0] E2MID[0] W2MID[0] _3142_/A _2620_/Q _2680_/Q VPWR VGND sg13cmos5l_mux4_1
X_1861_ _1862_/B _1860_/X _1859_/X _1871_/S VPWR VGND sg13cmos5l_mux2_1
X_1792_ _1958_/B _1800_/S _1793_/B VPWR VGND sg13cmos5l_nand2_1
XFILLER_28_0 VPWR VGND sg13cmos5l_fill_2
X_2413_ _2413_/Q FrameData[22] FrameStrobe[16] VPWR VGND sg13cmos5l_dlhq_1
X_2344_ _2344_/Q FrameData[17] FrameStrobe[18] VPWR VGND sg13cmos5l_dlhq_1
XANTENNA__3081__X FrameData_O[18] VPWR VGND sg13cmos5l_antennanp
X_1157_ _1649_/B _1698_/X VPWR VGND sg13cmos5l_inv_1
X_1226_ _1226_/Y _2859_/Q _1957_/Y _1225_/Y VPWR VGND sg13cmos5l_a21oi_1
X_2275_ _2302_/D _2273_/Y _2274_/Y _2271_/X VPWR VGND sg13cmos5l_o21ai_1
XFILLER_52_289 VPWR VGND sg13cmos5l_fill_1
XFILLER_28_242 VPWR VGND sg13cmos5l_decap_8
XANTENNA__3166__X WW4BEG[2] VPWR VGND sg13cmos5l_antennanp
X_2060_ _2060_/Y _2890_/Q _2060_/B VPWR VGND sg13cmos5l_nand2b_1
X_2893_ _2893_/Q FrameData[30] FrameStrobe[1] VPWR VGND sg13cmos5l_dlhq_1
X_2962_ EE4BEG[3] EE4END[7] VPWR VGND sg13cmos5l_buf_1
X_1913_ _1913_/X N2MID[7] E2MID[7] S2MID[7] W2MID[7] _2563_/Q _2594_/Q VPWR VGND sg13cmos5l_mux4_1
XANTENNA__3076__X FrameData_O[13] VPWR VGND sg13cmos5l_antennanp
X_1844_ _1844_/Y _1837_/Y _1838_/Y _2727_/Q VPWR VGND sg13cmos5l_a21oi_1
X_1775_ _1777_/B _2352_/Q _1778_/B VPWR VGND sg13cmos5l_nand2_1
X_2327_ _2327_/Q FrameData[0] FrameStrobe[18] VPWR VGND sg13cmos5l_dlhq_1
X_2258_ _2258_/X _2347_/Q _1783_/Y _2258_/S VPWR VGND sg13cmos5l_mux2_1
XFILLER_25_223 VPWR VGND sg13cmos5l_fill_2
X_1209_ _1209_/Y _2656_/Q _1203_/X _2632_/Q VPWR VGND sg13cmos5l_o21ai_1
X_2189_ _2189_/Y _1112_/Y _2539_/Q _2507_/Q VPWR VGND sg13cmos5l_a21oi_1
XFILLER_0_344 VPWR VGND sg13cmos5l_fill_1
XFILLER_4_138 VPWR VGND sg13cmos5l_fill_1
XFILLER_31_248 VPWR VGND sg13cmos5l_decap_8
X_1560_ _1560_/Y _2759_/Q _1556_/X _1559_/Y VPWR VGND sg13cmos5l_a21oi_1
XFILLER_3_182 VPWR VGND sg13cmos5l_fill_1
X_1491_ _1862_/A _1446_/X _1448_/Y _1430_/Y _1425_/X _2450_/Q _2544_/Q VPWR VGND sg13cmos5l_mux4_1
X_3161_ W6BEG[9] W6END[11] VPWR VGND sg13cmos5l_buf_1
X_2112_ _2116_/A _2540_/Q _1938_/A _2111_/Y VPWR VGND sg13cmos5l_a21oi_1
X_3092_ FrameData_O[29] FrameData[29] VPWR VGND sg13cmos5l_buf_1
X_2043_ _2043_/Y _2748_/Q _2043_/B VPWR VGND sg13cmos5l_nor2_1
X_2876_ _2876_/Q FrameData[13] FrameStrobe[1] VPWR VGND sg13cmos5l_dlhq_1
X_2945_ E2BEGb[6] E2MID[6] VPWR VGND sg13cmos5l_buf_1
X_1827_ _1827_/Y _1827_/A VPWR VGND sg13cmos5l_inv_1
X_1758_ _1758_/Y _1120_/Y _2676_/Q _2614_/Q VPWR VGND sg13cmos5l_o21ai_1
X_1689_ _1689_/Y _1156_/Y _1688_/B _1688_/Y VPWR VGND sg13cmos5l_a21oi_1
XFILLER_5_403 VPWR VGND sg13cmos5l_fill_1
XFILLER_0_163 VPWR VGND sg13cmos5l_fill_2
XFILLER_28_70 VPWR VGND sg13cmos5l_fill_2
XFILLER_44_340 VPWR VGND sg13cmos5l_fill_2
X_2730_ _2730_/Q FrameData[19] FrameStrobe[6] VPWR VGND sg13cmos5l_dlhq_1
X_2661_ _2661_/Q FrameData[14] FrameStrobe[8] VPWR VGND sg13cmos5l_dlhq_1
X_1474_ _1475_/C _2873_/Q _1471_/Y _1473_/Y VPWR VGND sg13cmos5l_o21ai_1
X_1543_ _1544_/B _2060_/B _1896_/X _1784_/X _1802_/X _2308_/Q _2870_/Q VPWR VGND sg13cmos5l_mux4_1
X_1612_ _1612_/X _2986_/A _2938_/A _2776_/Q VPWR VGND sg13cmos5l_mux2_1
X_2592_ _2592_/Q FrameData[9] FrameStrobe[10] VPWR VGND sg13cmos5l_dlhq_1
XFILLER_10_0 VPWR VGND sg13cmos5l_fill_2
X_3075_ FrameData_O[12] FrameData[12] VPWR VGND sg13cmos5l_buf_1
X_3144_ W2BEGb[0] W2MID[0] VPWR VGND sg13cmos5l_buf_1
X_2026_ _2026_/Y _2720_/Q _2026_/B _2026_/C VPWR VGND sg13cmos5l_nor3_1
X_2859_ _2859_/Q FrameData[24] FrameStrobe[2] VPWR VGND sg13cmos5l_dlhq_1
X_2928_ E1BEG[1] _2928_/A VPWR VGND sg13cmos5l_buf_1
XANTENNA_103 W2MID[4] VPWR VGND sg13cmos5l_antennanp
XANTENNA_114 E2MID[5] VPWR VGND sg13cmos5l_antennanp
XANTENNA__3174__X WW4BEG[10] VPWR VGND sg13cmos5l_antennanp
X_1190_ _1190_/Y _2885_/Q _1186_/X _1189_/Y VPWR VGND sg13cmos5l_o21ai_1
XFILLER_36_137 VPWR VGND sg13cmos5l_fill_2
XFILLER_10_19 VPWR VGND sg13cmos5l_fill_2
X_2713_ _2713_/Q FrameData[2] FrameStrobe[6] VPWR VGND sg13cmos5l_dlhq_1
X_2644_ _2644_/Q FrameData[29] FrameStrobe[9] VPWR VGND sg13cmos5l_dlhq_1
XANTENNA__3084__X FrameData_O[21] VPWR VGND sg13cmos5l_antennanp
X_1457_ _1457_/X EE4END[2] E6END[0] _2654_/Q VPWR VGND sg13cmos5l_mux2_1
X_1526_ _1526_/Y _2444_/Q _1526_/B _1526_/C VPWR VGND sg13cmos5l_nor3_1
X_2575_ _2575_/Q FrameData[24] FrameStrobe[11] VPWR VGND sg13cmos5l_dlhq_1
X_1388_ _1388_/Y _2686_/Q _1387_/Y _2719_/Q VPWR VGND sg13cmos5l_o21ai_1
X_3058_ S4BEG[11] S4END[15] VPWR VGND sg13cmos5l_buf_1
X_3127_ SS4BEG[12] _3127_/A VPWR VGND sg13cmos5l_buf_1
XFILLER_23_321 VPWR VGND sg13cmos5l_fill_1
XFILLER_35_181 VPWR VGND sg13cmos5l_fill_1
X_2009_ _2009_/Y W6END[1] _2757_/Q _2008_/Y VPWR VGND sg13cmos5l_a21oi_1
XFILLER_2_214 VPWR VGND sg13cmos5l_fill_1
XFILLER_46_435 VPWR VGND sg13cmos5l_fill_1
XANTENNA__3169__X WW4BEG[5] VPWR VGND sg13cmos5l_antennanp
XFILLER_41_173 VPWR VGND sg13cmos5l_fill_2
X_1311_ _1311_/X N2MID[0] S2MID[0] _2619_/Q VPWR VGND sg13cmos5l_mux2_1
X_2360_ _2360_/Q FrameData[1] FrameStrobe[17] VPWR VGND sg13cmos5l_dlhq_1
X_2291_ _2292_/S _2359_/Q _2291_/B VPWR VGND sg13cmos5l_nand2_1
XFILLER_49_240 VPWR VGND sg13cmos5l_fill_1
X_1173_ _1174_/B _2690_/Q _1740_/B _1172_/Y VPWR VGND sg13cmos5l_o21ai_1
X_1242_ _1242_/Y _2857_/Q _1241_/X _2830_/Q VPWR VGND sg13cmos5l_a21oi_1
XANTENNA_14 EE4END[0] VPWR VGND sg13cmos5l_antennanp
XANTENNA_25 EE4END[2] VPWR VGND sg13cmos5l_antennanp
XANTENNA_36 N2MID[2] VPWR VGND sg13cmos5l_antennanp
XANTENNA_47 N2MID[5] VPWR VGND sg13cmos5l_antennanp
XANTENNA__3079__X FrameData_O[16] VPWR VGND sg13cmos5l_antennanp
XANTENNA_58 S1END[0] VPWR VGND sg13cmos5l_antennanp
XANTENNA_69 W1END[0] VPWR VGND sg13cmos5l_antennanp
X_2627_ _2627_/Q FrameData[12] FrameStrobe[9] VPWR VGND sg13cmos5l_dlhq_1
X_1509_ _1510_/B _2340_/Q _2345_/Q _2341_/Q _2377_/Q _1515_/A _1513_/B VPWR VGND sg13cmos5l_mux4_1
X_2558_ _2558_/Q FrameData[7] FrameStrobe[11] VPWR VGND sg13cmos5l_dlhq_1
X_2489_ _2489_/Q FrameData[2] FrameStrobe[13] VPWR VGND sg13cmos5l_dlhq_1
XFILLER_19_435 VPWR VGND sg13cmos5l_fill_1
X_1860_ _1860_/X _2338_/Q _2337_/Q _1870_/S VPWR VGND sg13cmos5l_mux2_1
X_1791_ _1793_/B _1731_/A _1732_/X _1729_/A _1727_/X _2458_/Q _2489_/Q VPWR VGND sg13cmos5l_mux4_1
X_2412_ _2412_/Q FrameData[21] FrameStrobe[16] VPWR VGND sg13cmos5l_dlhq_1
X_2343_ _2343_/Q FrameData[16] FrameStrobe[18] VPWR VGND sg13cmos5l_dlhq_1
X_2274_ _2274_/Y _2572_/Q _2272_/Y _2271_/B VPWR VGND sg13cmos5l_o21ai_1
X_1156_ _1156_/Y _1957_/Y VPWR VGND sg13cmos5l_inv_1
X_1225_ _1225_/Y _2859_/Q _1740_/B VPWR VGND sg13cmos5l_nor2b_1
X_1989_ _2001_/A _2827_/Q _1982_/X _1988_/Y VPWR VGND sg13cmos5l_o21ai_1
XFILLER_19_232 VPWR VGND sg13cmos5l_fill_1
X_2892_ _2892_/Q FrameData[29] FrameStrobe[1] VPWR VGND sg13cmos5l_dlhq_1
X_2961_ EE4BEG[2] EE4END[6] VPWR VGND sg13cmos5l_buf_1
X_1912_ _1912_/X N2MID[6] S2MID[6] E2MID[6] _2985_/A _2623_/Q _2624_/Q VPWR VGND sg13cmos5l_mux4_1
X_1843_ _1843_/Y _2696_/Q _1842_/Y _2761_/Q VPWR VGND sg13cmos5l_o21ai_1
X_1774_ _1781_/A _1771_/Y _1772_/Y _1773_/X _1785_/C VPWR VGND sg13cmos5l_a22oi_1
XANTENNA__3092__X FrameData_O[29] VPWR VGND sg13cmos5l_antennanp
X_1208_ _1208_/Y _2657_/Q _1204_/X _1207_/Y VPWR VGND sg13cmos5l_a21oi_1
X_2326_ _2326_/Q FrameData[25] FrameStrobe[19] VPWR VGND sg13cmos5l_dlhq_1
X_2257_ _2258_/S _2329_/Q _2291_/B VPWR VGND sg13cmos5l_nand2_1
XFILLER_25_246 VPWR VGND sg13cmos5l_decap_4
XFILLER_43_49 VPWR VGND sg13cmos5l_fill_2
X_1139_ _1139_/Y _2880_/Q VPWR VGND sg13cmos5l_inv_1
X_2188_ _2188_/Y _2507_/Q _2184_/Y _2187_/Y VPWR VGND sg13cmos5l_a21oi_1
XFILLER_48_316 VPWR VGND sg13cmos5l_fill_1
XANTENNA__3177__X WW4BEG[13] VPWR VGND sg13cmos5l_antennanp
XFILLER_8_434 VPWR VGND sg13cmos5l_fill_2
X_1490_ _1871_/S _1484_/X _1485_/X _1467_/X _1466_/X _2611_/Q _2612_/Q VPWR VGND sg13cmos5l_mux4_1
X_3160_ W6BEG[8] W6END[10] VPWR VGND sg13cmos5l_buf_1
X_3091_ FrameData_O[28] FrameData[28] VPWR VGND sg13cmos5l_buf_1
X_2111_ _2111_/Y _2540_/Q _1448_/A _2509_/Q VPWR VGND sg13cmos5l_o21ai_1
X_2042_ _2043_/B _2814_/Q _2040_/Y _2041_/Y VPWR VGND sg13cmos5l_a21oi_1
XFILLER_22_205 VPWR VGND sg13cmos5l_fill_2
XANTENNA__3087__X FrameData_O[24] VPWR VGND sg13cmos5l_antennanp
X_2875_ _2875_/Q FrameData[12] FrameStrobe[1] VPWR VGND sg13cmos5l_dlhq_1
X_2944_ E2BEGb[5] E2MID[5] VPWR VGND sg13cmos5l_buf_1
X_1826_ _1827_/A N2END[6] SS4END[3] E2END[6] W2END[6] _2626_/Q _2627_/Q VPWR VGND
+ sg13cmos5l_mux4_1
X_1757_ _1757_/X EE4END[3] S4END[0] _2676_/Q VPWR VGND sg13cmos5l_mux2_1
X_1688_ _1688_/Y _1981_/Y _1688_/B VPWR VGND sg13cmos5l_nor2_1
X_2309_ _2309_/Q FrameData[8] FrameStrobe[19] VPWR VGND sg13cmos5l_dlhq_1
XFILLER_13_216 VPWR VGND sg13cmos5l_fill_2
X_1611_ _1611_/Y _2808_/Q _1611_/B _1611_/C VPWR VGND sg13cmos5l_nand3_1
X_2660_ _2660_/Q FrameData[13] FrameStrobe[8] VPWR VGND sg13cmos5l_dlhq_1
X_1473_ _1473_/Y _2873_/Q _1472_/X _1469_/B VPWR VGND sg13cmos5l_a21oi_1
X_1542_ _1542_/X _2060_/B _1896_/X _1692_/B VPWR VGND sg13cmos5l_mux2_1
X_2591_ _2591_/Q FrameData[8] FrameStrobe[10] VPWR VGND sg13cmos5l_dlhq_1
X_3074_ FrameData_O[11] FrameData[11] VPWR VGND sg13cmos5l_buf_1
X_3143_ W2BEG[7] _3143_/A VPWR VGND sg13cmos5l_buf_1
X_2025_ _2026_/C _2845_/Q _2024_/X VPWR VGND sg13cmos5l_nor2b_1
XFILLER_35_352 VPWR VGND sg13cmos5l_fill_1
X_2927_ E1BEG[0] _2927_/A VPWR VGND sg13cmos5l_buf_1
X_2858_ _2858_/Q FrameData[23] FrameStrobe[2] VPWR VGND sg13cmos5l_dlhq_1
X_2789_ _2789_/Q FrameData[14] FrameStrobe[4] VPWR VGND sg13cmos5l_dlhq_1
X_1809_ _1809_/Y _2747_/Q _1805_/X _1808_/Y VPWR VGND sg13cmos5l_a21oi_1
XANTENNA_104 W2MID[4] VPWR VGND sg13cmos5l_antennanp
XANTENNA_115 N2MID[0] VPWR VGND sg13cmos5l_antennanp
XFILLER_18_319 VPWR VGND sg13cmos5l_fill_2
XFILLER_41_333 VPWR VGND sg13cmos5l_fill_1
XFILLER_36_105 VPWR VGND sg13cmos5l_fill_1
XFILLER_17_374 VPWR VGND sg13cmos5l_fill_1
XFILLER_32_344 VPWR VGND sg13cmos5l_fill_1
X_2712_ _2712_/Q FrameData[1] FrameStrobe[6] VPWR VGND sg13cmos5l_dlhq_1
X_2643_ _2643_/Q FrameData[28] FrameStrobe[9] VPWR VGND sg13cmos5l_dlhq_1
X_2574_ _2574_/Q FrameData[23] FrameStrobe[11] VPWR VGND sg13cmos5l_dlhq_1
X_1387_ _1387_/Y E2END[3] _2755_/Q _1386_/Y VPWR VGND sg13cmos5l_a21oi_1
X_1456_ _1456_/Y W2END[2] _1126_/Y _1455_/X VPWR VGND sg13cmos5l_a21oi_1
X_1525_ _1526_/C _2520_/Q _1524_/X VPWR VGND sg13cmos5l_nor2b_1
X_3057_ S4BEG[10] S4END[14] VPWR VGND sg13cmos5l_buf_1
X_3126_ SS4BEG[11] SS4END[15] VPWR VGND sg13cmos5l_buf_1
X_2008_ _2008_/Y _2757_/Q E6END[1] VPWR VGND sg13cmos5l_nor2b_1
XFILLER_46_414 VPWR VGND sg13cmos5l_fill_1
X_1241_ _1241_/X E1END[1] E2END[5] W1END[1] W1END[3] _2878_/Q _2797_/Q VPWR VGND sg13cmos5l_mux4_1
X_1310_ _1310_/Y _2714_/Q _1309_/X _1308_/Y VPWR VGND sg13cmos5l_o21ai_1
X_2290_ _2293_/S _2277_/A _2455_/Q VPWR VGND sg13cmos5l_nand2b_1
X_1172_ _1172_/Y _2690_/Q _1156_/Y _2760_/Q VPWR VGND sg13cmos5l_a21oi_1
XANTENNA_15 EE4END[0] VPWR VGND sg13cmos5l_antennanp
XANTENNA_26 EE4END[2] VPWR VGND sg13cmos5l_antennanp
XANTENNA_37 N2MID[2] VPWR VGND sg13cmos5l_antennanp
XANTENNA_48 N2MID[5] VPWR VGND sg13cmos5l_antennanp
XANTENNA_59 S1END[0] VPWR VGND sg13cmos5l_antennanp
XANTENNA__3095__X FrameStrobe_O[0] VPWR VGND sg13cmos5l_antennanp
X_2626_ _2626_/Q FrameData[11] FrameStrobe[9] VPWR VGND sg13cmos5l_dlhq_1
X_2557_ _2557_/Q FrameData[6] FrameStrobe[11] VPWR VGND sg13cmos5l_dlhq_1
X_1439_ _1440_/B N1END[2] E6END[0] N2END[4] S2END[4] _2821_/Q _2848_/Q VPWR VGND sg13cmos5l_mux4_1
X_1508_ _1508_/Y _1375_/Y _1501_/Y _1507_/Y VPWR VGND sg13cmos5l_a21oi_1
X_2488_ _2488_/Q FrameData[1] FrameStrobe[13] VPWR VGND sg13cmos5l_dlhq_1
XFILLER_43_406 VPWR VGND sg13cmos5l_fill_2
X_3109_ FrameStrobe_O[14] FrameStrobe[14] VPWR VGND sg13cmos5l_buf_1
XFILLER_46_288 VPWR VGND sg13cmos5l_fill_1
XFILLER_14_141 VPWR VGND sg13cmos5l_fill_1
X_1790_ _1800_/S _1699_/X _1700_/X _1702_/X _1701_/X _2552_/Q _2425_/Q VPWR VGND sg13cmos5l_mux4_1
X_2411_ _2411_/Q FrameData[20] FrameStrobe[16] VPWR VGND sg13cmos5l_dlhq_1
X_1224_ _1224_/X _2031_/B _1698_/X _2859_/Q VPWR VGND sg13cmos5l_mux2_1
X_2342_ _2342_/Q FrameData[15] FrameStrobe[18] VPWR VGND sg13cmos5l_dlhq_1
X_2273_ _2273_/Y _1948_/Y _1955_/X _2291_/B _2467_/Q VPWR VGND sg13cmos5l_a22oi_1
X_1155_ _1155_/Y _1802_/X VPWR VGND sg13cmos5l_inv_1
X_1988_ _1988_/Y _2796_/Q _1988_/B VPWR VGND sg13cmos5l_nor2_1
X_2609_ _2609_/Q FrameData[26] FrameStrobe[10] VPWR VGND sg13cmos5l_dlhq_1
XFILLER_28_200 VPWR VGND sg13cmos5l_fill_1
XFILLER_3_387 VPWR VGND sg13cmos5l_fill_1
X_2960_ EE4BEG[1] EE4END[5] VPWR VGND sg13cmos5l_buf_1
X_2891_ _2891_/Q FrameData[28] FrameStrobe[1] VPWR VGND sg13cmos5l_dlhq_1
X_1911_ _1911_/Y _1916_/B _1916_/C VPWR VGND sg13cmos5l_nor2_1
X_1842_ _1842_/Y E6END[0] _2795_/Q _1841_/Y VPWR VGND sg13cmos5l_a21oi_1
X_1773_ _1773_/X _1142_/Y _1143_/Y _1778_/B VPWR VGND sg13cmos5l_mux2_1
X_1207_ _1207_/Y _2657_/Q _1206_/Y _2656_/Q VPWR VGND sg13cmos5l_o21ai_1
X_2325_ _2325_/Q FrameData[24] FrameStrobe[19] VPWR VGND sg13cmos5l_dlhq_1
X_2256_ _2291_/B _2253_/Y _2255_/Y _2251_/Y VPWR VGND sg13cmos5l_a21oi_1
X_2187_ _2187_/Y _2507_/Q _2186_/Y _2478_/Q VPWR VGND sg13cmos5l_o21ai_1
X_1138_ _1138_/Y _2869_/Q VPWR VGND sg13cmos5l_inv_1
XFILLER_47_383 VPWR VGND sg13cmos5l_fill_1
X_3090_ FrameData_O[27] FrameData[27] VPWR VGND sg13cmos5l_buf_1
X_2110_ _3128_/A _2108_/X _2109_/X _2736_/Q VPWR VGND sg13cmos5l_mux2_1
X_2041_ _2041_/Y _2814_/Q _2038_/X _2813_/Q VPWR VGND sg13cmos5l_o21ai_1
X_2943_ E2BEGb[4] E2MID[4] VPWR VGND sg13cmos5l_buf_1
X_2874_ _2874_/Q FrameData[11] FrameStrobe[1] VPWR VGND sg13cmos5l_dlhq_1
X_1825_ _1825_/X NN4END[3] WW4END[0] S4END[3] _2980_/A _2635_/Q _2881_/Q VPWR VGND
+ sg13cmos5l_mux4_1
X_1756_ _3139_/A _2858_/Q _1744_/Y _1749_/Y _1755_/Y VPWR VGND sg13cmos5l_a22oi_1
X_2308_ _2308_/Q FrameData[7] FrameStrobe[19] VPWR VGND sg13cmos5l_dlhq_1
X_1687_ _1688_/B _2799_/Q _1690_/S _1686_/Y VPWR VGND sg13cmos5l_o21ai_1
X_2239_ _2239_/Y _2516_/Q _1930_/X _2238_/Y VPWR VGND sg13cmos5l_o21ai_1
X_1610_ _1611_/C _2776_/Q _3038_/A VPWR VGND sg13cmos5l_nand2b_1
X_2590_ _2590_/Q FrameData[7] FrameStrobe[10] VPWR VGND sg13cmos5l_dlhq_1
X_1472_ _1472_/X _1784_/X _1698_/X _2853_/Q VPWR VGND sg13cmos5l_mux2_1
X_1541_ _2031_/B _1540_/Y _2298_/Q _2356_/Q VPWR VGND sg13cmos5l_mux2_1
X_3142_ W2BEG[6] _3142_/A VPWR VGND sg13cmos5l_buf_1
X_3073_ FrameData_O[10] FrameData[10] VPWR VGND sg13cmos5l_buf_1
X_2024_ _2024_/X N1END[3] N2END[1] E6END[1] S2END[1] _2786_/Q _2721_/Q VPWR VGND sg13cmos5l_mux4_1
XANTENNA__3098__X FrameStrobe_O[3] VPWR VGND sg13cmos5l_antennanp
X_2857_ _2857_/Q FrameData[22] FrameStrobe[2] VPWR VGND sg13cmos5l_dlhq_1
X_2926_ _2926_/L_HI VPWR VGND sg13cmos5l_tiehi
XFILLER_40_29 VPWR VGND sg13cmos5l_fill_2
X_2788_ _2788_/Q FrameData[13] FrameStrobe[4] VPWR VGND sg13cmos5l_dlhq_1
X_1808_ _1808_/Y _2747_/Q _1807_/Y _2782_/Q VPWR VGND sg13cmos5l_o21ai_1
X_1739_ _1739_/Y _2879_/Q _1784_/X _1738_/Y VPWR VGND sg13cmos5l_o21ai_1
XANTENNA_105 WW4END[3] VPWR VGND sg13cmos5l_antennanp
XANTENNA_116 N2MID[0] VPWR VGND sg13cmos5l_antennanp
XFILLER_14_74 VPWR VGND sg13cmos5l_fill_1
XFILLER_32_323 VPWR VGND sg13cmos5l_fill_1
X_2711_ _2711_/Q FrameData[0] FrameStrobe[6] VPWR VGND sg13cmos5l_dlhq_1
X_1524_ _1524_/X _1376_/X _1377_/X _2553_/Q VPWR VGND sg13cmos5l_mux2_1
X_2642_ _2642_/Q FrameData[27] FrameStrobe[9] VPWR VGND sg13cmos5l_dlhq_1
X_2573_ _2573_/Q FrameData[22] FrameStrobe[11] VPWR VGND sg13cmos5l_dlhq_1
X_1386_ _1386_/Y _2755_/Q E1END[1] VPWR VGND sg13cmos5l_nor2b_1
X_1455_ _1455_/X W6END[0] _2654_/Q VPWR VGND sg13cmos5l_and2_1
X_3125_ SS4BEG[10] SS4END[14] VPWR VGND sg13cmos5l_buf_1
X_3056_ S4BEG[9] S4END[13] VPWR VGND sg13cmos5l_buf_1
X_2007_ _2007_/Y _2791_/Q _2007_/B VPWR VGND sg13cmos5l_nand2b_1
X_2909_ _2909_/Q FrameData[15] FrameStrobe[0] VPWR VGND sg13cmos5l_dlhq_1
X_1171_ _1171_/Y _2690_/Q _1649_/B _1170_/Y VPWR VGND sg13cmos5l_a21oi_1
X_1240_ _1240_/Y _1240_/A _1240_/B VPWR VGND sg13cmos5l_nand2_1
XANTENNA_16 EE4END[0] VPWR VGND sg13cmos5l_antennanp
XANTENNA_27 EE4END[2] VPWR VGND sg13cmos5l_antennanp
XANTENNA_38 N2MID[2] VPWR VGND sg13cmos5l_antennanp
XANTENNA_49 N2MID[5] VPWR VGND sg13cmos5l_antennanp
X_1507_ _1507_/Y _1503_/Y _1504_/X _1506_/Y VPWR VGND sg13cmos5l_o21ai_1
X_2625_ _2625_/Q FrameData[10] FrameStrobe[9] VPWR VGND sg13cmos5l_dlhq_1
X_2556_ _2556_/Q FrameData[5] FrameStrobe[11] VPWR VGND sg13cmos5l_dlhq_1
X_2487_ _2487_/Q FrameData[0] FrameStrobe[13] VPWR VGND sg13cmos5l_dlhq_1
XFILLER_28_415 VPWR VGND sg13cmos5l_fill_1
X_1369_ _1370_/A N2END[2] E2END[2] S2END[2] WW4END[2] _2781_/Q _2746_/Q VPWR VGND
+ sg13cmos5l_mux4_1
X_1438_ _1438_/Y _2820_/Q _1438_/B VPWR VGND sg13cmos5l_nand2_1
X_3108_ FrameStrobe_O[13] FrameStrobe[13] VPWR VGND sg13cmos5l_buf_1
X_3039_ S2BEGb[0] S2MID[0] VPWR VGND sg13cmos5l_buf_1
X_2410_ _2410_/Q FrameData[19] FrameStrobe[16] VPWR VGND sg13cmos5l_dlhq_1
X_2341_ _2341_/Q FrameData[14] FrameStrobe[18] VPWR VGND sg13cmos5l_dlhq_1
X_1154_ _1154_/Y _2825_/Q VPWR VGND sg13cmos5l_inv_1
X_1223_ _1223_/X _2060_/B _1896_/X _1802_/X _1981_/Y _2316_/Q _2859_/Q VPWR VGND sg13cmos5l_mux4_1
X_2272_ _2272_/Y _2467_/Q _2291_/B VPWR VGND sg13cmos5l_nand2_1
X_1987_ _1988_/B _2762_/Q _1983_/X _1986_/Y VPWR VGND sg13cmos5l_a21oi_1
X_2608_ _2608_/Q FrameData[25] FrameStrobe[10] VPWR VGND sg13cmos5l_dlhq_1
X_2539_ _2539_/Q FrameData[20] FrameStrobe[12] VPWR VGND sg13cmos5l_dlhq_1
XFILLER_28_256 VPWR VGND sg13cmos5l_fill_2
XFILLER_51_281 VPWR VGND sg13cmos5l_fill_1
X_2890_ _2890_/Q FrameData[27] FrameStrobe[1] VPWR VGND sg13cmos5l_dlhq_1
X_1910_ _1916_/C _1958_/B _1958_/C _1907_/Y VPWR VGND sg13cmos5l_a21oi_1
X_1841_ _1841_/Y _2795_/Q E2END[2] VPWR VGND sg13cmos5l_nor2b_1
X_1772_ _1772_/Y _2348_/Q _1778_/B _1770_/Y VPWR VGND sg13cmos5l_a21oi_1
X_2324_ _2324_/Q FrameData[23] FrameStrobe[19] VPWR VGND sg13cmos5l_dlhq_1
X_1137_ _1137_/Y _2529_/Q VPWR VGND sg13cmos5l_inv_1
X_1206_ _1206_/Y _2692_/Q _1957_/Y _1205_/Y VPWR VGND sg13cmos5l_a21oi_1
X_2255_ _2255_/Y _2517_/Q _2254_/X _1125_/Y VPWR VGND sg13cmos5l_a21oi_1
X_2186_ _2186_/Y _2539_/Q _1981_/Y _2185_/Y VPWR VGND sg13cmos5l_o21ai_1
XFILLER_4_108 VPWR VGND sg13cmos5l_fill_1
XFILLER_12_421 VPWR VGND sg13cmos5l_fill_1
X_2040_ _2040_/Y E2END[1] _2783_/Q _2039_/Y VPWR VGND sg13cmos5l_o21ai_1
X_2873_ _2873_/Q FrameData[10] FrameStrobe[1] VPWR VGND sg13cmos5l_dlhq_1
X_2942_ E2BEGb[3] E2MID[3] VPWR VGND sg13cmos5l_buf_1
X_1824_ _2980_/A _1809_/Y _1815_/Y _1823_/Y VPWR VGND sg13cmos5l_o21ai_1
X_1755_ _1755_/Y _2858_/Q _1755_/B VPWR VGND sg13cmos5l_nor2_1
X_1686_ _1686_/Y _2799_/Q _1686_/B VPWR VGND sg13cmos5l_nand2_1
X_2307_ _2307_/Q FrameData[6] FrameStrobe[19] VPWR VGND sg13cmos5l_dlhq_1
X_2238_ _2238_/Y _2486_/Q _2238_/B VPWR VGND sg13cmos5l_nor2_1
XFILLER_13_218 VPWR VGND sg13cmos5l_fill_1
X_2169_ _2169_/Y _2637_/Q _1905_/X _2168_/Y VPWR VGND sg13cmos5l_a21oi_1
X_1540_ _1540_/Y _1533_/Y _1535_/Y _1538_/Y _1539_/Y VPWR VGND sg13cmos5l_a22oi_1
X_1471_ _1471_/Y _2853_/Q _1957_/Y _1470_/Y VPWR VGND sg13cmos5l_a21oi_1
X_3141_ W2BEG[5] _3141_/A VPWR VGND sg13cmos5l_buf_1
X_3072_ FrameData_O[9] FrameData[9] VPWR VGND sg13cmos5l_buf_1
X_2023_ _2026_/B _2786_/Q _2020_/Y _2022_/Y VPWR VGND sg13cmos5l_a21oi_1
X_2856_ _2856_/Q FrameData[21] FrameStrobe[2] VPWR VGND sg13cmos5l_dlhq_1
X_2925_ _2925_/L_HI VPWR VGND sg13cmos5l_tiehi
X_1807_ _1807_/Y _2722_/Q _1957_/Y _1806_/Y VPWR VGND sg13cmos5l_a21oi_1
X_2787_ _2787_/Q FrameData[12] FrameStrobe[4] VPWR VGND sg13cmos5l_dlhq_1
X_1738_ _1738_/Y _1542_/X _2879_/Q VPWR VGND sg13cmos5l_nand2b_1
X_1669_ _1670_/B _2871_/Q _1665_/X _1668_/Y VPWR VGND sg13cmos5l_a21oi_1
XANTENNA_106 WW4END[3] VPWR VGND sg13cmos5l_antennanp
XANTENNA_117 N2MID[0] VPWR VGND sg13cmos5l_antennanp
XFILLER_49_435 VPWR VGND sg13cmos5l_fill_1
X_2710_ _2710_/Q FrameData[31] FrameStrobe[7] VPWR VGND sg13cmos5l_dlhq_1
X_1454_ _1460_/A _2658_/Q _1451_/Y _1452_/Y _1453_/Y _2688_/Q VPWR VGND sg13cmos5l_a221oi_1
X_1523_ _1526_/B _2553_/Q _1403_/X _1522_/Y VPWR VGND sg13cmos5l_a21oi_1
X_2641_ _2641_/Q FrameData[26] FrameStrobe[9] VPWR VGND sg13cmos5l_dlhq_1
X_2572_ _2572_/Q FrameData[21] FrameStrobe[11] VPWR VGND sg13cmos5l_dlhq_1
X_1385_ _1385_/Y _1120_/Y _2755_/Q _1384_/Y VPWR VGND sg13cmos5l_a21oi_1
X_3055_ S4BEG[8] S4END[12] VPWR VGND sg13cmos5l_buf_1
X_3124_ SS4BEG[9] SS4END[13] VPWR VGND sg13cmos5l_buf_1
XFILLER_23_379 VPWR VGND sg13cmos5l_fill_2
XFILLER_35_162 VPWR VGND sg13cmos5l_fill_1
X_2006_ _2007_/B NN4END[1] E1END[3] S2END[1] S4END[1] _2792_/Q _2757_/Q VPWR VGND
+ sg13cmos5l_mux4_1
X_2839_ _2839_/Q FrameData[4] FrameStrobe[2] VPWR VGND sg13cmos5l_dlhq_1
X_2908_ _2908_/Q FrameData[14] FrameStrobe[0] VPWR VGND sg13cmos5l_dlhq_1
XFILLER_18_107 VPWR VGND sg13cmos5l_fill_2
X_1170_ _1170_/Y _2690_/Q _2031_/B _2760_/Q VPWR VGND sg13cmos5l_o21ai_1
XANTENNA_17 EE4END[0] VPWR VGND sg13cmos5l_antennanp
XANTENNA_28 N2MID[2] VPWR VGND sg13cmos5l_antennanp
XANTENNA_39 N2MID[2] VPWR VGND sg13cmos5l_antennanp
X_2624_ _2624_/Q FrameData[9] FrameStrobe[9] VPWR VGND sg13cmos5l_dlhq_1
X_1437_ _1438_/B _2822_/Q _1437_/B VPWR VGND sg13cmos5l_nand2b_1
X_1506_ _1506_/Y _1137_/Y _1513_/B _1505_/Y VPWR VGND sg13cmos5l_o21ai_1
X_2555_ _2555_/Q FrameData[4] FrameStrobe[11] VPWR VGND sg13cmos5l_dlhq_1
X_2486_ _2486_/Q FrameData[31] FrameStrobe[14] VPWR VGND sg13cmos5l_dlhq_1
X_1299_ _1299_/Y _2595_/Q _1299_/B _1299_/C VPWR VGND sg13cmos5l_nor3_1
X_1368_ _1368_/X N4END[2] E2END[2] W2END[7] _2933_/A _2707_/Q _2774_/Q VPWR VGND sg13cmos5l_mux4_1
X_3038_ S2BEG[7] _3038_/A VPWR VGND sg13cmos5l_buf_1
X_3107_ FrameStrobe_O[12] FrameStrobe[12] VPWR VGND sg13cmos5l_buf_1
XFILLER_23_198 VPWR VGND sg13cmos5l_decap_8
X_2340_ _2340_/Q FrameData[13] FrameStrobe[18] VPWR VGND sg13cmos5l_dlhq_1
X_2271_ _2271_/X _2271_/A _2271_/B VPWR VGND sg13cmos5l_or2_1
X_1153_ _1153_/Y _2850_/Q VPWR VGND sg13cmos5l_inv_1
X_1222_ _1222_/Y _1217_/Y _1220_/Y _1221_/Y VPWR VGND sg13cmos5l_o21ai_1
X_1986_ _1986_/Y _2762_/Q _1985_/Y _2827_/Q VPWR VGND sg13cmos5l_o21ai_1
X_2607_ _2607_/Q FrameData[24] FrameStrobe[10] VPWR VGND sg13cmos5l_dlhq_1
X_2538_ _2538_/Q FrameData[19] FrameStrobe[12] VPWR VGND sg13cmos5l_dlhq_1
X_2469_ _2469_/Q FrameData[14] FrameStrobe[14] VPWR VGND sg13cmos5l_dlhq_1
XFILLER_28_279 VPWR VGND sg13cmos5l_fill_2
XFILLER_22_42 VPWR VGND sg13cmos5l_fill_1
XFILLER_3_378 VPWR VGND sg13cmos5l_fill_1
XANTENNA__3000__X N4BEG[5] VPWR VGND sg13cmos5l_antennanp
X_1840_ _1840_/Y _1113_/Y _2795_/Q _1839_/Y VPWR VGND sg13cmos5l_a21oi_1
XFILLER_10_190 VPWR VGND sg13cmos5l_fill_1
X_1771_ _1771_/Y _1778_/B _2349_/Q VPWR VGND sg13cmos5l_nand2b_1
X_2323_ _2323_/Q FrameData[22] FrameStrobe[19] VPWR VGND sg13cmos5l_dlhq_1
X_2254_ _2254_/X _3032_/A _3137_/A _2579_/Q VPWR VGND sg13cmos5l_mux2_1
XFILLER_19_0 VPWR VGND sg13cmos5l_fill_2
XFILLER_43_19 VPWR VGND sg13cmos5l_fill_1
X_1136_ _1136_/Y _2725_/Q VPWR VGND sg13cmos5l_inv_1
X_1205_ _1205_/Y _2692_/Q _1740_/B VPWR VGND sg13cmos5l_nor2b_1
X_2185_ _2185_/Y _2539_/Q _2185_/B VPWR VGND sg13cmos5l_nand2_1
X_1969_ _1969_/Y _2533_/Q _1907_/Y _1962_/Y _2501_/Q VPWR VGND sg13cmos5l_a22oi_1
XFILLER_16_227 VPWR VGND sg13cmos5l_fill_2
XFILLER_3_131 VPWR VGND sg13cmos5l_fill_2
XFILLER_3_164 VPWR VGND sg13cmos5l_fill_1
X_2872_ _2872_/Q FrameData[9] FrameStrobe[1] VPWR VGND sg13cmos5l_dlhq_1
X_2941_ E2BEGb[2] E2MID[2] VPWR VGND sg13cmos5l_buf_1
X_1823_ _1823_/Y _2782_/Q _1816_/X _1822_/Y VPWR VGND sg13cmos5l_o21ai_1
X_1754_ _1755_/B _2903_/Q _1752_/Y _1753_/Y VPWR VGND sg13cmos5l_a21oi_1
X_1685_ _1690_/S _1696_/S _1695_/S _2835_/Q VPWR VGND sg13cmos5l_mux2_1
X_2306_ _2306_/Q FrameData[5] FrameStrobe[19] VPWR VGND sg13cmos5l_dlhq_1
X_2237_ _2238_/B _2243_/S _2237_/B VPWR VGND sg13cmos5l_nor2_1
X_1119_ _1119_/Y _2295_/Q VPWR VGND sg13cmos5l_inv_1
X_2168_ _2168_/Y _2637_/Q _1740_/B VPWR VGND sg13cmos5l_nor2b_1
X_2099_ _2102_/A _2578_/Q _1310_/Y _2098_/Y VPWR VGND sg13cmos5l_a21oi_1
XFILLER_0_145 VPWR VGND sg13cmos5l_fill_2
XFILLER_5_23 VPWR VGND sg13cmos5l_fill_1
XFILLER_5_45 VPWR VGND sg13cmos5l_fill_2
X_1470_ _1470_/Y _2853_/Q _1740_/B VPWR VGND sg13cmos5l_nor2b_1
X_3071_ FrameData_O[8] FrameData[8] VPWR VGND sg13cmos5l_buf_1
X_3140_ W2BEG[4] _3140_/A VPWR VGND sg13cmos5l_buf_1
X_2022_ _2022_/Y _2786_/Q _2021_/X _2845_/Q VPWR VGND sg13cmos5l_o21ai_1
X_2855_ _2855_/Q FrameData[20] FrameStrobe[2] VPWR VGND sg13cmos5l_dlhq_1
X_2924_ _2924_/L_HI VPWR VGND sg13cmos5l_tiehi
X_2786_ _2786_/Q FrameData[11] FrameStrobe[4] VPWR VGND sg13cmos5l_dlhq_1
X_1806_ _1806_/Y _2722_/Q _2031_/B VPWR VGND sg13cmos5l_nor2b_1
X_1599_ _1599_/Y _1599_/A _2904_/Q VPWR VGND sg13cmos5l_nor2b_1
X_1737_ _1737_/X _2060_/B _1896_/X _1802_/X _1981_/Y _2903_/Q _2879_/Q VPWR VGND sg13cmos5l_mux4_1
X_1668_ _1668_/Y _2871_/Q _1667_/Y _2849_/Q VPWR VGND sg13cmos5l_o21ai_1
XANTENNA_107 WW4END[3] VPWR VGND sg13cmos5l_antennanp
XANTENNA_118 N2MID[0] VPWR VGND sg13cmos5l_antennanp
XFILLER_53_174 VPWR VGND sg13cmos5l_fill_2
XFILLER_39_51 VPWR VGND sg13cmos5l_fill_2
XFILLER_44_185 VPWR VGND sg13cmos5l_fill_2
X_2640_ _2640_/Q FrameData[25] FrameStrobe[9] VPWR VGND sg13cmos5l_dlhq_1
X_1453_ _1453_/Y NN4END[2] _1126_/Y _2658_/Q VPWR VGND sg13cmos5l_a21oi_1
X_1522_ _1522_/Y _2553_/Q _1405_/A _2520_/Q VPWR VGND sg13cmos5l_o21ai_1
X_2571_ _2571_/Q FrameData[20] FrameStrobe[11] VPWR VGND sg13cmos5l_dlhq_1
X_1384_ _1384_/Y W2END[3] _2755_/Q _2686_/Q VPWR VGND sg13cmos5l_o21ai_1
X_3054_ S4BEG[7] S4END[11] VPWR VGND sg13cmos5l_buf_1
X_3123_ SS4BEG[8] SS4END[12] VPWR VGND sg13cmos5l_buf_1
X_2005_ _2005_/Y _2791_/Q _2002_/X _2004_/Y VPWR VGND sg13cmos5l_a21oi_1
X_2907_ _2907_/Q FrameData[13] FrameStrobe[0] VPWR VGND sg13cmos5l_dlhq_1
X_2838_ _2838_/Q FrameData[1] FrameStrobe[2] VPWR VGND sg13cmos5l_dlhq_1
X_2769_ _2769_/Q FrameData[26] FrameStrobe[5] VPWR VGND sg13cmos5l_dlhq_1
XANTENNA__2932__X E2BEG[1] VPWR VGND sg13cmos5l_antennanp
XFILLER_25_64 VPWR VGND sg13cmos5l_fill_2
XFILLER_2_46 VPWR VGND sg13cmos5l_fill_1
XFILLER_49_299 VPWR VGND sg13cmos5l_fill_1
XANTENNA_18 EE4END[0] VPWR VGND sg13cmos5l_antennanp
XANTENNA_29 N2MID[2] VPWR VGND sg13cmos5l_antennanp
XANTENNA__3003__X N4BEG[8] VPWR VGND sg13cmos5l_antennanp
XFILLER_32_133 VPWR VGND sg13cmos5l_fill_1
XFILLER_32_155 VPWR VGND sg13cmos5l_fill_1
XFILLER_9_362 VPWR VGND sg13cmos5l_fill_1
X_2623_ _2623_/Q FrameData[8] FrameStrobe[9] VPWR VGND sg13cmos5l_dlhq_1
X_2554_ _2554_/Q FrameData[3] FrameStrobe[11] VPWR VGND sg13cmos5l_dlhq_1
XFILLER_49_0 VPWR VGND sg13cmos5l_fill_2
X_1367_ _2933_/A _2687_/Q _1355_/Y _1366_/Y VPWR VGND sg13cmos5l_a21oi_1
X_1436_ _1437_/B _2060_/B _1896_/X _1802_/X _1981_/Y _2848_/Q _2821_/Q VPWR VGND sg13cmos5l_mux4_1
X_1505_ _1505_/Y _2431_/Q _1513_/B _1375_/Y VPWR VGND sg13cmos5l_a21oi_1
X_2485_ _2485_/Q FrameData[30] FrameStrobe[14] VPWR VGND sg13cmos5l_dlhq_1
X_1298_ _1299_/C _2633_/Q _1295_/Y _1296_/Y _1297_/Y _2695_/Q VPWR VGND sg13cmos5l_a221oi_1
X_3037_ S2BEG[6] _3037_/A VPWR VGND sg13cmos5l_buf_1
X_3106_ FrameStrobe_O[11] FrameStrobe[11] VPWR VGND sg13cmos5l_buf_1
XANTENNA__2927__X E1BEG[0] VPWR VGND sg13cmos5l_antennanp
XFILLER_34_409 VPWR VGND sg13cmos5l_fill_1
XFILLER_10_372 VPWR VGND sg13cmos5l_fill_1
X_1221_ _1221_/Y _1214_/Y _1215_/Y _2887_/Q VPWR VGND sg13cmos5l_a21oi_1
X_2270_ _2271_/B _2277_/A _2392_/Q VPWR VGND sg13cmos5l_nand2b_1
X_1152_ _1152_/Y _2830_/Q VPWR VGND sg13cmos5l_inv_1
X_1985_ _1985_/Y _2828_/Q E6END[1] _1984_/Y VPWR VGND sg13cmos5l_a21oi_1
X_2606_ _2606_/Q FrameData[23] FrameStrobe[10] VPWR VGND sg13cmos5l_dlhq_1
X_2537_ _2537_/Q FrameData[18] FrameStrobe[12] VPWR VGND sg13cmos5l_dlhq_1
X_1419_ _1419_/Y _2785_/Q _1419_/B VPWR VGND sg13cmos5l_nor2_1
X_2468_ _2468_/Q FrameData[13] FrameStrobe[14] VPWR VGND sg13cmos5l_dlhq_1
X_2399_ _2399_/Q FrameData[8] FrameStrobe[16] VPWR VGND sg13cmos5l_dlhq_1
XFILLER_28_258 VPWR VGND sg13cmos5l_fill_1
XFILLER_22_10 VPWR VGND sg13cmos5l_fill_1
X_1770_ _1770_/Y _1786_/A VPWR VGND sg13cmos5l_inv_1
X_1204_ _1204_/X _2031_/B _1542_/X _2692_/Q VPWR VGND sg13cmos5l_mux2_1
X_2322_ _2322_/Q FrameData[21] FrameStrobe[19] VPWR VGND sg13cmos5l_dlhq_1
X_2253_ _2253_/Y _2579_/Q _2980_/A _2252_/Y VPWR VGND sg13cmos5l_o21ai_1
X_2184_ _2184_/Y _2539_/Q _1448_/Y _2183_/Y VPWR VGND sg13cmos5l_o21ai_1
X_1135_ _1135_/Y _2794_/Q VPWR VGND sg13cmos5l_inv_1
X_1968_ _1968_/Y _2661_/Q _1916_/B _1961_/Y _2599_/Q VPWR VGND sg13cmos5l_a22oi_1
X_1899_ _1899_/X E2MID[4] W2MID[4] S2MID[4] _3037_/A _2621_/Q _2622_/Q VPWR VGND sg13cmos5l_mux4_1
XFILLER_17_54 VPWR VGND sg13cmos5l_fill_1
XANTENNA__2940__X E2BEGb[1] VPWR VGND sg13cmos5l_antennanp
XANTENNA__3101__X FrameStrobe_O[6] VPWR VGND sg13cmos5l_antennanp
XFILLER_17_76 VPWR VGND sg13cmos5l_fill_1
XFILLER_31_209 VPWR VGND sg13cmos5l_fill_1
XANTENNA__3011__X NN4BEG[0] VPWR VGND sg13cmos5l_antennanp
X_2940_ E2BEGb[1] E2MID[1] VPWR VGND sg13cmos5l_buf_1
X_2871_ _2871_/Q FrameData[8] FrameStrobe[1] VPWR VGND sg13cmos5l_dlhq_1
X_1822_ _1822_/Y _2756_/Q _1822_/B VPWR VGND sg13cmos5l_nor2_1
X_1753_ _1753_/Y _2903_/Q _1750_/X _2880_/Q VPWR VGND sg13cmos5l_o21ai_1
X_1684_ _1695_/S _2809_/Q _1683_/X _1682_/Y VPWR VGND sg13cmos5l_o21ai_1
X_2305_ _2305_/Q FrameData[4] FrameStrobe[19] VPWR VGND sg13cmos5l_dlhq_1
X_2236_ _2975_/A _1740_/B _1318_/B _3139_/A _1368_/X _2319_/Q _2318_/Q VPWR VGND sg13cmos5l_mux4_1
X_2167_ _2171_/A _2637_/Q _1405_/Y _2166_/Y VPWR VGND sg13cmos5l_a21oi_1
X_1118_ _2271_/A _2302_/Q VPWR VGND sg13cmos5l_inv_1
X_2098_ _2098_/Y _2578_/Q _1700_/X _2610_/Q VPWR VGND sg13cmos5l_o21ai_1
XANTENNA__2935__X E2BEG[4] VPWR VGND sg13cmos5l_antennanp
XFILLER_12_253 VPWR VGND sg13cmos5l_fill_2
XFILLER_8_235 VPWR VGND sg13cmos5l_fill_1
XANTENNA__3006__X N4BEG[11] VPWR VGND sg13cmos5l_antennanp
X_3070_ FrameData_O[7] FrameData[7] VPWR VGND sg13cmos5l_buf_1
X_2021_ _2021_/X N4END[1] W2END[1] _2721_/Q VPWR VGND sg13cmos5l_mux2_1
XFILLER_50_337 VPWR VGND sg13cmos5l_fill_1
X_2923_ _2923_/L_HI VPWR VGND sg13cmos5l_tiehi
X_2854_ _2854_/Q FrameData[19] FrameStrobe[2] VPWR VGND sg13cmos5l_dlhq_1
X_2785_ _2785_/Q FrameData[10] FrameStrobe[4] VPWR VGND sg13cmos5l_dlhq_1
X_1805_ _1805_/X _1784_/X _1698_/X _2722_/Q VPWR VGND sg13cmos5l_mux2_1
X_1736_ _2240_/B N2MID[1] E2MID[1] S2MID[1] W2MID[1] _2527_/Q _2495_/Q VPWR VGND sg13cmos5l_mux4_1
XFILLER_49_19 VPWR VGND sg13cmos5l_fill_1
X_1598_ _1599_/A _2313_/Q _1595_/Y _1597_/Y VPWR VGND sg13cmos5l_a21oi_1
X_1667_ _1667_/Y E2END[6] _2902_/Q _1666_/Y VPWR VGND sg13cmos5l_a21oi_1
XANTENNA_108 EE4END[4] VPWR VGND sg13cmos5l_antennanp
X_2219_ _2225_/A _2765_/Q _2219_/B VPWR VGND sg13cmos5l_nor2_1
XFILLER_44_120 VPWR VGND sg13cmos5l_fill_1
XFILLER_44_153 VPWR VGND sg13cmos5l_fill_1
X_2570_ _2570_/Q FrameData[19] FrameStrobe[11] VPWR VGND sg13cmos5l_dlhq_1
X_1383_ _1383_/Y _2686_/Q _1380_/X _2719_/Q VPWR VGND sg13cmos5l_a21oi_1
X_1452_ _1452_/Y E1END[0] _2654_/Q VPWR VGND sg13cmos5l_nand2_1
X_1521_ _1521_/Y _1521_/A VPWR VGND sg13cmos5l_inv_1
X_3122_ SS4BEG[7] SS4END[11] VPWR VGND sg13cmos5l_buf_1
XANTENNA__2294__Y Co VPWR VGND sg13cmos5l_antennanp
X_3053_ S4BEG[6] S4END[10] VPWR VGND sg13cmos5l_buf_1
X_2004_ _2004_/Y _2791_/Q _2003_/X VPWR VGND sg13cmos5l_nor2b_1
X_2906_ _2906_/Q FrameData[12] FrameStrobe[0] VPWR VGND sg13cmos5l_dlhq_1
X_2837_ _2837_/Q FrameData[31] FrameStrobe[3] VPWR VGND sg13cmos5l_dlhq_1
X_2768_ _2768_/Q FrameData[25] FrameStrobe[5] VPWR VGND sg13cmos5l_dlhq_1
X_2699_ _2699_/Q FrameData[20] FrameStrobe[7] VPWR VGND sg13cmos5l_dlhq_1
X_1719_ _1719_/Y _2869_/Q _1713_/X _2817_/Q VPWR VGND sg13cmos5l_o21ai_1
XFILLER_26_186 VPWR VGND sg13cmos5l_fill_1
XANTENNA_19 EE4END[2] VPWR VGND sg13cmos5l_antennanp
X_1504_ _1504_/X _2372_/Q _2373_/Q _1513_/B VPWR VGND sg13cmos5l_mux2_1
X_2622_ _2622_/Q FrameData[7] FrameStrobe[9] VPWR VGND sg13cmos5l_dlhq_1
X_2553_ _2553_/Q FrameData[2] FrameStrobe[11] VPWR VGND sg13cmos5l_dlhq_1
X_1366_ _1366_/Y _2687_/Q _1366_/B _1366_/C VPWR VGND sg13cmos5l_nor3_1
X_1435_ _1435_/Y _2848_/Q _1433_/Y _1434_/Y VPWR VGND sg13cmos5l_a21oi_1
X_3105_ FrameStrobe_O[10] FrameStrobe[10] VPWR VGND sg13cmos5l_buf_1
X_2484_ _2484_/Q FrameData[29] FrameStrobe[14] VPWR VGND sg13cmos5l_dlhq_1
XFILLER_23_101 VPWR VGND sg13cmos5l_fill_1
X_1297_ _1297_/Y N1END[1] _1121_/Y _2633_/Q VPWR VGND sg13cmos5l_a21oi_1
X_3036_ S2BEG[5] _3036_/A VPWR VGND sg13cmos5l_buf_1
XANTENNA__3104__X FrameStrobe_O[9] VPWR VGND sg13cmos5l_antennanp
XANTENNA__2943__X E2BEGb[4] VPWR VGND sg13cmos5l_antennanp
XFILLER_10_395 VPWR VGND sg13cmos5l_fill_1
X_1151_ _1240_/A _2857_/Q VPWR VGND sg13cmos5l_inv_1
X_1220_ _1220_/Y _2859_/Q _1219_/Y _2888_/Q VPWR VGND sg13cmos5l_o21ai_1
XANTENNA__3014__X NN4BEG[3] VPWR VGND sg13cmos5l_antennanp
X_1984_ _1984_/Y _2828_/Q E2END[1] VPWR VGND sg13cmos5l_nor2b_1
X_2605_ _2605_/Q FrameData[22] FrameStrobe[10] VPWR VGND sg13cmos5l_dlhq_1
X_2536_ _2536_/Q FrameData[17] FrameStrobe[12] VPWR VGND sg13cmos5l_dlhq_1
X_2467_ _2467_/Q FrameData[12] FrameStrobe[14] VPWR VGND sg13cmos5l_dlhq_1
X_1349_ _1372_/B N2MID[2] W2MID[2] E2MID[2] _2935_/A _2493_/Q _2468_/Q VPWR VGND sg13cmos5l_mux4_1
X_1418_ _1419_/B N4END[2] W2END[2] _2691_/Q VPWR VGND sg13cmos5l_mux2_1
X_2398_ _2398_/Q FrameData[7] FrameStrobe[16] VPWR VGND sg13cmos5l_dlhq_1
XFILLER_24_432 VPWR VGND sg13cmos5l_fill_1
X_3019_ NN4BEG[8] NN4END[12] VPWR VGND sg13cmos5l_buf_1
XANTENNA__2938__X E2BEG[7] VPWR VGND sg13cmos5l_antennanp
XFILLER_19_259 VPWR VGND sg13cmos5l_fill_2
XFILLER_27_281 VPWR VGND sg13cmos5l_decap_4
XANTENNA__3009__X N4BEG[14] VPWR VGND sg13cmos5l_antennanp
X_2321_ _2321_/Q FrameData[20] FrameStrobe[19] VPWR VGND sg13cmos5l_dlhq_1
X_1134_ _1417_/A _2718_/Q VPWR VGND sg13cmos5l_inv_1
X_1203_ _1203_/X _2060_/B _1896_/X _1784_/X _1802_/X _2657_/Q _2692_/Q VPWR VGND sg13cmos5l_mux4_1
X_2252_ _2252_/Y _2579_/Q _1424_/A _2517_/Q VPWR VGND sg13cmos5l_a21oi_1
X_2183_ _2183_/Y _2539_/Q _2183_/B VPWR VGND sg13cmos5l_nand2_1
XFILLER_21_435 VPWR VGND sg13cmos5l_fill_1
XFILLER_33_284 VPWR VGND sg13cmos5l_fill_2
X_1967_ _1971_/B _1930_/X _1939_/B _1938_/Y _1932_/X _2554_/Q _2522_/Q VPWR VGND sg13cmos5l_mux4_1
X_1898_ _1898_/X NN4END[1] S2END[5] E2END[5] W2END[5] _2784_/Q _2815_/Q VPWR VGND
+ sg13cmos5l_mux4_1
X_2519_ _2519_/Q FrameData[0] FrameStrobe[12] VPWR VGND sg13cmos5l_dlhq_1
XFILLER_16_229 VPWR VGND sg13cmos5l_fill_1
X_2870_ _2870_/Q FrameData[7] FrameStrobe[1] VPWR VGND sg13cmos5l_dlhq_1
X_1821_ _1822_/B _2747_/Q _1817_/X _1820_/Y VPWR VGND sg13cmos5l_a21oi_1
X_1752_ _1752_/Y E6END[0] _2879_/Q _1751_/Y VPWR VGND sg13cmos5l_o21ai_1
X_1683_ _1683_/X _2984_/A _2936_/A _2838_/Q VPWR VGND sg13cmos5l_mux2_1
XFILLER_24_0 VPWR VGND sg13cmos5l_fill_1
X_2304_ _2304_/Q FrameData[3] FrameStrobe[19] VPWR VGND sg13cmos5l_dlhq_1
X_1117_ _1117_/Y _2301_/Q VPWR VGND sg13cmos5l_inv_1
X_2235_ _2976_/A _2031_/B _1724_/X _3136_/A _1727_/X _2317_/Q _2909_/Q VPWR VGND sg13cmos5l_mux4_1
X_2166_ _2166_/Y _2637_/Q _1700_/X _2605_/Q VPWR VGND sg13cmos5l_o21ai_1
X_2097_ _3130_/A _2096_/X _2095_/X _2640_/Q VPWR VGND sg13cmos5l_mux2_1
X_2999_ N4BEG[4] N4END[8] VPWR VGND sg13cmos5l_buf_1
XANTENNA__2951__X E6BEG[4] VPWR VGND sg13cmos5l_antennanp
XANTENNA__3112__X FrameStrobe_O[17] VPWR VGND sg13cmos5l_antennanp
XANTENNA__3022__X NN4BEG[11] VPWR VGND sg13cmos5l_antennanp
X_2020_ _2020_/Y W6END[1] _2721_/Q _2019_/Y VPWR VGND sg13cmos5l_a21oi_1
X_2853_ _2853_/Q FrameData[18] FrameStrobe[2] VPWR VGND sg13cmos5l_dlhq_1
X_2922_ _2922_/L_HI VPWR VGND sg13cmos5l_tiehi
X_2784_ _2784_/Q FrameData[9] FrameStrobe[4] VPWR VGND sg13cmos5l_dlhq_1
X_1804_ _1804_/X N2MID[7] E2MID[7] S2MID[7] W2MID[7] _2867_/Q _2558_/Q VPWR VGND sg13cmos5l_mux4_1
X_1735_ _1735_/X E2MID[0] S2MID[0] W2MID[0] _3141_/A _2590_/Q _2589_/Q VPWR VGND sg13cmos5l_mux4_1
X_1666_ _1666_/Y _2902_/Q E1END[2] VPWR VGND sg13cmos5l_nor2b_1
X_1597_ _1597_/Y _2313_/Q _1596_/X _2312_/Q VPWR VGND sg13cmos5l_o21ai_1
XANTENNA_109 N4END[6] VPWR VGND sg13cmos5l_antennanp
XFILLER_53_121 VPWR VGND sg13cmos5l_fill_1
X_2218_ _2219_/B N1END[3] E1END[3] W1END[3] _2060_/B _2767_/Q _2766_/Q VPWR VGND sg13cmos5l_mux4_1
X_2149_ _2149_/Y _2139_/Y _2142_/Y _2148_/Y VPWR VGND sg13cmos5l_o21ai_1
XANTENNA__3107__X FrameStrobe_O[12] VPWR VGND sg13cmos5l_antennanp
XFILLER_5_239 VPWR VGND sg13cmos5l_fill_1
XANTENNA__2946__X E2BEGb[7] VPWR VGND sg13cmos5l_antennanp
X_1520_ _1521_/A _1319_/B _1317_/Y _1310_/Y _1305_/X _2487_/Q _2456_/Q VPWR VGND sg13cmos5l_mux4_1
XANTENNA__3017__X NN4BEG[6] VPWR VGND sg13cmos5l_antennanp
X_1382_ _1382_/Y _2686_/Q _1382_/B VPWR VGND sg13cmos5l_nand2b_1
X_1451_ _1451_/Y S4END[2] _1126_/Y _1450_/X VPWR VGND sg13cmos5l_a21oi_1
X_3121_ SS4BEG[6] SS4END[10] VPWR VGND sg13cmos5l_buf_1
XFILLER_35_110 VPWR VGND sg13cmos5l_fill_2
X_3052_ S4BEG[5] S4END[9] VPWR VGND sg13cmos5l_buf_1
X_2003_ _2003_/X _1896_/X _1740_/B _1802_/X _1981_/Y _2792_/Q _2757_/Q VPWR VGND sg13cmos5l_mux4_1
X_2836_ _2836_/Q FrameData[30] FrameStrobe[3] VPWR VGND sg13cmos5l_dlhq_1
X_2905_ _2905_/Q FrameData[11] FrameStrobe[0] VPWR VGND sg13cmos5l_dlhq_1
X_1649_ _1649_/Y _2901_/Q _1649_/B VPWR VGND sg13cmos5l_nand2_1
X_2767_ _2767_/Q FrameData[24] FrameStrobe[5] VPWR VGND sg13cmos5l_dlhq_1
X_2698_ _2698_/Q FrameData[19] FrameStrobe[7] VPWR VGND sg13cmos5l_dlhq_1
X_1718_ _1718_/Y _2898_/Q _1714_/X _1717_/Y VPWR VGND sg13cmos5l_a21oi_1
XFILLER_46_419 VPWR VGND sg13cmos5l_fill_1
XFILLER_17_143 VPWR VGND sg13cmos5l_fill_2
X_1503_ _1503_/Y _1515_/B _1515_/A VPWR VGND sg13cmos5l_nand2b_1
X_2621_ _2621_/Q FrameData[6] FrameStrobe[9] VPWR VGND sg13cmos5l_dlhq_1
X_2552_ _2552_/Q FrameData[1] FrameStrobe[11] VPWR VGND sg13cmos5l_dlhq_1
X_2483_ _2483_/Q FrameData[28] FrameStrobe[14] VPWR VGND sg13cmos5l_dlhq_1
X_1296_ _1296_/Y N2END[3] _2660_/Q VPWR VGND sg13cmos5l_nand2_1
X_1365_ _1366_/C _2723_/Q _1362_/Y _1364_/Y VPWR VGND sg13cmos5l_a21oi_1
X_1434_ _1434_/Y _2848_/Q _1431_/X _2822_/Q VPWR VGND sg13cmos5l_o21ai_1
X_3035_ S2BEG[4] _3035_/A VPWR VGND sg13cmos5l_buf_1
X_3104_ FrameStrobe_O[9] FrameStrobe[9] VPWR VGND sg13cmos5l_buf_1
X_2819_ _2819_/Q FrameData[13] FrameStrobe[3] VPWR VGND sg13cmos5l_dlhq_1
XANTENNA__3120__X SS4BEG[5] VPWR VGND sg13cmos5l_antennanp
X_1150_ _1469_/B _2872_/Q VPWR VGND sg13cmos5l_inv_1
XANTENNA__3030__X S1BEG[3] VPWR VGND sg13cmos5l_antennanp
X_2604_ _2604_/Q FrameData[21] FrameStrobe[10] VPWR VGND sg13cmos5l_dlhq_1
X_1983_ _1983_/X W2END[1] W6END[1] _2828_/Q VPWR VGND sg13cmos5l_mux2_1
X_1417_ _1417_/Y _1417_/A _1417_/B VPWR VGND sg13cmos5l_nand2_1
X_2535_ _2535_/Q FrameData[16] FrameStrobe[12] VPWR VGND sg13cmos5l_dlhq_1
X_2466_ _2466_/Q FrameData[11] FrameStrobe[14] VPWR VGND sg13cmos5l_dlhq_1
XFILLER_28_249 VPWR VGND sg13cmos5l_decap_8
X_1279_ _2935_/A _1154_/Y _1271_/Y _1278_/Y VPWR VGND sg13cmos5l_o21ai_1
X_1348_ _1515_/A _1346_/X _1347_/X _1345_/A _1343_/X _2673_/Q _2484_/Q VPWR VGND sg13cmos5l_mux4_1
X_3018_ NN4BEG[7] NN4END[11] VPWR VGND sg13cmos5l_buf_1
X_2397_ _2397_/Q FrameData[6] FrameStrobe[16] VPWR VGND sg13cmos5l_dlhq_1
XANTENNA__3115__X SS4BEG[0] VPWR VGND sg13cmos5l_antennanp
XFILLER_47_42 VPWR VGND sg13cmos5l_fill_1
XANTENNA__2954__X E6BEG[7] VPWR VGND sg13cmos5l_antennanp
X_2320_ _2320_/Q FrameData[19] FrameStrobe[19] VPWR VGND sg13cmos5l_dlhq_1
X_2251_ _2251_/Y _2548_/Q _2251_/B VPWR VGND sg13cmos5l_nor2_1
XANTENNA__3025__X NN4BEG[14] VPWR VGND sg13cmos5l_antennanp
X_1133_ _1411_/A _2785_/Q VPWR VGND sg13cmos5l_inv_1
X_1202_ _1202_/Y _2656_/Q _1194_/X _1201_/Y VPWR VGND sg13cmos5l_o21ai_1
X_2182_ _2972_/A _2182_/A _2182_/B VPWR VGND sg13cmos5l_nor2_1
X_1966_ _1971_/A _1975_/A _1966_/B VPWR VGND sg13cmos5l_nand2_1
X_1897_ _1897_/X E6END[1] S4END[1] WW4END[3] _3035_/A _2741_/Q _2675_/Q VPWR VGND
+ sg13cmos5l_mux4_1
X_2518_ _2518_/Q FrameData[31] FrameStrobe[13] VPWR VGND sg13cmos5l_dlhq_1
X_2449_ _2449_/Q FrameData[26] FrameStrobe[15] VPWR VGND sg13cmos5l_dlhq_1
XFILLER_33_55 VPWR VGND sg13cmos5l_fill_2
XANTENNA__2949__X E6BEG[2] VPWR VGND sg13cmos5l_antennanp
X_1820_ _1820_/Y _2747_/Q _1819_/Y _2782_/Q VPWR VGND sg13cmos5l_o21ai_1
X_1751_ _1751_/Y WW4END[2] _2879_/Q VPWR VGND sg13cmos5l_nand2b_1
X_1682_ _1682_/Y _2809_/Q _1682_/B _1682_/C VPWR VGND sg13cmos5l_nand3_1
X_2303_ _2303_/Q FrameData[2] FrameStrobe[19] VPWR VGND sg13cmos5l_dlhq_1
X_2234_ _2977_/A _1784_/X _3137_/A _1905_/X _1932_/X _2907_/Q _2908_/Q VPWR VGND sg13cmos5l_mux4_1
X_1116_ _2243_/S _2516_/Q VPWR VGND sg13cmos5l_inv_1
X_2165_ _2974_/A _2163_/Y _2164_/Y _2159_/Y VPWR VGND sg13cmos5l_a21oi_1
X_2096_ _2096_/X N1END[1] E1END[1] W1END[1] _2031_/B _2671_/Q _2704_/Q VPWR VGND sg13cmos5l_mux4_1
XFILLER_21_244 VPWR VGND sg13cmos5l_fill_2
X_2998_ N4BEG[3] N4END[7] VPWR VGND sg13cmos5l_buf_1
X_1949_ _1949_/Y _2536_/Q _1922_/Y _1923_/Y _2505_/Q VPWR VGND sg13cmos5l_a22oi_1
XFILLER_29_311 VPWR VGND sg13cmos5l_fill_1
XFILLER_29_322 VPWR VGND sg13cmos5l_fill_2
X_2852_ _2852_/Q FrameData[17] FrameStrobe[2] VPWR VGND sg13cmos5l_dlhq_1
X_2921_ _2921_/L_HI VPWR VGND sg13cmos5l_tiehi
X_2783_ _2783_/Q FrameData[8] FrameStrobe[4] VPWR VGND sg13cmos5l_dlhq_1
X_1803_ _1803_/X N2MID[6] W2MID[6] S2MID[6] _2982_/A _2556_/Q _2615_/Q VPWR VGND sg13cmos5l_mux4_1
X_1596_ _1596_/X _1740_/B _1981_/Y _2905_/Q VPWR VGND sg13cmos5l_mux2_1
X_1734_ _1734_/X _2380_/Q _2385_/Q _2379_/Q _2384_/Q _1769_/B _1778_/B VPWR VGND sg13cmos5l_mux4_1
X_1665_ _1665_/X S2END[6] W1END[2] _2902_/Q VPWR VGND sg13cmos5l_mux2_1
XFILLER_26_303 VPWR VGND sg13cmos5l_fill_2
X_2217_ _3025_/A _2211_/Y _2212_/Y _2214_/Y _2216_/Y VPWR VGND sg13cmos5l_a22oi_1
X_2148_ _2148_/Y _2770_/Q _2147_/Y VPWR VGND sg13cmos5l_nor2b_1
X_2079_ _2080_/B N1END[3] W1END[3] S1END[3] _2060_/B _2893_/Q _2894_/Q VPWR VGND sg13cmos5l_mux4_1
XFILLER_1_435 VPWR VGND sg13cmos5l_fill_1
XFILLER_49_417 VPWR VGND sg13cmos5l_fill_2
XANTENNA__2962__X EE4BEG[3] VPWR VGND sg13cmos5l_antennanp
XANTENNA__3123__X SS4BEG[8] VPWR VGND sg13cmos5l_antennanp
X_1450_ _1450_/X _2654_/Q SS4END[2] VPWR VGND sg13cmos5l_and2_1
XANTENNA__3033__X S2BEG[2] VPWR VGND sg13cmos5l_antennanp
X_1381_ _1382_/B N2END[3] N4END[3] _2755_/Q VPWR VGND sg13cmos5l_mux2_1
X_3051_ S4BEG[4] S4END[8] VPWR VGND sg13cmos5l_buf_1
X_3120_ SS4BEG[5] SS4END[9] VPWR VGND sg13cmos5l_buf_1
X_2002_ _2002_/X _2031_/B _1957_/Y _1784_/X _1697_/X _2757_/Q _2792_/Q VPWR VGND sg13cmos5l_mux4_1
X_2835_ _2835_/Q FrameData[29] FrameStrobe[3] VPWR VGND sg13cmos5l_dlhq_1
X_2904_ _2904_/Q FrameData[10] FrameStrobe[0] VPWR VGND sg13cmos5l_dlhq_1
X_2766_ _2766_/Q FrameData[23] FrameStrobe[5] VPWR VGND sg13cmos5l_dlhq_1
X_1579_ _1579_/X _2031_/B _1698_/X _2854_/Q VPWR VGND sg13cmos5l_mux2_1
X_1648_ _1648_/Y _1145_/Y _1740_/B _2310_/Q VPWR VGND sg13cmos5l_a21oi_1
X_2697_ _2697_/Q FrameData[18] FrameStrobe[7] VPWR VGND sg13cmos5l_dlhq_1
X_1717_ _1717_/Y _2898_/Q _1716_/Y _2869_/Q VPWR VGND sg13cmos5l_o21ai_1
XFILLER_14_317 VPWR VGND sg13cmos5l_fill_2
XANTENNA__3118__X SS4BEG[3] VPWR VGND sg13cmos5l_antennanp
XANTENNA__2957__X E6BEG[10] VPWR VGND sg13cmos5l_antennanp
XFILLER_13_361 VPWR VGND sg13cmos5l_fill_1
X_2620_ _2620_/Q FrameData[5] FrameStrobe[9] VPWR VGND sg13cmos5l_dlhq_1
XANTENNA__3028__X S1BEG[1] VPWR VGND sg13cmos5l_antennanp
X_1433_ _1433_/Y _2821_/Q _1784_/X _1432_/Y VPWR VGND sg13cmos5l_o21ai_1
X_1502_ _1502_/Y _1515_/B _1515_/A VPWR VGND sg13cmos5l_nor2b_1
X_2551_ _2551_/Q FrameData[0] FrameStrobe[11] VPWR VGND sg13cmos5l_dlhq_1
X_2482_ _2482_/Q FrameData[27] FrameStrobe[14] VPWR VGND sg13cmos5l_dlhq_1
X_1295_ _1295_/Y S4END[3] _1121_/Y _1294_/X VPWR VGND sg13cmos5l_a21oi_1
X_1364_ _1364_/Y _2723_/Q _1363_/X _2823_/Q VPWR VGND sg13cmos5l_o21ai_1
X_3034_ S2BEG[3] _3034_/A VPWR VGND sg13cmos5l_buf_1
X_3103_ FrameStrobe_O[8] FrameStrobe[8] VPWR VGND sg13cmos5l_buf_1
XFILLER_51_423 VPWR VGND sg13cmos5l_fill_1
X_2818_ _2818_/Q FrameData[12] FrameStrobe[3] VPWR VGND sg13cmos5l_dlhq_1
X_2749_ _2749_/Q FrameData[6] FrameStrobe[5] VPWR VGND sg13cmos5l_dlhq_1
XFILLER_10_353 VPWR VGND sg13cmos5l_fill_2
XFILLER_52_32 VPWR VGND sg13cmos5l_fill_1
X_1982_ _1982_/X N1END[3] N2END[1] S2END[1] S4END[1] _2828_/Q _2762_/Q VPWR VGND sg13cmos5l_mux4_1
X_2603_ _2603_/Q FrameData[20] FrameStrobe[10] VPWR VGND sg13cmos5l_dlhq_1
X_2534_ _2534_/Q FrameData[15] FrameStrobe[12] VPWR VGND sg13cmos5l_dlhq_1
XFILLER_47_0 VPWR VGND sg13cmos5l_fill_2
X_1347_ _1347_/X N2MID[5] E2MID[5] S2MID[5] W2MID[5] _2592_/Q _2469_/Q VPWR VGND sg13cmos5l_mux4_1
X_1416_ _1417_/B N1END[0] E6END[0] N2END[2] S2END[2] _2691_/Q _2785_/Q VPWR VGND sg13cmos5l_mux4_1
X_2465_ _2465_/Q FrameData[10] FrameStrobe[14] VPWR VGND sg13cmos5l_dlhq_1
X_2396_ _2396_/Q FrameData[5] FrameStrobe[16] VPWR VGND sg13cmos5l_dlhq_1
XFILLER_51_231 VPWR VGND sg13cmos5l_fill_1
X_1278_ _1278_/Y _2850_/Q _1272_/X _1277_/Y VPWR VGND sg13cmos5l_o21ai_1
X_3017_ NN4BEG[6] NN4END[10] VPWR VGND sg13cmos5l_buf_1
XANTENNA__2970__X EE4BEG[11] VPWR VGND sg13cmos5l_antennanp
XANTENNA__3131__X UserCLKo VPWR VGND sg13cmos5l_antennanp
XFILLER_12_90 VPWR VGND sg13cmos5l_fill_1
X_1201_ _1201_/Y _2632_/Q _1201_/B VPWR VGND sg13cmos5l_nor2_1
X_2250_ _2251_/B _1912_/X _1804_/X _1377_/X _1724_/X _2579_/Q _2517_/Q VPWR VGND sg13cmos5l_mux4_1
XANTENNA__3041__X S2BEGb[2] VPWR VGND sg13cmos5l_antennanp
X_1132_ _1132_/Y EE4END[2] VPWR VGND sg13cmos5l_inv_1
X_2181_ _2182_/B _2664_/Q _2179_/X _2180_/Y VPWR VGND sg13cmos5l_a21oi_1
X_1965_ _1966_/B _1965_/A _1965_/B VPWR VGND sg13cmos5l_nand2_1
X_2517_ _2517_/Q FrameData[30] FrameStrobe[13] VPWR VGND sg13cmos5l_dlhq_1
X_1896_ _1896_/X _1895_/X _2296_/Q _2395_/Q VPWR VGND sg13cmos5l_mux2_1
X_2448_ _2448_/Q FrameData[25] FrameStrobe[15] VPWR VGND sg13cmos5l_dlhq_1
X_2379_ _2379_/Q FrameData[20] FrameStrobe[17] VPWR VGND sg13cmos5l_dlhq_1
XFILLER_17_35 VPWR VGND sg13cmos5l_fill_2
XANTENNA__3126__X SS4BEG[11] VPWR VGND sg13cmos5l_antennanp
XANTENNA__2965__X EE4BEG[6] VPWR VGND sg13cmos5l_antennanp
XFILLER_15_275 VPWR VGND sg13cmos5l_fill_2
X_1750_ _1750_/X E2END[4] W2END[4] _2879_/Q VPWR VGND sg13cmos5l_mux2_1
X_1681_ _1682_/C _2838_/Q _3036_/A VPWR VGND sg13cmos5l_nand2b_1
XANTENNA__3036__X S2BEG[5] VPWR VGND sg13cmos5l_antennanp
X_2302_ _2302_/Q _2302_/CLK _2302_/D _2924_/L_HI VPWR VGND sg13cmos5l_dfrbpq_1
X_2233_ _2978_/A _1802_/X _3138_/A _1467_/X _1825_/X _2662_/Q _2698_/Q VPWR VGND sg13cmos5l_mux4_1
X_2164_ _2164_/Y _2164_/A _2576_/Q VPWR VGND sg13cmos5l_nor2b_1
X_1115_ _1115_/Y _2702_/Q VPWR VGND sg13cmos5l_inv_1
X_2095_ _2095_/X _1784_/X _1731_/A _1899_/X _1855_/X _2671_/Q _2704_/Q VPWR VGND sg13cmos5l_mux4_1
X_2997_ N4BEG[2] N4END[6] VPWR VGND sg13cmos5l_buf_1
X_1948_ _1948_/Y _1929_/Y _1955_/A _1948_/C VPWR VGND sg13cmos5l_nand3b_1
X_1879_ _1880_/A _1856_/X _2237_/B _1855_/X _1854_/X _2452_/Q _2421_/Q VPWR VGND sg13cmos5l_mux4_1
XFILLER_29_378 VPWR VGND sg13cmos5l_fill_1
XFILLER_12_201 VPWR VGND sg13cmos5l_fill_1
X_2920_ _2920_/L_HI VPWR VGND sg13cmos5l_tiehi
X_2851_ _2851_/Q FrameData[16] FrameStrobe[2] VPWR VGND sg13cmos5l_dlhq_1
X_2782_ _2782_/Q FrameData[7] FrameStrobe[4] VPWR VGND sg13cmos5l_dlhq_1
X_1802_ _1802_/X _1801_/X _2300_/Q _2418_/Q VPWR VGND sg13cmos5l_mux2_1
X_1733_ _1769_/B _1731_/A _1732_/X _1729_/A _1727_/X _2461_/Q _2711_/Q VPWR VGND sg13cmos5l_mux4_1
X_1595_ _1595_/Y _2905_/Q _2031_/B _1594_/Y VPWR VGND sg13cmos5l_o21ai_1
X_1664_ _1664_/X N1END[2] N2END[6] S1END[0] S1END[2] _2902_/Q _2871_/Q VPWR VGND sg13cmos5l_mux4_1
XFILLER_38_175 VPWR VGND sg13cmos5l_fill_1
X_2216_ _2216_/Y _2800_/Q _2215_/X _2769_/Q VPWR VGND sg13cmos5l_a21oi_1
X_2147_ _2147_/Y _2735_/Q _2144_/Y _2146_/Y VPWR VGND sg13cmos5l_o21ai_1
X_2078_ _3178_/A _2078_/A _2078_/B VPWR VGND sg13cmos5l_nor2_1
XFILLER_30_57 VPWR VGND sg13cmos5l_fill_1
X_1380_ _1380_/X E6END[1] S2END[3] _2755_/Q VPWR VGND sg13cmos5l_mux2_1
X_3050_ S4BEG[3] S4END[7] VPWR VGND sg13cmos5l_buf_1
X_2001_ _3136_/A _2001_/A _2001_/B VPWR VGND sg13cmos5l_nand2_1
XFILLER_16_392 VPWR VGND sg13cmos5l_fill_2
X_2903_ _2903_/Q FrameData[9] FrameStrobe[0] VPWR VGND sg13cmos5l_dlhq_1
XFILLER_6_70 VPWR VGND sg13cmos5l_fill_1
X_2834_ _2834_/Q FrameData[28] FrameStrobe[3] VPWR VGND sg13cmos5l_dlhq_1
X_2765_ _2765_/Q FrameData[22] FrameStrobe[5] VPWR VGND sg13cmos5l_dlhq_1
X_2696_ _2696_/Q FrameData[17] FrameStrobe[7] VPWR VGND sg13cmos5l_dlhq_1
X_1716_ _1716_/Y _2843_/Q _1957_/Y _1715_/Y VPWR VGND sg13cmos5l_a21oi_1
X_1578_ _1578_/Y _2854_/Q _1981_/Y _1577_/Y VPWR VGND sg13cmos5l_a21oi_1
X_1647_ _1647_/Y _2901_/Q _1957_/Y VPWR VGND sg13cmos5l_nand2_1
X_3179_ WW4BEG[15] _3179_/A VPWR VGND sg13cmos5l_buf_1
XFILLER_1_222 VPWR VGND sg13cmos5l_fill_1
XANTENNA__2973__X EE4BEG[14] VPWR VGND sg13cmos5l_antennanp
XANTENNA__3134__X W1BEG[2] VPWR VGND sg13cmos5l_antennanp
X_2550_ _2550_/Q FrameData[31] FrameStrobe[12] VPWR VGND sg13cmos5l_dlhq_1
XANTENNA__3044__X S2BEGb[5] VPWR VGND sg13cmos5l_antennanp
X_1363_ _1363_/X N4END[3] E2END[3] _2725_/Q VPWR VGND sg13cmos5l_mux2_1
X_1432_ _1432_/Y _1697_/X _2821_/Q VPWR VGND sg13cmos5l_nand2b_1
X_1501_ _1501_/Y _1515_/A _1498_/X _1500_/Y VPWR VGND sg13cmos5l_o21ai_1
X_2481_ _2481_/Q FrameData[26] FrameStrobe[14] VPWR VGND sg13cmos5l_dlhq_1
X_1294_ _1294_/X _2660_/Q SS4END[3] VPWR VGND sg13cmos5l_and2_1
X_3033_ S2BEG[2] _3033_/A VPWR VGND sg13cmos5l_buf_1
X_3102_ FrameStrobe_O[7] FrameStrobe[7] VPWR VGND sg13cmos5l_buf_1
X_2817_ _2817_/Q FrameData[11] FrameStrobe[3] VPWR VGND sg13cmos5l_dlhq_1
X_2748_ _2748_/Q FrameData[5] FrameStrobe[5] VPWR VGND sg13cmos5l_dlhq_1
X_2679_ _2679_/Q FrameData[0] FrameStrobe[7] VPWR VGND sg13cmos5l_dlhq_1
XFILLER_42_435 VPWR VGND sg13cmos5l_fill_1
XANTENNA__3129__X SS4BEG[14] VPWR VGND sg13cmos5l_antennanp
XANTENNA__2968__X EE4BEG[9] VPWR VGND sg13cmos5l_antennanp
XFILLER_7_0 VPWR VGND sg13cmos5l_fill_2
X_1981_ _1981_/Y _1117_/Y _2475_/Q _1980_/Y VPWR VGND sg13cmos5l_a21oi_1
XANTENNA__3039__X S2BEGb[0] VPWR VGND sg13cmos5l_antennanp
X_2602_ _2602_/Q FrameData[19] FrameStrobe[10] VPWR VGND sg13cmos5l_dlhq_1
X_2533_ _2533_/Q FrameData[14] FrameStrobe[12] VPWR VGND sg13cmos5l_dlhq_1
X_1346_ _1346_/X N2MID[4] S2MID[4] E2MID[4] _3035_/A _2810_/Q _2839_/Q VPWR VGND sg13cmos5l_mux4_1
X_1415_ _1415_/Y _1411_/Y _1413_/Y _1414_/Y VPWR VGND sg13cmos5l_o21ai_1
X_2464_ _2464_/Q FrameData[9] FrameStrobe[14] VPWR VGND sg13cmos5l_dlhq_1
X_2395_ _2395_/Q FrameData[4] FrameStrobe[16] VPWR VGND sg13cmos5l_dlhq_1
X_1277_ _1277_/Y _1274_/Y _1276_/Y _2825_/Q VPWR VGND sg13cmos5l_a21oi_1
X_3016_ NN4BEG[5] NN4END[9] VPWR VGND sg13cmos5l_buf_1
XFILLER_15_435 VPWR VGND sg13cmos5l_fill_1
X_1200_ _1201_/B _2692_/Q _1196_/Y _1199_/Y VPWR VGND sg13cmos5l_a21oi_1
X_2180_ _2180_/Y _2664_/Q _2178_/Y _2638_/Q VPWR VGND sg13cmos5l_o21ai_1
X_1131_ _1131_/Y W2MID[2] VPWR VGND sg13cmos5l_inv_1
X_1964_ _1965_/B _2534_/Q _1907_/Y _1916_/B _2567_/Q VPWR VGND sg13cmos5l_a22oi_1
X_1895_ _1895_/X _1878_/Y _1894_/Y _1888_/Y VPWR VGND sg13cmos5l_a21o_1
X_2516_ _2516_/Q FrameData[29] FrameStrobe[13] VPWR VGND sg13cmos5l_dlhq_1
X_2447_ _2447_/Q FrameData[24] FrameStrobe[15] VPWR VGND sg13cmos5l_dlhq_1
X_1329_ _1329_/X S2END[3] S4END[3] _2693_/Q VPWR VGND sg13cmos5l_mux2_1
X_2378_ _2378_/Q FrameData[19] FrameStrobe[17] VPWR VGND sg13cmos5l_dlhq_1
XANTENNA__2981__X N2BEG[2] VPWR VGND sg13cmos5l_antennanp
XANTENNA__3142__X W2BEG[6] VPWR VGND sg13cmos5l_antennanp
XFILLER_23_90 VPWR VGND sg13cmos5l_fill_2
X_2301_ _2301_/Q _2302_/CLK _2301_/D _2925_/L_HI VPWR VGND sg13cmos5l_dfrbpq_1
X_1680_ _1682_/B _2838_/Q _3141_/A VPWR VGND sg13cmos5l_nand2_1
XANTENNA__3052__X S4BEG[5] VPWR VGND sg13cmos5l_antennanp
X_1114_ _1114_/Y S4END[2] VPWR VGND sg13cmos5l_inv_1
X_2232_ _3007_/A N2END[2] N4END[1] E6END[1] _1784_/X _2834_/Q _2861_/Q VPWR VGND sg13cmos5l_mux4_1
X_2163_ _2163_/Y _2604_/Q _1784_/X _2162_/Y VPWR VGND sg13cmos5l_o21ai_1
X_2094_ _3132_/A _1802_/X _1318_/B _3034_/A _1368_/X _2321_/Q _2320_/Q VPWR VGND sg13cmos5l_mux4_1
X_2996_ N4BEG[1] N4END[5] VPWR VGND sg13cmos5l_buf_1
X_1947_ _1948_/C _1916_/X _1919_/X _1946_/X VPWR VGND sg13cmos5l_a21o_1
X_1878_ _1878_/Y _2432_/Q _1494_/Y _1877_/Y VPWR VGND sg13cmos5l_a21oi_1
XANTENNA__3137__X W2BEG[1] VPWR VGND sg13cmos5l_antennanp
XANTENNA__2976__X N1BEG[1] VPWR VGND sg13cmos5l_antennanp
XFILLER_18_90 VPWR VGND sg13cmos5l_fill_2
XFILLER_47_198 VPWR VGND sg13cmos5l_fill_2
X_2850_ _2850_/Q FrameData[15] FrameStrobe[2] VPWR VGND sg13cmos5l_dlhq_1
X_2781_ _2781_/Q FrameData[6] FrameStrobe[4] VPWR VGND sg13cmos5l_dlhq_1
X_1801_ _1801_/X _1797_/X _1800_/X _1801_/S VPWR VGND sg13cmos5l_mux2_1
X_1732_ _1732_/X N2MID[5] E2MID[5] S2MID[5] W2MID[5] _2497_/Q _2496_/Q VPWR VGND sg13cmos5l_mux4_1
X_1663_ _2984_/A _2900_/Q _1661_/Y _1662_/Y VPWR VGND sg13cmos5l_o21ai_1
XANTENNA__3047__X S4BEG[0] VPWR VGND sg13cmos5l_antennanp
XFILLER_22_0 VPWR VGND sg13cmos5l_fill_2
X_1594_ _1594_/Y _1542_/X _2905_/Q VPWR VGND sg13cmos5l_nand2b_1
X_2215_ _2215_/X E1END[0] _1896_/X _2764_/Q VPWR VGND sg13cmos5l_mux2_1
X_2146_ _2146_/Y _2735_/Q _2145_/X _2804_/Q VPWR VGND sg13cmos5l_a21oi_1
X_2077_ _2078_/B _2323_/Q _2077_/B VPWR VGND sg13cmos5l_nor2_1
X_2979_ N2BEG[0] _2979_/A VPWR VGND sg13cmos5l_buf_1
X_2000_ _2001_/B _2796_/Q _2000_/B _2000_/C VPWR VGND sg13cmos5l_nand3_1
X_2833_ _2833_/Q FrameData[27] FrameStrobe[3] VPWR VGND sg13cmos5l_dlhq_1
X_2902_ _2902_/Q FrameData[8] FrameStrobe[0] VPWR VGND sg13cmos5l_dlhq_1
X_1646_ _3036_/A _1635_/Y _1637_/Y _1643_/Y _1645_/Y VPWR VGND sg13cmos5l_a22oi_1
X_2764_ _2764_/Q FrameData[21] FrameStrobe[5] VPWR VGND sg13cmos5l_dlhq_1
X_2695_ _2695_/Q FrameData[16] FrameStrobe[7] VPWR VGND sg13cmos5l_dlhq_1
X_1715_ _1715_/Y _2843_/Q _1740_/B VPWR VGND sg13cmos5l_nor2b_1
X_1577_ _1577_/Y _2854_/Q _1740_/B VPWR VGND sg13cmos5l_nor2b_1
X_3178_ WW4BEG[14] _3178_/A VPWR VGND sg13cmos5l_buf_1
X_2129_ _2130_/A _2060_/B _1896_/X _1784_/X _1802_/X _2734_/Q _2733_/Q VPWR VGND sg13cmos5l_mux4_1
XANTENNA__3150__X W2BEGb[6] VPWR VGND sg13cmos5l_antennanp
X_1500_ _1500_/Y _1499_/X _1515_/B VPWR VGND sg13cmos5l_nand2b_1
X_2480_ _2480_/Q FrameData[25] FrameStrobe[14] VPWR VGND sg13cmos5l_dlhq_1
X_1293_ _1299_/B _2633_/Q _1291_/Y _1292_/Y VPWR VGND sg13cmos5l_a21oi_1
X_1362_ _1362_/Y W6END[1] _2725_/Q _1361_/Y VPWR VGND sg13cmos5l_a21oi_1
X_1431_ _1431_/X _1740_/B _1957_/Y _2821_/Q VPWR VGND sg13cmos5l_mux2_1
X_3101_ FrameStrobe_O[6] FrameStrobe[6] VPWR VGND sg13cmos5l_buf_1
XANTENNA__3060__X S4BEG[13] VPWR VGND sg13cmos5l_antennanp
X_3032_ S2BEG[1] _3032_/A VPWR VGND sg13cmos5l_buf_1
X_2816_ _2816_/Q FrameData[10] FrameStrobe[3] VPWR VGND sg13cmos5l_dlhq_1
X_1629_ _3141_/A _2314_/Q _1628_/Y _1621_/Y VPWR VGND sg13cmos5l_o21ai_1
X_2747_ _2747_/Q FrameData[4] FrameStrobe[5] VPWR VGND sg13cmos5l_dlhq_1
X_2678_ _2678_/Q FrameData[31] FrameStrobe[8] VPWR VGND sg13cmos5l_dlhq_1
XFILLER_39_271 VPWR VGND sg13cmos5l_fill_2
XFILLER_14_116 VPWR VGND sg13cmos5l_fill_2
XFILLER_52_89 VPWR VGND sg13cmos5l_fill_1
XFILLER_6_304 VPWR VGND sg13cmos5l_fill_1
XANTENNA__2984__X N2BEG[5] VPWR VGND sg13cmos5l_antennanp
XANTENNA__3145__X W2BEGb[1] VPWR VGND sg13cmos5l_antennanp
X_1980_ _1980_/Y _1971_/Y _1979_/Y _2475_/Q VPWR VGND sg13cmos5l_a21oi_1
XANTENNA__3055__X S4BEG[8] VPWR VGND sg13cmos5l_antennanp
X_2601_ _2601_/Q FrameData[18] FrameStrobe[10] VPWR VGND sg13cmos5l_dlhq_1
X_2532_ _2532_/Q FrameData[13] FrameStrobe[12] VPWR VGND sg13cmos5l_dlhq_1
X_2463_ _2463_/Q FrameData[8] FrameStrobe[14] VPWR VGND sg13cmos5l_dlhq_1
X_1276_ _1276_/Y _2851_/Q _1275_/X _1153_/Y VPWR VGND sg13cmos5l_a21oi_1
X_1345_ _1345_/Y _1345_/A VPWR VGND sg13cmos5l_inv_1
X_1414_ _1414_/Y _1417_/A _1409_/X _1135_/Y VPWR VGND sg13cmos5l_a21oi_1
X_3015_ NN4BEG[4] NN4END[8] VPWR VGND sg13cmos5l_buf_1
X_2394_ _2394_/Q FrameData[3] FrameStrobe[16] VPWR VGND sg13cmos5l_dlhq_1
XFILLER_27_274 VPWR VGND sg13cmos5l_fill_2
XFILLER_27_285 VPWR VGND sg13cmos5l_fill_2
XFILLER_47_89 VPWR VGND sg13cmos5l_fill_2
XANTENNA__2979__X N2BEG[0] VPWR VGND sg13cmos5l_antennanp
X_1130_ _1130_/Y S2MID[2] VPWR VGND sg13cmos5l_inv_1
X_1963_ _1965_/A _2763_/Q _1961_/Y _1962_/Y _2502_/Q VPWR VGND sg13cmos5l_a22oi_1
X_1894_ _1894_/Y _1889_/Y _1890_/Y _1892_/Y _1893_/Y VPWR VGND sg13cmos5l_a22oi_1
XFILLER_52_0 VPWR VGND sg13cmos5l_fill_2
X_2515_ _2515_/Q FrameData[28] FrameStrobe[13] VPWR VGND sg13cmos5l_dlhq_1
X_2446_ _2446_/Q FrameData[23] FrameStrobe[15] VPWR VGND sg13cmos5l_dlhq_1
X_1259_ _1259_/Y _2788_/Q E2END[5] VPWR VGND sg13cmos5l_nor2b_1
X_1328_ _1328_/Y _1326_/Y _1327_/Y _2655_/Q VPWR VGND sg13cmos5l_o21ai_1
X_2377_ _2377_/Q FrameData[18] FrameStrobe[17] VPWR VGND sg13cmos5l_dlhq_1
X_2300_ _2300_/Q _2300_/CLK _2300_/D _2926_/L_HI VPWR VGND sg13cmos5l_dfrbpq_1
X_2231_ _3008_/A N2END[3] N4END[2] E6END[0] _1802_/X _2833_/Q _2798_/Q VPWR VGND sg13cmos5l_mux4_1
X_1113_ _1113_/Y W6END[0] VPWR VGND sg13cmos5l_inv_1
X_2162_ _2162_/Y _2604_/Q _1731_/Y _2609_/Q VPWR VGND sg13cmos5l_a21oi_1
X_2093_ _3133_/A _1981_/Y _1724_/X _3031_/A _1727_/X _2911_/Q _2910_/Q VPWR VGND sg13cmos5l_mux4_1
X_2995_ N4BEG[0] N4END[4] VPWR VGND sg13cmos5l_buf_1
X_1946_ _1946_/X _1946_/A _1946_/B VPWR VGND sg13cmos5l_and2_1
X_1877_ _1877_/Y _2432_/Q _1877_/B VPWR VGND sg13cmos5l_nor2_1
XFILLER_29_303 VPWR VGND sg13cmos5l_fill_1
X_2429_ _2429_/Q FrameData[6] FrameStrobe[15] VPWR VGND sg13cmos5l_dlhq_1
XFILLER_44_57 VPWR VGND sg13cmos5l_fill_2
XFILLER_4_435 VPWR VGND sg13cmos5l_fill_1
XANTENNA__2992__X N2BEGb[5] VPWR VGND sg13cmos5l_antennanp
XANTENNA__3153__X W6BEG[1] VPWR VGND sg13cmos5l_antennanp
XFILLER_43_372 VPWR VGND sg13cmos5l_fill_2
X_1800_ _1800_/X _1798_/X _1799_/X _1800_/S VPWR VGND sg13cmos5l_mux2_1
X_2780_ _2780_/Q FrameData[5] FrameStrobe[4] VPWR VGND sg13cmos5l_dlhq_1
X_1731_ _1731_/Y _1731_/A VPWR VGND sg13cmos5l_inv_1
X_1662_ _1662_/Y _1651_/Y _1653_/X _2900_/Q VPWR VGND sg13cmos5l_o21ai_1
XANTENNA__3063__X FrameData_O[0] VPWR VGND sg13cmos5l_antennanp
X_1593_ _1593_/Y _2312_/Q _1593_/B VPWR VGND sg13cmos5l_nand2b_1
X_2214_ _2214_/Y N1END[0] _2764_/Q _2213_/Y VPWR VGND sg13cmos5l_o21ai_1
XFILLER_15_0 VPWR VGND sg13cmos5l_fill_1
X_2145_ _2145_/X _1740_/B _2031_/B _2772_/Q VPWR VGND sg13cmos5l_mux2_1
X_2076_ _2077_/B N1END[0] W1END[0] S1END[0] _1896_/X _2324_/Q _2325_/Q VPWR VGND sg13cmos5l_mux4_1
X_2978_ N1BEG[3] _2978_/A VPWR VGND sg13cmos5l_buf_1
X_1929_ _1929_/Y _2537_/Q _1911_/Y _1924_/Y _1928_/Y _1918_/Y VPWR VGND sg13cmos5l_a221oi_1
XFILLER_1_416 VPWR VGND sg13cmos5l_fill_1
XANTENNA__3148__X W2BEGb[4] VPWR VGND sg13cmos5l_antennanp
XANTENNA__2987__X N2BEGb[0] VPWR VGND sg13cmos5l_antennanp
X_2832_ _2832_/Q FrameData[26] FrameStrobe[3] VPWR VGND sg13cmos5l_dlhq_1
X_2901_ _2901_/Q FrameData[7] FrameStrobe[0] VPWR VGND sg13cmos5l_dlhq_1
X_2763_ _2763_/Q FrameData[20] FrameStrobe[5] VPWR VGND sg13cmos5l_dlhq_1
XANTENNA__3058__X S4BEG[11] VPWR VGND sg13cmos5l_antennanp
X_1576_ _1576_/X _2060_/B _1896_/X _1784_/X _1802_/X _2875_/Q _2854_/Q VPWR VGND sg13cmos5l_mux4_1
X_1645_ _1645_/Y _1122_/Y _1644_/X _2876_/Q VPWR VGND sg13cmos5l_a21oi_1
X_2694_ _2694_/Q FrameData[15] FrameStrobe[7] VPWR VGND sg13cmos5l_dlhq_1
X_1714_ _1714_/X _1784_/X _1283_/Y _2843_/Q VPWR VGND sg13cmos5l_mux2_1
X_3177_ WW4BEG[13] _3177_/A VPWR VGND sg13cmos5l_buf_1
X_2128_ _2128_/X E1END[2] W1END[2] _1740_/B _2031_/B _2734_/Q _2733_/Q VPWR VGND sg13cmos5l_mux4_1
X_2059_ _2059_/X E1END[3] W1END[3] _1740_/B _2031_/B _2322_/Q _2890_/Q VPWR VGND sg13cmos5l_mux4_1
X_1430_ _1430_/Y _2745_/Q _1429_/X _1428_/Y VPWR VGND sg13cmos5l_o21ai_1
X_1292_ _1292_/Y _2633_/Q _1289_/X _2695_/Q VPWR VGND sg13cmos5l_o21ai_1
X_1361_ _1361_/Y _2725_/Q W2END[3] VPWR VGND sg13cmos5l_nor2b_1
X_3031_ S2BEG[0] _3031_/A VPWR VGND sg13cmos5l_buf_1
X_3100_ FrameStrobe_O[5] FrameStrobe[5] VPWR VGND sg13cmos5l_buf_1
X_2815_ _2815_/Q FrameData[9] FrameStrobe[3] VPWR VGND sg13cmos5l_dlhq_1
X_2746_ _2746_/Q FrameData[3] FrameStrobe[5] VPWR VGND sg13cmos5l_dlhq_1
X_1559_ _1559_/Y _2759_/Q _1558_/Y _2758_/Q VPWR VGND sg13cmos5l_o21ai_1
X_1628_ _1628_/Y _2886_/Q _1622_/X _1627_/X VPWR VGND sg13cmos5l_o21ai_1
X_2677_ _2677_/Q FrameData[30] FrameStrobe[8] VPWR VGND sg13cmos5l_dlhq_1
XFILLER_39_294 VPWR VGND sg13cmos5l_fill_2
XFILLER_10_323 VPWR VGND sg13cmos5l_fill_1
XFILLER_52_57 VPWR VGND sg13cmos5l_fill_1
XANTENNA__3161__X W6BEG[9] VPWR VGND sg13cmos5l_antennanp
X_2600_ _2600_/Q FrameData[17] FrameStrobe[10] VPWR VGND sg13cmos5l_dlhq_1
X_1413_ _1413_/Y _2785_/Q _1412_/X _2718_/Q VPWR VGND sg13cmos5l_o21ai_1
X_2531_ _2531_/Q FrameData[12] FrameStrobe[12] VPWR VGND sg13cmos5l_dlhq_1
X_2462_ _2462_/Q FrameData[7] FrameStrobe[14] VPWR VGND sg13cmos5l_dlhq_1
X_2393_ _2393_/Q FrameData[2] FrameStrobe[16] VPWR VGND sg13cmos5l_dlhq_1
XANTENNA__3071__X FrameData_O[8] VPWR VGND sg13cmos5l_antennanp
X_1275_ _1275_/X E2END[5] W1END[1] _2826_/Q VPWR VGND sg13cmos5l_mux2_1
X_1344_ _1345_/A N2END[4] E2END[4] SS4END[2] W2END[4] _2812_/Q _2811_/Q VPWR VGND
+ sg13cmos5l_mux4_1
X_3014_ NN4BEG[3] NN4END[7] VPWR VGND sg13cmos5l_buf_1
X_2729_ _2729_/Q FrameData[18] FrameStrobe[6] VPWR VGND sg13cmos5l_dlhq_1
XANTENNA__2995__X N4BEG[0] VPWR VGND sg13cmos5l_antennanp
XANTENNA__3156__X W6BEG[4] VPWR VGND sg13cmos5l_antennanp
XFILLER_26_8 VPWR VGND sg13cmos5l_fill_1
X_1962_ _1962_/Y _1962_/A _1961_/A VPWR VGND sg13cmos5l_nor2b_1
XANTENNA__3066__X FrameData_O[3] VPWR VGND sg13cmos5l_antennanp
X_1893_ _1893_/Y _2530_/Q _1487_/Y _1488_/Y _2367_/Q _1891_/X VPWR VGND sg13cmos5l_a221oi_1
XFILLER_45_0 VPWR VGND sg13cmos5l_fill_1
X_2514_ _2514_/Q FrameData[27] FrameStrobe[13] VPWR VGND sg13cmos5l_dlhq_1
X_2445_ _2445_/Q FrameData[22] FrameStrobe[15] VPWR VGND sg13cmos5l_dlhq_1
X_2376_ _2376_/Q FrameData[17] FrameStrobe[17] VPWR VGND sg13cmos5l_dlhq_1
X_1189_ _1189_/Y _2885_/Q _1188_/Y _1184_/S VPWR VGND sg13cmos5l_a21oi_1
X_1258_ _1258_/Y S1END[1] _2788_/Q _1257_/Y VPWR VGND sg13cmos5l_a21oi_1
X_1327_ _1327_/Y W2END[3] _2693_/Q _2631_/Q VPWR VGND sg13cmos5l_o21ai_1
XFILLER_12_429 VPWR VGND sg13cmos5l_fill_1
X_2230_ _3009_/A N2END[0] N4END[3] W6END[1] _1981_/Y _2832_/Q _2860_/Q VPWR VGND sg13cmos5l_mux4_1
X_1112_ _1112_/Y S1END[2] VPWR VGND sg13cmos5l_inv_1
X_2161_ _2164_/A _2604_/Q _1827_/Y _2160_/Y VPWR VGND sg13cmos5l_a21oi_1
X_2092_ _3134_/A _1957_/Y _3032_/A _1905_/X _1932_/X _2917_/Q _2918_/Q VPWR VGND sg13cmos5l_mux4_1
XFILLER_9_50 VPWR VGND sg13cmos5l_fill_2
X_2994_ N2BEGb[7] N2MID[7] VPWR VGND sg13cmos5l_buf_1
X_1945_ _1946_/B _2531_/Q _1922_/Y _1927_/A _2603_/Q VPWR VGND sg13cmos5l_a22oi_1
X_1876_ _1877_/B _1803_/X _1804_/X _1827_/A _1825_/X _2514_/Q _2513_/Q VPWR VGND sg13cmos5l_mux4_1
X_2428_ _2428_/Q FrameData[5] FrameStrobe[15] VPWR VGND sg13cmos5l_dlhq_1
X_2359_ _2359_/Q FrameData[0] FrameStrobe[17] VPWR VGND sg13cmos5l_dlhq_1
XFILLER_8_208 VPWR VGND sg13cmos5l_fill_2
XFILLER_47_112 VPWR VGND sg13cmos5l_fill_1
X_1592_ _1593_/B _2060_/B _1896_/X _1784_/X _1802_/X _2313_/Q _2905_/Q VPWR VGND sg13cmos5l_mux4_1
X_1730_ _1731_/A N2MID[4] S2MID[4] W2MID[4] _3036_/A _2840_/Q _2778_/Q VPWR VGND sg13cmos5l_mux4_1
X_1661_ _1661_/Y _1653_/A _1654_/X _1660_/Y VPWR VGND sg13cmos5l_a21oi_1
X_2213_ _2213_/Y _1603_/A _2764_/Q _2800_/Q VPWR VGND sg13cmos5l_a21oi_1
X_2144_ _2144_/Y E1END[3] _2772_/Q _2143_/Y VPWR VGND sg13cmos5l_o21ai_1
XFILLER_34_340 VPWR VGND sg13cmos5l_fill_2
X_2075_ _2078_/A _2075_/A _2075_/B VPWR VGND sg13cmos5l_nor2_1
X_2977_ N1BEG[2] _2977_/A VPWR VGND sg13cmos5l_buf_1
X_1928_ _1928_/Y _2571_/Q _1925_/Y _1927_/A _2570_/Q VPWR VGND sg13cmos5l_a22oi_1
X_1859_ _1859_/X _2333_/Q _2332_/Q _1870_/S VPWR VGND sg13cmos5l_mux2_1
XFILLER_17_329 VPWR VGND sg13cmos5l_fill_2
XFILLER_25_395 VPWR VGND sg13cmos5l_fill_2
XANTENNA__3164__X WW4BEG[0] VPWR VGND sg13cmos5l_antennanp
X_2900_ _2900_/Q FrameData[6] FrameStrobe[0] VPWR VGND sg13cmos5l_dlhq_1
X_2831_ _2831_/Q FrameData[25] FrameStrobe[3] VPWR VGND sg13cmos5l_dlhq_1
X_2762_ _2762_/Q FrameData[19] FrameStrobe[5] VPWR VGND sg13cmos5l_dlhq_1
X_1713_ _1713_/X _2060_/B _1896_/X _1802_/X _1981_/Y _2898_/Q _2843_/Q VPWR VGND sg13cmos5l_mux4_1
XANTENNA__3074__X FrameData_O[11] VPWR VGND sg13cmos5l_antennanp
X_1575_ _2938_/A _1560_/Y _1566_/Y _1574_/Y VPWR VGND sg13cmos5l_o21ai_1
X_1644_ _1644_/X N1END[2] S1END[2] N2END[6] S2END[6] _2855_/Q _2877_/Q VPWR VGND sg13cmos5l_mux4_1
X_2693_ _2693_/Q FrameData[14] FrameStrobe[7] VPWR VGND sg13cmos5l_dlhq_1
X_3176_ WW4BEG[12] _3176_/A VPWR VGND sg13cmos5l_buf_1
X_2127_ _3027_/A _1784_/X _1318_/B _2934_/A _1368_/X _2773_/Q _2740_/Q VPWR VGND sg13cmos5l_mux4_1
XFILLER_41_118 VPWR VGND sg13cmos5l_fill_2
X_2058_ _2058_/Y _1108_/Y _2055_/X _1109_/Y VPWR VGND sg13cmos5l_a21oi_1
XFILLER_41_48 VPWR VGND sg13cmos5l_fill_1
XANTENNA__2998__X N4BEG[3] VPWR VGND sg13cmos5l_antennanp
XANTENNA__3159__X W6BEG[7] VPWR VGND sg13cmos5l_antennanp
X_1360_ _1366_/B _2723_/Q _1357_/Y _1358_/Y _1359_/Y _2823_/Q VPWR VGND sg13cmos5l_a221oi_1
X_1291_ _1291_/Y W2END[3] _1121_/Y _1290_/X VPWR VGND sg13cmos5l_a21oi_1
X_3030_ S1BEG[3] _3030_/A VPWR VGND sg13cmos5l_buf_1
XANTENNA__3069__X FrameData_O[6] VPWR VGND sg13cmos5l_antennanp
XFILLER_11_18 VPWR VGND sg13cmos5l_fill_1
X_2814_ _2814_/Q FrameData[8] FrameStrobe[3] VPWR VGND sg13cmos5l_dlhq_1
X_2745_ _2745_/Q FrameData[2] FrameStrobe[5] VPWR VGND sg13cmos5l_dlhq_1
X_2676_ _2676_/Q FrameData[29] FrameStrobe[8] VPWR VGND sg13cmos5l_dlhq_1
X_1489_ _1489_/Y _1882_/A _1882_/B VPWR VGND sg13cmos5l_nand2b_1
X_1558_ _1558_/Y _2689_/Q _1981_/Y _1557_/Y VPWR VGND sg13cmos5l_a21oi_1
X_1627_ _1627_/X _2315_/Q _1623_/X _1626_/Y VPWR VGND sg13cmos5l_a21o_1
XFILLER_14_118 VPWR VGND sg13cmos5l_fill_1
X_3159_ W6BEG[7] W6END[9] VPWR VGND sg13cmos5l_buf_1
XFILLER_18_435 VPWR VGND sg13cmos5l_fill_1
X_2530_ _2530_/Q FrameData[11] FrameStrobe[12] VPWR VGND sg13cmos5l_dlhq_1
X_1343_ _1343_/X NN4END[1] EE4END[1] S4END[1] _3033_/A _2706_/Q _2644_/Q VPWR VGND
+ sg13cmos5l_mux4_1
X_1412_ _1412_/X _2031_/B _1957_/Y _2691_/Q VPWR VGND sg13cmos5l_mux2_1
X_2461_ _2461_/Q FrameData[6] FrameStrobe[14] VPWR VGND sg13cmos5l_dlhq_1
X_2392_ _2392_/Q FrameData[1] FrameStrobe[16] VPWR VGND sg13cmos5l_dlhq_1
XFILLER_24_405 VPWR VGND sg13cmos5l_fill_1
X_1274_ _1274_/Y _2851_/Q _1274_/B VPWR VGND sg13cmos5l_nand2b_1
X_3013_ NN4BEG[2] NN4END[6] VPWR VGND sg13cmos5l_buf_1
X_2728_ _2728_/Q FrameData[17] FrameStrobe[6] VPWR VGND sg13cmos5l_dlhq_1
X_2659_ _2659_/Q FrameData[12] FrameStrobe[8] VPWR VGND sg13cmos5l_dlhq_1
XANTENNA__3172__X WW4BEG[8] VPWR VGND sg13cmos5l_antennanp
X_1961_ _1961_/Y _1961_/A _1962_/A VPWR VGND sg13cmos5l_nor2b_1
X_1892_ _1892_/Y _2728_/Q _1883_/B _1880_/Y VPWR VGND sg13cmos5l_a21oi_1
X_2513_ _2513_/Q FrameData[26] FrameStrobe[13] VPWR VGND sg13cmos5l_dlhq_1
XANTENNA__3082__X FrameData_O[19] VPWR VGND sg13cmos5l_antennanp
XFILLER_38_0 VPWR VGND sg13cmos5l_fill_2
X_1326_ _1326_/Y W6END[1] _2693_/Q VPWR VGND sg13cmos5l_nor2b_1
X_2444_ _2444_/Q FrameData[21] FrameStrobe[15] VPWR VGND sg13cmos5l_dlhq_1
X_2375_ _2375_/Q FrameData[16] FrameStrobe[17] VPWR VGND sg13cmos5l_dlhq_1
XFILLER_17_17 VPWR VGND sg13cmos5l_fill_1
XFILLER_49_390 VPWR VGND sg13cmos5l_fill_2
X_1188_ _1188_/Y W1END[3] _2883_/Q _1187_/Y VPWR VGND sg13cmos5l_a21oi_1
X_1257_ _1257_/Y _2788_/Q N1END[1] VPWR VGND sg13cmos5l_nor2b_1
XANTENNA__3167__X WW4BEG[3] VPWR VGND sg13cmos5l_antennanp
XFILLER_7_434 VPWR VGND sg13cmos5l_fill_2
XFILLER_38_327 VPWR VGND sg13cmos5l_fill_1
X_2160_ _2160_/Y _2604_/Q _1899_/X _2609_/Q VPWR VGND sg13cmos5l_o21ai_1
X_1111_ _1603_/A W1END[0] VPWR VGND sg13cmos5l_inv_1
X_2091_ _3135_/A _2060_/B _3033_/A _1467_/X _1825_/X _2641_/Q _2672_/Q VPWR VGND sg13cmos5l_mux4_1
XANTENNA__3077__X FrameData_O[14] VPWR VGND sg13cmos5l_antennanp
X_2993_ N2BEGb[6] N2MID[6] VPWR VGND sg13cmos5l_buf_1
X_1944_ _1946_/A _2598_/Q _1923_/Y _1925_/Y _2663_/Q VPWR VGND sg13cmos5l_a22oi_1
X_1875_ _2060_/B _2430_/Q _1873_/Y _1874_/Y VPWR VGND sg13cmos5l_o21ai_1
X_2427_ _2427_/Q FrameData[4] FrameStrobe[15] VPWR VGND sg13cmos5l_dlhq_1
X_1309_ _1309_/X N2END[0] EE4END[1] _2650_/Q VPWR VGND sg13cmos5l_mux2_1
X_2358_ _2358_/Q FrameData[31] FrameStrobe[18] VPWR VGND sg13cmos5l_dlhq_1
X_2289_ _2297_/D _2297_/Q _2288_/Y _2289_/S VPWR VGND sg13cmos5l_mux2_1
XFILLER_4_415 VPWR VGND sg13cmos5l_fill_1
XFILLER_28_360 VPWR VGND sg13cmos5l_fill_1
X_1591_ _3038_/A _2829_/Q _1590_/Y _1583_/Y VPWR VGND sg13cmos5l_o21ai_1
X_1660_ _1660_/Y _2310_/Q _1658_/Y _1659_/Y VPWR VGND sg13cmos5l_a21oi_1
XFILLER_53_105 VPWR VGND sg13cmos5l_fill_1
X_2212_ _2212_/Y _2212_/A _2769_/Q VPWR VGND sg13cmos5l_nor2b_1
X_2143_ _2143_/Y W1END[3] _2772_/Q VPWR VGND sg13cmos5l_nand2b_1
X_2074_ _2075_/B _2325_/Q _2073_/Y _2323_/Q VPWR VGND sg13cmos5l_o21ai_1
X_2976_ N1BEG[1] _2976_/A VPWR VGND sg13cmos5l_buf_1
X_1927_ _1927_/Y _1927_/A VPWR VGND sg13cmos5l_inv_1
X_1858_ _1863_/B _1856_/X _2237_/B _1855_/X _1854_/X _2482_/Q _2449_/Q VPWR VGND sg13cmos5l_mux4_1
X_1789_ _1797_/S _1788_/A _1786_/Y _1788_/Y VPWR VGND sg13cmos5l_o21ai_1
XFILLER_29_135 VPWR VGND sg13cmos5l_fill_2
X_2830_ _2830_/Q FrameData[24] FrameStrobe[3] VPWR VGND sg13cmos5l_dlhq_1
XANTENNA_1 E2MID[6] VPWR VGND sg13cmos5l_antennanp
XFILLER_6_52 VPWR VGND sg13cmos5l_fill_1
X_1643_ _1643_/Y _2877_/Q _1641_/Y _1642_/Y VPWR VGND sg13cmos5l_o21ai_1
X_2761_ _2761_/Q FrameData[18] FrameStrobe[5] VPWR VGND sg13cmos5l_dlhq_1
X_2692_ _2692_/Q FrameData[13] FrameStrobe[7] VPWR VGND sg13cmos5l_dlhq_1
X_1712_ _1712_/Y _2869_/Q _1706_/X _1711_/Y VPWR VGND sg13cmos5l_o21ai_1
X_1574_ _1574_/Y _2758_/Q _1567_/X _1573_/Y VPWR VGND sg13cmos5l_o21ai_1
XANTENNA__3090__X FrameData_O[27] VPWR VGND sg13cmos5l_antennanp
XFILLER_20_0 VPWR VGND sg13cmos5l_fill_2
X_3175_ WW4BEG[11] WW4END[15] VPWR VGND sg13cmos5l_buf_1
X_2126_ _3028_/A _1802_/X _1724_/X _2931_/A _1727_/X _2739_/Q _2738_/Q VPWR VGND sg13cmos5l_mux4_1
X_2057_ _2057_/Y _2914_/Q _2057_/B VPWR VGND sg13cmos5l_nand2_1
X_2959_ EE4BEG[0] EE4END[4] VPWR VGND sg13cmos5l_buf_1
XFILLER_9_326 VPWR VGND sg13cmos5l_fill_1
XANTENNA__3175__X WW4BEG[11] VPWR VGND sg13cmos5l_antennanp
X_1290_ _1290_/X W6END[1] _2660_/Q VPWR VGND sg13cmos5l_and2_1
X_2813_ _2813_/Q FrameData[7] FrameStrobe[3] VPWR VGND sg13cmos5l_dlhq_1
XANTENNA__3085__X FrameData_O[22] VPWR VGND sg13cmos5l_antennanp
X_1626_ _1626_/Y _2315_/Q _1625_/Y _2886_/Q VPWR VGND sg13cmos5l_o21ai_1
X_2744_ _2744_/Q FrameData[1] FrameStrobe[5] VPWR VGND sg13cmos5l_dlhq_1
X_2675_ _2675_/Q FrameData[28] FrameStrobe[8] VPWR VGND sg13cmos5l_dlhq_1
X_1488_ _1488_/Y _1882_/A _1882_/B VPWR VGND sg13cmos5l_nor2b_1
X_1557_ _1557_/Y _2689_/Q _1740_/B VPWR VGND sg13cmos5l_nor2b_1
X_3089_ FrameData_O[26] FrameData[26] VPWR VGND sg13cmos5l_buf_1
X_3158_ W6BEG[6] W6END[8] VPWR VGND sg13cmos5l_buf_1
X_2109_ _2109_/X _1957_/Y _1346_/X _1484_/X _1762_/X _2668_/Q _2771_/Q VPWR VGND sg13cmos5l_mux4_1
XFILLER_52_26 VPWR VGND sg13cmos5l_fill_1
XFILLER_45_233 VPWR VGND sg13cmos5l_fill_1
X_2460_ _2460_/Q FrameData[5] FrameStrobe[14] VPWR VGND sg13cmos5l_dlhq_1
X_1273_ _1274_/B E1END[1] S2END[5] _2826_/Q VPWR VGND sg13cmos5l_mux2_1
X_1342_ _3033_/A _1340_/Y _1341_/Y _1334_/Y VPWR VGND sg13cmos5l_o21ai_1
X_1411_ _1411_/Y _1411_/A _1411_/B VPWR VGND sg13cmos5l_nor2_1
X_2391_ _2391_/Q FrameData[0] FrameStrobe[16] VPWR VGND sg13cmos5l_dlhq_1
X_3012_ NN4BEG[1] NN4END[5] VPWR VGND sg13cmos5l_buf_1
X_1609_ _1611_/B _2776_/Q _3143_/A VPWR VGND sg13cmos5l_nand2_1
X_2727_ _2727_/Q FrameData[16] FrameStrobe[6] VPWR VGND sg13cmos5l_dlhq_1
X_2658_ _2658_/Q FrameData[11] FrameStrobe[8] VPWR VGND sg13cmos5l_dlhq_1
X_2589_ _2589_/Q FrameData[6] FrameStrobe[10] VPWR VGND sg13cmos5l_dlhq_1
XFILLER_12_84 VPWR VGND sg13cmos5l_fill_1
X_1960_ _1975_/A _2532_/Q _1959_/X _1958_/Y VPWR VGND sg13cmos5l_o21ai_1
X_1891_ _1891_/X _2396_/Q _1891_/B VPWR VGND sg13cmos5l_and2_1
X_2512_ _2512_/Q FrameData[25] FrameStrobe[13] VPWR VGND sg13cmos5l_dlhq_1
X_2443_ _2443_/Q FrameData[20] FrameStrobe[15] VPWR VGND sg13cmos5l_dlhq_1
X_1256_ _1256_/Y S2END[5] _2788_/Q _1255_/Y VPWR VGND sg13cmos5l_a21oi_1
X_1325_ _1325_/Y _1323_/Y _1324_/Y _2631_/Q VPWR VGND sg13cmos5l_a21oi_1
X_2374_ _2374_/Q FrameData[15] FrameStrobe[17] VPWR VGND sg13cmos5l_dlhq_1
X_1187_ _1187_/Y _2883_/Q E2END[7] VPWR VGND sg13cmos5l_nor2b_1
XFILLER_7_413 VPWR VGND sg13cmos5l_fill_1
X_1110_ _1110_/Y W1END[1] VPWR VGND sg13cmos5l_inv_1
X_2090_ _3176_/A _2089_/X _2088_/X _2915_/Q VPWR VGND sg13cmos5l_mux2_1
XFILLER_0_54 VPWR VGND sg13cmos5l_fill_2
X_2992_ N2BEGb[5] N2MID[5] VPWR VGND sg13cmos5l_buf_1
X_1943_ _1955_/A _1939_/Y _1940_/Y _1942_/Y VPWR VGND sg13cmos5l_a21o_1
X_1874_ _1874_/Y _2295_/Q _2430_/Q VPWR VGND sg13cmos5l_nand2_1
XANTENNA__3093__X FrameData_O[30] VPWR VGND sg13cmos5l_antennanp
XFILLER_50_0 VPWR VGND sg13cmos5l_fill_1
Xclkbuf_0_UserCLK clkbuf_0_UserCLK/X UserCLK VPWR VGND sg13cmos5l_buf_8
X_2426_ _2426_/Q FrameData[3] FrameStrobe[15] VPWR VGND sg13cmos5l_dlhq_1
X_1239_ _1240_/B N1END[1] S1END[1] N2END[5] S2END[5] _2797_/Q _2878_/Q VPWR VGND sg13cmos5l_mux4_1
X_1308_ _1308_/Y _2714_/Q _1308_/B _1308_/C VPWR VGND sg13cmos5l_nand3_1
X_2357_ _2357_/Q FrameData[30] FrameStrobe[18] VPWR VGND sg13cmos5l_dlhq_1
X_2288_ _2288_/Y _1517_/Y _2287_/B _2287_/Y VPWR VGND sg13cmos5l_o21ai_1
XANTENNA__3178__X WW4BEG[14] VPWR VGND sg13cmos5l_antennanp
X_1590_ _1590_/Y _2874_/Q _1584_/X _1589_/X VPWR VGND sg13cmos5l_o21ai_1
X_2211_ _2211_/Y _2800_/Q _2211_/B VPWR VGND sg13cmos5l_nand2b_1
X_2142_ _2142_/Y _2735_/Q _2141_/Y _2804_/Q VPWR VGND sg13cmos5l_o21ai_1
X_2073_ _2073_/Y _2324_/Q _1905_/X _2072_/Y VPWR VGND sg13cmos5l_a21oi_1
XANTENNA__3088__X FrameData_O[25] VPWR VGND sg13cmos5l_antennanp
X_2975_ N1BEG[0] _2975_/A VPWR VGND sg13cmos5l_buf_1
X_1926_ _1927_/A _1926_/A _1926_/B VPWR VGND sg13cmos5l_and2_1
X_1857_ _2237_/B N2MID[1] E2MID[1] S2MID[1] W2MID[1] _2528_/Q _2498_/Q VPWR VGND sg13cmos5l_mux4_1
X_1788_ _1788_/Y _1788_/A _1788_/B VPWR VGND sg13cmos5l_nand2_1
X_2409_ _2409_/Q FrameData[18] FrameStrobe[16] VPWR VGND sg13cmos5l_dlhq_1
XFILLER_40_334 VPWR VGND sg13cmos5l_fill_2
XFILLER_20_84 VPWR VGND sg13cmos5l_fill_1
XFILLER_4_257 VPWR VGND sg13cmos5l_fill_1
XFILLER_4_279 VPWR VGND sg13cmos5l_fill_1
XFILLER_43_150 VPWR VGND sg13cmos5l_fill_1
XANTENNA_2 E2MID[6] VPWR VGND sg13cmos5l_antennanp
X_1642_ _1642_/Y _2877_/Q _1639_/Y _1122_/Y VPWR VGND sg13cmos5l_a21oi_1
X_2760_ _2760_/Q FrameData[17] FrameStrobe[5] VPWR VGND sg13cmos5l_dlhq_1
X_2691_ _2691_/Q FrameData[12] FrameStrobe[7] VPWR VGND sg13cmos5l_dlhq_1
X_1711_ _1711_/Y _1709_/Y _1710_/Y _2817_/Q VPWR VGND sg13cmos5l_a21oi_1
X_1573_ _1573_/Y _2724_/Q _1573_/B VPWR VGND sg13cmos5l_nor2_1
XFILLER_19_191 VPWR VGND sg13cmos5l_fill_1
XFILLER_26_117 VPWR VGND sg13cmos5l_fill_1
X_3174_ WW4BEG[10] WW4END[14] VPWR VGND sg13cmos5l_buf_1
X_2125_ _3029_/A _1981_/Y _2932_/A _1905_/X _1932_/X _2670_/Q _2737_/Q VPWR VGND sg13cmos5l_mux4_1
X_2056_ _2057_/B _1542_/X _1697_/X _1700_/X _1905_/X _2322_/Q _2890_/Q VPWR VGND sg13cmos5l_mux4_1
X_2958_ E6BEG[11] _2958_/A VPWR VGND sg13cmos5l_buf_1
X_1909_ _1958_/C _1786_/A _1786_/B _1793_/X VPWR VGND sg13cmos5l_o21ai_1
X_2889_ _2889_/Q FrameData[26] FrameStrobe[1] VPWR VGND sg13cmos5l_dlhq_1
XFILLER_13_367 VPWR VGND sg13cmos5l_fill_2
XFILLER_51_418 VPWR VGND sg13cmos5l_fill_1
XFILLER_31_175 VPWR VGND sg13cmos5l_fill_1
X_2812_ _2812_/Q FrameData[6] FrameStrobe[3] VPWR VGND sg13cmos5l_dlhq_1
X_2743_ _2743_/Q FrameData[0] FrameStrobe[5] VPWR VGND sg13cmos5l_dlhq_1
X_1556_ _1556_/X _2031_/B _1697_/X _2689_/Q VPWR VGND sg13cmos5l_mux2_1
X_1625_ _1625_/Y _2906_/Q _1784_/X _1624_/Y VPWR VGND sg13cmos5l_a21oi_1
X_2674_ _2674_/Q FrameData[27] FrameStrobe[8] VPWR VGND sg13cmos5l_dlhq_1
X_1487_ _1487_/Y _1882_/B _1882_/A VPWR VGND sg13cmos5l_nor2b_1
X_3157_ W6BEG[5] W6END[7] VPWR VGND sg13cmos5l_buf_1
X_3088_ FrameData_O[25] FrameData[25] VPWR VGND sg13cmos5l_buf_1
X_2108_ _2108_/X N1END[3] E1END[3] W1END[3] _2060_/B _2771_/Q _2668_/Q VPWR VGND sg13cmos5l_mux4_1
X_2039_ _2039_/Y W6END[1] _2783_/Q VPWR VGND sg13cmos5l_nand2b_1
XFILLER_52_49 VPWR VGND sg13cmos5l_fill_1
XFILLER_9_124 VPWR VGND sg13cmos5l_fill_2
XFILLER_42_93 VPWR VGND sg13cmos5l_fill_1
X_1410_ _1411_/B _1784_/X _1542_/X _2691_/Q VPWR VGND sg13cmos5l_mux2_1
X_1272_ _1272_/X N1END[1] S1END[1] N2END[5] S1END[3] _2826_/Q _2851_/Q VPWR VGND sg13cmos5l_mux4_1
X_1341_ _1341_/Y _2655_/Q _1335_/X _2630_/Q VPWR VGND sg13cmos5l_o21ai_1
X_3011_ NN4BEG[0] NN4END[4] VPWR VGND sg13cmos5l_buf_1
X_2390_ _2390_/Q FrameData[31] FrameStrobe[17] VPWR VGND sg13cmos5l_dlhq_1
XANTENNA__3096__X FrameStrobe_O[1] VPWR VGND sg13cmos5l_antennanp
X_2726_ _2726_/Q FrameData[15] FrameStrobe[6] VPWR VGND sg13cmos5l_dlhq_1
X_1539_ _1539_/Y _1531_/A _1536_/X _1521_/A VPWR VGND sg13cmos5l_a21oi_1
X_1608_ _3143_/A _1593_/Y _1599_/Y _1601_/Y _1607_/Y VPWR VGND sg13cmos5l_a22oi_1
X_2657_ _2657_/Q FrameData[10] FrameStrobe[8] VPWR VGND sg13cmos5l_dlhq_1
X_2588_ _2588_/Q FrameData[5] FrameStrobe[10] VPWR VGND sg13cmos5l_dlhq_1
XFILLER_42_259 VPWR VGND sg13cmos5l_fill_1
XFILLER_6_127 VPWR VGND sg13cmos5l_fill_2
X_1890_ _1890_/Y _2400_/Q _1487_/Y _1891_/B _2434_/Q _1880_/A VPWR VGND sg13cmos5l_a221oi_1
X_2511_ _2511_/Q FrameData[24] FrameStrobe[13] VPWR VGND sg13cmos5l_dlhq_1
X_2442_ _2442_/Q FrameData[19] FrameStrobe[15] VPWR VGND sg13cmos5l_dlhq_1
X_2373_ _2373_/Q FrameData[14] FrameStrobe[17] VPWR VGND sg13cmos5l_dlhq_1
X_1186_ _1186_/X E1END[3] S2END[7] _2883_/Q VPWR VGND sg13cmos5l_mux2_1
X_1255_ _1255_/Y _2788_/Q N2END[5] VPWR VGND sg13cmos5l_nor2b_1
X_1324_ _1324_/Y _2693_/Q E2END[3] VPWR VGND sg13cmos5l_nand2b_1
X_2709_ _2709_/Q FrameData[30] FrameStrobe[7] VPWR VGND sg13cmos5l_dlhq_1
XFILLER_11_432 VPWR VGND sg13cmos5l_fill_1
XFILLER_30_229 VPWR VGND sg13cmos5l_fill_1
XFILLER_2_130 VPWR VGND sg13cmos5l_fill_1
XFILLER_24_8 VPWR VGND sg13cmos5l_fill_1
X_2991_ N2BEGb[4] N2MID[4] VPWR VGND sg13cmos5l_buf_1
X_1942_ _1942_/Y _2523_/Q _1932_/X _1941_/Y VPWR VGND sg13cmos5l_a21oi_1
X_1873_ _1873_/Y _1868_/Y _1872_/X _1863_/Y VPWR VGND sg13cmos5l_o21ai_1
XFILLER_43_0 VPWR VGND sg13cmos5l_fill_2
X_2425_ _2425_/Q FrameData[2] FrameStrobe[15] VPWR VGND sg13cmos5l_dlhq_1
X_2356_ _2356_/Q FrameData[29] FrameStrobe[18] VPWR VGND sg13cmos5l_dlhq_1
X_1169_ _1169_/Y _1166_/X _1167_/Y _1168_/X _1149_/Y _2726_/Q VPWR VGND sg13cmos5l_a221oi_1
X_1238_ _1238_/Y _1240_/A _1237_/X _1152_/Y VPWR VGND sg13cmos5l_a21oi_1
X_1307_ _1308_/C _2650_/Q S2END[0] VPWR VGND sg13cmos5l_nand2b_1
X_2287_ _2287_/Y _2376_/Q _2287_/B VPWR VGND sg13cmos5l_nand2_1
X_2210_ _2211_/B _1740_/B _1905_/X _2764_/Q VPWR VGND sg13cmos5l_mux2_1
XFILLER_46_170 VPWR VGND sg13cmos5l_fill_1
X_2141_ _2141_/Y _2772_/Q _2060_/B _2140_/Y VPWR VGND sg13cmos5l_o21ai_1
X_2072_ _2072_/Y _2324_/Q _1740_/B VPWR VGND sg13cmos5l_nor2b_1
X_2974_ EE4BEG[15] _2974_/A VPWR VGND sg13cmos5l_buf_1
X_1925_ _1925_/Y _1926_/B _1926_/A VPWR VGND sg13cmos5l_nor2b_1
X_1856_ _1856_/X N2MID[0] S2MID[0] E2MID[0] _3139_/A _2625_/Q _2591_/Q VPWR VGND sg13cmos5l_mux4_1
X_1787_ _1788_/B _1723_/X _1724_/X _1722_/X _1721_/X _2459_/Q _2426_/Q VPWR VGND sg13cmos5l_mux4_1
X_2408_ _2408_/Q FrameData[17] FrameStrobe[16] VPWR VGND sg13cmos5l_dlhq_1
X_2339_ _2339_/Q FrameData[12] FrameStrobe[18] VPWR VGND sg13cmos5l_dlhq_1
XFILLER_48_435 VPWR VGND sg13cmos5l_fill_1
XANTENNA_3 E2MID[6] VPWR VGND sg13cmos5l_antennanp
X_1572_ _1573_/B _2759_/Q _1568_/X _1571_/Y VPWR VGND sg13cmos5l_a21oi_1
X_1641_ _1641_/Y _1603_/A _2855_/Q _1640_/Y VPWR VGND sg13cmos5l_a21oi_1
X_2690_ _2690_/Q FrameData[11] FrameStrobe[7] VPWR VGND sg13cmos5l_dlhq_1
X_1710_ _1710_/Y _2843_/Q _1707_/X _1138_/Y VPWR VGND sg13cmos5l_a21oi_1
X_3173_ WW4BEG[9] WW4END[13] VPWR VGND sg13cmos5l_buf_1
X_2124_ _3030_/A _1957_/Y _2933_/A _1467_/X _1825_/X _2703_/Q _2805_/Q VPWR VGND sg13cmos5l_mux4_1
XANTENNA__3099__X FrameStrobe_O[4] VPWR VGND sg13cmos5l_antennanp
X_2055_ _2055_/X _1981_/Y _1957_/Y _1448_/A _1351_/A _2322_/Q _2890_/Q VPWR VGND sg13cmos5l_mux4_1
X_2888_ _2888_/Q FrameData[25] FrameStrobe[1] VPWR VGND sg13cmos5l_dlhq_1
X_2957_ E6BEG[10] _2957_/A VPWR VGND sg13cmos5l_buf_1
X_1908_ _1916_/B _1962_/A _1961_/A VPWR VGND sg13cmos5l_and2_1
X_1839_ _1839_/Y W2END[2] _2795_/Q _2696_/Q VPWR VGND sg13cmos5l_o21ai_1
XFILLER_48_243 VPWR VGND sg13cmos5l_fill_1
XFILLER_31_187 VPWR VGND sg13cmos5l_fill_2
X_2811_ _2811_/Q FrameData[5] FrameStrobe[3] VPWR VGND sg13cmos5l_dlhq_1
X_2742_ _2742_/Q FrameData[31] FrameStrobe[6] VPWR VGND sg13cmos5l_dlhq_1
X_1555_ _2986_/A _2899_/Q _1546_/Y _1553_/Y _1554_/Y VPWR VGND sg13cmos5l_a22oi_1
X_1624_ _1624_/Y _2906_/Q _2060_/B VPWR VGND sg13cmos5l_nor2b_1
X_2673_ _2673_/Q FrameData[26] FrameStrobe[8] VPWR VGND sg13cmos5l_dlhq_1
X_1486_ _1882_/B _1484_/X _1485_/X _1467_/X _1466_/X _2643_/Q _2705_/Q VPWR VGND sg13cmos5l_mux4_1
X_3087_ FrameData_O[24] FrameData[24] VPWR VGND sg13cmos5l_buf_1
X_3156_ W6BEG[4] W6END[6] VPWR VGND sg13cmos5l_buf_1
X_2107_ _3129_/A _2101_/Y _2102_/Y _2104_/Y _2106_/Y VPWR VGND sg13cmos5l_a22oi_1
X_2038_ _2038_/X E1END[3] W2END[1] _2783_/Q VPWR VGND sg13cmos5l_mux2_1
XFILLER_22_198 VPWR VGND sg13cmos5l_decap_8
XFILLER_33_419 VPWR VGND sg13cmos5l_fill_1
X_1340_ _1340_/Y _2693_/Q _1336_/X _1339_/Y VPWR VGND sg13cmos5l_a21oi_1
X_1271_ _1271_/Y _2850_/Q _1265_/X _1270_/Y VPWR VGND sg13cmos5l_o21ai_1
X_3010_ N4BEG[15] _3010_/A VPWR VGND sg13cmos5l_buf_1
X_2725_ _2725_/Q FrameData[14] FrameStrobe[6] VPWR VGND sg13cmos5l_dlhq_1
X_2656_ _2656_/Q FrameData[9] FrameStrobe[8] VPWR VGND sg13cmos5l_dlhq_1
X_1469_ _1475_/B _1468_/X _1469_/B VPWR VGND sg13cmos5l_nand2b_1
X_1538_ _1538_/Y _1531_/A _1538_/B VPWR VGND sg13cmos5l_nand2b_1
X_1607_ _1607_/Y _2904_/Q _1607_/B VPWR VGND sg13cmos5l_nor2_1
X_2587_ _2587_/Q FrameData[4] FrameStrobe[10] VPWR VGND sg13cmos5l_dlhq_1
X_3139_ W2BEG[3] _3139_/A VPWR VGND sg13cmos5l_buf_1
X_2510_ _2510_/Q FrameData[23] FrameStrobe[13] VPWR VGND sg13cmos5l_dlhq_1
X_1323_ _1323_/Y E6END[1] _2693_/Q VPWR VGND sg13cmos5l_nand2_1
X_2441_ _2441_/Q FrameData[18] FrameStrobe[15] VPWR VGND sg13cmos5l_dlhq_1
X_2372_ _2372_/Q FrameData[13] FrameStrobe[17] VPWR VGND sg13cmos5l_dlhq_1
XFILLER_24_227 VPWR VGND sg13cmos5l_fill_2
X_1185_ _1185_/Y _1185_/A _2882_/Q VPWR VGND sg13cmos5l_nor2b_1
X_1254_ _1254_/Y _2787_/Q _1254_/B _1254_/C VPWR VGND sg13cmos5l_nand3_1
XFILLER_32_282 VPWR VGND sg13cmos5l_fill_2
X_2708_ _2708_/Q FrameData[29] FrameStrobe[7] VPWR VGND sg13cmos5l_dlhq_1
X_2639_ _2639_/Q FrameData[24] FrameStrobe[9] VPWR VGND sg13cmos5l_dlhq_1
XFILLER_3_0 VPWR VGND sg13cmos5l_fill_2
X_2990_ N2BEGb[3] N2MID[3] VPWR VGND sg13cmos5l_buf_1
X_1941_ _1941_/Y _2523_/Q _1938_/A _2492_/Q VPWR VGND sg13cmos5l_o21ai_1
X_1872_ _1872_/X _1862_/A _1871_/X _1863_/B VPWR VGND sg13cmos5l_a21o_1
X_1306_ _1308_/B W2END[0] _2650_/Q VPWR VGND sg13cmos5l_nand2_1
X_2424_ _2424_/Q FrameData[1] FrameStrobe[15] VPWR VGND sg13cmos5l_dlhq_1
X_2355_ _2355_/Q FrameData[28] FrameStrobe[18] VPWR VGND sg13cmos5l_dlhq_1
X_2286_ _2287_/B _2357_/Q _2291_/B VPWR VGND sg13cmos5l_and2_1
X_1168_ _1168_/X _2060_/B _1784_/X _2690_/Q VPWR VGND sg13cmos5l_mux2_1
X_1237_ _1237_/X _2060_/B _1896_/X _1802_/X _1981_/Y _2878_/Q _2797_/Q VPWR VGND sg13cmos5l_mux4_1
X_2140_ _2140_/Y _1896_/X _2772_/Q VPWR VGND sg13cmos5l_nand2b_1
X_2071_ _2075_/A _2324_/Q _1345_/Y _2070_/Y VPWR VGND sg13cmos5l_a21oi_1
X_2973_ EE4BEG[14] _2973_/A VPWR VGND sg13cmos5l_buf_1
X_1924_ _1924_/Y _2636_/Q _1922_/Y _1923_/Y _2566_/Q VPWR VGND sg13cmos5l_a22oi_1
X_1855_ _1855_/X N2END[0] E2END[0] S2END[0] WW4END[3] _2717_/Q _2716_/Q VPWR VGND
+ sg13cmos5l_mux4_1
XFILLER_39_29 VPWR VGND sg13cmos5l_fill_1
X_1786_ _1786_/Y _1786_/A _1786_/B VPWR VGND sg13cmos5l_nor2_1
X_2407_ _2407_/Q FrameData[16] FrameStrobe[16] VPWR VGND sg13cmos5l_dlhq_1
X_2338_ _2338_/Q FrameData[11] FrameStrobe[18] VPWR VGND sg13cmos5l_dlhq_1
X_2269_ _2301_/D _2267_/Y _2268_/Y _2265_/Y VPWR VGND sg13cmos5l_o21ai_1
XFILLER_20_64 VPWR VGND sg13cmos5l_fill_2
XFILLER_29_95 VPWR VGND sg13cmos5l_fill_2
XANTENNA_4 E2MID[6] VPWR VGND sg13cmos5l_antennanp
X_1571_ _1571_/Y _2759_/Q _1570_/Y _2758_/Q VPWR VGND sg13cmos5l_o21ai_1
X_1640_ _1640_/Y E1END[2] _2855_/Q VPWR VGND sg13cmos5l_nor2_1
X_3172_ WW4BEG[8] WW4END[12] VPWR VGND sg13cmos5l_buf_1
X_2123_ _3059_/A E6END[1] S4END[1] S2END[2] _2060_/B _2669_/Q _2639_/Q VPWR VGND sg13cmos5l_mux4_1
X_2054_ _3163_/A _2046_/Y _2048_/Y _2053_/Y VPWR VGND sg13cmos5l_o21ai_1
XFILLER_30_391 VPWR VGND sg13cmos5l_fill_2
X_2887_ _2887_/Q FrameData[24] FrameStrobe[1] VPWR VGND sg13cmos5l_dlhq_1
X_2956_ E6BEG[9] E6END[11] VPWR VGND sg13cmos5l_buf_1
X_1907_ _1907_/Y _1962_/A _1961_/A VPWR VGND sg13cmos5l_nor2_1
X_1838_ _1838_/Y _2696_/Q _1835_/X _2761_/Q VPWR VGND sg13cmos5l_a21oi_1
X_1769_ _1786_/A _1769_/A _1769_/B VPWR VGND sg13cmos5l_and2_1
XFILLER_31_100 VPWR VGND sg13cmos5l_fill_2
X_2810_ _2810_/Q FrameData[4] FrameStrobe[3] VPWR VGND sg13cmos5l_dlhq_1
X_2741_ _2741_/Q FrameData[30] FrameStrobe[6] VPWR VGND sg13cmos5l_dlhq_1
X_2672_ _2672_/Q FrameData[25] FrameStrobe[8] VPWR VGND sg13cmos5l_dlhq_1
X_1485_ _1485_/X N2END[4] S2END[4] EE4END[0] W2END[4] _2841_/Q _2868_/Q VPWR VGND
+ sg13cmos5l_mux4_1
X_1554_ _1554_/Y _1544_/A _1547_/X _2899_/Q VPWR VGND sg13cmos5l_a21oi_1
X_1623_ _1623_/X _1896_/X _1981_/Y _2906_/Q VPWR VGND sg13cmos5l_mux2_1
.ends
