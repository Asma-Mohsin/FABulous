* NGSPICE file created from AXIL_S_IO_W.ext - technology: ihp-sg13cmos5l

* Black-box entry subcircuit for sg13cmos5l_fill_1 abstract view
.subckt sg13cmos5l_fill_1 VDD VSS
.ends

* Black-box entry subcircuit for sg13cmos5l_dlhq_1 abstract view
.subckt sg13cmos5l_dlhq_1 Q D GATE VDD VSS
.ends

* Black-box entry subcircuit for sg13cmos5l_fill_2 abstract view
.subckt sg13cmos5l_fill_2 VDD VSS
.ends

* Black-box entry subcircuit for sg13cmos5l_decap_8 abstract view
.subckt sg13cmos5l_decap_8 VDD VSS
.ends

* Black-box entry subcircuit for sg13cmos5l_antennanp abstract view
.subckt sg13cmos5l_antennanp A VDD VSS
.ends

* Black-box entry subcircuit for sg13cmos5l_decap_4 abstract view
.subckt sg13cmos5l_decap_4 VDD VSS
.ends

* Black-box entry subcircuit for sg13cmos5l_nand2b_1 abstract view
.subckt sg13cmos5l_nand2b_1 Y A_N B VDD VSS
.ends

* Black-box entry subcircuit for sg13cmos5l_buf_1 abstract view
.subckt sg13cmos5l_buf_1 X A VDD VSS
.ends

* Black-box entry subcircuit for sg13cmos5l_mux4_1 abstract view
.subckt sg13cmos5l_mux4_1 X A0 A1 A2 A3 S0 S1 VDD VSS
.ends

* Black-box entry subcircuit for sg13cmos5l_mux2_1 abstract view
.subckt sg13cmos5l_mux2_1 X A0 A1 S VDD VSS
.ends

* Black-box entry subcircuit for sg13cmos5l_o21ai_1 abstract view
.subckt sg13cmos5l_o21ai_1 Y A1 A2 B1 VDD VSS
.ends

* Black-box entry subcircuit for sg13cmos5l_inv_1 abstract view
.subckt sg13cmos5l_inv_1 Y A VDD VSS
.ends

* Black-box entry subcircuit for sg13cmos5l_and2_1 abstract view
.subckt sg13cmos5l_and2_1 X A B VDD VSS
.ends

* Black-box entry subcircuit for sg13cmos5l_a22oi_1 abstract view
.subckt sg13cmos5l_a22oi_1 Y A1 A2 B1 B2 VDD VSS
.ends

* Black-box entry subcircuit for sg13cmos5l_a21oi_1 abstract view
.subckt sg13cmos5l_a21oi_1 Y A1 A2 B1 VDD VSS
.ends

* Black-box entry subcircuit for sg13cmos5l_nand3b_1 abstract view
.subckt sg13cmos5l_nand3b_1 Y A_N B C VDD VSS
.ends

* Black-box entry subcircuit for sg13cmos5l_a21o_1 abstract view
.subckt sg13cmos5l_a21o_1 X A1 A2 B1 VDD VSS
.ends

* Black-box entry subcircuit for sg13cmos5l_nor3_1 abstract view
.subckt sg13cmos5l_nor3_1 Y A B C VDD VSS
.ends

* Black-box entry subcircuit for sg13cmos5l_nor2_1 abstract view
.subckt sg13cmos5l_nor2_1 Y A B VDD VSS
.ends

* Black-box entry subcircuit for sg13cmos5l_nor2b_1 abstract view
.subckt sg13cmos5l_nor2b_1 Y A B_N VDD VSS
.ends

* Black-box entry subcircuit for sg13cmos5l_a221oi_1 abstract view
.subckt sg13cmos5l_a221oi_1 Y A1 A2 B1 B2 C1 VDD VSS
.ends

* Black-box entry subcircuit for sg13cmos5l_nand3_1 abstract view
.subckt sg13cmos5l_nand3_1 Y A B C VDD VSS
.ends

* Black-box entry subcircuit for sg13cmos5l_nand2_1 abstract view
.subckt sg13cmos5l_nand2_1 Y A B VDD VSS
.ends

.subckt AXIL_S_IO_W AXIL_S_SOC_ARADDR0 AXIL_S_SOC_ARADDR1 AXIL_S_SOC_ARADDR2 AXIL_S_SOC_ARADDR3
+ AXIL_S_SOC_ARADDR4 AXIL_S_SOC_ARADDR5 AXIL_S_SOC_ARADDR6 AXIL_S_SOC_ARADDR7 AXIL_S_SOC_ARADDR8
+ AXIL_S_SOC_ARADDR9 AXIL_S_SOC_ARREADY AXIL_S_SOC_ARVALID AXIL_S_SOC_AWADDR0 AXIL_S_SOC_AWADDR1
+ AXIL_S_SOC_AWADDR2 AXIL_S_SOC_AWADDR3 AXIL_S_SOC_AWADDR4 AXIL_S_SOC_AWADDR5 AXIL_S_SOC_AWADDR6
+ AXIL_S_SOC_AWADDR7 AXIL_S_SOC_AWADDR8 AXIL_S_SOC_AWADDR9 AXIL_S_SOC_AWREADY AXIL_S_SOC_AWVALID
+ AXIL_S_SOC_BREADY AXIL_S_SOC_BRESP0 AXIL_S_SOC_BRESP1 AXIL_S_SOC_BVALID AXIL_S_SOC_RDATA0
+ AXIL_S_SOC_RDATA1 AXIL_S_SOC_RDATA10 AXIL_S_SOC_RDATA11 AXIL_S_SOC_RDATA12 AXIL_S_SOC_RDATA13
+ AXIL_S_SOC_RDATA14 AXIL_S_SOC_RDATA15 AXIL_S_SOC_RDATA16 AXIL_S_SOC_RDATA17 AXIL_S_SOC_RDATA18
+ AXIL_S_SOC_RDATA19 AXIL_S_SOC_RDATA2 AXIL_S_SOC_RDATA20 AXIL_S_SOC_RDATA21 AXIL_S_SOC_RDATA22
+ AXIL_S_SOC_RDATA23 AXIL_S_SOC_RDATA24 AXIL_S_SOC_RDATA25 AXIL_S_SOC_RDATA26 AXIL_S_SOC_RDATA27
+ AXIL_S_SOC_RDATA28 AXIL_S_SOC_RDATA29 AXIL_S_SOC_RDATA3 AXIL_S_SOC_RDATA30 AXIL_S_SOC_RDATA31
+ AXIL_S_SOC_RDATA4 AXIL_S_SOC_RDATA5 AXIL_S_SOC_RDATA6 AXIL_S_SOC_RDATA7 AXIL_S_SOC_RDATA8
+ AXIL_S_SOC_RDATA9 AXIL_S_SOC_RREADY AXIL_S_SOC_RRESP0 AXIL_S_SOC_RRESP1 AXIL_S_SOC_RVALID
+ AXIL_S_SOC_WDATA0 AXIL_S_SOC_WDATA1 AXIL_S_SOC_WDATA10 AXIL_S_SOC_WDATA11 AXIL_S_SOC_WDATA12
+ AXIL_S_SOC_WDATA13 AXIL_S_SOC_WDATA14 AXIL_S_SOC_WDATA15 AXIL_S_SOC_WDATA16 AXIL_S_SOC_WDATA17
+ AXIL_S_SOC_WDATA18 AXIL_S_SOC_WDATA19 AXIL_S_SOC_WDATA2 AXIL_S_SOC_WDATA20 AXIL_S_SOC_WDATA21
+ AXIL_S_SOC_WDATA22 AXIL_S_SOC_WDATA23 AXIL_S_SOC_WDATA24 AXIL_S_SOC_WDATA25 AXIL_S_SOC_WDATA26
+ AXIL_S_SOC_WDATA27 AXIL_S_SOC_WDATA28 AXIL_S_SOC_WDATA29 AXIL_S_SOC_WDATA3 AXIL_S_SOC_WDATA30
+ AXIL_S_SOC_WDATA31 AXIL_S_SOC_WDATA4 AXIL_S_SOC_WDATA5 AXIL_S_SOC_WDATA6 AXIL_S_SOC_WDATA7
+ AXIL_S_SOC_WDATA8 AXIL_S_SOC_WDATA9 AXIL_S_SOC_WREADY AXIL_S_SOC_WSTRB0 AXIL_S_SOC_WSTRB1
+ AXIL_S_SOC_WSTRB2 AXIL_S_SOC_WSTRB3 AXIL_S_SOC_WVALID Tile_X0Y0_E1BEG[0] Tile_X0Y0_E1BEG[1]
+ Tile_X0Y0_E1BEG[2] Tile_X0Y0_E1BEG[3] Tile_X0Y0_E2BEG[0] Tile_X0Y0_E2BEG[1] Tile_X0Y0_E2BEG[2]
+ Tile_X0Y0_E2BEG[3] Tile_X0Y0_E2BEG[4] Tile_X0Y0_E2BEG[5] Tile_X0Y0_E2BEG[6] Tile_X0Y0_E2BEG[7]
+ Tile_X0Y0_E2BEGb[0] Tile_X0Y0_E2BEGb[1] Tile_X0Y0_E2BEGb[2] Tile_X0Y0_E2BEGb[3]
+ Tile_X0Y0_E2BEGb[4] Tile_X0Y0_E2BEGb[5] Tile_X0Y0_E2BEGb[6] Tile_X0Y0_E2BEGb[7]
+ Tile_X0Y0_E6BEG[0] Tile_X0Y0_E6BEG[10] Tile_X0Y0_E6BEG[11] Tile_X0Y0_E6BEG[1] Tile_X0Y0_E6BEG[2]
+ Tile_X0Y0_E6BEG[3] Tile_X0Y0_E6BEG[4] Tile_X0Y0_E6BEG[5] Tile_X0Y0_E6BEG[6] Tile_X0Y0_E6BEG[7]
+ Tile_X0Y0_E6BEG[8] Tile_X0Y0_E6BEG[9] Tile_X0Y0_EE4BEG[0] Tile_X0Y0_EE4BEG[10] Tile_X0Y0_EE4BEG[11]
+ Tile_X0Y0_EE4BEG[12] Tile_X0Y0_EE4BEG[13] Tile_X0Y0_EE4BEG[14] Tile_X0Y0_EE4BEG[15]
+ Tile_X0Y0_EE4BEG[1] Tile_X0Y0_EE4BEG[2] Tile_X0Y0_EE4BEG[3] Tile_X0Y0_EE4BEG[4]
+ Tile_X0Y0_EE4BEG[5] Tile_X0Y0_EE4BEG[6] Tile_X0Y0_EE4BEG[7] Tile_X0Y0_EE4BEG[8]
+ Tile_X0Y0_EE4BEG[9] Tile_X0Y0_FrameData[0] Tile_X0Y0_FrameData[10] Tile_X0Y0_FrameData[11]
+ Tile_X0Y0_FrameData[12] Tile_X0Y0_FrameData[13] Tile_X0Y0_FrameData[14] Tile_X0Y0_FrameData[15]
+ Tile_X0Y0_FrameData[16] Tile_X0Y0_FrameData[17] Tile_X0Y0_FrameData[18] Tile_X0Y0_FrameData[19]
+ Tile_X0Y0_FrameData[1] Tile_X0Y0_FrameData[20] Tile_X0Y0_FrameData[21] Tile_X0Y0_FrameData[22]
+ Tile_X0Y0_FrameData[23] Tile_X0Y0_FrameData[24] Tile_X0Y0_FrameData[25] Tile_X0Y0_FrameData[26]
+ Tile_X0Y0_FrameData[27] Tile_X0Y0_FrameData[28] Tile_X0Y0_FrameData[29] Tile_X0Y0_FrameData[2]
+ Tile_X0Y0_FrameData[30] Tile_X0Y0_FrameData[31] Tile_X0Y0_FrameData[3] Tile_X0Y0_FrameData[4]
+ Tile_X0Y0_FrameData[5] Tile_X0Y0_FrameData[6] Tile_X0Y0_FrameData[7] Tile_X0Y0_FrameData[8]
+ Tile_X0Y0_FrameData[9] Tile_X0Y0_FrameData_O[0] Tile_X0Y0_FrameData_O[10] Tile_X0Y0_FrameData_O[11]
+ Tile_X0Y0_FrameData_O[12] Tile_X0Y0_FrameData_O[13] Tile_X0Y0_FrameData_O[14] Tile_X0Y0_FrameData_O[15]
+ Tile_X0Y0_FrameData_O[16] Tile_X0Y0_FrameData_O[17] Tile_X0Y0_FrameData_O[18] Tile_X0Y0_FrameData_O[19]
+ Tile_X0Y0_FrameData_O[1] Tile_X0Y0_FrameData_O[20] Tile_X0Y0_FrameData_O[21] Tile_X0Y0_FrameData_O[22]
+ Tile_X0Y0_FrameData_O[23] Tile_X0Y0_FrameData_O[24] Tile_X0Y0_FrameData_O[25] Tile_X0Y0_FrameData_O[26]
+ Tile_X0Y0_FrameData_O[27] Tile_X0Y0_FrameData_O[28] Tile_X0Y0_FrameData_O[29] Tile_X0Y0_FrameData_O[2]
+ Tile_X0Y0_FrameData_O[30] Tile_X0Y0_FrameData_O[31] Tile_X0Y0_FrameData_O[3] Tile_X0Y0_FrameData_O[4]
+ Tile_X0Y0_FrameData_O[5] Tile_X0Y0_FrameData_O[6] Tile_X0Y0_FrameData_O[7] Tile_X0Y0_FrameData_O[8]
+ Tile_X0Y0_FrameData_O[9] Tile_X0Y0_FrameStrobe_O[0] Tile_X0Y0_FrameStrobe_O[10]
+ Tile_X0Y0_FrameStrobe_O[11] Tile_X0Y0_FrameStrobe_O[12] Tile_X0Y0_FrameStrobe_O[13]
+ Tile_X0Y0_FrameStrobe_O[14] Tile_X0Y0_FrameStrobe_O[15] Tile_X0Y0_FrameStrobe_O[16]
+ Tile_X0Y0_FrameStrobe_O[17] Tile_X0Y0_FrameStrobe_O[18] Tile_X0Y0_FrameStrobe_O[19]
+ Tile_X0Y0_FrameStrobe_O[1] Tile_X0Y0_FrameStrobe_O[2] Tile_X0Y0_FrameStrobe_O[3]
+ Tile_X0Y0_FrameStrobe_O[4] Tile_X0Y0_FrameStrobe_O[5] Tile_X0Y0_FrameStrobe_O[6]
+ Tile_X0Y0_FrameStrobe_O[7] Tile_X0Y0_FrameStrobe_O[8] Tile_X0Y0_FrameStrobe_O[9]
+ Tile_X0Y0_N1BEG[0] Tile_X0Y0_N1BEG[1] Tile_X0Y0_N1BEG[2] Tile_X0Y0_N1BEG[3] Tile_X0Y0_N2BEG[0]
+ Tile_X0Y0_N2BEG[1] Tile_X0Y0_N2BEG[2] Tile_X0Y0_N2BEG[3] Tile_X0Y0_N2BEG[4] Tile_X0Y0_N2BEG[5]
+ Tile_X0Y0_N2BEG[6] Tile_X0Y0_N2BEG[7] Tile_X0Y0_N2BEGb[0] Tile_X0Y0_N2BEGb[1] Tile_X0Y0_N2BEGb[2]
+ Tile_X0Y0_N2BEGb[3] Tile_X0Y0_N2BEGb[4] Tile_X0Y0_N2BEGb[5] Tile_X0Y0_N2BEGb[6]
+ Tile_X0Y0_N2BEGb[7] Tile_X0Y0_N4BEG[0] Tile_X0Y0_N4BEG[10] Tile_X0Y0_N4BEG[11] Tile_X0Y0_N4BEG[12]
+ Tile_X0Y0_N4BEG[13] Tile_X0Y0_N4BEG[14] Tile_X0Y0_N4BEG[15] Tile_X0Y0_N4BEG[1] Tile_X0Y0_N4BEG[2]
+ Tile_X0Y0_N4BEG[3] Tile_X0Y0_N4BEG[4] Tile_X0Y0_N4BEG[5] Tile_X0Y0_N4BEG[6] Tile_X0Y0_N4BEG[7]
+ Tile_X0Y0_N4BEG[8] Tile_X0Y0_N4BEG[9] Tile_X0Y0_S1END[0] Tile_X0Y0_S1END[1] Tile_X0Y0_S1END[2]
+ Tile_X0Y0_S1END[3] Tile_X0Y0_S2END[0] Tile_X0Y0_S2END[1] Tile_X0Y0_S2END[2] Tile_X0Y0_S2END[3]
+ Tile_X0Y0_S2END[4] Tile_X0Y0_S2END[5] Tile_X0Y0_S2END[6] Tile_X0Y0_S2END[7] Tile_X0Y0_S2MID[0]
+ Tile_X0Y0_S2MID[1] Tile_X0Y0_S2MID[2] Tile_X0Y0_S2MID[3] Tile_X0Y0_S2MID[4] Tile_X0Y0_S2MID[5]
+ Tile_X0Y0_S2MID[6] Tile_X0Y0_S2MID[7] Tile_X0Y0_S4END[0] Tile_X0Y0_S4END[10] Tile_X0Y0_S4END[11]
+ Tile_X0Y0_S4END[12] Tile_X0Y0_S4END[13] Tile_X0Y0_S4END[14] Tile_X0Y0_S4END[15]
+ Tile_X0Y0_S4END[1] Tile_X0Y0_S4END[2] Tile_X0Y0_S4END[3] Tile_X0Y0_S4END[4] Tile_X0Y0_S4END[5]
+ Tile_X0Y0_S4END[6] Tile_X0Y0_S4END[7] Tile_X0Y0_S4END[8] Tile_X0Y0_S4END[9] Tile_X0Y0_UserCLK
+ Tile_X0Y0_UserCLKo Tile_X0Y0_W1END[0] Tile_X0Y0_W1END[1] Tile_X0Y0_W1END[2] Tile_X0Y0_W1END[3]
+ Tile_X0Y0_W2END[0] Tile_X0Y0_W2END[1] Tile_X0Y0_W2END[2] Tile_X0Y0_W2END[3] Tile_X0Y0_W2END[4]
+ Tile_X0Y0_W2END[5] Tile_X0Y0_W2END[6] Tile_X0Y0_W2END[7] Tile_X0Y0_W2MID[0] Tile_X0Y0_W2MID[1]
+ Tile_X0Y0_W2MID[2] Tile_X0Y0_W2MID[3] Tile_X0Y0_W2MID[4] Tile_X0Y0_W2MID[5] Tile_X0Y0_W2MID[6]
+ Tile_X0Y0_W2MID[7] Tile_X0Y0_W6END[0] Tile_X0Y0_W6END[10] Tile_X0Y0_W6END[11] Tile_X0Y0_W6END[1]
+ Tile_X0Y0_W6END[2] Tile_X0Y0_W6END[3] Tile_X0Y0_W6END[4] Tile_X0Y0_W6END[5] Tile_X0Y0_W6END[6]
+ Tile_X0Y0_W6END[7] Tile_X0Y0_W6END[8] Tile_X0Y0_W6END[9] Tile_X0Y0_WW4END[0] Tile_X0Y0_WW4END[10]
+ Tile_X0Y0_WW4END[11] Tile_X0Y0_WW4END[12] Tile_X0Y0_WW4END[13] Tile_X0Y0_WW4END[14]
+ Tile_X0Y0_WW4END[15] Tile_X0Y0_WW4END[1] Tile_X0Y0_WW4END[2] Tile_X0Y0_WW4END[3]
+ Tile_X0Y0_WW4END[4] Tile_X0Y0_WW4END[5] Tile_X0Y0_WW4END[6] Tile_X0Y0_WW4END[7]
+ Tile_X0Y0_WW4END[8] Tile_X0Y0_WW4END[9] Tile_X0Y1_E1BEG[0] Tile_X0Y1_E1BEG[1] Tile_X0Y1_E1BEG[2]
+ Tile_X0Y1_E1BEG[3] Tile_X0Y1_E2BEG[0] Tile_X0Y1_E2BEG[1] Tile_X0Y1_E2BEG[2] Tile_X0Y1_E2BEG[3]
+ Tile_X0Y1_E2BEG[4] Tile_X0Y1_E2BEG[5] Tile_X0Y1_E2BEG[6] Tile_X0Y1_E2BEG[7] Tile_X0Y1_E2BEGb[0]
+ Tile_X0Y1_E2BEGb[1] Tile_X0Y1_E2BEGb[2] Tile_X0Y1_E2BEGb[3] Tile_X0Y1_E2BEGb[4]
+ Tile_X0Y1_E2BEGb[5] Tile_X0Y1_E2BEGb[6] Tile_X0Y1_E2BEGb[7] Tile_X0Y1_E6BEG[0] Tile_X0Y1_E6BEG[10]
+ Tile_X0Y1_E6BEG[11] Tile_X0Y1_E6BEG[1] Tile_X0Y1_E6BEG[2] Tile_X0Y1_E6BEG[3] Tile_X0Y1_E6BEG[4]
+ Tile_X0Y1_E6BEG[5] Tile_X0Y1_E6BEG[6] Tile_X0Y1_E6BEG[7] Tile_X0Y1_E6BEG[8] Tile_X0Y1_E6BEG[9]
+ Tile_X0Y1_EE4BEG[0] Tile_X0Y1_EE4BEG[10] Tile_X0Y1_EE4BEG[11] Tile_X0Y1_EE4BEG[12]
+ Tile_X0Y1_EE4BEG[13] Tile_X0Y1_EE4BEG[14] Tile_X0Y1_EE4BEG[15] Tile_X0Y1_EE4BEG[1]
+ Tile_X0Y1_EE4BEG[2] Tile_X0Y1_EE4BEG[3] Tile_X0Y1_EE4BEG[4] Tile_X0Y1_EE4BEG[5]
+ Tile_X0Y1_EE4BEG[6] Tile_X0Y1_EE4BEG[7] Tile_X0Y1_EE4BEG[8] Tile_X0Y1_EE4BEG[9]
+ Tile_X0Y1_FrameData[0] Tile_X0Y1_FrameData[10] Tile_X0Y1_FrameData[11] Tile_X0Y1_FrameData[12]
+ Tile_X0Y1_FrameData[13] Tile_X0Y1_FrameData[14] Tile_X0Y1_FrameData[15] Tile_X0Y1_FrameData[16]
+ Tile_X0Y1_FrameData[17] Tile_X0Y1_FrameData[18] Tile_X0Y1_FrameData[19] Tile_X0Y1_FrameData[1]
+ Tile_X0Y1_FrameData[20] Tile_X0Y1_FrameData[21] Tile_X0Y1_FrameData[22] Tile_X0Y1_FrameData[23]
+ Tile_X0Y1_FrameData[24] Tile_X0Y1_FrameData[25] Tile_X0Y1_FrameData[26] Tile_X0Y1_FrameData[27]
+ Tile_X0Y1_FrameData[28] Tile_X0Y1_FrameData[29] Tile_X0Y1_FrameData[2] Tile_X0Y1_FrameData[30]
+ Tile_X0Y1_FrameData[31] Tile_X0Y1_FrameData[3] Tile_X0Y1_FrameData[4] Tile_X0Y1_FrameData[5]
+ Tile_X0Y1_FrameData[6] Tile_X0Y1_FrameData[7] Tile_X0Y1_FrameData[8] Tile_X0Y1_FrameData[9]
+ Tile_X0Y1_FrameData_O[0] Tile_X0Y1_FrameData_O[10] Tile_X0Y1_FrameData_O[11] Tile_X0Y1_FrameData_O[12]
+ Tile_X0Y1_FrameData_O[13] Tile_X0Y1_FrameData_O[14] Tile_X0Y1_FrameData_O[15] Tile_X0Y1_FrameData_O[16]
+ Tile_X0Y1_FrameData_O[17] Tile_X0Y1_FrameData_O[18] Tile_X0Y1_FrameData_O[19] Tile_X0Y1_FrameData_O[1]
+ Tile_X0Y1_FrameData_O[20] Tile_X0Y1_FrameData_O[21] Tile_X0Y1_FrameData_O[22] Tile_X0Y1_FrameData_O[23]
+ Tile_X0Y1_FrameData_O[24] Tile_X0Y1_FrameData_O[25] Tile_X0Y1_FrameData_O[26] Tile_X0Y1_FrameData_O[27]
+ Tile_X0Y1_FrameData_O[28] Tile_X0Y1_FrameData_O[29] Tile_X0Y1_FrameData_O[2] Tile_X0Y1_FrameData_O[30]
+ Tile_X0Y1_FrameData_O[31] Tile_X0Y1_FrameData_O[3] Tile_X0Y1_FrameData_O[4] Tile_X0Y1_FrameData_O[5]
+ Tile_X0Y1_FrameData_O[6] Tile_X0Y1_FrameData_O[7] Tile_X0Y1_FrameData_O[8] Tile_X0Y1_FrameData_O[9]
+ Tile_X0Y1_UserCLK Tile_X0Y1_UserCLKo Tile_X0Y1_W1END[0] Tile_X0Y1_W1END[1] Tile_X0Y1_W1END[2]
+ Tile_X0Y1_W1END[3] Tile_X0Y1_W2END[0] Tile_X0Y1_W2END[1] Tile_X0Y1_W2END[2] Tile_X0Y1_W2END[3]
+ Tile_X0Y1_W2END[4] Tile_X0Y1_W2END[5] Tile_X0Y1_W2END[6] Tile_X0Y1_W2END[7] Tile_X0Y1_W2MID[0]
+ Tile_X0Y1_W2MID[1] Tile_X0Y1_W2MID[2] Tile_X0Y1_W2MID[3] Tile_X0Y1_W2MID[4] Tile_X0Y1_W2MID[5]
+ Tile_X0Y1_W2MID[6] Tile_X0Y1_W2MID[7] Tile_X0Y1_W6END[0] Tile_X0Y1_W6END[10] Tile_X0Y1_W6END[11]
+ Tile_X0Y1_W6END[1] Tile_X0Y1_W6END[2] Tile_X0Y1_W6END[3] Tile_X0Y1_W6END[4] Tile_X0Y1_W6END[5]
+ Tile_X0Y1_W6END[6] Tile_X0Y1_W6END[7] Tile_X0Y1_W6END[8] Tile_X0Y1_W6END[9] Tile_X0Y1_WW4END[0]
+ Tile_X0Y1_WW4END[10] Tile_X0Y1_WW4END[11] Tile_X0Y1_WW4END[12] Tile_X0Y1_WW4END[13]
+ Tile_X0Y1_WW4END[14] Tile_X0Y1_WW4END[15] Tile_X0Y1_WW4END[1] Tile_X0Y1_WW4END[2]
+ Tile_X0Y1_WW4END[3] Tile_X0Y1_WW4END[4] Tile_X0Y1_WW4END[5] Tile_X0Y1_WW4END[6]
+ Tile_X0Y1_WW4END[7] Tile_X0Y1_WW4END[8] Tile_X0Y1_WW4END[9] Tile_X0Y2_E1BEG[0] Tile_X0Y2_E1BEG[1]
+ Tile_X0Y2_E1BEG[2] Tile_X0Y2_E1BEG[3] Tile_X0Y2_E2BEG[0] Tile_X0Y2_E2BEG[1] Tile_X0Y2_E2BEG[2]
+ Tile_X0Y2_E2BEG[3] Tile_X0Y2_E2BEG[4] Tile_X0Y2_E2BEG[5] Tile_X0Y2_E2BEG[6] Tile_X0Y2_E2BEG[7]
+ Tile_X0Y2_E2BEGb[0] Tile_X0Y2_E2BEGb[1] Tile_X0Y2_E2BEGb[2] Tile_X0Y2_E2BEGb[3]
+ Tile_X0Y2_E2BEGb[4] Tile_X0Y2_E2BEGb[5] Tile_X0Y2_E2BEGb[6] Tile_X0Y2_E2BEGb[7]
+ Tile_X0Y2_E6BEG[0] Tile_X0Y2_E6BEG[10] Tile_X0Y2_E6BEG[11] Tile_X0Y2_E6BEG[1] Tile_X0Y2_E6BEG[2]
+ Tile_X0Y2_E6BEG[3] Tile_X0Y2_E6BEG[4] Tile_X0Y2_E6BEG[5] Tile_X0Y2_E6BEG[6] Tile_X0Y2_E6BEG[7]
+ Tile_X0Y2_E6BEG[8] Tile_X0Y2_E6BEG[9] Tile_X0Y2_EE4BEG[0] Tile_X0Y2_EE4BEG[10] Tile_X0Y2_EE4BEG[11]
+ Tile_X0Y2_EE4BEG[12] Tile_X0Y2_EE4BEG[13] Tile_X0Y2_EE4BEG[14] Tile_X0Y2_EE4BEG[15]
+ Tile_X0Y2_EE4BEG[1] Tile_X0Y2_EE4BEG[2] Tile_X0Y2_EE4BEG[3] Tile_X0Y2_EE4BEG[4]
+ Tile_X0Y2_EE4BEG[5] Tile_X0Y2_EE4BEG[6] Tile_X0Y2_EE4BEG[7] Tile_X0Y2_EE4BEG[8]
+ Tile_X0Y2_EE4BEG[9] Tile_X0Y2_FrameData[0] Tile_X0Y2_FrameData[10] Tile_X0Y2_FrameData[11]
+ Tile_X0Y2_FrameData[12] Tile_X0Y2_FrameData[13] Tile_X0Y2_FrameData[14] Tile_X0Y2_FrameData[15]
+ Tile_X0Y2_FrameData[16] Tile_X0Y2_FrameData[17] Tile_X0Y2_FrameData[18] Tile_X0Y2_FrameData[19]
+ Tile_X0Y2_FrameData[1] Tile_X0Y2_FrameData[20] Tile_X0Y2_FrameData[21] Tile_X0Y2_FrameData[22]
+ Tile_X0Y2_FrameData[23] Tile_X0Y2_FrameData[24] Tile_X0Y2_FrameData[25] Tile_X0Y2_FrameData[26]
+ Tile_X0Y2_FrameData[27] Tile_X0Y2_FrameData[28] Tile_X0Y2_FrameData[29] Tile_X0Y2_FrameData[2]
+ Tile_X0Y2_FrameData[30] Tile_X0Y2_FrameData[31] Tile_X0Y2_FrameData[3] Tile_X0Y2_FrameData[4]
+ Tile_X0Y2_FrameData[5] Tile_X0Y2_FrameData[6] Tile_X0Y2_FrameData[7] Tile_X0Y2_FrameData[8]
+ Tile_X0Y2_FrameData[9] Tile_X0Y2_FrameData_O[0] Tile_X0Y2_FrameData_O[10] Tile_X0Y2_FrameData_O[11]
+ Tile_X0Y2_FrameData_O[12] Tile_X0Y2_FrameData_O[13] Tile_X0Y2_FrameData_O[14] Tile_X0Y2_FrameData_O[15]
+ Tile_X0Y2_FrameData_O[16] Tile_X0Y2_FrameData_O[17] Tile_X0Y2_FrameData_O[18] Tile_X0Y2_FrameData_O[19]
+ Tile_X0Y2_FrameData_O[1] Tile_X0Y2_FrameData_O[20] Tile_X0Y2_FrameData_O[21] Tile_X0Y2_FrameData_O[22]
+ Tile_X0Y2_FrameData_O[23] Tile_X0Y2_FrameData_O[24] Tile_X0Y2_FrameData_O[25] Tile_X0Y2_FrameData_O[26]
+ Tile_X0Y2_FrameData_O[27] Tile_X0Y2_FrameData_O[28] Tile_X0Y2_FrameData_O[29] Tile_X0Y2_FrameData_O[2]
+ Tile_X0Y2_FrameData_O[30] Tile_X0Y2_FrameData_O[31] Tile_X0Y2_FrameData_O[3] Tile_X0Y2_FrameData_O[4]
+ Tile_X0Y2_FrameData_O[5] Tile_X0Y2_FrameData_O[6] Tile_X0Y2_FrameData_O[7] Tile_X0Y2_FrameData_O[8]
+ Tile_X0Y2_FrameData_O[9] Tile_X0Y2_UserCLK Tile_X0Y2_UserCLKo Tile_X0Y2_W1END[0]
+ Tile_X0Y2_W1END[1] Tile_X0Y2_W1END[2] Tile_X0Y2_W1END[3] Tile_X0Y2_W2END[0] Tile_X0Y2_W2END[1]
+ Tile_X0Y2_W2END[2] Tile_X0Y2_W2END[3] Tile_X0Y2_W2END[4] Tile_X0Y2_W2END[5] Tile_X0Y2_W2END[6]
+ Tile_X0Y2_W2END[7] Tile_X0Y2_W2MID[0] Tile_X0Y2_W2MID[1] Tile_X0Y2_W2MID[2] Tile_X0Y2_W2MID[3]
+ Tile_X0Y2_W2MID[4] Tile_X0Y2_W2MID[5] Tile_X0Y2_W2MID[6] Tile_X0Y2_W2MID[7] Tile_X0Y2_W6END[0]
+ Tile_X0Y2_W6END[10] Tile_X0Y2_W6END[11] Tile_X0Y2_W6END[1] Tile_X0Y2_W6END[2] Tile_X0Y2_W6END[3]
+ Tile_X0Y2_W6END[4] Tile_X0Y2_W6END[5] Tile_X0Y2_W6END[6] Tile_X0Y2_W6END[7] Tile_X0Y2_W6END[8]
+ Tile_X0Y2_W6END[9] Tile_X0Y2_WW4END[0] Tile_X0Y2_WW4END[10] Tile_X0Y2_WW4END[11]
+ Tile_X0Y2_WW4END[12] Tile_X0Y2_WW4END[13] Tile_X0Y2_WW4END[14] Tile_X0Y2_WW4END[15]
+ Tile_X0Y2_WW4END[1] Tile_X0Y2_WW4END[2] Tile_X0Y2_WW4END[3] Tile_X0Y2_WW4END[4]
+ Tile_X0Y2_WW4END[5] Tile_X0Y2_WW4END[6] Tile_X0Y2_WW4END[7] Tile_X0Y2_WW4END[8]
+ Tile_X0Y2_WW4END[9] Tile_X0Y3_E1BEG[0] Tile_X0Y3_E1BEG[1] Tile_X0Y3_E1BEG[2] Tile_X0Y3_E1BEG[3]
+ Tile_X0Y3_E2BEG[0] Tile_X0Y3_E2BEG[1] Tile_X0Y3_E2BEG[2] Tile_X0Y3_E2BEG[3] Tile_X0Y3_E2BEG[4]
+ Tile_X0Y3_E2BEG[5] Tile_X0Y3_E2BEG[6] Tile_X0Y3_E2BEG[7] Tile_X0Y3_E2BEGb[0] Tile_X0Y3_E2BEGb[1]
+ Tile_X0Y3_E2BEGb[2] Tile_X0Y3_E2BEGb[3] Tile_X0Y3_E2BEGb[4] Tile_X0Y3_E2BEGb[5]
+ Tile_X0Y3_E2BEGb[6] Tile_X0Y3_E2BEGb[7] Tile_X0Y3_E6BEG[0] Tile_X0Y3_E6BEG[10] Tile_X0Y3_E6BEG[11]
+ Tile_X0Y3_E6BEG[1] Tile_X0Y3_E6BEG[2] Tile_X0Y3_E6BEG[3] Tile_X0Y3_E6BEG[4] Tile_X0Y3_E6BEG[5]
+ Tile_X0Y3_E6BEG[6] Tile_X0Y3_E6BEG[7] Tile_X0Y3_E6BEG[8] Tile_X0Y3_E6BEG[9] Tile_X0Y3_EE4BEG[0]
+ Tile_X0Y3_EE4BEG[10] Tile_X0Y3_EE4BEG[11] Tile_X0Y3_EE4BEG[12] Tile_X0Y3_EE4BEG[13]
+ Tile_X0Y3_EE4BEG[14] Tile_X0Y3_EE4BEG[15] Tile_X0Y3_EE4BEG[1] Tile_X0Y3_EE4BEG[2]
+ Tile_X0Y3_EE4BEG[3] Tile_X0Y3_EE4BEG[4] Tile_X0Y3_EE4BEG[5] Tile_X0Y3_EE4BEG[6]
+ Tile_X0Y3_EE4BEG[7] Tile_X0Y3_EE4BEG[8] Tile_X0Y3_EE4BEG[9] Tile_X0Y3_FrameData[0]
+ Tile_X0Y3_FrameData[10] Tile_X0Y3_FrameData[11] Tile_X0Y3_FrameData[12] Tile_X0Y3_FrameData[13]
+ Tile_X0Y3_FrameData[14] Tile_X0Y3_FrameData[15] Tile_X0Y3_FrameData[16] Tile_X0Y3_FrameData[17]
+ Tile_X0Y3_FrameData[18] Tile_X0Y3_FrameData[19] Tile_X0Y3_FrameData[1] Tile_X0Y3_FrameData[20]
+ Tile_X0Y3_FrameData[21] Tile_X0Y3_FrameData[22] Tile_X0Y3_FrameData[23] Tile_X0Y3_FrameData[24]
+ Tile_X0Y3_FrameData[25] Tile_X0Y3_FrameData[26] Tile_X0Y3_FrameData[27] Tile_X0Y3_FrameData[28]
+ Tile_X0Y3_FrameData[29] Tile_X0Y3_FrameData[2] Tile_X0Y3_FrameData[30] Tile_X0Y3_FrameData[31]
+ Tile_X0Y3_FrameData[3] Tile_X0Y3_FrameData[4] Tile_X0Y3_FrameData[5] Tile_X0Y3_FrameData[6]
+ Tile_X0Y3_FrameData[7] Tile_X0Y3_FrameData[8] Tile_X0Y3_FrameData[9] Tile_X0Y3_FrameData_O[0]
+ Tile_X0Y3_FrameData_O[10] Tile_X0Y3_FrameData_O[11] Tile_X0Y3_FrameData_O[12] Tile_X0Y3_FrameData_O[13]
+ Tile_X0Y3_FrameData_O[14] Tile_X0Y3_FrameData_O[15] Tile_X0Y3_FrameData_O[16] Tile_X0Y3_FrameData_O[17]
+ Tile_X0Y3_FrameData_O[18] Tile_X0Y3_FrameData_O[19] Tile_X0Y3_FrameData_O[1] Tile_X0Y3_FrameData_O[20]
+ Tile_X0Y3_FrameData_O[21] Tile_X0Y3_FrameData_O[22] Tile_X0Y3_FrameData_O[23] Tile_X0Y3_FrameData_O[24]
+ Tile_X0Y3_FrameData_O[25] Tile_X0Y3_FrameData_O[26] Tile_X0Y3_FrameData_O[27] Tile_X0Y3_FrameData_O[28]
+ Tile_X0Y3_FrameData_O[29] Tile_X0Y3_FrameData_O[2] Tile_X0Y3_FrameData_O[30] Tile_X0Y3_FrameData_O[31]
+ Tile_X0Y3_FrameData_O[3] Tile_X0Y3_FrameData_O[4] Tile_X0Y3_FrameData_O[5] Tile_X0Y3_FrameData_O[6]
+ Tile_X0Y3_FrameData_O[7] Tile_X0Y3_FrameData_O[8] Tile_X0Y3_FrameData_O[9] Tile_X0Y3_FrameStrobe[0]
+ Tile_X0Y3_FrameStrobe[10] Tile_X0Y3_FrameStrobe[11] Tile_X0Y3_FrameStrobe[12] Tile_X0Y3_FrameStrobe[13]
+ Tile_X0Y3_FrameStrobe[14] Tile_X0Y3_FrameStrobe[15] Tile_X0Y3_FrameStrobe[16] Tile_X0Y3_FrameStrobe[17]
+ Tile_X0Y3_FrameStrobe[18] Tile_X0Y3_FrameStrobe[19] Tile_X0Y3_FrameStrobe[1] Tile_X0Y3_FrameStrobe[2]
+ Tile_X0Y3_FrameStrobe[3] Tile_X0Y3_FrameStrobe[4] Tile_X0Y3_FrameStrobe[5] Tile_X0Y3_FrameStrobe[6]
+ Tile_X0Y3_FrameStrobe[7] Tile_X0Y3_FrameStrobe[8] Tile_X0Y3_FrameStrobe[9] Tile_X0Y3_N1END[0]
+ Tile_X0Y3_N1END[1] Tile_X0Y3_N1END[2] Tile_X0Y3_N1END[3] Tile_X0Y3_N2END[0] Tile_X0Y3_N2END[1]
+ Tile_X0Y3_N2END[2] Tile_X0Y3_N2END[3] Tile_X0Y3_N2END[4] Tile_X0Y3_N2END[5] Tile_X0Y3_N2END[6]
+ Tile_X0Y3_N2END[7] Tile_X0Y3_N2MID[0] Tile_X0Y3_N2MID[1] Tile_X0Y3_N2MID[2] Tile_X0Y3_N2MID[3]
+ Tile_X0Y3_N2MID[4] Tile_X0Y3_N2MID[5] Tile_X0Y3_N2MID[6] Tile_X0Y3_N2MID[7] Tile_X0Y3_N4END[0]
+ Tile_X0Y3_N4END[10] Tile_X0Y3_N4END[11] Tile_X0Y3_N4END[12] Tile_X0Y3_N4END[13]
+ Tile_X0Y3_N4END[14] Tile_X0Y3_N4END[15] Tile_X0Y3_N4END[1] Tile_X0Y3_N4END[2] Tile_X0Y3_N4END[3]
+ Tile_X0Y3_N4END[4] Tile_X0Y3_N4END[5] Tile_X0Y3_N4END[6] Tile_X0Y3_N4END[7] Tile_X0Y3_N4END[8]
+ Tile_X0Y3_N4END[9] Tile_X0Y3_S1BEG[0] Tile_X0Y3_S1BEG[1] Tile_X0Y3_S1BEG[2] Tile_X0Y3_S1BEG[3]
+ Tile_X0Y3_S2BEG[0] Tile_X0Y3_S2BEG[1] Tile_X0Y3_S2BEG[2] Tile_X0Y3_S2BEG[3] Tile_X0Y3_S2BEG[4]
+ Tile_X0Y3_S2BEG[5] Tile_X0Y3_S2BEG[6] Tile_X0Y3_S2BEG[7] Tile_X0Y3_S2BEGb[0] Tile_X0Y3_S2BEGb[1]
+ Tile_X0Y3_S2BEGb[2] Tile_X0Y3_S2BEGb[3] Tile_X0Y3_S2BEGb[4] Tile_X0Y3_S2BEGb[5]
+ Tile_X0Y3_S2BEGb[6] Tile_X0Y3_S2BEGb[7] Tile_X0Y3_S4BEG[0] Tile_X0Y3_S4BEG[10] Tile_X0Y3_S4BEG[11]
+ Tile_X0Y3_S4BEG[12] Tile_X0Y3_S4BEG[13] Tile_X0Y3_S4BEG[14] Tile_X0Y3_S4BEG[15]
+ Tile_X0Y3_S4BEG[1] Tile_X0Y3_S4BEG[2] Tile_X0Y3_S4BEG[3] Tile_X0Y3_S4BEG[4] Tile_X0Y3_S4BEG[5]
+ Tile_X0Y3_S4BEG[6] Tile_X0Y3_S4BEG[7] Tile_X0Y3_S4BEG[8] Tile_X0Y3_S4BEG[9] Tile_X0Y3_UserCLK
+ Tile_X0Y3_UserCLKo Tile_X0Y3_W1END[0] Tile_X0Y3_W1END[1] Tile_X0Y3_W1END[2] Tile_X0Y3_W1END[3]
+ Tile_X0Y3_W2END[0] Tile_X0Y3_W2END[1] Tile_X0Y3_W2END[2] Tile_X0Y3_W2END[3] Tile_X0Y3_W2END[4]
+ Tile_X0Y3_W2END[5] Tile_X0Y3_W2END[6] Tile_X0Y3_W2END[7] Tile_X0Y3_W2MID[0] Tile_X0Y3_W2MID[1]
+ Tile_X0Y3_W2MID[2] Tile_X0Y3_W2MID[3] Tile_X0Y3_W2MID[4] Tile_X0Y3_W2MID[5] Tile_X0Y3_W2MID[6]
+ Tile_X0Y3_W2MID[7] Tile_X0Y3_W6END[0] Tile_X0Y3_W6END[10] Tile_X0Y3_W6END[11] Tile_X0Y3_W6END[1]
+ Tile_X0Y3_W6END[2] Tile_X0Y3_W6END[3] Tile_X0Y3_W6END[4] Tile_X0Y3_W6END[5] Tile_X0Y3_W6END[6]
+ Tile_X0Y3_W6END[7] Tile_X0Y3_W6END[8] Tile_X0Y3_W6END[9] Tile_X0Y3_WW4END[0] Tile_X0Y3_WW4END[10]
+ Tile_X0Y3_WW4END[11] Tile_X0Y3_WW4END[12] Tile_X0Y3_WW4END[13] Tile_X0Y3_WW4END[14]
+ Tile_X0Y3_WW4END[15] Tile_X0Y3_WW4END[1] Tile_X0Y3_WW4END[2] Tile_X0Y3_WW4END[3]
+ Tile_X0Y3_WW4END[4] Tile_X0Y3_WW4END[5] Tile_X0Y3_WW4END[6] Tile_X0Y3_WW4END[7]
+ Tile_X0Y3_WW4END[8] Tile_X0Y3_WW4END[9] VGND VPWR
XFILLER_223_54 VPWR VGND sg13cmos5l_fill_1
X_2106_ _2106_/Q Tile_X0Y3_FrameData[25] Tile_X0Y3_FrameStrobe[5] VPWR VGND sg13cmos5l_dlhq_1
XFILLER_54_236 VPWR VGND sg13cmos5l_fill_2
XFILLER_223_76 VPWR VGND sg13cmos5l_fill_1
X_2037_ _2037_/Q Tile_X0Y3_FrameData[30] Tile_X0Y3_FrameStrobe[3] VPWR VGND sg13cmos5l_dlhq_1
XFILLER_168_18 VPWR VGND sg13cmos5l_fill_2
XFILLER_210_234 VPWR VGND sg13cmos5l_decap_8
XFILLER_22_188 VPWR VGND sg13cmos5l_fill_1
XANTENNA__0717__A0 Tile_X0Y0_W2MID[7] VPWR VGND sg13cmos5l_antennanp
XFILLER_116_293 VPWR VGND sg13cmos5l_fill_2
XFILLER_131_263 VPWR VGND sg13cmos5l_decap_8
XFILLER_133_32 VPWR VGND sg13cmos5l_decap_8
XFILLER_93_69 VPWR VGND sg13cmos5l_decap_4
XFILLER_45_269 VPWR VGND sg13cmos5l_fill_1
XFILLER_165_2 VPWR VGND sg13cmos5l_fill_1
XFILLER_198_241 VPWR VGND sg13cmos5l_decap_8
XFILLER_201_223 VPWR VGND sg13cmos5l_decap_8
XANTENNA__1554__GATE Tile_X0Y3_FrameStrobe[3] VPWR VGND sg13cmos5l_antennanp
XFILLER_201_278 VPWR VGND sg13cmos5l_fill_1
XANTENNA__0956__A0 AXIL_S_SOC_WDATA19 VPWR VGND sg13cmos5l_antennanp
XFILLER_166_171 VPWR VGND sg13cmos5l_decap_8
XFILLER_181_141 VPWR VGND sg13cmos5l_decap_8
XANTENNA__0708__A0 Tile_X0Y3_W1END[3] VPWR VGND sg13cmos5l_antennanp
XANTENNA__1569__GATE Tile_X0Y3_FrameStrobe[3] VPWR VGND sg13cmos5l_antennanp
XFILLER_107_293 VPWR VGND sg13cmos5l_fill_2
XFILLER_122_285 VPWR VGND sg13cmos5l_fill_2
X_1270_ _1270_/Q Tile_X0Y0_FrameData[21] Tile_X0Y3_FrameStrobe[2] VPWR VGND sg13cmos5l_dlhq_1
XANTENNA__2275__A Tile_X0Y1_UserCLK VPWR VGND sg13cmos5l_antennanp
XANTENNA__1507__GATE Tile_X0Y3_FrameStrobe[1] VPWR VGND sg13cmos5l_antennanp
XFILLER_51_217 VPWR VGND sg13cmos5l_decap_4
XFILLER_51_206 VPWR VGND sg13cmos5l_decap_8
XFILLER_51_239 VPWR VGND sg13cmos5l_fill_2
XANTENNA__2562__X Tile_X0Y3_FrameData_O[20] VPWR VGND sg13cmos5l_antennanp
XFILLER_199_91 VPWR VGND sg13cmos5l_fill_1
XFILLER_189_285 VPWR VGND sg13cmos5l_fill_2
XFILLER_164_119 VPWR VGND sg13cmos5l_decap_4
X_0985_ _0985_/Y _1627_/Q _0985_/B VPWR VGND sg13cmos5l_nand2b_1
XFILLER_66_0 VPWR VGND sg13cmos5l_fill_2
XFILLER_172_152 VPWR VGND sg13cmos5l_decap_8
XFILLER_172_141 VPWR VGND sg13cmos5l_decap_8
XANTENNA__2160__D Tile_X0Y3_FrameData[3] VPWR VGND sg13cmos5l_antennanp
X_1606_ _1606_/Q Tile_X0Y1_FrameData[29] Tile_X0Y3_FrameStrobe[5] VPWR VGND sg13cmos5l_dlhq_1
X_2586_ Tile_X0Y3_S2BEGb[0] _2586_/A VPWR VGND sg13cmos5l_buf_1
X_1537_ _1537_/Q Tile_X0Y1_FrameData[2] Tile_X0Y3_FrameStrobe[2] VPWR VGND sg13cmos5l_dlhq_1
X_1468_ _1468_/Q Tile_X0Y1_FrameData[7] Tile_X0Y3_FrameStrobe[0] VPWR VGND sg13cmos5l_dlhq_1
XFILLER_86_147 VPWR VGND sg13cmos5l_decap_8
XANTENNA__1124__A0 AXIL_S_SOC_WDATA1 VPWR VGND sg13cmos5l_antennanp
XANTENNA__1504__D Tile_X0Y1_FrameData[3] VPWR VGND sg13cmos5l_antennanp
X_1399_ _1399_/Q Tile_X0Y0_FrameData[20] Tile_X0Y3_FrameStrobe[6] VPWR VGND sg13cmos5l_dlhq_1
XFILLER_103_57 VPWR VGND sg13cmos5l_decap_4
XFILLER_27_236 VPWR VGND sg13cmos5l_decap_4
XFILLER_35_280 VPWR VGND sg13cmos5l_fill_1
XANTENNA__2472__X Tile_X0Y0_E6BEG[10] VPWR VGND sg13cmos5l_antennanp
XFILLER_50_294 VPWR VGND sg13cmos5l_fill_1
XFILLER_10_136 VPWR VGND sg13cmos5l_decap_8
XFILLER_195_277 VPWR VGND sg13cmos5l_decap_4
XANTENNA__0433__A Tile_X0Y0_W6END[3] VPWR VGND sg13cmos5l_antennanp
XANTENNA__0938__A0 Tile_X0Y1_W1END[0] VPWR VGND sg13cmos5l_antennanp
XFILLER_163_141 VPWR VGND sg13cmos5l_fill_2
XANTENNA__2070__D Tile_X0Y3_FrameData[29] VPWR VGND sg13cmos5l_antennanp
XFILLER_88_14 VPWR VGND sg13cmos5l_decap_8
XFILLER_5_4 VPWR VGND sg13cmos5l_fill_1
XANTENNA__1115__A0 AXIL_S_SOC_WDATA2 VPWR VGND sg13cmos5l_antennanp
XANTENNA__1414__D Tile_X0Y0_FrameData[5] VPWR VGND sg13cmos5l_antennanp
XFILLER_160_41 VPWR VGND sg13cmos5l_fill_1
XFILLER_160_52 VPWR VGND sg13cmos5l_fill_1
XFILLER_18_236 VPWR VGND sg13cmos5l_decap_8
XFILLER_160_63 VPWR VGND sg13cmos5l_fill_1
XFILLER_33_217 VPWR VGND sg13cmos5l_decap_4
XANTENNA__2382__X Tile_X0Y0_N2BEG[0] VPWR VGND sg13cmos5l_antennanp
XANTENNA__1493__GATE Tile_X0Y3_FrameStrobe[1] VPWR VGND sg13cmos5l_antennanp
XFILLER_41_283 VPWR VGND sg13cmos5l_fill_1
XANTENNA__0641__A2 Tile_X0Y2_W6END[7] VPWR VGND sg13cmos5l_antennanp
XFILLER_186_277 VPWR VGND sg13cmos5l_decap_4
XFILLER_139_171 VPWR VGND sg13cmos5l_decap_4
XFILLER_139_193 VPWR VGND sg13cmos5l_fill_2
X_0770_ _0770_/X Tile_X0Y1_W1END[2] _0465_/X Tile_X0Y1_W6END[6] _0469_/Y _1686_/Q
+ _1687_/Q VPWR VGND sg13cmos5l_mux4_1
XFILLER_154_185 VPWR VGND sg13cmos5l_decap_8
X_2440_ Tile_X0Y0_FrameData_O[26] Tile_X0Y0_FrameData[26] VPWR VGND sg13cmos5l_buf_1
XFILLER_5_162 VPWR VGND sg13cmos5l_fill_1
XANTENNA__1431__GATE Tile_X0Y3_FrameStrobe[7] VPWR VGND sg13cmos5l_antennanp
X_2371_ Tile_X0Y0_N4BEG[13] _2371_/A VPWR VGND sg13cmos5l_buf_1
X_1322_ _1322_/Q Tile_X0Y0_FrameData[1] Tile_X0Y3_FrameStrobe[3] VPWR VGND sg13cmos5l_dlhq_1
XFILLER_68_125 VPWR VGND sg13cmos5l_decap_8
XANTENNA__1106__A0 AXIL_S_SOC_WDATA7 VPWR VGND sg13cmos5l_antennanp
XANTENNA__1324__D Tile_X0Y0_FrameData[31] VPWR VGND sg13cmos5l_antennanp
XANTENNA__2557__X Tile_X0Y3_FrameData_O[15] VPWR VGND sg13cmos5l_antennanp
X_1253_ _1253_/Q Tile_X0Y0_FrameData[6] Tile_X0Y3_FrameStrobe[1] VPWR VGND sg13cmos5l_dlhq_1
XFILLER_68_169 VPWR VGND sg13cmos5l_decap_8
XFILLER_83_139 VPWR VGND sg13cmos5l_fill_1
XFILLER_209_153 VPWR VGND sg13cmos5l_decap_8
XANTENNA__1446__GATE Tile_X0Y3_FrameStrobe[0] VPWR VGND sg13cmos5l_antennanp
X_1184_ _1184_/X Tile_X0Y3_W1END[1] Tile_X0Y3_W6END[9] Tile_X0Y3_WW4END[1] _0616_/X
+ _2159_/Q _2160_/Q VPWR VGND sg13cmos5l_mux4_1
XFILLER_24_239 VPWR VGND sg13cmos5l_decap_8
XFILLER_17_280 VPWR VGND sg13cmos5l_fill_2
XANTENNA__2155__D Tile_X0Y3_FrameData[8] VPWR VGND sg13cmos5l_antennanp
XANTENNA__2292__X Tile_X0Y2_E2BEGb[4] VPWR VGND sg13cmos5l_antennanp
XFILLER_32_250 VPWR VGND sg13cmos5l_decap_8
XFILLER_220_77 VPWR VGND sg13cmos5l_fill_2
XFILLER_177_222 VPWR VGND sg13cmos5l_fill_1
XANTENNA__1994__D Tile_X0Y3_FrameData[9] VPWR VGND sg13cmos5l_antennanp
XFILLER_177_277 VPWR VGND sg13cmos5l_fill_2
X_0968_ _0968_/X Tile_X0Y1_W1END[3] Tile_X0Y1_WW4END[15] _1622_/Q VPWR VGND sg13cmos5l_mux2_1
XFILLER_145_185 VPWR VGND sg13cmos5l_decap_8
X_0899_ _2471_/A AXIL_S_SOC_WSTRB0 _0785_/X _0786_/X _0736_/X _1281_/Q _1280_/Q VPWR
+ VGND sg13cmos5l_mux4_1
X_2569_ Tile_X0Y3_FrameData_O[27] Tile_X0Y3_FrameData[27] VPWR VGND sg13cmos5l_buf_1
XFILLER_101_222 VPWR VGND sg13cmos5l_decap_8
XANTENNA__1234__D Tile_X0Y0_FrameData[25] VPWR VGND sg13cmos5l_antennanp
XANTENNA__2467__X Tile_X0Y0_E6BEG[5] VPWR VGND sg13cmos5l_antennanp
XFILLER_74_38 VPWR VGND sg13cmos5l_decap_8
XFILLER_215_101 VPWR VGND sg13cmos5l_decap_4
XANTENNA__1112__A3 Tile_X0Y0_S4END[11] VPWR VGND sg13cmos5l_antennanp
XANTENNA__0871__A2 Tile_X0Y2_W6END[5] VPWR VGND sg13cmos5l_antennanp
XFILLER_15_239 VPWR VGND sg13cmos5l_fill_1
XANTENNA__2065__D Tile_X0Y3_FrameData[2] VPWR VGND sg13cmos5l_antennanp
XFILLER_130_88 VPWR VGND sg13cmos5l_decap_4
XFILLER_90_26 VPWR VGND sg13cmos5l_fill_1
XFILLER_23_294 VPWR VGND sg13cmos5l_fill_1
XFILLER_183_203 VPWR VGND sg13cmos5l_decap_8
XFILLER_128_2 VPWR VGND sg13cmos5l_fill_1
XFILLER_99_13 VPWR VGND sg13cmos5l_fill_2
XANTENNA__0926__A3 Tile_X0Y0_S4END[5] VPWR VGND sg13cmos5l_antennanp
XANTENNA__1409__D Tile_X0Y0_FrameData[10] VPWR VGND sg13cmos5l_antennanp
XFILLER_136_185 VPWR VGND sg13cmos5l_fill_2
XFILLER_151_111 VPWR VGND sg13cmos5l_decap_8
XFILLER_99_79 VPWR VGND sg13cmos5l_fill_2
XFILLER_155_41 VPWR VGND sg13cmos5l_fill_1
XFILLER_2_121 VPWR VGND sg13cmos5l_decap_8
XFILLER_151_177 VPWR VGND sg13cmos5l_decap_8
XANTENNA__2161__GATE Tile_X0Y3_FrameStrobe[6] VPWR VGND sg13cmos5l_antennanp
XFILLER_151_188 VPWR VGND sg13cmos5l_fill_2
XANTENNA__2377__X Tile_X0Y0_N2BEGb[3] VPWR VGND sg13cmos5l_antennanp
XFILLER_171_73 VPWR VGND sg13cmos5l_decap_4
XANTENNA__1103__A3 Tile_X0Y0_S4END[11] VPWR VGND sg13cmos5l_antennanp
XANTENNA__2176__GATE Tile_X0Y3_FrameStrobe[7] VPWR VGND sg13cmos5l_antennanp
XFILLER_0_46 VPWR VGND sg13cmos5l_fill_1
XFILLER_0_79 VPWR VGND sg13cmos5l_fill_1
XFILLER_73_183 VPWR VGND sg13cmos5l_fill_2
XFILLER_159_211 VPWR VGND sg13cmos5l_decap_4
XFILLER_221_137 VPWR VGND sg13cmos5l_decap_8
XFILLER_221_126 VPWR VGND sg13cmos5l_fill_1
XFILLER_221_115 VPWR VGND sg13cmos5l_fill_2
XANTENNA__2553__A Tile_X0Y3_FrameData[11] VPWR VGND sg13cmos5l_antennanp
X_1940_ _1940_/Q Tile_X0Y2_FrameData[31] Tile_X0Y3_FrameStrobe[0] VPWR VGND sg13cmos5l_dlhq_1
XFILLER_9_33 VPWR VGND sg13cmos5l_decap_8
XFILLER_9_22 VPWR VGND sg13cmos5l_fill_1
XFILLER_221_148 VPWR VGND sg13cmos5l_fill_1
X_1871_ _1871_/Q Tile_X0Y2_FrameData[12] Tile_X0Y3_FrameStrobe[5] VPWR VGND sg13cmos5l_dlhq_1
X_0822_ _0822_/Y _0445_/Y _0458_/Y _1372_/Q VPWR VGND sg13cmos5l_o21ai_1
XFILLER_9_99 VPWR VGND sg13cmos5l_fill_2
XANTENNA__2114__GATE Tile_X0Y3_FrameStrobe[5] VPWR VGND sg13cmos5l_antennanp
XFILLER_127_130 VPWR VGND sg13cmos5l_decap_8
XFILLER_127_141 VPWR VGND sg13cmos5l_fill_1
XANTENNA__1319__D Tile_X0Y0_FrameData[4] VPWR VGND sg13cmos5l_antennanp
X_0753_ _2381_/A Tile_X0Y1_W2MID[0] Tile_X0Y1_W2END[0] Tile_X0Y1_W6END[0] _0862_/X
+ _1669_/Q _1668_/Q VPWR VGND sg13cmos5l_mux4_1
XANTENNA__1370__GATE Tile_X0Y3_FrameStrobe[5] VPWR VGND sg13cmos5l_antennanp
X_0684_ _2537_/A AXIL_S_SOC_ARADDR2 AXIL_S_SOC_ARADDR6 _0605_/X _0590_/X _2053_/Q
+ _2052_/Q VPWR VGND sg13cmos5l_mux4_1
X_2423_ Tile_X0Y0_FrameData_O[9] Tile_X0Y0_FrameData[9] VPWR VGND sg13cmos5l_buf_1
XANTENNA__2129__GATE Tile_X0Y3_FrameStrobe[5] VPWR VGND sg13cmos5l_antennanp
X_2354_ Tile_X0Y2_FrameData_O[30] Tile_X0Y2_FrameData[30] VPWR VGND sg13cmos5l_buf_1
XFILLER_96_220 VPWR VGND sg13cmos5l_fill_1
XANTENNA__2287__X Tile_X0Y2_E2BEG[7] VPWR VGND sg13cmos5l_antennanp
X_1305_ _1305_/Q Tile_X0Y0_FrameData[18] Tile_X0Y3_FrameStrobe[3] VPWR VGND sg13cmos5l_dlhq_1
XFILLER_96_253 VPWR VGND sg13cmos5l_fill_2
XFILLER_96_242 VPWR VGND sg13cmos5l_decap_8
XFILLER_29_0 VPWR VGND sg13cmos5l_fill_2
XANTENNA__1385__GATE Tile_X0Y3_FrameStrobe[5] VPWR VGND sg13cmos5l_antennanp
X_2285_ Tile_X0Y2_E2BEG[5] _2285_/A VPWR VGND sg13cmos5l_buf_1
XANTENNA__1989__D Tile_X0Y3_FrameData[14] VPWR VGND sg13cmos5l_antennanp
X_1236_ _1236_/Q Tile_X0Y0_FrameData[23] Tile_X0Y3_FrameStrobe[1] VPWR VGND sg13cmos5l_dlhq_1
X_1167_ _1168_/B _1906_/Q _0500_/X _1166_/X VPWR VGND sg13cmos5l_o21ai_1
XFILLER_64_150 VPWR VGND sg13cmos5l_decap_8
XFILLER_44_19 VPWR VGND sg13cmos5l_fill_2
X_1098_ _2312_/A AXIL_S_SOC_WDATA4 AXIL_S_SOC_WDATA8 _1097_/A _0746_/X _1819_/Q _1818_/Q
+ VPWR VGND sg13cmos5l_mux4_1
XFILLER_100_25 VPWR VGND sg13cmos5l_fill_1
XANTENNA__1323__GATE Tile_X0Y3_FrameStrobe[3] VPWR VGND sg13cmos5l_antennanp
XANTENNA__1953__GATE Tile_X0Y3_FrameStrobe[0] VPWR VGND sg13cmos5l_antennanp
XANTENNA__1229__D Tile_X0Y0_FrameData[30] VPWR VGND sg13cmos5l_antennanp
XFILLER_114_8 VPWR VGND sg13cmos5l_fill_2
XANTENNA__1338__GATE Tile_X0Y3_FrameStrobe[4] VPWR VGND sg13cmos5l_antennanp
XFILLER_118_185 VPWR VGND sg13cmos5l_decap_8
XANTENNA__1968__GATE Tile_X0Y3_FrameStrobe[0] VPWR VGND sg13cmos5l_antennanp
XFILLER_133_144 VPWR VGND sg13cmos5l_decap_8
XANTENNA__2197__X Tile_X0Y1_E1BEG[2] VPWR VGND sg13cmos5l_antennanp
XFILLER_85_26 VPWR VGND sg13cmos5l_decap_4
XFILLER_85_15 VPWR VGND sg13cmos5l_fill_1
XANTENNA__0541__A1 Tile_X0Y3_W6END[8] VPWR VGND sg13cmos5l_antennanp
XFILLER_47_117 VPWR VGND sg13cmos5l_decap_4
XANTENNA__1899__D Tile_X0Y2_FrameData[16] VPWR VGND sg13cmos5l_antennanp
XFILLER_141_87 VPWR VGND sg13cmos5l_decap_8
XFILLER_18_97 VPWR VGND sg13cmos5l_fill_1
XANTENNA__1906__GATE Tile_X0Y3_FrameStrobe[6] VPWR VGND sg13cmos5l_antennanp
XFILLER_203_159 VPWR VGND sg13cmos5l_decap_8
XFILLER_211_170 VPWR VGND sg13cmos5l_decap_8
XFILLER_133_0 VPWR VGND sg13cmos5l_decap_4
XFILLER_156_214 VPWR VGND sg13cmos5l_decap_8
XANTENNA__1021__A2 AXIL_S_SOC_WDATA27 VPWR VGND sg13cmos5l_antennanp
XFILLER_124_111 VPWR VGND sg13cmos5l_fill_1
XFILLER_22_7 VPWR VGND sg13cmos5l_decap_8
XANTENNA__2548__A Tile_X0Y3_FrameData[6] VPWR VGND sg13cmos5l_antennanp
XFILLER_182_94 VPWR VGND sg13cmos5l_decap_8
X_2070_ _2070_/Q Tile_X0Y3_FrameData[29] Tile_X0Y3_FrameStrobe[4] VPWR VGND sg13cmos5l_dlhq_1
XANTENNA__1088__A2 AXIL_S_SOC_WDATA13 VPWR VGND sg13cmos5l_antennanp
XANTENNA__1602__D Tile_X0Y1_FrameData[1] VPWR VGND sg13cmos5l_antennanp
X_1021_ _2234_/A AXIL_S_SOC_WDATA23 _0914_/A AXIL_S_SOC_WDATA27 _0859_/X _1564_/Q
+ _1565_/Q VPWR VGND sg13cmos5l_mux4_1
XFILLER_46_183 VPWR VGND sg13cmos5l_decap_8
XFILLER_46_161 VPWR VGND sg13cmos5l_fill_1
XFILLER_201_13 VPWR VGND sg13cmos5l_decap_4
XFILLER_61_142 VPWR VGND sg13cmos5l_fill_2
XFILLER_201_24 VPWR VGND sg13cmos5l_decap_8
X_1923_ _1923_/Q Tile_X0Y2_FrameData[24] Tile_X0Y3_FrameStrobe[7] VPWR VGND sg13cmos5l_dlhq_1
XANTENNA__0599__A1 Tile_X0Y3_W2MID[1] VPWR VGND sg13cmos5l_antennanp
XANTENNA__2570__X Tile_X0Y3_FrameData_O[28] VPWR VGND sg13cmos5l_antennanp
XANTENNA__2053__GATE Tile_X0Y3_FrameStrobe[3] VPWR VGND sg13cmos5l_antennanp
X_1854_ _1854_/Q Tile_X0Y2_FrameData[29] Tile_X0Y3_FrameStrobe[5] VPWR VGND sg13cmos5l_dlhq_1
X_1785_ _1785_/Q Tile_X0Y2_FrameData[2] Tile_X0Y3_FrameStrobe[2] VPWR VGND sg13cmos5l_dlhq_1
X_0805_ _0805_/X _0775_/X _0736_/X _1378_/Q VPWR VGND sg13cmos5l_mux2_1
XANTENNA__0531__A Tile_X0Y2_W6END[0] VPWR VGND sg13cmos5l_antennanp
XANTENNA__1012__A2 Tile_X0Y1_W6END[6] VPWR VGND sg13cmos5l_antennanp
XFILLER_115_133 VPWR VGND sg13cmos5l_decap_8
X_0736_ _0736_/X _2379_/A _0734_/X Tile_X0Y0_S2MID[5] Tile_X0Y0_S2END[5] _1209_/Q
+ _1208_/Q VPWR VGND sg13cmos5l_mux4_1
XANTENNA__2068__GATE Tile_X0Y3_FrameStrobe[4] VPWR VGND sg13cmos5l_antennanp
XFILLER_170_250 VPWR VGND sg13cmos5l_fill_1
XFILLER_115_188 VPWR VGND sg13cmos5l_decap_4
XFILLER_170_272 VPWR VGND sg13cmos5l_decap_4
X_2406_ Tile_X0Y0_FrameStrobe_O[12] Tile_X0Y3_FrameStrobe[12] VPWR VGND sg13cmos5l_buf_1
X_0667_ _2508_/A _0638_/Y _0483_/X AXIL_S_SOC_ARADDR5 _0594_/X _2086_/Q _2087_/Q VPWR
+ VGND sg13cmos5l_mux4_1
X_0598_ _0598_/X Tile_X0Y3_N2MID[6] Tile_X0Y3_N2END[6] _2592_/A _0596_/X _1951_/Q
+ _1950_/Q VPWR VGND sg13cmos5l_mux4_1
X_2337_ Tile_X0Y2_FrameData_O[13] Tile_X0Y2_FrameData[13] VPWR VGND sg13cmos5l_buf_1
XFILLER_29_106 VPWR VGND sg13cmos5l_decap_4
X_2268_ Tile_X0Y1_FrameData_O[25] Tile_X0Y1_FrameData[25] VPWR VGND sg13cmos5l_buf_1
XFILLER_217_218 VPWR VGND sg13cmos5l_decap_8
XANTENNA__1512__D Tile_X0Y1_FrameData[27] VPWR VGND sg13cmos5l_antennanp
X_1219_ _1219_/Q Tile_X0Y0_FrameData[8] Tile_X0Y3_FrameStrobe[0] VPWR VGND sg13cmos5l_dlhq_1
X_2199_ Tile_X0Y1_E2BEG[0] _2199_/A VPWR VGND sg13cmos5l_buf_1
XANTENNA__2006__GATE Tile_X0Y3_FrameStrobe[2] VPWR VGND sg13cmos5l_antennanp
XANTENNA__1262__GATE Tile_X0Y3_FrameStrobe[2] VPWR VGND sg13cmos5l_antennanp
XANTENNA__1892__GATE Tile_X0Y3_FrameStrobe[6] VPWR VGND sg13cmos5l_antennanp
XANTENNA__2480__X Tile_X0Y0_E2BEGb[6] VPWR VGND sg13cmos5l_antennanp
XFILLER_138_236 VPWR VGND sg13cmos5l_decap_8
XANTENNA__1277__GATE Tile_X0Y3_FrameStrobe[2] VPWR VGND sg13cmos5l_antennanp
XANTENNA__0441__A Tile_X0Y0_WW4END[14] VPWR VGND sg13cmos5l_antennanp
XANTENNA__1003__A2 Tile_X0Y1_W6END[0] VPWR VGND sg13cmos5l_antennanp
XFILLER_20_43 VPWR VGND sg13cmos5l_decap_8
XFILLER_106_155 VPWR VGND sg13cmos5l_decap_8
XFILLER_20_54 VPWR VGND sg13cmos5l_fill_1
XANTENNA__0762__A1 Tile_X0Y0_S1END[0] VPWR VGND sg13cmos5l_antennanp
XANTENNA__1200__GATE Tile_X0Y3_FrameStrobe[0] VPWR VGND sg13cmos5l_antennanp
XFILLER_161_283 VPWR VGND sg13cmos5l_fill_1
XFILLER_161_294 VPWR VGND sg13cmos5l_fill_1
XFILLER_96_14 VPWR VGND sg13cmos5l_fill_1
XANTENNA__1830__GATE Tile_X0Y3_FrameStrobe[4] VPWR VGND sg13cmos5l_antennanp
XFILLER_96_69 VPWR VGND sg13cmos5l_fill_1
XFILLER_96_36 VPWR VGND sg13cmos5l_fill_1
XANTENNA__0514__A1 Tile_X0Y3_WW4END[3] VPWR VGND sg13cmos5l_antennanp
XFILLER_75_245 VPWR VGND sg13cmos5l_decap_8
XFILLER_29_63 VPWR VGND sg13cmos5l_fill_2
XANTENNA__1215__GATE Tile_X0Y3_FrameStrobe[0] VPWR VGND sg13cmos5l_antennanp
XANTENNA__1422__D Tile_X0Y0_FrameData[29] VPWR VGND sg13cmos5l_antennanp
XANTENNA__1845__GATE Tile_X0Y3_FrameStrobe[4] VPWR VGND sg13cmos5l_antennanp
XFILLER_28_172 VPWR VGND sg13cmos5l_decap_4
XANTENNA__0817__A2 Tile_X0Y0_S1END[2] VPWR VGND sg13cmos5l_antennanp
XANTENNA__2390__X Tile_X0Y0_N1BEG[0] VPWR VGND sg13cmos5l_antennanp
XFILLER_77_8 VPWR VGND sg13cmos5l_fill_2
XANTENNA_5 AXIL_S_SOC_AWADDR3 VPWR VGND sg13cmos5l_antennanp
X_1570_ _1570_/Q Tile_X0Y1_FrameData[1] Tile_X0Y3_FrameStrobe[3] VPWR VGND sg13cmos5l_dlhq_1
XFILLER_6_45 VPWR VGND sg13cmos5l_decap_8
X_0521_ _0521_/X Tile_X0Y0_W1END[0] Tile_X0Y0_W6END[8] _0520_/A _0518_/Y _1407_/Q
+ _1406_/Q VPWR VGND sg13cmos5l_mux4_1
XFILLER_6_89 VPWR VGND sg13cmos5l_fill_2
XANTENNA__0753__A1 Tile_X0Y1_W2END[0] VPWR VGND sg13cmos5l_antennanp
XFILLER_152_294 VPWR VGND sg13cmos5l_fill_1
XFILLER_112_136 VPWR VGND sg13cmos5l_decap_8
X_0452_ _0972_/S _1622_/Q VPWR VGND sg13cmos5l_inv_1
XFILLER_3_293 VPWR VGND sg13cmos5l_fill_2
XANTENNA__0505__A1 Tile_X0Y2_W6END[11] VPWR VGND sg13cmos5l_antennanp
X_2122_ _2122_/Q Tile_X0Y3_FrameData[9] Tile_X0Y3_FrameStrobe[5] VPWR VGND sg13cmos5l_dlhq_1
XANTENNA__2565__X Tile_X0Y3_FrameData_O[23] VPWR VGND sg13cmos5l_antennanp
XFILLER_66_267 VPWR VGND sg13cmos5l_decap_8
XANTENNA__1332__D Tile_X0Y0_FrameData[23] VPWR VGND sg13cmos5l_antennanp
X_2053_ _2053_/Q Tile_X0Y3_FrameData[14] Tile_X0Y3_FrameStrobe[3] VPWR VGND sg13cmos5l_dlhq_1
XFILLER_81_226 VPWR VGND sg13cmos5l_fill_2
X_1004_ _2226_/A AXIL_S_SOC_WDATA19 _0906_/A _0916_/B _0862_/X _1525_/Q _1524_/Q VPWR
+ VGND sg13cmos5l_mux4_1
XFILLER_222_243 VPWR VGND sg13cmos5l_decap_8
XFILLER_96_0 VPWR VGND sg13cmos5l_fill_2
XANTENNA__2163__D Tile_X0Y3_FrameData[0] VPWR VGND sg13cmos5l_antennanp
X_1906_ _1906_/Q Tile_X0Y2_FrameData[9] Tile_X0Y3_FrameStrobe[6] VPWR VGND sg13cmos5l_dlhq_1
X_1837_ _1837_/Q Tile_X0Y2_FrameData[14] Tile_X0Y3_FrameStrobe[4] VPWR VGND sg13cmos5l_dlhq_1
XFILLER_135_228 VPWR VGND sg13cmos5l_decap_8
X_1768_ _1768_/Q Tile_X0Y2_FrameData[19] Tile_X0Y3_FrameStrobe[2] VPWR VGND sg13cmos5l_dlhq_1
XANTENNA__0744__A1 Tile_X0Y0_W2END[4] VPWR VGND sg13cmos5l_antennanp
XANTENNA__1507__D Tile_X0Y1_FrameData[0] VPWR VGND sg13cmos5l_antennanp
XFILLER_103_114 VPWR VGND sg13cmos5l_fill_1
X_1699_ _1699_/Q Tile_X0Y2_FrameData[24] Tile_X0Y3_FrameStrobe[0] VPWR VGND sg13cmos5l_dlhq_1
X_0719_ _0719_/X _0718_/X _0577_/X Tile_X0Y3_N2MID[0] _0717_/X _1714_/Q _1715_/Q VPWR
+ VGND sg13cmos5l_mux4_1
XFILLER_1_219 VPWR VGND sg13cmos5l_fill_2
XFILLER_103_125 VPWR VGND sg13cmos5l_decap_4
XFILLER_106_24 VPWR VGND sg13cmos5l_decap_4
XFILLER_106_79 VPWR VGND sg13cmos5l_decap_8
XFILLER_111_191 VPWR VGND sg13cmos5l_fill_1
XFILLER_57_234 VPWR VGND sg13cmos5l_decap_4
XANTENNA__1242__D Tile_X0Y0_FrameData[17] VPWR VGND sg13cmos5l_antennanp
XANTENNA__2475__X Tile_X0Y0_E2BEGb[1] VPWR VGND sg13cmos5l_antennanp
XFILLER_213_210 VPWR VGND sg13cmos5l_fill_2
XFILLER_213_254 VPWR VGND sg13cmos5l_decap_8
XANTENNA__0680__A0 AXIL_S_SOC_ARADDR2 VPWR VGND sg13cmos5l_antennanp
XFILLER_198_49 VPWR VGND sg13cmos5l_decap_8
XANTENNA__2073__D Tile_X0Y3_FrameData[26] VPWR VGND sg13cmos5l_antennanp
XFILLER_15_87 VPWR VGND sg13cmos5l_decap_8
XFILLER_147_31 VPWR VGND sg13cmos5l_decap_4
XFILLER_141_209 VPWR VGND sg13cmos5l_decap_8
XFILLER_147_64 VPWR VGND sg13cmos5l_decap_8
XANTENNA__0735__A1 Tile_X0Y1_W2END[2] VPWR VGND sg13cmos5l_antennanp
XANTENNA__1417__D Tile_X0Y0_FrameData[2] VPWR VGND sg13cmos5l_antennanp
XFILLER_0_230 VPWR VGND sg13cmos5l_decap_8
XANTENNA__0499__A0 Tile_X0Y1_W1END[3] VPWR VGND sg13cmos5l_antennanp
XANTENNA__1160__A1 Tile_X0Y2_W6END[10] VPWR VGND sg13cmos5l_antennanp
XANTENNA__1784__GATE Tile_X0Y3_FrameStrobe[2] VPWR VGND sg13cmos5l_antennanp
XFILLER_48_278 VPWR VGND sg13cmos5l_fill_2
XANTENNA__2385__X Tile_X0Y0_N2BEG[3] VPWR VGND sg13cmos5l_antennanp
XFILLER_16_142 VPWR VGND sg13cmos5l_fill_1
XANTENNA__0671__A0 AXIL_S_SOC_ARADDR1 VPWR VGND sg13cmos5l_antennanp
XANTENNA__1799__GATE Tile_X0Y3_FrameStrobe[3] VPWR VGND sg13cmos5l_antennanp
XANTENNA__2561__A Tile_X0Y3_FrameData[19] VPWR VGND sg13cmos5l_antennanp
XFILLER_188_93 VPWR VGND sg13cmos5l_decap_8
XANTENNA__1722__GATE Tile_X0Y3_FrameStrobe[0] VPWR VGND sg13cmos5l_antennanp
XFILLER_117_239 VPWR VGND sg13cmos5l_decap_4
X_1622_ _1622_/Q Tile_X0Y1_FrameData[13] Tile_X0Y3_FrameStrobe[5] VPWR VGND sg13cmos5l_dlhq_1
XFILLER_68_4 VPWR VGND sg13cmos5l_fill_1
XANTENNA__0726__A1 Tile_X0Y0_W2END[5] VPWR VGND sg13cmos5l_antennanp
XANTENNA__1327__D Tile_X0Y0_FrameData[28] VPWR VGND sg13cmos5l_antennanp
XANTENNA__1737__GATE Tile_X0Y3_FrameStrobe[1] VPWR VGND sg13cmos5l_antennanp
XFILLER_125_250 VPWR VGND sg13cmos5l_decap_8
X_1553_ _1553_/Q Tile_X0Y1_FrameData[18] Tile_X0Y3_FrameStrobe[3] VPWR VGND sg13cmos5l_dlhq_1
X_1484_ _1484_/Q Tile_X0Y1_FrameData[23] Tile_X0Y3_FrameStrobe[1] VPWR VGND sg13cmos5l_dlhq_1
X_0504_ _0504_/Y _1940_/Q _0503_/Y _0501_/Y VPWR VGND sg13cmos5l_o21ai_1
XFILLER_98_123 VPWR VGND sg13cmos5l_decap_8
XFILLER_207_78 VPWR VGND sg13cmos5l_decap_8
X_0435_ _0435_/Y _1416_/Q VPWR VGND sg13cmos5l_inv_1
XFILLER_223_11 VPWR VGND sg13cmos5l_fill_1
XANTENNA__2158__D Tile_X0Y3_FrameData[5] VPWR VGND sg13cmos5l_antennanp
XFILLER_11_0 VPWR VGND sg13cmos5l_fill_1
XFILLER_39_245 VPWR VGND sg13cmos5l_decap_4
XANTENNA__2295__X Tile_X0Y2_E2BEGb[7] VPWR VGND sg13cmos5l_antennanp
X_2105_ _2105_/Q Tile_X0Y3_FrameData[26] Tile_X0Y3_FrameStrobe[5] VPWR VGND sg13cmos5l_dlhq_1
XFILLER_223_99 VPWR VGND sg13cmos5l_decap_4
XANTENNA__1997__D Tile_X0Y3_FrameData[6] VPWR VGND sg13cmos5l_antennanp
X_2036_ _2036_/Q Tile_X0Y3_FrameData[31] Tile_X0Y3_FrameStrobe[3] VPWR VGND sg13cmos5l_dlhq_1
XANTENNA__0662__A0 AXIL_S_SOC_ARADDR0 VPWR VGND sg13cmos5l_antennanp
XFILLER_22_167 VPWR VGND sg13cmos5l_decap_8
XFILLER_184_18 VPWR VGND sg13cmos5l_decap_8
XFILLER_175_183 VPWR VGND sg13cmos5l_decap_4
XANTENNA__0717__A1 Tile_X0Y0_W2END[7] VPWR VGND sg13cmos5l_antennanp
XANTENNA__1237__D Tile_X0Y0_FrameData[22] VPWR VGND sg13cmos5l_antennanp
XFILLER_190_197 VPWR VGND sg13cmos5l_decap_8
XFILLER_131_242 VPWR VGND sg13cmos5l_decap_8
XFILLER_77_16 VPWR VGND sg13cmos5l_decap_8
XFILLER_89_178 VPWR VGND sg13cmos5l_decap_8
XANTENNA__2068__D Tile_X0Y3_FrameData[31] VPWR VGND sg13cmos5l_antennanp
XFILLER_93_26 VPWR VGND sg13cmos5l_fill_2
XFILLER_172_4 VPWR VGND sg13cmos5l_fill_1
XANTENNA__1700__D Tile_X0Y2_FrameData[23] VPWR VGND sg13cmos5l_antennanp
XFILLER_201_202 VPWR VGND sg13cmos5l_decap_8
XFILLER_158_128 VPWR VGND sg13cmos5l_fill_2
XFILLER_166_150 VPWR VGND sg13cmos5l_decap_8
XANTENNA__0956__A1 AXIL_S_SOC_WDATA27 VPWR VGND sg13cmos5l_antennanp
XFILLER_181_120 VPWR VGND sg13cmos5l_decap_4
XANTENNA__0708__A1 Tile_X0Y3_WW4END[12] VPWR VGND sg13cmos5l_antennanp
XFILLER_107_261 VPWR VGND sg13cmos5l_fill_1
XFILLER_107_283 VPWR VGND sg13cmos5l_fill_1
XFILLER_122_220 VPWR VGND sg13cmos5l_decap_4
XFILLER_122_242 VPWR VGND sg13cmos5l_decap_8
XFILLER_3_46 VPWR VGND sg13cmos5l_fill_1
XFILLER_3_35 VPWR VGND sg13cmos5l_decap_8
XFILLER_3_57 VPWR VGND sg13cmos5l_decap_4
XANTENNA__2556__A Tile_X0Y3_FrameData[14] VPWR VGND sg13cmos5l_antennanp
XANTENNA__0892__A0 Tile_X0Y0_W1END[2] VPWR VGND sg13cmos5l_antennanp
XANTENNA__0644__A0 Tile_X0Y1_W2MID[6] VPWR VGND sg13cmos5l_antennanp
XANTENNA__1610__D Tile_X0Y1_FrameData[25] VPWR VGND sg13cmos5l_antennanp
XFILLER_189_253 VPWR VGND sg13cmos5l_decap_4
XANTENNA__1661__GATE Tile_X0Y3_FrameStrobe[6] VPWR VGND sg13cmos5l_antennanp
X_0984_ _0985_/B _0926_/X _0925_/X _1628_/Q VPWR VGND sg13cmos5l_mux2_1
XFILLER_172_120 VPWR VGND sg13cmos5l_decap_8
XANTENNA__1676__GATE Tile_X0Y3_FrameStrobe[7] VPWR VGND sg13cmos5l_antennanp
XANTENNA__1194__X AXIL_S_SOC_RDATA18 VPWR VGND sg13cmos5l_antennanp
X_1605_ _1605_/Q Tile_X0Y1_FrameData[30] Tile_X0Y3_FrameStrobe[5] VPWR VGND sg13cmos5l_dlhq_1
X_2585_ Tile_X0Y3_S2BEG[7] _2585_/A VPWR VGND sg13cmos5l_buf_1
XFILLER_59_0 VPWR VGND sg13cmos5l_fill_2
XFILLER_172_186 VPWR VGND sg13cmos5l_fill_1
XFILLER_113_220 VPWR VGND sg13cmos5l_decap_4
X_1536_ _1536_/Q Tile_X0Y1_FrameData[3] Tile_X0Y3_FrameStrobe[2] VPWR VGND sg13cmos5l_dlhq_1
XFILLER_113_286 VPWR VGND sg13cmos5l_fill_1
X_1467_ _1467_/Q Tile_X0Y1_FrameData[8] Tile_X0Y3_FrameStrobe[0] VPWR VGND sg13cmos5l_dlhq_1
XFILLER_47_19 VPWR VGND sg13cmos5l_decap_8
X_1398_ _1398_/Q Tile_X0Y0_FrameData[21] Tile_X0Y3_FrameStrobe[6] VPWR VGND sg13cmos5l_dlhq_1
XANTENNA__0478__A3 Tile_X0Y0_S4END[14] VPWR VGND sg13cmos5l_antennanp
XFILLER_103_14 VPWR VGND sg13cmos5l_decap_4
XFILLER_94_170 VPWR VGND sg13cmos5l_decap_8
XANTENNA__0883__A0 AXIL_S_SOC_AWADDR1 VPWR VGND sg13cmos5l_antennanp
XANTENNA__1614__GATE Tile_X0Y3_FrameStrobe[5] VPWR VGND sg13cmos5l_antennanp
XFILLER_94_181 VPWR VGND sg13cmos5l_fill_2
XANTENNA__1520__D Tile_X0Y1_FrameData[19] VPWR VGND sg13cmos5l_antennanp
X_2019_ _2019_/Q Tile_X0Y3_FrameData[16] Tile_X0Y3_FrameStrobe[2] VPWR VGND sg13cmos5l_dlhq_1
XFILLER_179_29 VPWR VGND sg13cmos5l_fill_2
XANTENNA__1629__GATE Tile_X0Y3_FrameStrobe[5] VPWR VGND sg13cmos5l_antennanp
XFILLER_10_115 VPWR VGND sg13cmos5l_decap_8
XANTENNA__0650__A3 AXIL_S_SOC_ARADDR0 VPWR VGND sg13cmos5l_antennanp
XANTENNA__0938__A1 Tile_X0Y1_WW4END[12] VPWR VGND sg13cmos5l_antennanp
XFILLER_12_22 VPWR VGND sg13cmos5l_decap_8
XFILLER_128_55 VPWR VGND sg13cmos5l_fill_1
XFILLER_12_88 VPWR VGND sg13cmos5l_decap_8
XFILLER_128_66 VPWR VGND sg13cmos5l_fill_1
XFILLER_104_242 VPWR VGND sg13cmos5l_decap_8
XFILLER_104_253 VPWR VGND sg13cmos5l_fill_2
XFILLER_104_286 VPWR VGND sg13cmos5l_fill_1
XFILLER_144_87 VPWR VGND sg13cmos5l_decap_4
XFILLER_144_98 VPWR VGND sg13cmos5l_decap_8
XFILLER_218_154 VPWR VGND sg13cmos5l_decap_8
XFILLER_18_215 VPWR VGND sg13cmos5l_decap_4
XANTENNA__0874__A0 Tile_X0Y3_N4END[12] VPWR VGND sg13cmos5l_antennanp
XFILLER_37_85 VPWR VGND sg13cmos5l_decap_4
XFILLER_218_187 VPWR VGND sg13cmos5l_decap_8
XFILLER_163_0 VPWR VGND sg13cmos5l_decap_4
XFILLER_218_198 VPWR VGND sg13cmos5l_fill_1
XANTENNA__1430__D Tile_X0Y0_FrameData[21] VPWR VGND sg13cmos5l_antennanp
XFILLER_26_281 VPWR VGND sg13cmos5l_fill_1
XANTENNA__0626__A0 Tile_X0Y3_W2MID[1] VPWR VGND sg13cmos5l_antennanp
XFILLER_53_51 VPWR VGND sg13cmos5l_fill_2
XFILLER_53_84 VPWR VGND sg13cmos5l_decap_4
XFILLER_41_273 VPWR VGND sg13cmos5l_fill_2
XFILLER_41_262 VPWR VGND sg13cmos5l_decap_8
XFILLER_186_234 VPWR VGND sg13cmos5l_decap_4
XFILLER_186_256 VPWR VGND sg13cmos5l_decap_4
XFILLER_154_131 VPWR VGND sg13cmos5l_fill_2
X_2370_ Tile_X0Y0_N4BEG[12] _2370_/A VPWR VGND sg13cmos5l_buf_1
XANTENNA__1605__D Tile_X0Y1_FrameData[30] VPWR VGND sg13cmos5l_antennanp
X_1321_ _1321_/Q Tile_X0Y0_FrameData[2] Tile_X0Y3_FrameStrobe[3] VPWR VGND sg13cmos5l_dlhq_1
X_1252_ _1252_/Q Tile_X0Y0_FrameData[7] Tile_X0Y3_FrameStrobe[1] VPWR VGND sg13cmos5l_dlhq_1
XFILLER_204_24 VPWR VGND sg13cmos5l_fill_1
XFILLER_110_278 VPWR VGND sg13cmos5l_decap_8
X_1183_ _1183_/X _0610_/X _0611_/X _0561_/X _0584_/X _2160_/Q _2159_/Q VPWR VGND sg13cmos5l_mux4_1
XANTENNA__1340__D Tile_X0Y0_FrameData[15] VPWR VGND sg13cmos5l_antennanp
XANTENNA__2573__X Tile_X0Y3_FrameData_O[31] VPWR VGND sg13cmos5l_antennanp
XFILLER_91_184 VPWR VGND sg13cmos5l_decap_8
XANTENNA__0617__A0 Tile_X0Y3_W1END[1] VPWR VGND sg13cmos5l_antennanp
XANTENNA__2171__D Tile_X0Y3_FrameData[24] VPWR VGND sg13cmos5l_antennanp
X_0967_ _0967_/Y _0972_/S _0949_/X _0966_/Y VPWR VGND sg13cmos5l_o21ai_1
XFILLER_192_248 VPWR VGND sg13cmos5l_decap_8
XFILLER_145_164 VPWR VGND sg13cmos5l_decap_4
X_0898_ AXIL_S_SOC_BRESP0 Tile_X0Y0_W1END[0] Tile_X0Y0_W6END[8] Tile_X0Y0_WW4END[15]
+ _0518_/Y _1258_/Q _1259_/Q VPWR VGND sg13cmos5l_mux4_1
X_2568_ Tile_X0Y3_FrameData_O[26] Tile_X0Y3_FrameData[26] VPWR VGND sg13cmos5l_buf_1
XFILLER_99_251 VPWR VGND sg13cmos5l_fill_1
XANTENNA__1515__D Tile_X0Y1_FrameData[24] VPWR VGND sg13cmos5l_antennanp
X_1519_ _1519_/Q Tile_X0Y1_FrameData[20] Tile_X0Y3_FrameStrobe[2] VPWR VGND sg13cmos5l_dlhq_1
X_2499_ Tile_X0Y3_E2BEG[1] _2499_/A VPWR VGND sg13cmos5l_buf_1
XFILLER_59_159 VPWR VGND sg13cmos5l_fill_1
XANTENNA__1553__GATE Tile_X0Y3_FrameStrobe[3] VPWR VGND sg13cmos5l_antennanp
XANTENNA__0856__A0 AXIL_S_SOC_AWADDR1 VPWR VGND sg13cmos5l_antennanp
XFILLER_215_113 VPWR VGND sg13cmos5l_fill_1
XANTENNA__1250__D Tile_X0Y0_FrameData[9] VPWR VGND sg13cmos5l_antennanp
XANTENNA__2483__X Tile_X0Y0_E2BEG[1] VPWR VGND sg13cmos5l_antennanp
XFILLER_15_218 VPWR VGND sg13cmos5l_decap_8
XFILLER_82_195 VPWR VGND sg13cmos5l_decap_8
XFILLER_215_179 VPWR VGND sg13cmos5l_decap_8
XANTENNA__0608__A0 Tile_X0Y3_W1END[0] VPWR VGND sg13cmos5l_antennanp
XANTENNA__1568__GATE Tile_X0Y3_FrameStrobe[3] VPWR VGND sg13cmos5l_antennanp
XFILLER_130_67 VPWR VGND sg13cmos5l_decap_8
XANTENNA__0444__A Tile_X0Y0_WW4END[3] VPWR VGND sg13cmos5l_antennanp
XANTENNA__1033__A0 AXIL_S_SOC_WDATA21 VPWR VGND sg13cmos5l_antennanp
XANTENNA__2081__D Tile_X0Y3_FrameData[18] VPWR VGND sg13cmos5l_antennanp
XFILLER_99_36 VPWR VGND sg13cmos5l_decap_4
XFILLER_23_98 VPWR VGND sg13cmos5l_fill_2
XFILLER_183_248 VPWR VGND sg13cmos5l_decap_8
XANTENNA__1506__GATE Tile_X0Y3_FrameStrobe[1] VPWR VGND sg13cmos5l_antennanp
XFILLER_151_156 VPWR VGND sg13cmos5l_decap_8
XANTENNA__1425__D Tile_X0Y0_FrameData[26] VPWR VGND sg13cmos5l_antennanp
XFILLER_155_86 VPWR VGND sg13cmos5l_decap_4
XFILLER_2_166 VPWR VGND sg13cmos5l_fill_2
XFILLER_48_51 VPWR VGND sg13cmos5l_decap_8
XFILLER_65_107 VPWR VGND sg13cmos5l_decap_4
XFILLER_171_52 VPWR VGND sg13cmos5l_decap_8
XANTENNA__0847__A0 AXIL_S_SOC_WSTRB3 VPWR VGND sg13cmos5l_antennanp
XFILLER_0_25 VPWR VGND sg13cmos5l_decap_8
XFILLER_58_181 VPWR VGND sg13cmos5l_decap_8
XFILLER_171_96 VPWR VGND sg13cmos5l_decap_8
XANTENNA__2393__X Tile_X0Y0_N1BEG[3] VPWR VGND sg13cmos5l_antennanp
XFILLER_221_105 VPWR VGND sg13cmos5l_fill_1
XFILLER_206_146 VPWR VGND sg13cmos5l_decap_8
XANTENNA__0862__A3 Tile_X0Y0_S2MID[7] VPWR VGND sg13cmos5l_antennanp
XFILLER_119_109 VPWR VGND sg13cmos5l_fill_2
X_1870_ _1870_/Q Tile_X0Y2_FrameData[13] Tile_X0Y3_FrameStrobe[5] VPWR VGND sg13cmos5l_dlhq_1
XFILLER_174_204 VPWR VGND sg13cmos5l_fill_1
X_0821_ _0821_/Y _1373_/Q _0821_/B VPWR VGND sg13cmos5l_nand2b_1
XFILLER_80_82 VPWR VGND sg13cmos5l_fill_1
XFILLER_196_60 VPWR VGND sg13cmos5l_fill_2
XFILLER_174_226 VPWR VGND sg13cmos5l_decap_4
XANTENNA__1024__A0 AXIL_S_SOC_WDATA20 VPWR VGND sg13cmos5l_antennanp
X_0752_ _0752_/X Tile_X0Y1_W1END[1] _0547_/X Tile_X0Y1_W6END[5] _0552_/X _1688_/Q
+ _1689_/Q VPWR VGND sg13cmos5l_mux4_1
XFILLER_174_248 VPWR VGND sg13cmos5l_fill_2
XFILLER_127_186 VPWR VGND sg13cmos5l_fill_1
X_0683_ _2536_/A AXIL_S_SOC_ARADDR1 AXIL_S_SOC_ARADDR5 _0610_/X _0594_/X _2055_/Q
+ _2054_/Q VPWR VGND sg13cmos5l_mux4_1
XFILLER_182_292 VPWR VGND sg13cmos5l_fill_2
XANTENNA__0537__B_N Tile_X0Y3_N1END[0] VPWR VGND sg13cmos5l_antennanp
X_2422_ Tile_X0Y0_FrameData_O[8] Tile_X0Y0_FrameData[8] VPWR VGND sg13cmos5l_buf_1
XANTENNA__1335__D Tile_X0Y0_FrameData[20] VPWR VGND sg13cmos5l_antennanp
XANTENNA__2568__X Tile_X0Y3_FrameData_O[26] VPWR VGND sg13cmos5l_antennanp
XFILLER_142_178 VPWR VGND sg13cmos5l_decap_8
XFILLER_142_189 VPWR VGND sg13cmos5l_fill_2
X_2353_ Tile_X0Y2_FrameData_O[29] Tile_X0Y2_FrameData[29] VPWR VGND sg13cmos5l_buf_1
XFILLER_36_2 VPWR VGND sg13cmos5l_fill_1
X_1304_ _1304_/Q Tile_X0Y0_FrameData[19] Tile_X0Y3_FrameStrobe[3] VPWR VGND sg13cmos5l_dlhq_1
X_2284_ Tile_X0Y2_E2BEG[4] _2284_/A VPWR VGND sg13cmos5l_buf_1
XFILLER_96_265 VPWR VGND sg13cmos5l_fill_2
XFILLER_56_118 VPWR VGND sg13cmos5l_fill_1
X_1235_ _1235_/Q Tile_X0Y0_FrameData[24] Tile_X0Y3_FrameStrobe[1] VPWR VGND sg13cmos5l_dlhq_1
XANTENNA__0838__A0 AXIL_S_SOC_WSTRB0 VPWR VGND sg13cmos5l_antennanp
X_1166_ _1166_/X _1905_/Q _1166_/B VPWR VGND sg13cmos5l_and2_1
XANTENNA__2166__D Tile_X0Y3_FrameData[29] VPWR VGND sg13cmos5l_antennanp
X_1097_ _1097_/Y _1097_/A VPWR VGND sg13cmos5l_inv_1
XFILLER_100_15 VPWR VGND sg13cmos5l_decap_4
XANTENNA__0605__A3 Tile_X0Y0_S4END[12] VPWR VGND sg13cmos5l_antennanp
XFILLER_100_48 VPWR VGND sg13cmos5l_fill_1
XFILLER_176_19 VPWR VGND sg13cmos5l_decap_4
XANTENNA__1015__A0 Tile_X0Y1_W1END[1] VPWR VGND sg13cmos5l_antennanp
X_1999_ _1999_/Q Tile_X0Y3_FrameData[4] Tile_X0Y3_FrameStrobe[1] VPWR VGND sg13cmos5l_dlhq_1
XFILLER_109_68 VPWR VGND sg13cmos5l_decap_8
XFILLER_109_79 VPWR VGND sg13cmos5l_decap_4
XANTENNA__1245__D Tile_X0Y0_FrameData[14] VPWR VGND sg13cmos5l_antennanp
XANTENNA__2478__X Tile_X0Y0_E2BEGb[4] VPWR VGND sg13cmos5l_antennanp
XANTENNA__1492__GATE Tile_X0Y3_FrameStrobe[1] VPWR VGND sg13cmos5l_antennanp
XFILLER_85_49 VPWR VGND sg13cmos5l_decap_8
XANTENNA__0439__A Tile_X0Y0_WW4END[1] VPWR VGND sg13cmos5l_antennanp
XFILLER_18_76 VPWR VGND sg13cmos5l_decap_8
XANTENNA__2076__D Tile_X0Y3_FrameData[23] VPWR VGND sg13cmos5l_antennanp
XFILLER_141_66 VPWR VGND sg13cmos5l_decap_8
XFILLER_55_184 VPWR VGND sg13cmos5l_decap_8
XFILLER_203_138 VPWR VGND sg13cmos5l_decap_8
XANTENNA__1430__GATE Tile_X0Y3_FrameStrobe[7] VPWR VGND sg13cmos5l_antennanp
XFILLER_34_97 VPWR VGND sg13cmos5l_decap_8
XANTENNA__1006__A0 AXIL_S_SOC_WDATA17 VPWR VGND sg13cmos5l_antennanp
XFILLER_126_0 VPWR VGND sg13cmos5l_decap_4
XANTENNA__1445__GATE Tile_X0Y3_FrameStrobe[0] VPWR VGND sg13cmos5l_antennanp
XFILLER_7_258 VPWR VGND sg13cmos5l_fill_1
XFILLER_50_63 VPWR VGND sg13cmos5l_fill_1
XFILLER_109_197 VPWR VGND sg13cmos5l_decap_8
XANTENNA__2388__X Tile_X0Y0_N2BEG[6] VPWR VGND sg13cmos5l_antennanp
XFILLER_78_210 VPWR VGND sg13cmos5l_fill_1
XFILLER_78_232 VPWR VGND sg13cmos5l_decap_8
XFILLER_59_83 VPWR VGND sg13cmos5l_decap_8
XFILLER_78_276 VPWR VGND sg13cmos5l_decap_4
XFILLER_38_118 VPWR VGND sg13cmos5l_decap_8
X_1020_ _2233_/A AXIL_S_SOC_WDATA22 AXIL_S_SOC_WDATA26 _0925_/X _0864_/X _1567_/Q
+ _1566_/Q VPWR VGND sg13cmos5l_mux4_1
XFILLER_93_257 VPWR VGND sg13cmos5l_decap_8
XFILLER_75_60 VPWR VGND sg13cmos5l_decap_8
XFILLER_219_293 VPWR VGND sg13cmos5l_fill_2
XANTENNA__2564__A Tile_X0Y3_FrameData[22] VPWR VGND sg13cmos5l_antennanp
XFILLER_61_176 VPWR VGND sg13cmos5l_decap_8
X_1922_ _1922_/Q Tile_X0Y2_FrameData[25] Tile_X0Y3_FrameStrobe[7] VPWR VGND sg13cmos5l_dlhq_1
XFILLER_98_4 VPWR VGND sg13cmos5l_fill_1
XANTENNA__0599__A2 Tile_X0Y3_W2END[1] VPWR VGND sg13cmos5l_antennanp
X_1853_ _1853_/Q Tile_X0Y2_FrameData[30] Tile_X0Y3_FrameStrobe[5] VPWR VGND sg13cmos5l_dlhq_1
XFILLER_147_237 VPWR VGND sg13cmos5l_fill_1
X_0804_ _2373_/A _0804_/A VPWR VGND sg13cmos5l_inv_1
XFILLER_162_218 VPWR VGND sg13cmos5l_decap_8
X_1784_ _1784_/Q Tile_X0Y2_FrameData[3] Tile_X0Y3_FrameStrobe[2] VPWR VGND sg13cmos5l_dlhq_1
X_0735_ _2379_/A Tile_X0Y1_W2MID[2] Tile_X0Y1_W2END[2] Tile_X0Y1_W6END[2] _0865_/X
+ _1673_/Q _1672_/Q VPWR VGND sg13cmos5l_mux4_1
XFILLER_115_167 VPWR VGND sg13cmos5l_decap_8
X_0666_ _2507_/A _0655_/X _0584_/X AXIL_S_SOC_ARADDR4 _0598_/X _2088_/Q _2089_/Q VPWR
+ VGND sg13cmos5l_mux4_1
XANTENNA__0771__A2 Tile_X0Y1_W6END[7] VPWR VGND sg13cmos5l_antennanp
XANTENNA__2298__X Tile_X0Y2_E6BEG[2] VPWR VGND sg13cmos5l_antennanp
X_2405_ Tile_X0Y0_FrameStrobe_O[11] Tile_X0Y3_FrameStrobe[11] VPWR VGND sg13cmos5l_buf_1
XFILLER_41_0 VPWR VGND sg13cmos5l_fill_2
X_0597_ _2592_/A Tile_X0Y2_W1END[2] Tile_X0Y2_W2END[1] Tile_X0Y2_W2MID[1] _0729_/X
+ _1882_/Q _1883_/Q VPWR VGND sg13cmos5l_mux4_1
X_2336_ Tile_X0Y2_FrameData_O[12] Tile_X0Y2_FrameData[12] VPWR VGND sg13cmos5l_buf_1
XFILLER_69_276 VPWR VGND sg13cmos5l_decap_8
X_2267_ Tile_X0Y1_FrameData_O[24] Tile_X0Y1_FrameData[24] VPWR VGND sg13cmos5l_buf_1
XFILLER_84_235 VPWR VGND sg13cmos5l_fill_2
XFILLER_29_129 VPWR VGND sg13cmos5l_fill_1
X_1218_ _1218_/Q Tile_X0Y0_FrameData[9] Tile_X0Y3_FrameStrobe[0] VPWR VGND sg13cmos5l_dlhq_1
XFILLER_37_151 VPWR VGND sg13cmos5l_fill_1
X_2198_ Tile_X0Y1_E1BEG[3] _2198_/A VPWR VGND sg13cmos5l_buf_1
XFILLER_111_14 VPWR VGND sg13cmos5l_decap_4
X_1149_ _1149_/X Tile_X0Y2_W1END[3] Tile_X0Y2_WW4END[15] Tile_X0Y2_W6END[7] _1112_/X
+ _1870_/Q _1869_/Q VPWR VGND sg13cmos5l_mux4_1
XFILLER_52_121 VPWR VGND sg13cmos5l_fill_2
XANTENNA__2160__GATE Tile_X0Y3_FrameStrobe[6] VPWR VGND sg13cmos5l_antennanp
XFILLER_224_8 VPWR VGND sg13cmos5l_fill_2
XANTENNA__2175__GATE Tile_X0Y3_FrameStrobe[7] VPWR VGND sg13cmos5l_antennanp
XFILLER_106_101 VPWR VGND sg13cmos5l_decap_8
XFILLER_146_270 VPWR VGND sg13cmos5l_decap_8
XFILLER_153_229 VPWR VGND sg13cmos5l_decap_8
XFILLER_4_217 VPWR VGND sg13cmos5l_decap_8
XFILLER_20_22 VPWR VGND sg13cmos5l_fill_1
XFILLER_106_134 VPWR VGND sg13cmos5l_decap_8
XANTENNA__0762__A2 Tile_X0Y3_N4END[12] VPWR VGND sg13cmos5l_antennanp
XFILLER_161_273 VPWR VGND sg13cmos5l_fill_2
XANTENNA__0514__A2 Tile_X0Y3_W6END[11] VPWR VGND sg13cmos5l_antennanp
XANTENNA__1703__D Tile_X0Y2_FrameData[20] VPWR VGND sg13cmos5l_antennanp
XANTENNA__2113__GATE Tile_X0Y3_FrameStrobe[5] VPWR VGND sg13cmos5l_antennanp
XANTENNA__0817__A3 AXIL_S_SOC_AWVALID VPWR VGND sg13cmos5l_antennanp
XFILLER_43_132 VPWR VGND sg13cmos5l_fill_2
XFILLER_216_285 VPWR VGND sg13cmos5l_fill_2
XFILLER_43_176 VPWR VGND sg13cmos5l_decap_8
XFILLER_43_154 VPWR VGND sg13cmos5l_fill_1
XANTENNA__2128__GATE Tile_X0Y3_FrameStrobe[5] VPWR VGND sg13cmos5l_antennanp
XANTENNA__1384__GATE Tile_X0Y3_FrameStrobe[5] VPWR VGND sg13cmos5l_antennanp
XANTENNA_6 AXIL_S_SOC_AWADDR3 VPWR VGND sg13cmos5l_antennanp
XFILLER_137_270 VPWR VGND sg13cmos5l_decap_8
X_0520_ _0520_/Y _0520_/A VPWR VGND sg13cmos5l_inv_1
XANTENNA__0753__A2 Tile_X0Y1_W6END[0] VPWR VGND sg13cmos5l_antennanp
XANTENNA__1399__GATE Tile_X0Y3_FrameStrobe[6] VPWR VGND sg13cmos5l_antennanp
XFILLER_112_104 VPWR VGND sg13cmos5l_fill_1
XANTENNA__2559__A Tile_X0Y3_FrameData[17] VPWR VGND sg13cmos5l_antennanp
XFILLER_112_159 VPWR VGND sg13cmos5l_decap_8
X_0451_ _0451_/Y _1621_/Q VPWR VGND sg13cmos5l_inv_1
XANTENNA__1322__GATE Tile_X0Y3_FrameStrobe[3] VPWR VGND sg13cmos5l_antennanp
XANTENNA__1613__D Tile_X0Y1_FrameData[22] VPWR VGND sg13cmos5l_antennanp
X_2121_ _2121_/Q Tile_X0Y3_FrameData[10] Tile_X0Y3_FrameStrobe[5] VPWR VGND sg13cmos5l_dlhq_1
XFILLER_86_92 VPWR VGND sg13cmos5l_fill_1
XANTENNA__1952__GATE Tile_X0Y3_FrameStrobe[0] VPWR VGND sg13cmos5l_antennanp
X_2052_ _2052_/Q Tile_X0Y3_FrameData[15] Tile_X0Y3_FrameStrobe[3] VPWR VGND sg13cmos5l_dlhq_1
X_1003_ AXIL_S_SOC_RDATA20 Tile_X0Y1_W2MID[0] Tile_X0Y1_W2END[0] Tile_X0Y1_W6END[0]
+ _0859_/X _1523_/Q _1522_/Q VPWR VGND sg13cmos5l_mux4_1
XFILLER_81_205 VPWR VGND sg13cmos5l_decap_8
XFILLER_212_35 VPWR VGND sg13cmos5l_decap_4
XFILLER_19_151 VPWR VGND sg13cmos5l_decap_8
XFILLER_74_290 VPWR VGND sg13cmos5l_decap_4
XFILLER_207_285 VPWR VGND sg13cmos5l_fill_2
XFILLER_19_195 VPWR VGND sg13cmos5l_decap_8
XANTENNA__1337__GATE Tile_X0Y3_FrameStrobe[4] VPWR VGND sg13cmos5l_antennanp
XFILLER_34_165 VPWR VGND sg13cmos5l_decap_4
XANTENNA__1967__GATE Tile_X0Y3_FrameStrobe[0] VPWR VGND sg13cmos5l_antennanp
XANTENNA__2581__X Tile_X0Y3_S2BEG[3] VPWR VGND sg13cmos5l_antennanp
XFILLER_89_0 VPWR VGND sg13cmos5l_fill_2
X_1905_ _1905_/Q Tile_X0Y2_FrameData[10] Tile_X0Y3_FrameStrobe[6] VPWR VGND sg13cmos5l_dlhq_1
X_1836_ _1836_/Q Tile_X0Y2_FrameData[15] Tile_X0Y3_FrameStrobe[4] VPWR VGND sg13cmos5l_dlhq_1
XFILLER_128_281 VPWR VGND sg13cmos5l_fill_1
X_1767_ _1767_/Q Tile_X0Y2_FrameData[20] Tile_X0Y3_FrameStrobe[2] VPWR VGND sg13cmos5l_dlhq_1
XFILLER_128_292 VPWR VGND sg13cmos5l_fill_2
X_0718_ _0718_/X Tile_X0Y3_W2MID[7] Tile_X0Y3_W2END[7] Tile_X0Y3_W6END[7] _0580_/A
+ _2179_/Q _2178_/Q VPWR VGND sg13cmos5l_mux4_1
XANTENNA__0744__A2 Tile_X0Y0_W6END[11] VPWR VGND sg13cmos5l_antennanp
XANTENNA__1905__GATE Tile_X0Y3_FrameStrobe[6] VPWR VGND sg13cmos5l_antennanp
X_1698_ _1698_/Q Tile_X0Y2_FrameData[25] Tile_X0Y3_FrameStrobe[0] VPWR VGND sg13cmos5l_dlhq_1
X_0649_ _0649_/X _0635_/B _0647_/X _0626_/X _0648_/X _2189_/Q _2190_/Q VPWR VGND sg13cmos5l_mux4_1
XFILLER_106_47 VPWR VGND sg13cmos5l_decap_8
XFILLER_106_58 VPWR VGND sg13cmos5l_fill_2
XANTENNA__1523__D Tile_X0Y1_FrameData[16] VPWR VGND sg13cmos5l_antennanp
X_2319_ Tile_X0Y2_EE4BEG[11] _2319_/A VPWR VGND sg13cmos5l_buf_1
XFILLER_122_35 VPWR VGND sg13cmos5l_fill_1
XFILLER_72_205 VPWR VGND sg13cmos5l_fill_2
XFILLER_82_28 VPWR VGND sg13cmos5l_decap_8
XFILLER_72_249 VPWR VGND sg13cmos5l_decap_8
XFILLER_65_290 VPWR VGND sg13cmos5l_decap_4
XFILLER_25_132 VPWR VGND sg13cmos5l_fill_1
XFILLER_25_121 VPWR VGND sg13cmos5l_decap_8
XFILLER_15_11 VPWR VGND sg13cmos5l_decap_8
XFILLER_15_22 VPWR VGND sg13cmos5l_fill_1
XFILLER_198_17 VPWR VGND sg13cmos5l_fill_1
XANTENNA__0680__A1 AXIL_S_SOC_ARADDR6 VPWR VGND sg13cmos5l_antennanp
XANTENNA__2491__X Tile_X0Y0_E1BEG[1] VPWR VGND sg13cmos5l_antennanp
XFILLER_15_33 VPWR VGND sg13cmos5l_fill_2
XFILLER_40_113 VPWR VGND sg13cmos5l_decap_8
XFILLER_25_198 VPWR VGND sg13cmos5l_decap_8
XFILLER_147_43 VPWR VGND sg13cmos5l_decap_8
XFILLER_193_184 VPWR VGND sg13cmos5l_decap_8
XANTENNA__0735__A2 Tile_X0Y1_W6END[2] VPWR VGND sg13cmos5l_antennanp
XANTENNA__0499__A1 Tile_X0Y1_W6END[11] VPWR VGND sg13cmos5l_antennanp
XANTENNA__1433__D Tile_X0Y0_FrameData[18] VPWR VGND sg13cmos5l_antennanp
XFILLER_0_275 VPWR VGND sg13cmos5l_fill_1
XFILLER_163_86 VPWR VGND sg13cmos5l_fill_1
XFILLER_163_97 VPWR VGND sg13cmos5l_fill_2
XFILLER_193_0 VPWR VGND sg13cmos5l_fill_2
XANTENNA__1160__A2 Tile_X0Y2_WW4END[2] VPWR VGND sg13cmos5l_antennanp
XANTENNA__2052__GATE Tile_X0Y3_FrameStrobe[3] VPWR VGND sg13cmos5l_antennanp
XFILLER_48_246 VPWR VGND sg13cmos5l_decap_8
XFILLER_56_95 VPWR VGND sg13cmos5l_decap_8
XFILLER_56_290 VPWR VGND sg13cmos5l_decap_4
XANTENNA__0671__A1 AXIL_S_SOC_ARADDR9 VPWR VGND sg13cmos5l_antennanp
XANTENNA__2067__GATE Tile_X0Y3_FrameStrobe[3] VPWR VGND sg13cmos5l_antennanp
XFILLER_112_90 VPWR VGND sg13cmos5l_decap_8
XFILLER_204_266 VPWR VGND sg13cmos5l_decap_4
XFILLER_72_83 VPWR VGND sg13cmos5l_decap_8
XFILLER_31_157 VPWR VGND sg13cmos5l_decap_4
XFILLER_188_61 VPWR VGND sg13cmos5l_decap_8
XFILLER_31_179 VPWR VGND sg13cmos5l_decap_8
X_1621_ _1621_/Q Tile_X0Y1_FrameData[14] Tile_X0Y3_FrameStrobe[5] VPWR VGND sg13cmos5l_dlhq_1
XANTENNA__1608__D Tile_X0Y1_FrameData[27] VPWR VGND sg13cmos5l_antennanp
XANTENNA__0726__A2 Tile_X0Y0_W6END[5] VPWR VGND sg13cmos5l_antennanp
XANTENNA__2005__GATE Tile_X0Y3_FrameStrobe[2] VPWR VGND sg13cmos5l_antennanp
X_1552_ _1552_/Q Tile_X0Y1_FrameData[19] Tile_X0Y3_FrameStrobe[3] VPWR VGND sg13cmos5l_dlhq_1
XFILLER_140_221 VPWR VGND sg13cmos5l_decap_8
X_1483_ _1483_/Q Tile_X0Y1_FrameData[24] Tile_X0Y3_FrameStrobe[1] VPWR VGND sg13cmos5l_dlhq_1
X_0503_ _0503_/Y _1693_/Q _0937_/X _0502_/Y VPWR VGND sg13cmos5l_o21ai_1
XANTENNA__1261__GATE Tile_X0Y3_FrameStrobe[2] VPWR VGND sg13cmos5l_antennanp
X_0434_ _0434_/Y Tile_X0Y0_S1END[1] VPWR VGND sg13cmos5l_inv_1
XFILLER_97_80 VPWR VGND sg13cmos5l_fill_2
XANTENNA__1891__GATE Tile_X0Y3_FrameStrobe[6] VPWR VGND sg13cmos5l_antennanp
XANTENNA__2576__X Tile_X0Y3_S1BEG[2] VPWR VGND sg13cmos5l_antennanp
XANTENNA__1343__D Tile_X0Y0_FrameData[12] VPWR VGND sg13cmos5l_antennanp
X_2104_ _2104_/Q Tile_X0Y3_FrameData[27] Tile_X0Y3_FrameStrobe[5] VPWR VGND sg13cmos5l_dlhq_1
XFILLER_223_45 VPWR VGND sg13cmos5l_fill_1
XANTENNA__1276__GATE Tile_X0Y3_FrameStrobe[2] VPWR VGND sg13cmos5l_antennanp
X_2035_ _2035_/Q Tile_X0Y3_FrameData[0] Tile_X0Y3_FrameStrobe[2] VPWR VGND sg13cmos5l_dlhq_1
XFILLER_54_238 VPWR VGND sg13cmos5l_fill_1
XANTENNA__0662__A1 AXIL_S_SOC_ARADDR8 VPWR VGND sg13cmos5l_antennanp
XANTENNA__2174__D Tile_X0Y3_FrameData[21] VPWR VGND sg13cmos5l_antennanp
XFILLER_62_293 VPWR VGND sg13cmos5l_fill_2
XFILLER_22_113 VPWR VGND sg13cmos5l_decap_8
XFILLER_167_129 VPWR VGND sg13cmos5l_decap_4
XFILLER_210_269 VPWR VGND sg13cmos5l_fill_2
XANTENNA__0965__A2 AXIL_S_SOC_WDATA16 VPWR VGND sg13cmos5l_antennanp
XANTENNA__1214__GATE Tile_X0Y3_FrameStrobe[0] VPWR VGND sg13cmos5l_antennanp
XFILLER_190_110 VPWR VGND sg13cmos5l_decap_4
XANTENNA__1518__D Tile_X0Y1_FrameData[21] VPWR VGND sg13cmos5l_antennanp
XANTENNA__1844__GATE Tile_X0Y3_FrameStrobe[4] VPWR VGND sg13cmos5l_antennanp
XFILLER_116_240 VPWR VGND sg13cmos5l_decap_4
X_1819_ _1819_/Q Tile_X0Y2_FrameData[0] Tile_X0Y3_FrameStrobe[3] VPWR VGND sg13cmos5l_dlhq_1
XFILLER_190_154 VPWR VGND sg13cmos5l_decap_8
XANTENNA__0717__A2 Tile_X0Y0_W6END[8] VPWR VGND sg13cmos5l_antennanp
XFILLER_117_57 VPWR VGND sg13cmos5l_decap_8
XFILLER_117_68 VPWR VGND sg13cmos5l_fill_2
XANTENNA__1229__GATE Tile_X0Y3_FrameStrobe[1] VPWR VGND sg13cmos5l_antennanp
XANTENNA__1859__GATE Tile_X0Y3_FrameStrobe[5] VPWR VGND sg13cmos5l_antennanp
XANTENNA__2486__X Tile_X0Y0_E2BEG[4] VPWR VGND sg13cmos5l_antennanp
XFILLER_133_12 VPWR VGND sg13cmos5l_decap_8
XANTENNA__1253__D Tile_X0Y0_FrameData[6] VPWR VGND sg13cmos5l_antennanp
XANTENNA__0447__A Tile_X0Y1_W6END[6] VPWR VGND sg13cmos5l_antennanp
XFILLER_38_290 VPWR VGND sg13cmos5l_decap_4
XANTENNA__2084__D Tile_X0Y3_FrameData[15] VPWR VGND sg13cmos5l_antennanp
XFILLER_13_113 VPWR VGND sg13cmos5l_fill_2
XFILLER_9_139 VPWR VGND sg13cmos5l_decap_8
XFILLER_42_42 VPWR VGND sg13cmos5l_decap_8
XFILLER_201_258 VPWR VGND sg13cmos5l_decap_8
XFILLER_158_31 VPWR VGND sg13cmos5l_fill_1
XFILLER_42_75 VPWR VGND sg13cmos5l_decap_8
XANTENNA__1428__D Tile_X0Y0_FrameData[23] VPWR VGND sg13cmos5l_antennanp
XFILLER_166_195 VPWR VGND sg13cmos5l_fill_2
XFILLER_206_0 VPWR VGND sg13cmos5l_fill_2
XANTENNA__0708__A2 Tile_X0Y3_W6END[11] VPWR VGND sg13cmos5l_antennanp
XFILLER_3_14 VPWR VGND sg13cmos5l_fill_2
XANTENNA__2396__X Tile_X0Y0_FrameStrobe_O[2] VPWR VGND sg13cmos5l_antennanp
XANTENNA__0892__A1 Tile_X0Y0_W6END[10] VPWR VGND sg13cmos5l_antennanp
XFILLER_36_227 VPWR VGND sg13cmos5l_decap_4
XFILLER_29_290 VPWR VGND sg13cmos5l_decap_4
XANTENNA__0644__A1 Tile_X0Y1_W2END[6] VPWR VGND sg13cmos5l_antennanp
XANTENNA__2572__A Tile_X0Y3_FrameData[30] VPWR VGND sg13cmos5l_antennanp
XFILLER_44_293 VPWR VGND sg13cmos5l_fill_2
XFILLER_189_276 VPWR VGND sg13cmos5l_fill_1
X_0983_ _2600_/A _0976_/Y _0978_/Y _0980_/Y _0982_/Y VPWR VGND sg13cmos5l_a22oi_1
XFILLER_157_173 VPWR VGND sg13cmos5l_decap_8
XFILLER_157_184 VPWR VGND sg13cmos5l_fill_1
XANTENNA__1338__D Tile_X0Y0_FrameData[17] VPWR VGND sg13cmos5l_antennanp
X_1604_ _1604_/Q Tile_X0Y1_FrameData[31] Tile_X0Y3_FrameStrobe[5] VPWR VGND sg13cmos5l_dlhq_1
X_2584_ Tile_X0Y3_S2BEG[6] _2584_/A VPWR VGND sg13cmos5l_buf_1
XFILLER_218_89 VPWR VGND sg13cmos5l_decap_4
XFILLER_172_176 VPWR VGND sg13cmos5l_decap_4
X_1535_ _1535_/Q Tile_X0Y1_FrameData[4] Tile_X0Y3_FrameStrobe[2] VPWR VGND sg13cmos5l_dlhq_1
XANTENNA__2169__D Tile_X0Y3_FrameData[26] VPWR VGND sg13cmos5l_antennanp
XFILLER_113_276 VPWR VGND sg13cmos5l_decap_4
X_1466_ _1466_/Q Tile_X0Y1_FrameData[9] Tile_X0Y3_FrameStrobe[0] VPWR VGND sg13cmos5l_dlhq_1
XFILLER_86_127 VPWR VGND sg13cmos5l_fill_2
X_1397_ _1397_/Q Tile_X0Y0_FrameData[22] Tile_X0Y3_FrameStrobe[6] VPWR VGND sg13cmos5l_dlhq_1
XANTENNA__1801__D Tile_X0Y2_FrameData[18] VPWR VGND sg13cmos5l_antennanp
X_2018_ _2018_/Q Tile_X0Y3_FrameData[17] Tile_X0Y3_FrameStrobe[2] VPWR VGND sg13cmos5l_dlhq_1
XFILLER_35_293 VPWR VGND sg13cmos5l_fill_2
XFILLER_50_263 VPWR VGND sg13cmos5l_fill_1
XFILLER_195_235 VPWR VGND sg13cmos5l_decap_4
XFILLER_148_151 VPWR VGND sg13cmos5l_fill_2
XFILLER_195_257 VPWR VGND sg13cmos5l_fill_2
XANTENNA__0938__A2 Tile_X0Y1_W6END[4] VPWR VGND sg13cmos5l_antennanp
XANTENNA__1248__D Tile_X0Y0_FrameData[11] VPWR VGND sg13cmos5l_antennanp
XANTENNA__1783__GATE Tile_X0Y3_FrameStrobe[2] VPWR VGND sg13cmos5l_antennanp
XFILLER_12_67 VPWR VGND sg13cmos5l_decap_8
XFILLER_163_121 VPWR VGND sg13cmos5l_fill_1
XANTENNA__1798__GATE Tile_X0Y3_FrameStrobe[3] VPWR VGND sg13cmos5l_antennanp
XFILLER_144_33 VPWR VGND sg13cmos5l_decap_4
XANTENNA__0571__A0 Tile_X0Y3_W1END[2] VPWR VGND sg13cmos5l_antennanp
XANTENNA__2079__D Tile_X0Y3_FrameData[20] VPWR VGND sg13cmos5l_antennanp
XFILLER_144_66 VPWR VGND sg13cmos5l_decap_4
XFILLER_77_138 VPWR VGND sg13cmos5l_decap_4
XANTENNA__1115__A2 AXIL_S_SOC_WDATA14 VPWR VGND sg13cmos5l_antennanp
XANTENNA__1721__GATE Tile_X0Y3_FrameStrobe[0] VPWR VGND sg13cmos5l_antennanp
XANTENNA__0874__A1 Tile_X0Y0_S4END[0] VPWR VGND sg13cmos5l_antennanp
XFILLER_37_53 VPWR VGND sg13cmos5l_decap_4
XANTENNA__1711__D Tile_X0Y2_FrameData[12] VPWR VGND sg13cmos5l_antennanp
XFILLER_160_76 VPWR VGND sg13cmos5l_decap_4
XFILLER_160_87 VPWR VGND sg13cmos5l_decap_4
XANTENNA__0626__A1 Tile_X0Y3_W2END[1] VPWR VGND sg13cmos5l_antennanp
XANTENNA__1736__GATE Tile_X0Y3_FrameStrobe[1] VPWR VGND sg13cmos5l_antennanp
XANTENNA__0929__A2 Tile_X0Y3_N4END[10] VPWR VGND sg13cmos5l_antennanp
XFILLER_5_120 VPWR VGND sg13cmos5l_decap_4
XFILLER_52_8 VPWR VGND sg13cmos5l_fill_2
XFILLER_5_186 VPWR VGND sg13cmos5l_fill_2
X_1320_ _1320_/Q Tile_X0Y0_FrameData[3] Tile_X0Y3_FrameStrobe[3] VPWR VGND sg13cmos5l_dlhq_1
XFILLER_78_82 VPWR VGND sg13cmos5l_fill_2
XFILLER_68_116 VPWR VGND sg13cmos5l_decap_4
XANTENNA__2567__A Tile_X0Y3_FrameData[25] VPWR VGND sg13cmos5l_antennanp
XFILLER_110_235 VPWR VGND sg13cmos5l_decap_8
X_1251_ _1251_/Q Tile_X0Y0_FrameData[8] Tile_X0Y3_FrameStrobe[1] VPWR VGND sg13cmos5l_dlhq_1
XANTENNA__1106__A2 AXIL_S_SOC_WDATA11 VPWR VGND sg13cmos5l_antennanp
X_1182_ AXIL_S_SOC_RDATA8 Tile_X0Y2_W2MID[0] Tile_X0Y2_W2END[0] Tile_X0Y2_W6END[0]
+ _0719_/X _1771_/Q _1770_/Q VPWR VGND sg13cmos5l_mux4_1
XFILLER_76_171 VPWR VGND sg13cmos5l_decap_8
XANTENNA__1621__D Tile_X0Y1_FrameData[14] VPWR VGND sg13cmos5l_antennanp
XFILLER_91_163 VPWR VGND sg13cmos5l_decap_8
XFILLER_224_114 VPWR VGND sg13cmos5l_fill_1
XFILLER_209_199 VPWR VGND sg13cmos5l_decap_8
XANTENNA__0617__A1 Tile_X0Y3_W6END[5] VPWR VGND sg13cmos5l_antennanp
XFILLER_17_293 VPWR VGND sg13cmos5l_fill_2
X_0966_ _0966_/Y _0446_/Y _0972_/S _0451_/Y VPWR VGND sg13cmos5l_a21oi_1
XFILLER_71_0 VPWR VGND sg13cmos5l_fill_2
XFILLER_145_143 VPWR VGND sg13cmos5l_decap_8
XFILLER_185_290 VPWR VGND sg13cmos5l_decap_4
X_0897_ AXIL_S_SOC_BRESP1 Tile_X0Y0_W1END[1] Tile_X0Y0_W6END[9] Tile_X0Y0_WW4END[14]
+ _0545_/Y _1256_/Q _1257_/Q VPWR VGND sg13cmos5l_mux4_1
XFILLER_160_113 VPWR VGND sg13cmos5l_fill_1
XFILLER_160_124 VPWR VGND sg13cmos5l_fill_2
XFILLER_160_168 VPWR VGND sg13cmos5l_fill_2
X_2567_ Tile_X0Y3_FrameData_O[25] Tile_X0Y3_FrameData[25] VPWR VGND sg13cmos5l_buf_1
XANTENNA__0553__A0 Tile_X0Y1_W1END[1] VPWR VGND sg13cmos5l_antennanp
X_1518_ _1518_/Q Tile_X0Y1_FrameData[21] Tile_X0Y3_FrameStrobe[2] VPWR VGND sg13cmos5l_dlhq_1
X_2498_ Tile_X0Y3_E2BEG[0] _2498_/A VPWR VGND sg13cmos5l_buf_1
XFILLER_59_127 VPWR VGND sg13cmos5l_decap_8
XFILLER_101_257 VPWR VGND sg13cmos5l_decap_8
X_1449_ _1449_/Q Tile_X0Y1_FrameData[26] Tile_X0Y3_FrameStrobe[0] VPWR VGND sg13cmos5l_dlhq_1
XFILLER_59_138 VPWR VGND sg13cmos5l_fill_1
XFILLER_67_171 VPWR VGND sg13cmos5l_fill_2
XANTENNA__0856__A1 AXIL_S_SOC_AWADDR9 VPWR VGND sg13cmos5l_antennanp
XANTENNA__1531__D Tile_X0Y1_FrameData[8] VPWR VGND sg13cmos5l_antennanp
XANTENNA__0608__A1 Tile_X0Y3_W6END[4] VPWR VGND sg13cmos5l_antennanp
XFILLER_130_46 VPWR VGND sg13cmos5l_decap_8
XFILLER_168_224 VPWR VGND sg13cmos5l_fill_2
XFILLER_23_11 VPWR VGND sg13cmos5l_fill_1
XFILLER_139_22 VPWR VGND sg13cmos5l_fill_1
XFILLER_168_268 VPWR VGND sg13cmos5l_decap_8
XFILLER_139_33 VPWR VGND sg13cmos5l_decap_8
XFILLER_23_66 VPWR VGND sg13cmos5l_decap_8
XFILLER_183_227 VPWR VGND sg13cmos5l_decap_8
XANTENNA__1033__A1 AXIL_S_SOC_WDATA29 VPWR VGND sg13cmos5l_antennanp
XFILLER_136_110 VPWR VGND sg13cmos5l_decap_8
XFILLER_176_290 VPWR VGND sg13cmos5l_decap_4
XFILLER_99_59 VPWR VGND sg13cmos5l_fill_1
XFILLER_136_187 VPWR VGND sg13cmos5l_fill_1
XFILLER_191_282 VPWR VGND sg13cmos5l_fill_2
XANTENNA__1706__D Tile_X0Y2_FrameData[17] VPWR VGND sg13cmos5l_antennanp
XFILLER_155_54 VPWR VGND sg13cmos5l_fill_2
XFILLER_2_145 VPWR VGND sg13cmos5l_decap_8
XANTENNA__1660__GATE Tile_X0Y3_FrameStrobe[6] VPWR VGND sg13cmos5l_antennanp
XFILLER_0_15 VPWR VGND sg13cmos5l_fill_1
XANTENNA__0847__A1 AXIL_S_SOC_AWADDR6 VPWR VGND sg13cmos5l_antennanp
XANTENNA__1441__D Tile_X0Y0_FrameData[10] VPWR VGND sg13cmos5l_antennanp
XFILLER_0_59 VPWR VGND sg13cmos5l_decap_8
XANTENNA__1675__GATE Tile_X0Y3_FrameStrobe[7] VPWR VGND sg13cmos5l_antennanp
XFILLER_73_185 VPWR VGND sg13cmos5l_fill_1
XFILLER_14_241 VPWR VGND sg13cmos5l_decap_8
XFILLER_9_68 VPWR VGND sg13cmos5l_decap_8
XFILLER_80_50 VPWR VGND sg13cmos5l_decap_8
X_0820_ _0821_/B Tile_X0Y0_W1END[3] Tile_X0Y0_WW4END[15] _0801_/X _0796_/X _1374_/Q
+ _1372_/Q VPWR VGND sg13cmos5l_mux4_1
XANTENNA__1024__A1 AXIL_S_SOC_WDATA24 VPWR VGND sg13cmos5l_antennanp
XFILLER_167_290 VPWR VGND sg13cmos5l_decap_4
X_0751_ _0751_/X _2380_/A _0750_/X Tile_X0Y0_S2MID[6] Tile_X0Y0_S2END[6] _1207_/Q
+ _1206_/Q VPWR VGND sg13cmos5l_mux4_1
XANTENNA__1613__GATE Tile_X0Y3_FrameStrobe[5] VPWR VGND sg13cmos5l_antennanp
XFILLER_127_198 VPWR VGND sg13cmos5l_decap_8
X_0682_ _2535_/A AXIL_S_SOC_ARADDR0 AXIL_S_SOC_ARADDR4 _0478_/X _0598_/X _2057_/Q
+ _2056_/Q VPWR VGND sg13cmos5l_mux4_1
XANTENNA__1616__D Tile_X0Y1_FrameData[19] VPWR VGND sg13cmos5l_antennanp
XFILLER_142_157 VPWR VGND sg13cmos5l_decap_8
X_2421_ Tile_X0Y0_FrameData_O[7] Tile_X0Y0_FrameData[7] VPWR VGND sg13cmos5l_buf_1
XANTENNA__0535__A0 Tile_X0Y2_W1END[0] VPWR VGND sg13cmos5l_antennanp
X_2352_ Tile_X0Y2_FrameData_O[28] Tile_X0Y2_FrameData[28] VPWR VGND sg13cmos5l_buf_1
XFILLER_215_13 VPWR VGND sg13cmos5l_decap_8
XANTENNA__1628__GATE Tile_X0Y3_FrameStrobe[5] VPWR VGND sg13cmos5l_antennanp
X_1303_ _1303_/Q Tile_X0Y0_FrameData[20] Tile_X0Y3_FrameStrobe[3] VPWR VGND sg13cmos5l_dlhq_1
X_2283_ Tile_X0Y2_E2BEG[3] _2283_/A VPWR VGND sg13cmos5l_buf_1
X_1234_ _1234_/Q Tile_X0Y0_FrameData[25] Tile_X0Y3_FrameStrobe[1] VPWR VGND sg13cmos5l_dlhq_1
XANTENNA__0838__A1 AXIL_S_SOC_AWADDR3 VPWR VGND sg13cmos5l_antennanp
XANTENNA__1351__D Tile_X0Y0_FrameData[4] VPWR VGND sg13cmos5l_antennanp
XANTENNA__2584__X Tile_X0Y3_S2BEG[6] VPWR VGND sg13cmos5l_antennanp
X_1165_ _1166_/B _0746_/X _1906_/Q VPWR VGND sg13cmos5l_nand2b_1
X_1096_ _1097_/A _0937_/X _0501_/B Tile_X0Y3_N4END[7] Tile_X0Y0_S4END[11] _1724_/Q
+ _1725_/Q VPWR VGND sg13cmos5l_mux4_1
XFILLER_64_185 VPWR VGND sg13cmos5l_fill_1
XANTENNA__2182__D Tile_X0Y3_FrameData[13] VPWR VGND sg13cmos5l_antennanp
XANTENNA__1015__A1 Tile_X0Y1_W6END[9] VPWR VGND sg13cmos5l_antennanp
X_1998_ _1998_/Q Tile_X0Y3_FrameData[5] Tile_X0Y3_FrameStrobe[1] VPWR VGND sg13cmos5l_dlhq_1
XFILLER_109_25 VPWR VGND sg13cmos5l_decap_8
XFILLER_109_47 VPWR VGND sg13cmos5l_decap_8
X_0949_ _0949_/X _0858_/X _0492_/X Tile_X0Y3_N4END[11] Tile_X0Y0_S4END[7] _1492_/Q
+ _1493_/Q VPWR VGND sg13cmos5l_mux4_1
XFILLER_173_293 VPWR VGND sg13cmos5l_fill_2
XANTENNA__1526__D Tile_X0Y1_FrameData[13] VPWR VGND sg13cmos5l_antennanp
XFILLER_133_179 VPWR VGND sg13cmos5l_decap_4
XFILLER_125_46 VPWR VGND sg13cmos5l_fill_2
XFILLER_87_255 VPWR VGND sg13cmos5l_decap_8
XFILLER_18_33 VPWR VGND sg13cmos5l_decap_4
XFILLER_18_22 VPWR VGND sg13cmos5l_fill_1
XANTENNA__1261__D Tile_X0Y0_FrameData[30] VPWR VGND sg13cmos5l_antennanp
XANTENNA__2494__X Tile_X0Y3_E1BEG[0] VPWR VGND sg13cmos5l_antennanp
XFILLER_55_152 VPWR VGND sg13cmos5l_decap_8
XFILLER_55_130 VPWR VGND sg13cmos5l_decap_4
XFILLER_18_55 VPWR VGND sg13cmos5l_decap_8
XFILLER_70_144 VPWR VGND sg13cmos5l_decap_4
XANTENNA__2092__D Tile_X0Y3_FrameData[7] VPWR VGND sg13cmos5l_antennanp
XFILLER_11_200 VPWR VGND sg13cmos5l_decap_8
XFILLER_34_76 VPWR VGND sg13cmos5l_decap_8
XFILLER_11_266 VPWR VGND sg13cmos5l_decap_8
XFILLER_109_121 VPWR VGND sg13cmos5l_decap_8
XFILLER_109_132 VPWR VGND sg13cmos5l_fill_1
XFILLER_50_42 VPWR VGND sg13cmos5l_fill_2
XFILLER_50_31 VPWR VGND sg13cmos5l_decap_4
XFILLER_109_143 VPWR VGND sg13cmos5l_decap_4
XFILLER_119_0 VPWR VGND sg13cmos5l_fill_2
XFILLER_109_176 VPWR VGND sg13cmos5l_decap_8
XFILLER_164_293 VPWR VGND sg13cmos5l_fill_2
XANTENNA__1436__D Tile_X0Y0_FrameData[15] VPWR VGND sg13cmos5l_antennanp
XFILLER_124_179 VPWR VGND sg13cmos5l_fill_2
XFILLER_1_0 VPWR VGND sg13cmos5l_fill_1
XFILLER_182_41 VPWR VGND sg13cmos5l_fill_1
XFILLER_46_141 VPWR VGND sg13cmos5l_fill_1
XFILLER_61_144 VPWR VGND sg13cmos5l_fill_1
X_1921_ _1921_/Q Tile_X0Y2_FrameData[26] Tile_X0Y3_FrameStrobe[7] VPWR VGND sg13cmos5l_dlhq_1
X_1852_ _1852_/Q Tile_X0Y2_FrameData[31] Tile_X0Y3_FrameStrobe[5] VPWR VGND sg13cmos5l_dlhq_1
XFILLER_202_194 VPWR VGND sg13cmos5l_decap_8
X_0803_ _0804_/A _1410_/Q _0802_/X _0800_/Y VPWR VGND sg13cmos5l_o21ai_1
XANTENNA__1552__GATE Tile_X0Y3_FrameStrobe[3] VPWR VGND sg13cmos5l_antennanp
X_1783_ _1783_/Q Tile_X0Y2_FrameData[4] Tile_X0Y3_FrameStrobe[2] VPWR VGND sg13cmos5l_dlhq_1
XANTENNA__0756__A0 Tile_X0Y0_W1END[3] VPWR VGND sg13cmos5l_antennanp
XFILLER_155_293 VPWR VGND sg13cmos5l_fill_2
X_0734_ _0734_/X Tile_X0Y2_W2MID[2] Tile_X0Y2_W2END[2] Tile_X0Y2_W6END[2] _0732_/X
+ _1921_/Q _1920_/Q VPWR VGND sg13cmos5l_mux4_1
XANTENNA__1346__D Tile_X0Y0_FrameData[9] VPWR VGND sg13cmos5l_antennanp
XANTENNA__2579__X Tile_X0Y3_S2BEG[1] VPWR VGND sg13cmos5l_antennanp
X_0665_ _2506_/A _0649_/X _0580_/A AXIL_S_SOC_ARADDR3 _0602_/X _2090_/Q _2091_/Q VPWR
+ VGND sg13cmos5l_mux4_1
XANTENNA__0508__A0 Tile_X0Y3_N1END[3] VPWR VGND sg13cmos5l_antennanp
XANTENNA__1567__GATE Tile_X0Y3_FrameStrobe[3] VPWR VGND sg13cmos5l_antennanp
X_2404_ Tile_X0Y0_FrameStrobe_O[10] Tile_X0Y3_FrameStrobe[10] VPWR VGND sg13cmos5l_buf_1
X_0596_ _0596_/X Tile_X0Y1_W1END[2] Tile_X0Y1_W2END[1] Tile_X0Y1_W2MID[1] _0866_/X
+ _1634_/Q _1635_/Q VPWR VGND sg13cmos5l_mux4_1
XFILLER_69_222 VPWR VGND sg13cmos5l_decap_8
XANTENNA__1181__A0 Tile_X0Y2_W2MID[1] VPWR VGND sg13cmos5l_antennanp
X_2335_ Tile_X0Y2_FrameData_O[11] Tile_X0Y2_FrameData[11] VPWR VGND sg13cmos5l_buf_1
X_2266_ Tile_X0Y1_FrameData_O[23] Tile_X0Y1_FrameData[23] VPWR VGND sg13cmos5l_buf_1
XANTENNA__2177__D Tile_X0Y3_FrameData[18] VPWR VGND sg13cmos5l_antennanp
X_1217_ _1217_/Q Tile_X0Y0_FrameData[10] Tile_X0Y3_FrameStrobe[0] VPWR VGND sg13cmos5l_dlhq_1
X_2197_ Tile_X0Y1_E1BEG[2] _2197_/A VPWR VGND sg13cmos5l_buf_1
XFILLER_111_26 VPWR VGND sg13cmos5l_fill_2
X_1148_ _2278_/A _0936_/X _0470_/X AXIL_S_SOC_WDATA0 AXIL_S_SOC_WDATA5 _1863_/Q _1862_/Q
+ VPWR VGND sg13cmos5l_mux4_1
XANTENNA__1505__GATE Tile_X0Y3_FrameStrobe[1] VPWR VGND sg13cmos5l_antennanp
X_1079_ _2285_/A AXIL_S_SOC_WDATA5 AXIL_S_SOC_WDATA13 _0725_/X _0732_/X _1849_/Q _1848_/Q
+ VPWR VGND sg13cmos5l_mux4_1
XFILLER_52_144 VPWR VGND sg13cmos5l_fill_2
XFILLER_197_127 VPWR VGND sg13cmos5l_decap_8
XFILLER_187_19 VPWR VGND sg13cmos5l_fill_1
XANTENNA__0995__A0 AXIL_S_SOC_WDATA20 VPWR VGND sg13cmos5l_antennanp
XFILLER_153_208 VPWR VGND sg13cmos5l_decap_8
XFILLER_217_8 VPWR VGND sg13cmos5l_fill_2
XANTENNA__0747__A0 Tile_X0Y0_W2MID[1] VPWR VGND sg13cmos5l_antennanp
XFILLER_112_7 VPWR VGND sg13cmos5l_decap_8
XANTENNA__1256__D Tile_X0Y0_FrameData[3] VPWR VGND sg13cmos5l_antennanp
XANTENNA__2489__X Tile_X0Y0_E2BEG[7] VPWR VGND sg13cmos5l_antennanp
XFILLER_136_12 VPWR VGND sg13cmos5l_decap_8
XFILLER_136_34 VPWR VGND sg13cmos5l_decap_8
XFILLER_146_293 VPWR VGND sg13cmos5l_fill_2
XANTENNA__0762__A3 Tile_X0Y0_S4END[0] VPWR VGND sg13cmos5l_antennanp
XFILLER_121_116 VPWR VGND sg13cmos5l_fill_2
XFILLER_136_89 VPWR VGND sg13cmos5l_decap_8
XFILLER_96_27 VPWR VGND sg13cmos5l_fill_1
XANTENNA__1172__A0 Tile_X0Y2_W2MID[7] VPWR VGND sg13cmos5l_antennanp
XFILLER_29_76 VPWR VGND sg13cmos5l_fill_2
XFILLER_29_65 VPWR VGND sg13cmos5l_fill_1
XANTENNA__2087__D Tile_X0Y3_FrameData[12] VPWR VGND sg13cmos5l_antennanp
XFILLER_90_217 VPWR VGND sg13cmos5l_fill_2
XFILLER_43_122 VPWR VGND sg13cmos5l_decap_4
XFILLER_177_30 VPWR VGND sg13cmos5l_decap_8
XANTENNA_7 AXIL_S_SOC_AWADDR3 VPWR VGND sg13cmos5l_antennanp
XANTENNA__0738__A0 Tile_X0Y1_W2MID[3] VPWR VGND sg13cmos5l_antennanp
XANTENNA__2399__X Tile_X0Y0_FrameStrobe_O[5] VPWR VGND sg13cmos5l_antennanp
XFILLER_137_293 VPWR VGND sg13cmos5l_fill_2
XFILLER_152_241 VPWR VGND sg13cmos5l_fill_2
XFILLER_152_274 VPWR VGND sg13cmos5l_fill_2
X_0450_ _0450_/Y _1626_/Q VPWR VGND sg13cmos5l_inv_1
X_2120_ _2120_/Q Tile_X0Y3_FrameData[11] Tile_X0Y3_FrameStrobe[5] VPWR VGND sg13cmos5l_dlhq_1
XFILLER_86_71 VPWR VGND sg13cmos5l_decap_8
XFILLER_120_193 VPWR VGND sg13cmos5l_decap_4
X_2051_ _2051_/Q Tile_X0Y3_FrameData[16] Tile_X0Y3_FrameStrobe[3] VPWR VGND sg13cmos5l_dlhq_1
XFILLER_19_130 VPWR VGND sg13cmos5l_decap_8
X_1002_ AXIL_S_SOC_RDATA23 Tile_X0Y1_W2MID[3] Tile_X0Y1_W2END[3] Tile_X0Y1_W6END[3]
+ _0868_/X _1517_/Q _1516_/Q VPWR VGND sg13cmos5l_mux4_1
XFILLER_81_228 VPWR VGND sg13cmos5l_fill_1
XFILLER_212_47 VPWR VGND sg13cmos5l_fill_2
XFILLER_34_111 VPWR VGND sg13cmos5l_decap_4
X_1904_ _1904_/Q Tile_X0Y2_FrameData[11] Tile_X0Y3_FrameStrobe[6] VPWR VGND sg13cmos5l_dlhq_1
XFILLER_194_119 VPWR VGND sg13cmos5l_decap_4
XANTENNA__1491__GATE Tile_X0Y3_FrameStrobe[1] VPWR VGND sg13cmos5l_antennanp
X_1835_ _1835_/Q Tile_X0Y2_FrameData[16] Tile_X0Y3_FrameStrobe[4] VPWR VGND sg13cmos5l_dlhq_1
X_1766_ _1766_/Q Tile_X0Y2_FrameData[21] Tile_X0Y3_FrameStrobe[2] VPWR VGND sg13cmos5l_dlhq_1
X_0717_ _0717_/X Tile_X0Y0_W2MID[7] Tile_X0Y0_W2END[7] Tile_X0Y0_W6END[8] _0643_/X
+ _1399_/Q _1398_/Q VPWR VGND sg13cmos5l_mux4_1
XFILLER_103_105 VPWR VGND sg13cmos5l_decap_8
X_1697_ _1697_/Q Tile_X0Y2_FrameData[26] Tile_X0Y3_FrameStrobe[0] VPWR VGND sg13cmos5l_dlhq_1
X_0648_ _0648_/X Tile_X0Y0_W2MID[1] Tile_X0Y0_W2END[1] Tile_X0Y0_W6END[1] _0646_/X
+ _1273_/Q _1272_/Q VPWR VGND sg13cmos5l_mux4_1
XANTENNA__1804__D Tile_X0Y2_FrameData[15] VPWR VGND sg13cmos5l_antennanp
X_0579_ _0580_/A Tile_X0Y3_N2MID[0] Tile_X0Y3_N2END[0] _2586_/A _0577_/X _1963_/Q
+ _1962_/Q VPWR VGND sg13cmos5l_mux4_1
XANTENNA__0901__A0 AXIL_S_SOC_AWADDR1 VPWR VGND sg13cmos5l_antennanp
XFILLER_111_182 VPWR VGND sg13cmos5l_decap_4
X_2318_ Tile_X0Y2_EE4BEG[10] _2318_/A VPWR VGND sg13cmos5l_buf_1
X_2249_ Tile_X0Y1_FrameData_O[6] Tile_X0Y1_FrameData[6] VPWR VGND sg13cmos5l_buf_1
XFILLER_72_228 VPWR VGND sg13cmos5l_decap_8
XFILLER_174_9 VPWR VGND sg13cmos5l_decap_8
XANTENNA__1444__GATE Tile_X0Y3_FrameStrobe[0] VPWR VGND sg13cmos5l_antennanp
XFILLER_122_58 VPWR VGND sg13cmos5l_decap_8
XFILLER_213_212 VPWR VGND sg13cmos5l_fill_1
XFILLER_80_294 VPWR VGND sg13cmos5l_fill_1
XFILLER_40_136 VPWR VGND sg13cmos5l_fill_2
XFILLER_185_119 VPWR VGND sg13cmos5l_decap_4
XANTENNA__0968__A0 Tile_X0Y1_W1END[3] VPWR VGND sg13cmos5l_antennanp
XANTENNA__1459__GATE Tile_X0Y3_FrameStrobe[0] VPWR VGND sg13cmos5l_antennanp
XFILLER_147_11 VPWR VGND sg13cmos5l_fill_1
XFILLER_31_44 VPWR VGND sg13cmos5l_decap_8
XFILLER_193_152 VPWR VGND sg13cmos5l_decap_8
XFILLER_31_66 VPWR VGND sg13cmos5l_decap_8
XFILLER_163_21 VPWR VGND sg13cmos5l_decap_8
XANTENNA__1714__D Tile_X0Y2_FrameData[9] VPWR VGND sg13cmos5l_antennanp
XANTENNA__2395__A Tile_X0Y3_FrameStrobe[1] VPWR VGND sg13cmos5l_antennanp
XFILLER_186_0 VPWR VGND sg13cmos5l_decap_4
XFILLER_16_111 VPWR VGND sg13cmos5l_fill_1
XFILLER_16_133 VPWR VGND sg13cmos5l_fill_1
XFILLER_16_199 VPWR VGND sg13cmos5l_decap_8
XFILLER_72_62 VPWR VGND sg13cmos5l_decap_8
XFILLER_71_294 VPWR VGND sg13cmos5l_fill_1
XFILLER_71_283 VPWR VGND sg13cmos5l_decap_4
XFILLER_204_245 VPWR VGND sg13cmos5l_decap_8
XFILLER_31_136 VPWR VGND sg13cmos5l_decap_8
XFILLER_188_40 VPWR VGND sg13cmos5l_decap_8
XFILLER_176_119 VPWR VGND sg13cmos5l_decap_4
XANTENNA__0959__A0 AXIL_S_SOC_WDATA16 VPWR VGND sg13cmos5l_antennanp
XFILLER_82_8 VPWR VGND sg13cmos5l_fill_2
X_1620_ _1620_/Q Tile_X0Y1_FrameData[15] Tile_X0Y3_FrameStrobe[5] VPWR VGND sg13cmos5l_dlhq_1
XFILLER_184_174 VPWR VGND sg13cmos5l_decap_8
XFILLER_140_200 VPWR VGND sg13cmos5l_decap_4
X_1551_ _1551_/Q Tile_X0Y1_FrameData[20] Tile_X0Y3_FrameStrobe[3] VPWR VGND sg13cmos5l_dlhq_1
XFILLER_207_14 VPWR VGND sg13cmos5l_decap_4
X_1482_ _1482_/Q Tile_X0Y1_FrameData[25] Tile_X0Y3_FrameStrobe[1] VPWR VGND sg13cmos5l_dlhq_1
X_0502_ _0502_/Y Tile_X0Y2_W6END[3] _1693_/Q VPWR VGND sg13cmos5l_nand2b_1
XANTENNA__1136__A0 Tile_X0Y2_W1END[2] VPWR VGND sg13cmos5l_antennanp
XANTENNA__1624__D Tile_X0Y1_FrameData[11] VPWR VGND sg13cmos5l_antennanp
X_0433_ _0433_/Y Tile_X0Y0_W6END[3] VPWR VGND sg13cmos5l_inv_1
X_2103_ _2103_/Q Tile_X0Y3_FrameData[28] Tile_X0Y3_FrameStrobe[5] VPWR VGND sg13cmos5l_dlhq_1
X_2034_ _2034_/Q Tile_X0Y3_FrameData[1] Tile_X0Y3_FrameStrobe[2] VPWR VGND sg13cmos5l_dlhq_1
XANTENNA__2174__GATE Tile_X0Y3_FrameStrobe[7] VPWR VGND sg13cmos5l_antennanp
XANTENNA__2592__X Tile_X0Y3_S2BEGb[6] VPWR VGND sg13cmos5l_antennanp
XANTENNA__2189__GATE Tile_X0Y3_FrameStrobe[7] VPWR VGND sg13cmos5l_antennanp
XFILLER_210_248 VPWR VGND sg13cmos5l_decap_8
XANTENNA__0965__A3 AXIL_S_SOC_WDATA21 VPWR VGND sg13cmos5l_antennanp
XANTENNA__2190__D Tile_X0Y3_FrameData[3] VPWR VGND sg13cmos5l_antennanp
X_1818_ _1818_/Q Tile_X0Y2_FrameData[1] Tile_X0Y3_FrameStrobe[3] VPWR VGND sg13cmos5l_dlhq_1
XANTENNA__2112__GATE Tile_X0Y3_FrameStrobe[5] VPWR VGND sg13cmos5l_antennanp
XFILLER_190_133 VPWR VGND sg13cmos5l_decap_8
XFILLER_116_263 VPWR VGND sg13cmos5l_decap_8
XFILLER_117_25 VPWR VGND sg13cmos5l_fill_2
X_1749_ _1749_/Q Tile_X0Y2_FrameData[6] Tile_X0Y3_FrameStrobe[1] VPWR VGND sg13cmos5l_dlhq_1
XFILLER_89_103 VPWR VGND sg13cmos5l_decap_8
XFILLER_116_285 VPWR VGND sg13cmos5l_fill_2
XANTENNA__1534__D Tile_X0Y1_FrameData[5] VPWR VGND sg13cmos5l_antennanp
XANTENNA__2127__GATE Tile_X0Y3_FrameStrobe[5] VPWR VGND sg13cmos5l_antennanp
XFILLER_131_277 VPWR VGND sg13cmos5l_fill_2
XFILLER_133_46 VPWR VGND sg13cmos5l_decap_8
XANTENNA__1383__GATE Tile_X0Y3_FrameStrobe[5] VPWR VGND sg13cmos5l_antennanp
XFILLER_93_39 VPWR VGND sg13cmos5l_decap_8
XFILLER_45_239 VPWR VGND sg13cmos5l_fill_2
XFILLER_45_228 VPWR VGND sg13cmos5l_fill_2
XFILLER_26_99 VPWR VGND sg13cmos5l_fill_1
XANTENNA__0653__A2 Tile_X0Y0_S2MID[2] VPWR VGND sg13cmos5l_antennanp
XANTENNA__1398__GATE Tile_X0Y3_FrameStrobe[6] VPWR VGND sg13cmos5l_antennanp
XFILLER_198_255 VPWR VGND sg13cmos5l_decap_8
XFILLER_201_237 VPWR VGND sg13cmos5l_decap_8
XANTENNA__1709__D Tile_X0Y2_FrameData[14] VPWR VGND sg13cmos5l_antennanp
XFILLER_158_54 VPWR VGND sg13cmos5l_fill_1
XANTENNA__1321__GATE Tile_X0Y3_FrameStrobe[3] VPWR VGND sg13cmos5l_antennanp
XANTENNA__1951__GATE Tile_X0Y3_FrameStrobe[0] VPWR VGND sg13cmos5l_antennanp
XFILLER_101_0 VPWR VGND sg13cmos5l_fill_2
XFILLER_107_252 VPWR VGND sg13cmos5l_decap_8
XFILLER_181_166 VPWR VGND sg13cmos5l_fill_1
XFILLER_181_155 VPWR VGND sg13cmos5l_decap_8
XFILLER_174_20 VPWR VGND sg13cmos5l_fill_1
XANTENNA__1336__GATE Tile_X0Y3_FrameStrobe[4] VPWR VGND sg13cmos5l_antennanp
XFILLER_181_188 VPWR VGND sg13cmos5l_decap_8
XANTENNA__1118__A0 Tile_X0Y3_N4END[4] VPWR VGND sg13cmos5l_antennanp
XANTENNA__1444__D Tile_X0Y0_FrameData[31] VPWR VGND sg13cmos5l_antennanp
XANTENNA__1966__GATE Tile_X0Y3_FrameStrobe[0] VPWR VGND sg13cmos5l_antennanp
XFILLER_174_97 VPWR VGND sg13cmos5l_decap_4
XANTENNA__0892__A2 Tile_X0Y0_WW4END[13] VPWR VGND sg13cmos5l_antennanp
XFILLER_190_96 VPWR VGND sg13cmos5l_decap_8
XFILLER_44_283 VPWR VGND sg13cmos5l_fill_1
XANTENNA__0644__A2 Tile_X0Y1_W6END[6] VPWR VGND sg13cmos5l_antennanp
XANTENNA__1904__GATE Tile_X0Y3_FrameStrobe[6] VPWR VGND sg13cmos5l_antennanp
X_0982_ _0982_/Y _0455_/Y _0981_/X _1623_/Q VPWR VGND sg13cmos5l_a21oi_1
XANTENNA__1619__D Tile_X0Y1_FrameData[16] VPWR VGND sg13cmos5l_antennanp
XANTENNA__1919__GATE Tile_X0Y3_FrameStrobe[7] VPWR VGND sg13cmos5l_antennanp
XFILLER_8_184 VPWR VGND sg13cmos5l_decap_8
XFILLER_218_46 VPWR VGND sg13cmos5l_fill_1
X_1603_ _1603_/Q Tile_X0Y1_FrameData[0] Tile_X0Y3_FrameStrobe[4] VPWR VGND sg13cmos5l_dlhq_1
X_2583_ Tile_X0Y3_S2BEG[5] _2583_/A VPWR VGND sg13cmos5l_buf_1
XFILLER_218_68 VPWR VGND sg13cmos5l_decap_8
X_1534_ _1534_/Q Tile_X0Y1_FrameData[5] Tile_X0Y3_FrameStrobe[2] VPWR VGND sg13cmos5l_dlhq_1
XANTENNA__1109__A0 AXIL_S_SOC_WDATA5 VPWR VGND sg13cmos5l_antennanp
XANTENNA__1354__D Tile_X0Y0_FrameData[1] VPWR VGND sg13cmos5l_antennanp
XANTENNA__2587__X Tile_X0Y3_S2BEGb[1] VPWR VGND sg13cmos5l_antennanp
X_1465_ _1465_/Q Tile_X0Y1_FrameData[10] Tile_X0Y3_FrameStrobe[0] VPWR VGND sg13cmos5l_dlhq_1
X_1396_ _1396_/Q Tile_X0Y0_FrameData[23] Tile_X0Y3_FrameStrobe[6] VPWR VGND sg13cmos5l_dlhq_1
XANTENNA__0883__A2 AXIL_S_SOC_AWADDR5 VPWR VGND sg13cmos5l_antennanp
XANTENNA__2185__D Tile_X0Y3_FrameData[10] VPWR VGND sg13cmos5l_antennanp
X_2017_ _2017_/Q Tile_X0Y3_FrameData[18] Tile_X0Y3_FrameStrobe[2] VPWR VGND sg13cmos5l_dlhq_1
XFILLER_195_203 VPWR VGND sg13cmos5l_decap_8
XANTENNA__1529__D Tile_X0Y1_FrameData[10] VPWR VGND sg13cmos5l_antennanp
XANTENNA__2051__GATE Tile_X0Y3_FrameStrobe[3] VPWR VGND sg13cmos5l_antennanp
XFILLER_128_24 VPWR VGND sg13cmos5l_decap_8
XFILLER_88_28 VPWR VGND sg13cmos5l_fill_1
XFILLER_88_39 VPWR VGND sg13cmos5l_fill_2
XANTENNA__2066__GATE Tile_X0Y3_FrameStrobe[3] VPWR VGND sg13cmos5l_antennanp
XANTENNA__2497__X Tile_X0Y3_E1BEG[3] VPWR VGND sg13cmos5l_antennanp
XFILLER_104_255 VPWR VGND sg13cmos5l_fill_1
XFILLER_144_12 VPWR VGND sg13cmos5l_decap_4
XANTENNA__1264__D Tile_X0Y0_FrameData[27] VPWR VGND sg13cmos5l_antennanp
XFILLER_104_266 VPWR VGND sg13cmos5l_fill_1
XFILLER_104_277 VPWR VGND sg13cmos5l_decap_8
XFILLER_37_21 VPWR VGND sg13cmos5l_decap_8
XFILLER_218_145 VPWR VGND sg13cmos5l_fill_2
XFILLER_218_112 VPWR VGND sg13cmos5l_fill_2
XANTENNA__2095__D Tile_X0Y3_FrameData[4] VPWR VGND sg13cmos5l_antennanp
XFILLER_160_99 VPWR VGND sg13cmos5l_fill_1
XFILLER_26_261 VPWR VGND sg13cmos5l_fill_1
XANTENNA__0626__A2 Tile_X0Y3_W6END[1] VPWR VGND sg13cmos5l_antennanp
XANTENNA__2004__GATE Tile_X0Y3_FrameStrobe[2] VPWR VGND sg13cmos5l_antennanp
XFILLER_26_294 VPWR VGND sg13cmos5l_fill_1
XFILLER_186_203 VPWR VGND sg13cmos5l_decap_8
XFILLER_149_0 VPWR VGND sg13cmos5l_fill_2
XFILLER_169_31 VPWR VGND sg13cmos5l_fill_2
XANTENNA__1260__GATE Tile_X0Y3_FrameStrobe[2] VPWR VGND sg13cmos5l_antennanp
XANTENNA__0929__A3 Tile_X0Y0_S4END[6] VPWR VGND sg13cmos5l_antennanp
XANTENNA__1439__D Tile_X0Y0_FrameData[12] VPWR VGND sg13cmos5l_antennanp
XANTENNA__1890__GATE Tile_X0Y3_FrameStrobe[6] VPWR VGND sg13cmos5l_antennanp
XANTENNA__2019__GATE Tile_X0Y3_FrameStrobe[2] VPWR VGND sg13cmos5l_antennanp
XFILLER_194_280 VPWR VGND sg13cmos5l_fill_1
XANTENNA__1275__GATE Tile_X0Y3_FrameStrobe[2] VPWR VGND sg13cmos5l_antennanp
XFILLER_185_63 VPWR VGND sg13cmos5l_fill_1
XFILLER_154_199 VPWR VGND sg13cmos5l_decap_8
XFILLER_110_214 VPWR VGND sg13cmos5l_decap_8
XANTENNA__2200__X Tile_X0Y1_E2BEG[1] VPWR VGND sg13cmos5l_antennanp
X_1250_ _1250_/Q Tile_X0Y0_FrameData[9] Tile_X0Y3_FrameStrobe[1] VPWR VGND sg13cmos5l_dlhq_1
XANTENNA__1902__D Tile_X0Y2_FrameData[13] VPWR VGND sg13cmos5l_antennanp
X_1181_ AXIL_S_SOC_RDATA9 Tile_X0Y2_W2MID[1] Tile_X0Y2_W2END[1] Tile_X0Y2_W6END[1]
+ _0715_/X _1769_/Q _1768_/Q VPWR VGND sg13cmos5l_mux4_1
XANTENNA__1213__GATE Tile_X0Y3_FrameStrobe[0] VPWR VGND sg13cmos5l_antennanp
XANTENNA__1843__GATE Tile_X0Y3_FrameStrobe[4] VPWR VGND sg13cmos5l_antennanp
XANTENNA__0617__A2 Tile_X0Y3_WW4END[13] VPWR VGND sg13cmos5l_antennanp
XANTENNA__1228__GATE Tile_X0Y3_FrameStrobe[1] VPWR VGND sg13cmos5l_antennanp
XFILLER_177_247 VPWR VGND sg13cmos5l_decap_4
XANTENNA__1349__D Tile_X0Y0_FrameData[6] VPWR VGND sg13cmos5l_antennanp
XANTENNA__1858__GATE Tile_X0Y3_FrameStrobe[5] VPWR VGND sg13cmos5l_antennanp
X_0965_ _2197_/A _0860_/X _0466_/B AXIL_S_SOC_WDATA16 AXIL_S_SOC_WDATA21 _1615_/Q
+ _1614_/Q VPWR VGND sg13cmos5l_mux4_1
X_0896_ AXIL_S_SOC_RRESP0 Tile_X0Y0_W2MID[4] Tile_X0Y0_W2END[4] Tile_X0Y0_W6END[4]
+ _0739_/X _1267_/Q _1266_/Q VPWR VGND sg13cmos5l_mux4_1
XFILLER_145_199 VPWR VGND sg13cmos5l_decap_8
X_2566_ Tile_X0Y3_FrameData_O[24] Tile_X0Y3_FrameData[24] VPWR VGND sg13cmos5l_buf_1
XFILLER_99_242 VPWR VGND sg13cmos5l_decap_4
XANTENNA__0553__A1 Tile_X0Y1_W6END[9] VPWR VGND sg13cmos5l_antennanp
X_1517_ _1517_/Q Tile_X0Y1_FrameData[22] Tile_X0Y3_FrameStrobe[2] VPWR VGND sg13cmos5l_dlhq_1
X_2497_ Tile_X0Y3_E1BEG[3] _2497_/A VPWR VGND sg13cmos5l_buf_1
XFILLER_101_236 VPWR VGND sg13cmos5l_decap_8
X_1448_ _1448_/Q Tile_X0Y1_FrameData[27] Tile_X0Y3_FrameStrobe[0] VPWR VGND sg13cmos5l_dlhq_1
XANTENNA__1812__D Tile_X0Y2_FrameData[7] VPWR VGND sg13cmos5l_antennanp
XFILLER_114_37 VPWR VGND sg13cmos5l_decap_4
X_1379_ _1379_/Q Tile_X0Y0_FrameData[8] Tile_X0Y3_FrameStrobe[5] VPWR VGND sg13cmos5l_dlhq_1
XANTENNA__0608__A2 Tile_X0Y3_WW4END[12] VPWR VGND sg13cmos5l_antennanp
XFILLER_223_170 VPWR VGND sg13cmos5l_fill_2
XFILLER_168_247 VPWR VGND sg13cmos5l_decap_8
XFILLER_23_286 VPWR VGND sg13cmos5l_fill_1
XANTENNA__1259__D Tile_X0Y0_FrameData[0] VPWR VGND sg13cmos5l_antennanp
XFILLER_191_294 VPWR VGND sg13cmos5l_fill_1
XFILLER_155_66 VPWR VGND sg13cmos5l_decap_8
XFILLER_2_135 VPWR VGND sg13cmos5l_decap_4
XANTENNA__1722__D Tile_X0Y2_FrameData[1] VPWR VGND sg13cmos5l_antennanp
XFILLER_171_43 VPWR VGND sg13cmos5l_decap_4
XFILLER_171_32 VPWR VGND sg13cmos5l_fill_1
XFILLER_14_220 VPWR VGND sg13cmos5l_decap_8
XFILLER_9_14 VPWR VGND sg13cmos5l_fill_1
XANTENNA__0480__A0 Tile_X0Y3_N1END[2] VPWR VGND sg13cmos5l_antennanp
XFILLER_14_286 VPWR VGND sg13cmos5l_fill_1
XFILLER_9_47 VPWR VGND sg13cmos5l_decap_8
X_0750_ _0750_/X Tile_X0Y2_W2MID[1] Tile_X0Y2_W2END[1] Tile_X0Y2_W6END[1] _0729_/X
+ _1919_/Q _1918_/Q VPWR VGND sg13cmos5l_mux4_1
X_2420_ Tile_X0Y0_FrameData_O[6] Tile_X0Y0_FrameData[6] VPWR VGND sg13cmos5l_buf_1
X_0681_ _2534_/A AXIL_S_SOC_ARVALID AXIL_S_SOC_ARADDR3 _0506_/X _0602_/X _2059_/Q
+ _2058_/Q VPWR VGND sg13cmos5l_mux4_1
XFILLER_182_294 VPWR VGND sg13cmos5l_fill_1
XFILLER_182_272 VPWR VGND sg13cmos5l_decap_8
XFILLER_142_136 VPWR VGND sg13cmos5l_decap_8
XFILLER_89_82 VPWR VGND sg13cmos5l_decap_8
XANTENNA__0535__A1 Tile_X0Y2_W6END[8] VPWR VGND sg13cmos5l_antennanp
X_2351_ Tile_X0Y2_FrameData_O[27] Tile_X0Y2_FrameData[27] VPWR VGND sg13cmos5l_buf_1
XFILLER_215_25 VPWR VGND sg13cmos5l_decap_8
X_1302_ _1302_/Q Tile_X0Y0_FrameData[21] Tile_X0Y3_FrameStrobe[3] VPWR VGND sg13cmos5l_dlhq_1
X_2282_ Tile_X0Y2_E2BEG[2] _2282_/A VPWR VGND sg13cmos5l_buf_1
XFILLER_215_47 VPWR VGND sg13cmos5l_decap_4
XFILLER_215_36 VPWR VGND sg13cmos5l_fill_1
X_1233_ _1233_/Q Tile_X0Y0_FrameData[26] Tile_X0Y3_FrameStrobe[1] VPWR VGND sg13cmos5l_dlhq_1
XFILLER_56_109 VPWR VGND sg13cmos5l_decap_8
XANTENNA__1632__D Tile_X0Y1_FrameData[3] VPWR VGND sg13cmos5l_antennanp
XANTENNA__1782__GATE Tile_X0Y3_FrameStrobe[2] VPWR VGND sg13cmos5l_antennanp
X_1164_ _1164_/Y _1906_/Q _1103_/X _1163_/Y VPWR VGND sg13cmos5l_o21ai_1
X_1095_ _2308_/A AXIL_S_SOC_WDATA0 _0500_/X AXIL_S_SOC_WDATA12 _0758_/X _1826_/Q _1827_/Q
+ VPWR VGND sg13cmos5l_mux4_1
XFILLER_64_164 VPWR VGND sg13cmos5l_decap_8
XFILLER_212_118 VPWR VGND sg13cmos5l_decap_4
XANTENNA__1797__GATE Tile_X0Y3_FrameStrobe[3] VPWR VGND sg13cmos5l_antennanp
XFILLER_100_39 VPWR VGND sg13cmos5l_decap_4
X_1997_ _1997_/Q Tile_X0Y3_FrameData[6] Tile_X0Y3_FrameStrobe[1] VPWR VGND sg13cmos5l_dlhq_1
XANTENNA__1015__A2 Tile_X0Y1_WW4END[14] VPWR VGND sg13cmos5l_antennanp
XFILLER_158_280 VPWR VGND sg13cmos5l_fill_1
XFILLER_165_239 VPWR VGND sg13cmos5l_decap_8
X_0948_ _0948_/X _0945_/X _0947_/A _0493_/X _0868_/X _1658_/Q _1657_/Q VPWR VGND sg13cmos5l_mux4_1
XANTENNA__1720__GATE Tile_X0Y3_FrameStrobe[0] VPWR VGND sg13cmos5l_antennanp
XFILLER_9_290 VPWR VGND sg13cmos5l_decap_4
XFILLER_173_250 VPWR VGND sg13cmos5l_fill_2
XANTENNA__1807__D Tile_X0Y2_FrameData[12] VPWR VGND sg13cmos5l_antennanp
XFILLER_133_103 VPWR VGND sg13cmos5l_decap_8
XFILLER_133_114 VPWR VGND sg13cmos5l_fill_2
X_0879_ _2465_/A Tile_X0Y3_N4END[15] Tile_X0Y0_S4END[3] _0760_/X _0520_/A _1293_/Q
+ _1292_/Q VPWR VGND sg13cmos5l_mux4_1
XFILLER_173_283 VPWR VGND sg13cmos5l_fill_1
XANTENNA__1735__GATE Tile_X0Y3_FrameStrobe[1] VPWR VGND sg13cmos5l_antennanp
X_2549_ Tile_X0Y3_FrameData_O[7] Tile_X0Y3_FrameData[7] VPWR VGND sg13cmos5l_buf_1
XFILLER_125_58 VPWR VGND sg13cmos5l_decap_8
XFILLER_87_278 VPWR VGND sg13cmos5l_decap_4
XANTENNA__1542__D Tile_X0Y1_FrameData[29] VPWR VGND sg13cmos5l_antennanp
XFILLER_141_35 VPWR VGND sg13cmos5l_decap_8
XFILLER_70_112 VPWR VGND sg13cmos5l_decap_8
XFILLER_34_22 VPWR VGND sg13cmos5l_fill_2
XFILLER_109_100 VPWR VGND sg13cmos5l_fill_2
XFILLER_156_228 VPWR VGND sg13cmos5l_decap_8
XANTENNA__1717__D Tile_X0Y2_FrameData[6] VPWR VGND sg13cmos5l_antennanp
XFILLER_164_261 VPWR VGND sg13cmos5l_fill_2
XFILLER_164_283 VPWR VGND sg13cmos5l_fill_1
XFILLER_124_136 VPWR VGND sg13cmos5l_fill_1
XFILLER_166_98 VPWR VGND sg13cmos5l_fill_1
XANTENNA__2398__A Tile_X0Y3_FrameStrobe[4] VPWR VGND sg13cmos5l_antennanp
XANTENNA__1452__D Tile_X0Y1_FrameData[23] VPWR VGND sg13cmos5l_antennanp
XFILLER_46_120 VPWR VGND sg13cmos5l_decap_8
X_1920_ _1920_/Q Tile_X0Y2_FrameData[27] Tile_X0Y3_FrameStrobe[7] VPWR VGND sg13cmos5l_dlhq_1
XFILLER_202_151 VPWR VGND sg13cmos5l_decap_8
X_1851_ _1851_/Q Tile_X0Y2_FrameData[0] Tile_X0Y3_FrameStrobe[4] VPWR VGND sg13cmos5l_dlhq_1
XFILLER_202_162 VPWR VGND sg13cmos5l_fill_2
X_0802_ _0802_/X Tile_X0Y0_W1END[3] Tile_X0Y0_W6END[11] _0801_/X _0488_/X _1409_/Q
+ _1408_/Q VPWR VGND sg13cmos5l_mux4_1
XFILLER_155_250 VPWR VGND sg13cmos5l_decap_8
X_1782_ _1782_/Q Tile_X0Y2_FrameData[5] Tile_X0Y3_FrameStrobe[2] VPWR VGND sg13cmos5l_dlhq_1
XANTENNA__0756__A1 Tile_X0Y0_W2END[0] VPWR VGND sg13cmos5l_antennanp
XANTENNA__1627__D Tile_X0Y1_FrameData[8] VPWR VGND sg13cmos5l_antennanp
XFILLER_115_114 VPWR VGND sg13cmos5l_fill_1
XFILLER_155_283 VPWR VGND sg13cmos5l_fill_1
X_0733_ _2387_/A Tile_X0Y0_W2MID[2] Tile_X0Y0_W2END[2] Tile_X0Y0_W6END[2] _0736_/X
+ _1425_/Q _1424_/Q VPWR VGND sg13cmos5l_mux4_1
XFILLER_115_147 VPWR VGND sg13cmos5l_fill_2
X_0664_ _2505_/A AXIL_S_SOC_ARADDR2 AXIL_S_SOC_BREADY _0580_/A _0602_/X _2093_/Q _2092_/Q
+ VPWR VGND sg13cmos5l_mux4_1
XFILLER_6_293 VPWR VGND sg13cmos5l_fill_2
XANTENNA__0508__A1 Tile_X0Y3_N4END[3] VPWR VGND sg13cmos5l_antennanp
X_2403_ Tile_X0Y0_FrameStrobe_O[9] Tile_X0Y3_FrameStrobe[9] VPWR VGND sg13cmos5l_buf_1
XFILLER_130_139 VPWR VGND sg13cmos5l_decap_8
X_2334_ Tile_X0Y2_FrameData_O[10] Tile_X0Y2_FrameData[10] VPWR VGND sg13cmos5l_buf_1
X_0595_ _2583_/A Tile_X0Y3_W1END[1] Tile_X0Y3_W2MID[2] Tile_X0Y3_W2END[2] _0594_/X
+ _2133_/Q _2132_/Q VPWR VGND sg13cmos5l_mux4_1
XANTENNA__1181__A1 Tile_X0Y2_W2END[1] VPWR VGND sg13cmos5l_antennanp
XFILLER_27_0 VPWR VGND sg13cmos5l_fill_2
XANTENNA__1362__D Tile_X0Y0_FrameData[25] VPWR VGND sg13cmos5l_antennanp
XANTENNA__2595__X Tile_X0Y3_S4BEG[1] VPWR VGND sg13cmos5l_antennanp
X_2265_ Tile_X0Y1_FrameData_O[22] Tile_X0Y1_FrameData[22] VPWR VGND sg13cmos5l_buf_1
XFILLER_84_215 VPWR VGND sg13cmos5l_fill_2
XFILLER_84_204 VPWR VGND sg13cmos5l_decap_8
X_1216_ _1216_/Q Tile_X0Y0_FrameData[11] Tile_X0Y3_FrameStrobe[0] VPWR VGND sg13cmos5l_dlhq_1
X_2196_ Tile_X0Y1_E1BEG[1] _2196_/A VPWR VGND sg13cmos5l_buf_1
XFILLER_37_142 VPWR VGND sg13cmos5l_decap_8
XANTENNA__0556__A Tile_X0Y2_W6END[1] VPWR VGND sg13cmos5l_antennanp
X_1147_ _2603_/A _1874_/Q _1146_/Y _1144_/Y VPWR VGND sg13cmos5l_a21oi_1
XFILLER_225_243 VPWR VGND sg13cmos5l_fill_2
XANTENNA__0692__A0 Tile_X0Y3_N4END[3] VPWR VGND sg13cmos5l_antennanp
XFILLER_37_197 VPWR VGND sg13cmos5l_decap_8
XANTENNA__2193__D Tile_X0Y3_FrameData[6] VPWR VGND sg13cmos5l_antennanp
X_1078_ _2286_/A AXIL_S_SOC_WDATA6 AXIL_S_SOC_WDATA14 _0715_/X _0729_/X _1847_/Q _1846_/Q
+ VPWR VGND sg13cmos5l_mux4_1
XFILLER_52_167 VPWR VGND sg13cmos5l_decap_4
XFILLER_197_106 VPWR VGND sg13cmos5l_decap_8
XANTENNA__0747__A1 Tile_X0Y0_W2END[1] VPWR VGND sg13cmos5l_antennanp
XANTENNA__1537__D Tile_X0Y1_FrameData[2] VPWR VGND sg13cmos5l_antennanp
XANTENNA__1674__GATE Tile_X0Y3_FrameStrobe[7] VPWR VGND sg13cmos5l_antennanp
XFILLER_106_169 VPWR VGND sg13cmos5l_decap_8
XFILLER_161_253 VPWR VGND sg13cmos5l_decap_4
XFILLER_161_275 VPWR VGND sg13cmos5l_fill_1
XFILLER_20_79 VPWR VGND sg13cmos5l_decap_4
XFILLER_121_139 VPWR VGND sg13cmos5l_decap_8
XFILLER_29_11 VPWR VGND sg13cmos5l_decap_4
XANTENNA__1172__A1 Tile_X0Y2_W2END[7] VPWR VGND sg13cmos5l_antennanp
XANTENNA__1272__D Tile_X0Y0_FrameData[19] VPWR VGND sg13cmos5l_antennanp
XANTENNA__1689__GATE Tile_X0Y3_FrameStrobe[7] VPWR VGND sg13cmos5l_antennanp
XFILLER_29_99 VPWR VGND sg13cmos5l_decap_8
XFILLER_28_131 VPWR VGND sg13cmos5l_decap_8
XFILLER_28_142 VPWR VGND sg13cmos5l_fill_2
XANTENNA__0683__A0 AXIL_S_SOC_ARADDR1 VPWR VGND sg13cmos5l_antennanp
XANTENNA__1612__GATE Tile_X0Y3_FrameStrobe[5] VPWR VGND sg13cmos5l_antennanp
XFILLER_43_134 VPWR VGND sg13cmos5l_fill_1
XFILLER_101_71 VPWR VGND sg13cmos5l_decap_4
XFILLER_101_93 VPWR VGND sg13cmos5l_decap_8
XANTENNA__1627__GATE Tile_X0Y3_FrameStrobe[5] VPWR VGND sg13cmos5l_antennanp
XFILLER_131_0 VPWR VGND sg13cmos5l_fill_2
XFILLER_196_194 VPWR VGND sg13cmos5l_fill_2
XFILLER_196_183 VPWR VGND sg13cmos5l_decap_8
XFILLER_6_15 VPWR VGND sg13cmos5l_fill_2
XANTENNA_8 AXIL_S_SOC_AWADDR3 VPWR VGND sg13cmos5l_antennanp
XANTENNA__0738__A1 Tile_X0Y1_W2END[3] VPWR VGND sg13cmos5l_antennanp
XANTENNA__1447__D Tile_X0Y1_FrameData[28] VPWR VGND sg13cmos5l_antennanp
XFILLER_6_37 VPWR VGND sg13cmos5l_fill_2
XFILLER_152_220 VPWR VGND sg13cmos5l_decap_8
XFILLER_6_59 VPWR VGND sg13cmos5l_decap_8
XFILLER_3_230 VPWR VGND sg13cmos5l_decap_4
XFILLER_105_191 VPWR VGND sg13cmos5l_decap_8
XANTENNA__0910__A1 Tile_X0Y1_W1END[0] VPWR VGND sg13cmos5l_antennanp
XFILLER_120_150 VPWR VGND sg13cmos5l_decap_8
X_2050_ _2050_/Q Tile_X0Y3_FrameData[17] Tile_X0Y3_FrameStrobe[3] VPWR VGND sg13cmos5l_dlhq_1
X_1001_ _2223_/A AXIL_S_SOC_WDATA16 _0945_/X _0949_/X _0869_/X _1530_/Q _1531_/Q VPWR
+ VGND sg13cmos5l_mux4_1
XANTENNA__1910__D Tile_X0Y2_FrameData[5] VPWR VGND sg13cmos5l_antennanp
XFILLER_212_59 VPWR VGND sg13cmos5l_decap_8
XFILLER_207_254 VPWR VGND sg13cmos5l_decap_8
XFILLER_222_224 VPWR VGND sg13cmos5l_fill_2
XFILLER_222_213 VPWR VGND sg13cmos5l_decap_8
XFILLER_222_257 VPWR VGND sg13cmos5l_fill_1
X_1903_ _1903_/Q Tile_X0Y2_FrameData[12] Tile_X0Y3_FrameStrobe[6] VPWR VGND sg13cmos5l_dlhq_1
X_1834_ _1834_/Q Tile_X0Y2_FrameData[17] Tile_X0Y3_FrameStrobe[4] VPWR VGND sg13cmos5l_dlhq_1
XANTENNA__1357__D Tile_X0Y0_FrameData[30] VPWR VGND sg13cmos5l_antennanp
X_1765_ _1765_/Q Tile_X0Y2_FrameData[22] Tile_X0Y3_FrameStrobe[2] VPWR VGND sg13cmos5l_dlhq_1
XFILLER_128_294 VPWR VGND sg13cmos5l_fill_1
X_0716_ _2383_/A Tile_X0Y0_W2MID[6] Tile_X0Y0_W2END[6] Tile_X0Y0_W6END[6] _0646_/X
+ _1433_/Q _1432_/Q VPWR VGND sg13cmos5l_mux4_1
X_1696_ _1696_/Q Tile_X0Y2_FrameData[27] Tile_X0Y3_FrameStrobe[0] VPWR VGND sg13cmos5l_dlhq_1
X_0647_ _0647_/X Tile_X0Y0_W2MID[0] Tile_X0Y0_W2END[0] Tile_X0Y0_W6END[0] _0643_/X
+ _1275_/Q _1274_/Q VPWR VGND sg13cmos5l_mux4_1
X_0578_ _2586_/A Tile_X0Y2_W2MID[7] Tile_X0Y2_W2END[7] Tile_X0Y2_W6END[8] _0719_/X
+ _1895_/Q _1894_/Q VPWR VGND sg13cmos5l_mux4_1
XANTENNA__2188__D Tile_X0Y3_FrameData[31] VPWR VGND sg13cmos5l_antennanp
X_2317_ Tile_X0Y2_EE4BEG[9] _2317_/A VPWR VGND sg13cmos5l_buf_1
X_2248_ Tile_X0Y1_FrameData_O[5] Tile_X0Y1_FrameData[5] VPWR VGND sg13cmos5l_buf_1
XANTENNA__1820__D Tile_X0Y2_FrameData[31] VPWR VGND sg13cmos5l_antennanp
X_2179_ _2179_/Q Tile_X0Y3_FrameData[16] Tile_X0Y3_FrameStrobe[7] VPWR VGND sg13cmos5l_dlhq_1
XFILLER_202_70 VPWR VGND sg13cmos5l_decap_8
XFILLER_15_35 VPWR VGND sg13cmos5l_fill_1
XFILLER_15_46 VPWR VGND sg13cmos5l_decap_8
XFILLER_213_268 VPWR VGND sg13cmos5l_decap_8
XANTENNA__0968__A1 Tile_X0Y1_WW4END[15] VPWR VGND sg13cmos5l_antennanp
XANTENNA__1090__A0 AXIL_S_SOC_WDATA6 VPWR VGND sg13cmos5l_antennanp
XANTENNA__1267__D Tile_X0Y0_FrameData[24] VPWR VGND sg13cmos5l_antennanp
XFILLER_119_294 VPWR VGND sg13cmos5l_fill_1
XFILLER_147_78 VPWR VGND sg13cmos5l_decap_8
XFILLER_134_253 VPWR VGND sg13cmos5l_decap_8
XFILLER_163_11 VPWR VGND sg13cmos5l_decap_8
XFILLER_0_244 VPWR VGND sg13cmos5l_decap_8
XANTENNA__2098__D Tile_X0Y3_FrameData[1] VPWR VGND sg13cmos5l_antennanp
XFILLER_102_172 VPWR VGND sg13cmos5l_decap_8
XFILLER_48_204 VPWR VGND sg13cmos5l_fill_2
XANTENNA__1551__GATE Tile_X0Y3_FrameStrobe[3] VPWR VGND sg13cmos5l_antennanp
XANTENNA__0656__A0 Tile_X0Y3_N1END[3] VPWR VGND sg13cmos5l_antennanp
XANTENNA__1730__D Tile_X0Y2_FrameData[25] VPWR VGND sg13cmos5l_antennanp
XFILLER_179_0 VPWR VGND sg13cmos5l_fill_2
XFILLER_204_213 VPWR VGND sg13cmos5l_fill_1
XFILLER_72_41 VPWR VGND sg13cmos5l_decap_8
XFILLER_71_262 VPWR VGND sg13cmos5l_decap_8
XFILLER_31_115 VPWR VGND sg13cmos5l_decap_8
XANTENNA__1566__GATE Tile_X0Y3_FrameStrobe[3] VPWR VGND sg13cmos5l_antennanp
XANTENNA__0959__A1 AXIL_S_SOC_WDATA24 VPWR VGND sg13cmos5l_antennanp
XANTENNA__1081__A0 AXIL_S_SOC_WDATA3 VPWR VGND sg13cmos5l_antennanp
XANTENNA__2203__X Tile_X0Y1_E2BEG[4] VPWR VGND sg13cmos5l_antennanp
X_1550_ _1550_/Q Tile_X0Y1_FrameData[21] Tile_X0Y3_FrameStrobe[3] VPWR VGND sg13cmos5l_dlhq_1
X_0501_ _0501_/Y _1693_/Q _0501_/B _1940_/Q VPWR VGND sg13cmos5l_nand3b_1
XANTENNA__1504__GATE Tile_X0Y3_FrameStrobe[1] VPWR VGND sg13cmos5l_antennanp
XANTENNA__1905__D Tile_X0Y2_FrameData[10] VPWR VGND sg13cmos5l_antennanp
X_1481_ _1481_/Q Tile_X0Y1_FrameData[26] Tile_X0Y3_FrameStrobe[1] VPWR VGND sg13cmos5l_dlhq_1
XANTENNA__1136__A1 Tile_X0Y2_WW4END[14] VPWR VGND sg13cmos5l_antennanp
XFILLER_140_256 VPWR VGND sg13cmos5l_decap_4
XFILLER_140_267 VPWR VGND sg13cmos5l_decap_8
X_0432_ _0432_/Y Tile_X0Y0_W1END[2] VPWR VGND sg13cmos5l_inv_1
XFILLER_97_82 VPWR VGND sg13cmos5l_fill_1
XANTENNA__0895__A0 Tile_X0Y0_W2MID[5] VPWR VGND sg13cmos5l_antennanp
X_2102_ _2102_/Q Tile_X0Y3_FrameData[29] Tile_X0Y3_FrameStrobe[5] VPWR VGND sg13cmos5l_dlhq_1
XANTENNA__1519__GATE Tile_X0Y3_FrameStrobe[2] VPWR VGND sg13cmos5l_antennanp
XFILLER_223_58 VPWR VGND sg13cmos5l_decap_4
XANTENNA__1640__D Tile_X0Y1_FrameData[27] VPWR VGND sg13cmos5l_antennanp
X_2033_ _2033_/Q Tile_X0Y3_FrameData[2] Tile_X0Y3_FrameStrobe[2] VPWR VGND sg13cmos5l_dlhq_1
XANTENNA__0647__A0 Tile_X0Y0_W2MID[0] VPWR VGND sg13cmos5l_antennanp
XFILLER_94_0 VPWR VGND sg13cmos5l_decap_4
XFILLER_108_209 VPWR VGND sg13cmos5l_fill_2
X_1817_ _1817_/Q Tile_X0Y2_FrameData[2] Tile_X0Y3_FrameStrobe[3] VPWR VGND sg13cmos5l_dlhq_1
X_1748_ _1748_/Q Tile_X0Y2_FrameData[7] Tile_X0Y3_FrameStrobe[1] VPWR VGND sg13cmos5l_dlhq_1
XANTENNA__1815__D Tile_X0Y2_FrameData[4] VPWR VGND sg13cmos5l_antennanp
X_1679_ _1679_/Q Tile_X0Y1_FrameData[20] Tile_X0Y3_FrameStrobe[7] VPWR VGND sg13cmos5l_dlhq_1
XFILLER_131_256 VPWR VGND sg13cmos5l_decap_8
XANTENNA__0886__A0 AXIL_S_SOC_WVALID VPWR VGND sg13cmos5l_antennanp
XFILLER_97_192 VPWR VGND sg13cmos5l_decap_8
XFILLER_45_218 VPWR VGND sg13cmos5l_decap_4
XANTENNA__1550__D Tile_X0Y1_FrameData[21] VPWR VGND sg13cmos5l_antennanp
XFILLER_53_240 VPWR VGND sg13cmos5l_fill_2
XFILLER_198_212 VPWR VGND sg13cmos5l_decap_8
XFILLER_53_284 VPWR VGND sg13cmos5l_fill_2
XANTENNA__0653__A3 Tile_X0Y0_S2END[2] VPWR VGND sg13cmos5l_antennanp
XFILLER_201_216 VPWR VGND sg13cmos5l_decap_8
XFILLER_166_131 VPWR VGND sg13cmos5l_decap_4
XANTENNA__0810__A0 Tile_X0Y0_W1END[1] VPWR VGND sg13cmos5l_antennanp
XFILLER_158_77 VPWR VGND sg13cmos5l_fill_1
XFILLER_166_164 VPWR VGND sg13cmos5l_decap_8
XFILLER_107_220 VPWR VGND sg13cmos5l_decap_8
XFILLER_206_2 VPWR VGND sg13cmos5l_fill_1
XANTENNA__1725__D Tile_X0Y2_FrameData[30] VPWR VGND sg13cmos5l_antennanp
XFILLER_122_256 VPWR VGND sg13cmos5l_fill_1
XANTENNA__1118__A1 Tile_X0Y0_S4END[8] VPWR VGND sg13cmos5l_antennanp
XFILLER_122_278 VPWR VGND sg13cmos5l_decap_8
XANTENNA__0877__A0 AXIL_S_SOC_AWVALID VPWR VGND sg13cmos5l_antennanp
XANTENNA__1490__GATE Tile_X0Y3_FrameStrobe[1] VPWR VGND sg13cmos5l_antennanp
XFILLER_88_170 VPWR VGND sg13cmos5l_decap_8
XFILLER_67_52 VPWR VGND sg13cmos5l_decap_8
XANTENNA__1460__D Tile_X0Y1_FrameData[15] VPWR VGND sg13cmos5l_antennanp
XFILLER_83_62 VPWR VGND sg13cmos5l_decap_8
XFILLER_83_95 VPWR VGND sg13cmos5l_fill_1
XFILLER_44_273 VPWR VGND sg13cmos5l_fill_2
XFILLER_44_262 VPWR VGND sg13cmos5l_fill_1
XFILLER_199_84 VPWR VGND sg13cmos5l_decap_8
X_0981_ _0981_/X Tile_X0Y1_W1END[2] Tile_X0Y1_WW4END[14] _1625_/Q VPWR VGND sg13cmos5l_mux2_1
XFILLER_157_142 VPWR VGND sg13cmos5l_fill_2
X_1602_ _1602_/Q Tile_X0Y1_FrameData[1] Tile_X0Y3_FrameStrobe[4] VPWR VGND sg13cmos5l_dlhq_1
XFILLER_218_14 VPWR VGND sg13cmos5l_decap_8
XFILLER_200_293 VPWR VGND sg13cmos5l_fill_2
XFILLER_172_134 VPWR VGND sg13cmos5l_decap_8
X_2582_ Tile_X0Y3_S2BEG[4] _2582_/A VPWR VGND sg13cmos5l_buf_1
XANTENNA__1443__GATE Tile_X0Y3_FrameStrobe[7] VPWR VGND sg13cmos5l_antennanp
XANTENNA__1635__D Tile_X0Y1_FrameData[0] VPWR VGND sg13cmos5l_antennanp
X_1533_ _1533_/Q Tile_X0Y1_FrameData[6] Tile_X0Y3_FrameStrobe[2] VPWR VGND sg13cmos5l_dlhq_1
X_1464_ _1464_/Q Tile_X0Y1_FrameData[11] Tile_X0Y3_FrameStrobe[0] VPWR VGND sg13cmos5l_dlhq_1
XANTENNA__1109__A1 AXIL_S_SOC_WDATA9 VPWR VGND sg13cmos5l_antennanp
XFILLER_113_267 VPWR VGND sg13cmos5l_decap_4
XFILLER_86_129 VPWR VGND sg13cmos5l_fill_1
XANTENNA__1458__GATE Tile_X0Y3_FrameStrobe[0] VPWR VGND sg13cmos5l_antennanp
X_1395_ _1395_/Q Tile_X0Y0_FrameData[24] Tile_X0Y3_FrameStrobe[6] VPWR VGND sg13cmos5l_dlhq_1
XFILLER_79_192 VPWR VGND sg13cmos5l_fill_2
XANTENNA__1370__D Tile_X0Y0_FrameData[17] VPWR VGND sg13cmos5l_antennanp
X_2016_ _2016_/Q Tile_X0Y3_FrameData[19] Tile_X0Y3_FrameStrobe[2] VPWR VGND sg13cmos5l_dlhq_1
XANTENNA__1012__X AXIL_S_SOC_RDATA26 VPWR VGND sg13cmos5l_antennanp
XFILLER_50_232 VPWR VGND sg13cmos5l_decap_4
XFILLER_50_276 VPWR VGND sg13cmos5l_fill_2
XFILLER_10_129 VPWR VGND sg13cmos5l_decap_8
XFILLER_195_259 VPWR VGND sg13cmos5l_fill_1
XFILLER_163_134 VPWR VGND sg13cmos5l_decap_8
XANTENNA__1545__D Tile_X0Y1_FrameData[26] VPWR VGND sg13cmos5l_antennanp
XFILLER_5_8 VPWR VGND sg13cmos5l_decap_8
XANTENNA__0571__A2 Tile_X0Y3_W6END[10] VPWR VGND sg13cmos5l_antennanp
XFILLER_218_135 VPWR VGND sg13cmos5l_decap_4
XANTENNA__1280__D Tile_X0Y0_FrameData[11] VPWR VGND sg13cmos5l_antennanp
XFILLER_160_12 VPWR VGND sg13cmos5l_fill_2
XFILLER_160_34 VPWR VGND sg13cmos5l_fill_1
XFILLER_218_168 VPWR VGND sg13cmos5l_decap_8
XFILLER_160_45 VPWR VGND sg13cmos5l_fill_2
XFILLER_160_56 VPWR VGND sg13cmos5l_decap_8
XFILLER_53_43 VPWR VGND sg13cmos5l_fill_2
XANTENNA__1036__A0 AXIL_S_SOC_WDATA23 VPWR VGND sg13cmos5l_antennanp
XFILLER_139_175 VPWR VGND sg13cmos5l_fill_1
XFILLER_211_0 VPWR VGND sg13cmos5l_decap_8
XFILLER_194_292 VPWR VGND sg13cmos5l_fill_2
XFILLER_185_53 VPWR VGND sg13cmos5l_fill_2
XFILLER_185_42 VPWR VGND sg13cmos5l_decap_8
XANTENNA__1455__D Tile_X0Y1_FrameData[20] VPWR VGND sg13cmos5l_antennanp
XANTENNA__2173__GATE Tile_X0Y3_FrameStrobe[7] VPWR VGND sg13cmos5l_antennanp
XFILLER_154_178 VPWR VGND sg13cmos5l_decap_8
XFILLER_204_16 VPWR VGND sg13cmos5l_fill_2
XANTENNA__2188__GATE Tile_X0Y3_FrameStrobe[0] VPWR VGND sg13cmos5l_antennanp
X_1180_ AXIL_S_SOC_RDATA10 Tile_X0Y2_W2MID[2] Tile_X0Y2_W2END[2] Tile_X0Y2_W6END[2]
+ _0725_/X _1767_/Q _1766_/Q VPWR VGND sg13cmos5l_mux4_1
XFILLER_94_72 VPWR VGND sg13cmos5l_fill_2
XFILLER_76_162 VPWR VGND sg13cmos5l_decap_4
XANTENNA__0865__A3 Tile_X0Y0_S2MID[5] VPWR VGND sg13cmos5l_antennanp
XANTENNA__2111__GATE Tile_X0Y3_FrameStrobe[5] VPWR VGND sg13cmos5l_antennanp
XFILLER_91_198 VPWR VGND sg13cmos5l_decap_8
XFILLER_32_210 VPWR VGND sg13cmos5l_decap_8
XFILLER_177_204 VPWR VGND sg13cmos5l_fill_1
XANTENNA__1027__A0 Tile_X0Y3_N4END[8] VPWR VGND sg13cmos5l_antennanp
XANTENNA__2126__GATE Tile_X0Y3_FrameStrobe[5] VPWR VGND sg13cmos5l_antennanp
X_0964_ _2195_/A _0870_/X _0521_/X AXIL_S_SOC_WDATA18 AXIL_S_SOC_WDATA23 _1619_/Q
+ _1618_/Q VPWR VGND sg13cmos5l_mux4_1
X_0895_ AXIL_S_SOC_RRESP1 Tile_X0Y0_W2MID[5] Tile_X0Y0_W2END[5] Tile_X0Y0_W6END[5]
+ _0736_/X _1265_/Q _1264_/Q VPWR VGND sg13cmos5l_mux4_1
XANTENNA__1382__GATE Tile_X0Y3_FrameStrobe[5] VPWR VGND sg13cmos5l_antennanp
XANTENNA__1365__D Tile_X0Y0_FrameData[22] VPWR VGND sg13cmos5l_antennanp
XANTENNA__2598__X Tile_X0Y3_S4BEG[4] VPWR VGND sg13cmos5l_antennanp
XFILLER_160_126 VPWR VGND sg13cmos5l_fill_1
X_2565_ Tile_X0Y3_FrameData_O[23] Tile_X0Y3_FrameData[23] VPWR VGND sg13cmos5l_buf_1
XFILLER_57_0 VPWR VGND sg13cmos5l_fill_1
X_1516_ _1516_/Q Tile_X0Y1_FrameData[23] Tile_X0Y3_FrameStrobe[2] VPWR VGND sg13cmos5l_dlhq_1
XANTENNA__1397__GATE Tile_X0Y3_FrameStrobe[6] VPWR VGND sg13cmos5l_antennanp
X_2496_ Tile_X0Y3_E1BEG[2] _2496_/A VPWR VGND sg13cmos5l_buf_1
XANTENNA__1007__X AXIL_S_SOC_RDATA22 VPWR VGND sg13cmos5l_antennanp
XFILLER_101_215 VPWR VGND sg13cmos5l_decap_8
XFILLER_114_16 VPWR VGND sg13cmos5l_fill_2
X_1447_ _1447_/Q Tile_X0Y1_FrameData[28] Tile_X0Y3_FrameStrobe[0] VPWR VGND sg13cmos5l_dlhq_1
X_1378_ _1378_/Q Tile_X0Y0_FrameData[9] Tile_X0Y3_FrameStrobe[5] VPWR VGND sg13cmos5l_dlhq_1
XANTENNA__1320__GATE Tile_X0Y3_FrameStrobe[3] VPWR VGND sg13cmos5l_antennanp
XFILLER_67_173 VPWR VGND sg13cmos5l_fill_1
XANTENNA__1950__GATE Tile_X0Y3_FrameStrobe[0] VPWR VGND sg13cmos5l_antennanp
XFILLER_215_105 VPWR VGND sg13cmos5l_fill_1
XANTENNA__1335__GATE Tile_X0Y3_FrameStrobe[4] VPWR VGND sg13cmos5l_antennanp
XFILLER_223_182 VPWR VGND sg13cmos5l_decap_8
XANTENNA__1018__A0 AXIL_S_SOC_WDATA17 VPWR VGND sg13cmos5l_antennanp
XANTENNA__1965__GATE Tile_X0Y3_FrameStrobe[0] VPWR VGND sg13cmos5l_antennanp
XFILLER_176_281 VPWR VGND sg13cmos5l_fill_1
XANTENNA__1275__D Tile_X0Y0_FrameData[16] VPWR VGND sg13cmos5l_antennanp
XFILLER_136_178 VPWR VGND sg13cmos5l_decap_8
XANTENNA__2301__X Tile_X0Y2_E6BEG[5] VPWR VGND sg13cmos5l_antennanp
XANTENNA__1903__GATE Tile_X0Y3_FrameStrobe[6] VPWR VGND sg13cmos5l_antennanp
XFILLER_58_140 VPWR VGND sg13cmos5l_fill_1
XFILLER_58_162 VPWR VGND sg13cmos5l_fill_2
XFILLER_171_77 VPWR VGND sg13cmos5l_fill_2
XFILLER_171_66 VPWR VGND sg13cmos5l_decap_8
XANTENNA__1918__GATE Tile_X0Y3_FrameStrobe[7] VPWR VGND sg13cmos5l_antennanp
XFILLER_0_39 VPWR VGND sg13cmos5l_decap_8
XFILLER_104_93 VPWR VGND sg13cmos5l_decap_8
XFILLER_161_0 VPWR VGND sg13cmos5l_fill_2
XFILLER_73_176 VPWR VGND sg13cmos5l_fill_2
XFILLER_159_215 VPWR VGND sg13cmos5l_fill_1
XFILLER_159_226 VPWR VGND sg13cmos5l_fill_2
XFILLER_9_26 VPWR VGND sg13cmos5l_decap_8
XANTENNA__0480__A1 Tile_X0Y3_N4END[2] VPWR VGND sg13cmos5l_antennanp
XANTENNA__1009__A0 Tile_X0Y1_W1END[2] VPWR VGND sg13cmos5l_antennanp
XFILLER_159_259 VPWR VGND sg13cmos5l_fill_2
XFILLER_127_123 VPWR VGND sg13cmos5l_decap_8
X_0680_ _2533_/A AXIL_S_SOC_ARADDR2 AXIL_S_SOC_ARADDR6 _0604_/X _0580_/A _2061_/Q
+ _2060_/Q VPWR VGND sg13cmos5l_mux4_1
XFILLER_182_251 VPWR VGND sg13cmos5l_decap_8
XFILLER_89_61 VPWR VGND sg13cmos5l_decap_4
XFILLER_50_7 VPWR VGND sg13cmos5l_decap_8
XANTENNA__2211__X Tile_X0Y1_E2BEGb[4] VPWR VGND sg13cmos5l_antennanp
X_2350_ Tile_X0Y2_FrameData_O[26] Tile_X0Y2_FrameData[26] VPWR VGND sg13cmos5l_buf_1
XANTENNA__1913__D Tile_X0Y2_FrameData[2] VPWR VGND sg13cmos5l_antennanp
XFILLER_150_170 VPWR VGND sg13cmos5l_decap_8
X_1301_ _1301_/Q Tile_X0Y0_FrameData[22] Tile_X0Y3_FrameStrobe[3] VPWR VGND sg13cmos5l_dlhq_1
X_2281_ Tile_X0Y2_E2BEG[1] _2281_/A VPWR VGND sg13cmos5l_buf_1
XFILLER_215_59 VPWR VGND sg13cmos5l_decap_8
X_1232_ _1232_/Q Tile_X0Y0_FrameData[27] Tile_X0Y3_FrameStrobe[1] VPWR VGND sg13cmos5l_dlhq_1
XANTENNA__2050__GATE Tile_X0Y3_FrameStrobe[3] VPWR VGND sg13cmos5l_antennanp
X_1163_ _1163_/Y _1906_/Q _1097_/Y _1905_/Q VPWR VGND sg13cmos5l_a21oi_1
XFILLER_64_143 VPWR VGND sg13cmos5l_decap_8
XFILLER_64_132 VPWR VGND sg13cmos5l_decap_8
XFILLER_49_195 VPWR VGND sg13cmos5l_decap_8
X_1094_ _2290_/A AXIL_S_SOC_WDATA2 AXIL_S_SOC_WDATA10 _0725_/X _0732_/X _1839_/Q _1838_/Q
+ VPWR VGND sg13cmos5l_mux4_1
XFILLER_205_160 VPWR VGND sg13cmos5l_decap_8
XANTENNA__2065__GATE Tile_X0Y3_FrameStrobe[3] VPWR VGND sg13cmos5l_antennanp
XFILLER_100_29 VPWR VGND sg13cmos5l_decap_4
XFILLER_20_202 VPWR VGND sg13cmos5l_fill_2
X_1996_ _1996_/Q Tile_X0Y3_FrameData[7] Tile_X0Y3_FrameStrobe[1] VPWR VGND sg13cmos5l_dlhq_1
XFILLER_20_257 VPWR VGND sg13cmos5l_fill_2
X_0947_ _0947_/Y _0947_/A VPWR VGND sg13cmos5l_inv_1
XFILLER_109_16 VPWR VGND sg13cmos5l_decap_4
X_0878_ _2466_/A AXIL_S_SOC_WSTRB3 _0796_/X _0801_/X _0643_/X _1290_/Q _1291_/Q VPWR
+ VGND sg13cmos5l_mux4_1
XFILLER_173_262 VPWR VGND sg13cmos5l_decap_8
XFILLER_133_137 VPWR VGND sg13cmos5l_decap_8
XANTENNA__2003__GATE Tile_X0Y3_FrameStrobe[1] VPWR VGND sg13cmos5l_antennanp
X_2548_ Tile_X0Y3_FrameData_O[6] Tile_X0Y3_FrameData[6] VPWR VGND sg13cmos5l_buf_1
XANTENNA__1823__D Tile_X0Y2_FrameData[28] VPWR VGND sg13cmos5l_antennanp
XFILLER_141_170 VPWR VGND sg13cmos5l_fill_1
X_2479_ Tile_X0Y0_E2BEGb[5] _2479_/A VPWR VGND sg13cmos5l_buf_1
XFILLER_85_19 VPWR VGND sg13cmos5l_decap_8
XANTENNA__2018__GATE Tile_X0Y3_FrameStrobe[2] VPWR VGND sg13cmos5l_antennanp
XANTENNA__1274__GATE Tile_X0Y3_FrameStrobe[2] VPWR VGND sg13cmos5l_antennanp
XFILLER_55_198 VPWR VGND sg13cmos5l_fill_2
XFILLER_211_130 VPWR VGND sg13cmos5l_decap_8
XANTENNA__0462__A1 Tile_X0Y3_N4END[14] VPWR VGND sg13cmos5l_antennanp
XFILLER_133_4 VPWR VGND sg13cmos5l_fill_2
XFILLER_156_207 VPWR VGND sg13cmos5l_decap_8
XFILLER_211_163 VPWR VGND sg13cmos5l_decap_8
XANTENNA__1289__GATE Tile_X0Y3_FrameStrobe[2] VPWR VGND sg13cmos5l_antennanp
XFILLER_164_240 VPWR VGND sg13cmos5l_decap_4
XFILLER_50_55 VPWR VGND sg13cmos5l_fill_1
XFILLER_50_44 VPWR VGND sg13cmos5l_fill_1
XANTENNA__1212__GATE Tile_X0Y3_FrameStrobe[0] VPWR VGND sg13cmos5l_antennanp
XANTENNA__1842__GATE Tile_X0Y3_FrameStrobe[4] VPWR VGND sg13cmos5l_antennanp
XANTENNA__1733__D Tile_X0Y2_FrameData[22] VPWR VGND sg13cmos5l_antennanp
XFILLER_132_170 VPWR VGND sg13cmos5l_decap_4
XANTENNA__1227__GATE Tile_X0Y3_FrameStrobe[0] VPWR VGND sg13cmos5l_antennanp
XFILLER_132_192 VPWR VGND sg13cmos5l_decap_8
XFILLER_78_246 VPWR VGND sg13cmos5l_fill_2
XFILLER_182_87 VPWR VGND sg13cmos5l_decap_8
XANTENNA__1857__GATE Tile_X0Y3_FrameStrobe[5] VPWR VGND sg13cmos5l_antennanp
XFILLER_219_241 VPWR VGND sg13cmos5l_decap_8
XFILLER_75_85 VPWR VGND sg13cmos5l_fill_2
XFILLER_61_135 VPWR VGND sg13cmos5l_decap_8
XFILLER_61_113 VPWR VGND sg13cmos5l_fill_1
XFILLER_201_17 VPWR VGND sg13cmos5l_fill_1
XFILLER_91_73 VPWR VGND sg13cmos5l_fill_2
XFILLER_199_181 VPWR VGND sg13cmos5l_fill_1
XANTENNA__2206__X Tile_X0Y1_E2BEG[7] VPWR VGND sg13cmos5l_antennanp
X_1850_ _1850_/Q Tile_X0Y2_FrameData[1] Tile_X0Y3_FrameStrobe[4] VPWR VGND sg13cmos5l_dlhq_1
X_1781_ _1781_/Q Tile_X0Y2_FrameData[6] Tile_X0Y3_FrameStrobe[2] VPWR VGND sg13cmos5l_dlhq_1
X_0801_ _0801_/X _0771_/X Tile_X0Y0_S1END[3] Tile_X0Y3_N4END[15] Tile_X0Y0_S4END[3]
+ _1236_/Q _1237_/Q VPWR VGND sg13cmos5l_mux4_1
XANTENNA__1908__D Tile_X0Y2_FrameData[7] VPWR VGND sg13cmos5l_antennanp
XANTENNA__0756__A2 Tile_X0Y0_W2MID[0] VPWR VGND sg13cmos5l_antennanp
X_0732_ _0732_/X _0731_/X _0593_/X Tile_X0Y3_N2MID[5] _0730_/X _1704_/Q _1705_/Q VPWR
+ VGND sg13cmos5l_mux4_1
XFILLER_115_126 VPWR VGND sg13cmos5l_decap_8
XFILLER_170_243 VPWR VGND sg13cmos5l_decap_8
X_0663_ _2504_/A AXIL_S_SOC_ARADDR1 AXIL_S_SOC_ARADDR9 _0584_/X _0598_/X _2095_/Q
+ _2094_/Q VPWR VGND sg13cmos5l_mux4_1
XFILLER_170_276 VPWR VGND sg13cmos5l_fill_2
X_2402_ Tile_X0Y0_FrameStrobe_O[8] Tile_X0Y3_FrameStrobe[8] VPWR VGND sg13cmos5l_buf_1
X_0594_ _0594_/X Tile_X0Y3_N2MID[5] Tile_X0Y3_N2END[5] _2591_/A _0593_/X _1953_/Q
+ _1952_/Q VPWR VGND sg13cmos5l_mux4_1
XANTENNA__1643__D Tile_X0Y1_FrameData[24] VPWR VGND sg13cmos5l_antennanp
X_2333_ Tile_X0Y2_FrameData_O[9] Tile_X0Y2_FrameData[9] VPWR VGND sg13cmos5l_buf_1
XANTENNA__1181__A2 Tile_X0Y2_W6END[1] VPWR VGND sg13cmos5l_antennanp
X_2264_ Tile_X0Y1_FrameData_O[21] Tile_X0Y1_FrameData[21] VPWR VGND sg13cmos5l_buf_1
X_1215_ _1215_/Q Tile_X0Y0_FrameData[12] Tile_X0Y3_FrameStrobe[0] VPWR VGND sg13cmos5l_dlhq_1
X_2195_ Tile_X0Y1_E1BEG[0] _2195_/A VPWR VGND sg13cmos5l_buf_1
X_1146_ _1146_/Y _1146_/A VPWR VGND sg13cmos5l_inv_1
XANTENNA__0692__A1 Tile_X0Y0_S4END[15] VPWR VGND sg13cmos5l_antennanp
XFILLER_92_293 VPWR VGND sg13cmos5l_fill_2
X_1077_ _2289_/A AXIL_S_SOC_WDATA1 AXIL_S_SOC_WDATA9 _0715_/X _0729_/X _1841_/Q _1840_/Q
+ VPWR VGND sg13cmos5l_mux4_1
XFILLER_52_157 VPWR VGND sg13cmos5l_decap_4
XFILLER_138_218 VPWR VGND sg13cmos5l_fill_1
XANTENNA__1818__D Tile_X0Y2_FrameData[1] VPWR VGND sg13cmos5l_antennanp
X_1979_ _1979_/Q Tile_X0Y3_FrameData[24] Tile_X0Y3_FrameStrobe[1] VPWR VGND sg13cmos5l_dlhq_1
XANTENNA__0747__A2 Tile_X0Y0_W6END[1] VPWR VGND sg13cmos5l_antennanp
XFILLER_105_8 VPWR VGND sg13cmos5l_fill_2
XFILLER_106_148 VPWR VGND sg13cmos5l_decap_8
XFILLER_161_232 VPWR VGND sg13cmos5l_decap_8
XFILLER_20_36 VPWR VGND sg13cmos5l_decap_8
XFILLER_161_265 VPWR VGND sg13cmos5l_decap_4
XANTENNA__1172__A2 Tile_X0Y2_W6END[7] VPWR VGND sg13cmos5l_antennanp
XANTENNA__1553__D Tile_X0Y1_FrameData[18] VPWR VGND sg13cmos5l_antennanp
XFILLER_152_13 VPWR VGND sg13cmos5l_fill_1
XFILLER_29_56 VPWR VGND sg13cmos5l_decap_8
XFILLER_28_110 VPWR VGND sg13cmos5l_decap_8
XFILLER_28_165 VPWR VGND sg13cmos5l_decap_8
XANTENNA__0683__A1 AXIL_S_SOC_ARADDR5 VPWR VGND sg13cmos5l_antennanp
XFILLER_83_293 VPWR VGND sg13cmos5l_fill_2
XFILLER_83_271 VPWR VGND sg13cmos5l_fill_2
XFILLER_28_176 VPWR VGND sg13cmos5l_fill_2
XFILLER_61_32 VPWR VGND sg13cmos5l_fill_1
XFILLER_61_21 VPWR VGND sg13cmos5l_fill_2
XFILLER_61_10 VPWR VGND sg13cmos5l_fill_1
XFILLER_196_162 VPWR VGND sg13cmos5l_decap_8
XANTENNA__1728__D Tile_X0Y2_FrameData[27] VPWR VGND sg13cmos5l_antennanp
XFILLER_124_0 VPWR VGND sg13cmos5l_fill_2
XANTENNA_9 AXIL_S_SOC_AWADDR3 VPWR VGND sg13cmos5l_antennanp
XANTENNA__0738__A2 Tile_X0Y1_W6END[3] VPWR VGND sg13cmos5l_antennanp
XANTENNA__1781__GATE Tile_X0Y3_FrameStrobe[2] VPWR VGND sg13cmos5l_antennanp
XFILLER_152_243 VPWR VGND sg13cmos5l_fill_1
XFILLER_152_265 VPWR VGND sg13cmos5l_decap_4
XFILLER_112_129 VPWR VGND sg13cmos5l_decap_8
XFILLER_3_286 VPWR VGND sg13cmos5l_fill_1
XANTENNA__1463__D Tile_X0Y1_FrameData[12] VPWR VGND sg13cmos5l_antennanp
XANTENNA__1796__GATE Tile_X0Y3_FrameStrobe[3] VPWR VGND sg13cmos5l_antennanp
X_1000_ _2221_/A AXIL_S_SOC_WDATA22 _0925_/X _0926_/X _0867_/X _1534_/Q _1535_/Q VPWR
+ VGND sg13cmos5l_mux4_1
XFILLER_81_219 VPWR VGND sg13cmos5l_decap_8
XFILLER_212_16 VPWR VGND sg13cmos5l_fill_2
XFILLER_207_233 VPWR VGND sg13cmos5l_decap_4
XFILLER_74_282 VPWR VGND sg13cmos5l_fill_1
XFILLER_19_176 VPWR VGND sg13cmos5l_fill_1
XFILLER_222_269 VPWR VGND sg13cmos5l_decap_4
XANTENNA__1734__GATE Tile_X0Y3_FrameStrobe[1] VPWR VGND sg13cmos5l_antennanp
X_1902_ _1902_/Q Tile_X0Y2_FrameData[13] Tile_X0Y3_FrameStrobe[6] VPWR VGND sg13cmos5l_dlhq_1
XANTENNA__1638__D Tile_X0Y1_FrameData[29] VPWR VGND sg13cmos5l_antennanp
X_1833_ _1833_/Q Tile_X0Y2_FrameData[18] Tile_X0Y3_FrameStrobe[4] VPWR VGND sg13cmos5l_dlhq_1
XANTENNA__0729__A2 Tile_X0Y3_N2MID[6] VPWR VGND sg13cmos5l_antennanp
XANTENNA__1749__GATE Tile_X0Y3_FrameStrobe[1] VPWR VGND sg13cmos5l_antennanp
X_1764_ _1764_/Q Tile_X0Y2_FrameData[23] Tile_X0Y3_FrameStrobe[2] VPWR VGND sg13cmos5l_dlhq_1
XFILLER_143_210 VPWR VGND sg13cmos5l_fill_2
X_0715_ _0715_/X _0714_/X _0582_/X Tile_X0Y3_N2MID[1] _0713_/X _1712_/Q _1713_/Q VPWR
+ VGND sg13cmos5l_mux4_1
X_1695_ _1695_/Q Tile_X0Y2_FrameData[28] Tile_X0Y3_FrameStrobe[0] VPWR VGND sg13cmos5l_dlhq_1
XFILLER_103_118 VPWR VGND sg13cmos5l_decap_8
XFILLER_106_17 VPWR VGND sg13cmos5l_decap_8
X_0646_ _0646_/X _2375_/A _0645_/X Tile_X0Y0_S2MID[1] Tile_X0Y0_S2END[1] _1217_/Q
+ _1216_/Q VPWR VGND sg13cmos5l_mux4_1
XANTENNA__1373__D Tile_X0Y0_FrameData[14] VPWR VGND sg13cmos5l_antennanp
XFILLER_106_28 VPWR VGND sg13cmos5l_fill_1
XFILLER_106_39 VPWR VGND sg13cmos5l_fill_2
X_0577_ _0577_/X Tile_X0Y1_W2MID[7] Tile_X0Y1_W2END[7] Tile_X0Y1_W6END[8] _0859_/X
+ _1647_/Q _1646_/Q VPWR VGND sg13cmos5l_mux4_1
XFILLER_111_140 VPWR VGND sg13cmos5l_fill_1
X_2316_ Tile_X0Y2_EE4BEG[8] _2316_/A VPWR VGND sg13cmos5l_buf_1
XFILLER_57_205 VPWR VGND sg13cmos5l_fill_2
X_2247_ Tile_X0Y1_FrameData_O[4] Tile_X0Y1_FrameData[4] VPWR VGND sg13cmos5l_buf_1
XFILLER_57_227 VPWR VGND sg13cmos5l_decap_8
XANTENNA__1015__X AXIL_S_SOC_RDATA29 VPWR VGND sg13cmos5l_antennanp
XFILLER_122_27 VPWR VGND sg13cmos5l_fill_1
X_2178_ _2178_/Q Tile_X0Y3_FrameData[17] Tile_X0Y3_FrameStrobe[7] VPWR VGND sg13cmos5l_dlhq_1
X_1129_ _1129_/Y Tile_X0Y2_W6END[4] _1879_/Q _1878_/Q VPWR VGND sg13cmos5l_o21ai_1
XFILLER_80_285 VPWR VGND sg13cmos5l_fill_2
XANTENNA__1090__A1 AXIL_S_SOC_WDATA14 VPWR VGND sg13cmos5l_antennanp
XFILLER_221_280 VPWR VGND sg13cmos5l_fill_1
XFILLER_178_162 VPWR VGND sg13cmos5l_decap_4
XANTENNA__1548__D Tile_X0Y1_FrameData[23] VPWR VGND sg13cmos5l_antennanp
XFILLER_147_35 VPWR VGND sg13cmos5l_fill_2
XFILLER_134_232 VPWR VGND sg13cmos5l_decap_8
XFILLER_147_57 VPWR VGND sg13cmos5l_decap_8
XFILLER_193_198 VPWR VGND sg13cmos5l_decap_8
XFILLER_0_201 VPWR VGND sg13cmos5l_decap_8
XANTENNA__1283__D Tile_X0Y0_FrameData[8] VPWR VGND sg13cmos5l_antennanp
XFILLER_0_223 VPWR VGND sg13cmos5l_decap_8
XFILLER_112_60 VPWR VGND sg13cmos5l_fill_1
XFILLER_112_71 VPWR VGND sg13cmos5l_fill_2
XFILLER_72_20 VPWR VGND sg13cmos5l_decap_8
XFILLER_169_140 VPWR VGND sg13cmos5l_decap_4
XFILLER_24_190 VPWR VGND sg13cmos5l_decap_4
XFILLER_72_97 VPWR VGND sg13cmos5l_decap_8
XFILLER_184_110 VPWR VGND sg13cmos5l_decap_4
XANTENNA__1081__A1 AXIL_S_SOC_WDATA11 VPWR VGND sg13cmos5l_antennanp
XANTENNA__1458__D Tile_X0Y1_FrameData[17] VPWR VGND sg13cmos5l_antennanp
XFILLER_184_132 VPWR VGND sg13cmos5l_decap_4
XFILLER_68_8 VPWR VGND sg13cmos5l_decap_8
X_0500_ _0500_/X _0937_/X _0501_/B Tile_X0Y3_N4END[7] Tile_X0Y0_S4END[11] _1716_/Q
+ _1717_/Q VPWR VGND sg13cmos5l_mux4_1
XANTENNA__0592__A0 Tile_X0Y2_W1END[1] VPWR VGND sg13cmos5l_antennanp
X_1480_ _1480_/Q Tile_X0Y1_FrameData[27] Tile_X0Y3_FrameStrobe[1] VPWR VGND sg13cmos5l_dlhq_1
X_0431_ _0431_/Y Tile_X0Y0_S1END[0] VPWR VGND sg13cmos5l_inv_1
XANTENNA__1136__A2 Tile_X0Y2_W6END[6] VPWR VGND sg13cmos5l_antennanp
XANTENNA__0895__A1 Tile_X0Y0_W2END[5] VPWR VGND sg13cmos5l_antennanp
X_2101_ _2101_/Q Tile_X0Y3_FrameData[30] Tile_X0Y3_FrameStrobe[5] VPWR VGND sg13cmos5l_dlhq_1
XFILLER_39_249 VPWR VGND sg13cmos5l_fill_2
XANTENNA__1921__D Tile_X0Y2_FrameData[26] VPWR VGND sg13cmos5l_antennanp
X_2032_ _2032_/Q Tile_X0Y3_FrameData[3] Tile_X0Y3_FrameStrobe[2] VPWR VGND sg13cmos5l_dlhq_1
XANTENNA__0647__A1 Tile_X0Y0_W2END[0] VPWR VGND sg13cmos5l_antennanp
XANTENNA__1673__GATE Tile_X0Y3_FrameStrobe[7] VPWR VGND sg13cmos5l_antennanp
XFILLER_87_0 VPWR VGND sg13cmos5l_fill_2
XFILLER_210_228 VPWR VGND sg13cmos5l_fill_1
XANTENNA__1368__D Tile_X0Y0_FrameData[19] VPWR VGND sg13cmos5l_antennanp
XANTENNA__1688__GATE Tile_X0Y3_FrameStrobe[7] VPWR VGND sg13cmos5l_antennanp
X_1816_ _1816_/Q Tile_X0Y2_FrameData[3] Tile_X0Y3_FrameStrobe[3] VPWR VGND sg13cmos5l_dlhq_1
XFILLER_175_187 VPWR VGND sg13cmos5l_fill_1
X_1747_ _1747_/Q Tile_X0Y2_FrameData[8] Tile_X0Y3_FrameStrobe[1] VPWR VGND sg13cmos5l_dlhq_1
XFILLER_190_179 VPWR VGND sg13cmos5l_fill_1
XANTENNA__0583__A0 Tile_X0Y2_W2MID[6] VPWR VGND sg13cmos5l_antennanp
XANTENNA__1611__GATE Tile_X0Y3_FrameStrobe[5] VPWR VGND sg13cmos5l_antennanp
X_1678_ _1678_/Q Tile_X0Y1_FrameData[21] Tile_X0Y3_FrameStrobe[7] VPWR VGND sg13cmos5l_dlhq_1
XFILLER_131_235 VPWR VGND sg13cmos5l_decap_8
X_0629_ _0629_/Y _2019_/Q _0580_/Y _0628_/Y VPWR VGND sg13cmos5l_a21oi_1
XFILLER_131_279 VPWR VGND sg13cmos5l_fill_1
XANTENNA__0886__A1 AXIL_S_SOC_AWADDR6 VPWR VGND sg13cmos5l_antennanp
XANTENNA__1626__GATE Tile_X0Y3_FrameStrobe[5] VPWR VGND sg13cmos5l_antennanp
XFILLER_97_171 VPWR VGND sg13cmos5l_decap_8
XANTENNA__1831__D Tile_X0Y2_FrameData[20] VPWR VGND sg13cmos5l_antennanp
XFILLER_38_282 VPWR VGND sg13cmos5l_fill_2
XFILLER_38_271 VPWR VGND sg13cmos5l_decap_4
XFILLER_172_8 VPWR VGND sg13cmos5l_decap_8
XANTENNA__1278__D Tile_X0Y0_FrameData[13] VPWR VGND sg13cmos5l_antennanp
XFILLER_158_45 VPWR VGND sg13cmos5l_fill_2
XANTENNA__2304__X Tile_X0Y2_E6BEG[8] VPWR VGND sg13cmos5l_antennanp
XFILLER_42_89 VPWR VGND sg13cmos5l_decap_8
XFILLER_181_113 VPWR VGND sg13cmos5l_decap_8
XFILLER_122_213 VPWR VGND sg13cmos5l_decap_8
XFILLER_122_224 VPWR VGND sg13cmos5l_fill_1
XFILLER_191_0 VPWR VGND sg13cmos5l_fill_2
XANTENNA__1741__D Tile_X0Y2_FrameData[14] VPWR VGND sg13cmos5l_antennanp
XFILLER_130_290 VPWR VGND sg13cmos5l_decap_4
XFILLER_67_97 VPWR VGND sg13cmos5l_fill_2
XFILLER_123_81 VPWR VGND sg13cmos5l_decap_8
XFILLER_44_241 VPWR VGND sg13cmos5l_decap_8
XFILLER_44_252 VPWR VGND sg13cmos5l_fill_2
XFILLER_199_52 VPWR VGND sg13cmos5l_decap_8
XFILLER_189_213 VPWR VGND sg13cmos5l_fill_2
XFILLER_189_257 VPWR VGND sg13cmos5l_fill_2
X_0980_ _0980_/Y _0977_/S _0929_/X _0979_/Y VPWR VGND sg13cmos5l_o21ai_1
XFILLER_8_120 VPWR VGND sg13cmos5l_fill_1
XANTENNA__0801__A1 Tile_X0Y0_S1END[3] VPWR VGND sg13cmos5l_antennanp
XANTENNA__2214__X Tile_X0Y1_E2BEGb[7] VPWR VGND sg13cmos5l_antennanp
XFILLER_12_182 VPWR VGND sg13cmos5l_decap_8
X_1601_ _1601_/Q Tile_X0Y1_FrameData[2] Tile_X0Y3_FrameStrobe[4] VPWR VGND sg13cmos5l_dlhq_1
XFILLER_218_37 VPWR VGND sg13cmos5l_fill_2
XFILLER_172_113 VPWR VGND sg13cmos5l_decap_8
XANTENNA__1916__D Tile_X0Y2_FrameData[31] VPWR VGND sg13cmos5l_antennanp
X_2581_ Tile_X0Y3_S2BEG[3] _2581_/A VPWR VGND sg13cmos5l_buf_1
XFILLER_113_213 VPWR VGND sg13cmos5l_decap_8
X_1532_ _1532_/Q Tile_X0Y1_FrameData[7] Tile_X0Y3_FrameStrobe[2] VPWR VGND sg13cmos5l_dlhq_1
XFILLER_113_224 VPWR VGND sg13cmos5l_fill_2
X_1463_ _1463_/Q Tile_X0Y1_FrameData[12] Tile_X0Y3_FrameStrobe[0] VPWR VGND sg13cmos5l_dlhq_1
X_1394_ _1394_/Q Tile_X0Y0_FrameData[25] Tile_X0Y3_FrameStrobe[6] VPWR VGND sg13cmos5l_dlhq_1
XANTENNA__1651__D Tile_X0Y1_FrameData[16] VPWR VGND sg13cmos5l_antennanp
XFILLER_121_290 VPWR VGND sg13cmos5l_decap_4
X_2015_ _2015_/Q Tile_X0Y3_FrameData[20] Tile_X0Y3_FrameStrobe[2] VPWR VGND sg13cmos5l_dlhq_1
XFILLER_50_222 VPWR VGND sg13cmos5l_decap_8
XFILLER_10_108 VPWR VGND sg13cmos5l_decap_8
XFILLER_12_15 VPWR VGND sg13cmos5l_fill_1
XFILLER_128_15 VPWR VGND sg13cmos5l_fill_2
XFILLER_163_102 VPWR VGND sg13cmos5l_decap_8
XFILLER_163_113 VPWR VGND sg13cmos5l_fill_2
XANTENNA__1550__GATE Tile_X0Y3_FrameStrobe[3] VPWR VGND sg13cmos5l_antennanp
XANTENNA__1826__D Tile_X0Y2_FrameData[25] VPWR VGND sg13cmos5l_antennanp
XFILLER_128_59 VPWR VGND sg13cmos5l_decap_8
XFILLER_104_235 VPWR VGND sg13cmos5l_decap_8
XANTENNA__1565__GATE Tile_X0Y3_FrameStrobe[3] VPWR VGND sg13cmos5l_antennanp
XANTENNA__1561__D Tile_X0Y1_FrameData[10] VPWR VGND sg13cmos5l_antennanp
XFILLER_85_141 VPWR VGND sg13cmos5l_decap_8
XFILLER_37_45 VPWR VGND sg13cmos5l_fill_1
XFILLER_218_147 VPWR VGND sg13cmos5l_fill_1
XFILLER_18_208 VPWR VGND sg13cmos5l_decap_8
XFILLER_85_196 VPWR VGND sg13cmos5l_decap_4
XFILLER_37_89 VPWR VGND sg13cmos5l_fill_2
XFILLER_37_78 VPWR VGND sg13cmos5l_decap_8
XFILLER_163_4 VPWR VGND sg13cmos5l_fill_1
XANTENNA__1503__GATE Tile_X0Y3_FrameStrobe[1] VPWR VGND sg13cmos5l_antennanp
XFILLER_169_22 VPWR VGND sg13cmos5l_fill_2
XFILLER_53_88 VPWR VGND sg13cmos5l_fill_1
XANTENNA__1036__A1 AXIL_S_SOC_WDATA31 VPWR VGND sg13cmos5l_antennanp
XFILLER_186_238 VPWR VGND sg13cmos5l_fill_1
XFILLER_139_143 VPWR VGND sg13cmos5l_decap_8
XANTENNA__1518__GATE Tile_X0Y3_FrameStrobe[2] VPWR VGND sg13cmos5l_antennanp
XANTENNA__1736__D Tile_X0Y2_FrameData[19] VPWR VGND sg13cmos5l_antennanp
XFILLER_154_157 VPWR VGND sg13cmos5l_decap_4
XFILLER_204_0 VPWR VGND sg13cmos5l_fill_1
XFILLER_78_96 VPWR VGND sg13cmos5l_decap_8
XANTENNA__1471__D Tile_X0Y1_FrameData[4] VPWR VGND sg13cmos5l_antennanp
XFILLER_76_130 VPWR VGND sg13cmos5l_decap_8
XFILLER_209_114 VPWR VGND sg13cmos5l_fill_1
XANTENNA__2209__X Tile_X0Y1_E2BEGb[2] VPWR VGND sg13cmos5l_antennanp
XFILLER_91_177 VPWR VGND sg13cmos5l_decap_8
XFILLER_32_200 VPWR VGND sg13cmos5l_fill_1
XFILLER_220_49 VPWR VGND sg13cmos5l_fill_1
X_0963_ _2196_/A _0871_/X _0546_/X AXIL_S_SOC_WDATA19 AXIL_S_SOC_WDATA22 _1617_/Q
+ _1616_/Q VPWR VGND sg13cmos5l_mux4_1
XFILLER_145_102 VPWR VGND sg13cmos5l_fill_2
X_0894_ AXIL_S_SOC_ARREADY Tile_X0Y0_W2MID[6] Tile_X0Y0_W2END[6] Tile_X0Y0_W6END[6]
+ _0751_/X _1263_/Q _1262_/Q VPWR VGND sg13cmos5l_mux4_1
XANTENNA__1646__D Tile_X0Y1_FrameData[21] VPWR VGND sg13cmos5l_antennanp
XFILLER_145_157 VPWR VGND sg13cmos5l_decap_8
X_2564_ Tile_X0Y3_FrameData_O[22] Tile_X0Y3_FrameData[22] VPWR VGND sg13cmos5l_buf_1
X_1515_ _1515_/Q Tile_X0Y1_FrameData[24] Tile_X0Y3_FrameStrobe[2] VPWR VGND sg13cmos5l_dlhq_1
X_2495_ Tile_X0Y3_E1BEG[1] _2495_/A VPWR VGND sg13cmos5l_buf_1
XFILLER_99_277 VPWR VGND sg13cmos5l_decap_4
XFILLER_59_108 VPWR VGND sg13cmos5l_decap_4
X_1446_ _1446_/Q Tile_X0Y1_FrameData[29] Tile_X0Y3_FrameStrobe[0] VPWR VGND sg13cmos5l_dlhq_1
XANTENNA__1381__D Tile_X0Y0_FrameData[6] VPWR VGND sg13cmos5l_antennanp
X_1377_ _1377_/Q Tile_X0Y0_FrameData[10] Tile_X0Y3_FrameStrobe[5] VPWR VGND sg13cmos5l_dlhq_1
XANTENNA__0710__A0 Tile_X0Y1_W2MID[4] VPWR VGND sg13cmos5l_antennanp
XFILLER_82_133 VPWR VGND sg13cmos5l_fill_2
XFILLER_215_117 VPWR VGND sg13cmos5l_fill_2
XFILLER_130_16 VPWR VGND sg13cmos5l_fill_1
XFILLER_82_188 VPWR VGND sg13cmos5l_decap_8
XFILLER_223_172 VPWR VGND sg13cmos5l_fill_1
XFILLER_223_161 VPWR VGND sg13cmos5l_decap_4
XFILLER_23_277 VPWR VGND sg13cmos5l_fill_1
XFILLER_139_47 VPWR VGND sg13cmos5l_decap_4
XANTENNA__1556__D Tile_X0Y1_FrameData[15] VPWR VGND sg13cmos5l_antennanp
XFILLER_136_146 VPWR VGND sg13cmos5l_decap_4
XFILLER_151_138 VPWR VGND sg13cmos5l_fill_1
XFILLER_151_149 VPWR VGND sg13cmos5l_decap_8
XANTENNA__1291__D Tile_X0Y0_FrameData[0] VPWR VGND sg13cmos5l_antennanp
XFILLER_48_44 VPWR VGND sg13cmos5l_decap_8
XANTENNA__0701__A0 Tile_X0Y3_W2MID[4] VPWR VGND sg13cmos5l_antennanp
XFILLER_100_293 VPWR VGND sg13cmos5l_fill_2
XFILLER_64_21 VPWR VGND sg13cmos5l_decap_8
XFILLER_206_139 VPWR VGND sg13cmos5l_decap_8
XANTENNA__1442__GATE Tile_X0Y3_FrameStrobe[7] VPWR VGND sg13cmos5l_antennanp
XFILLER_14_255 VPWR VGND sg13cmos5l_decap_4
XFILLER_154_0 VPWR VGND sg13cmos5l_fill_2
XFILLER_159_205 VPWR VGND sg13cmos5l_fill_1
XFILLER_214_161 VPWR VGND sg13cmos5l_decap_8
XANTENNA__1009__A1 Tile_X0Y1_W6END[10] VPWR VGND sg13cmos5l_antennanp
XFILLER_120_82 VPWR VGND sg13cmos5l_decap_8
XFILLER_14_277 VPWR VGND sg13cmos5l_decap_4
XFILLER_159_249 VPWR VGND sg13cmos5l_decap_4
XFILLER_80_75 VPWR VGND sg13cmos5l_decap_8
XANTENNA__1457__GATE Tile_X0Y3_FrameStrobe[0] VPWR VGND sg13cmos5l_antennanp
XANTENNA__1466__D Tile_X0Y1_FrameData[9] VPWR VGND sg13cmos5l_antennanp
XFILLER_127_179 VPWR VGND sg13cmos5l_decap_8
XFILLER_89_40 VPWR VGND sg13cmos5l_decap_8
X_1300_ _1300_/Q Tile_X0Y0_FrameData[23] Tile_X0Y3_FrameStrobe[3] VPWR VGND sg13cmos5l_dlhq_1
X_2280_ Tile_X0Y2_E2BEG[0] _2280_/A VPWR VGND sg13cmos5l_buf_1
X_1231_ _1231_/Q Tile_X0Y0_FrameData[28] Tile_X0Y3_FrameStrobe[1] VPWR VGND sg13cmos5l_dlhq_1
XFILLER_49_141 VPWR VGND sg13cmos5l_decap_8
XFILLER_1_181 VPWR VGND sg13cmos5l_fill_2
X_1162_ _2364_/A _1160_/X _1161_/X _1907_/Q VPWR VGND sg13cmos5l_mux2_1
XFILLER_64_111 VPWR VGND sg13cmos5l_decap_8
X_1093_ _2291_/A AXIL_S_SOC_WDATA3 AXIL_S_SOC_WDATA11 _0746_/X _0742_/X _1837_/Q _1836_/Q
+ VPWR VGND sg13cmos5l_mux4_1
XFILLER_100_19 VPWR VGND sg13cmos5l_fill_1
XANTENNA__0471__A2 Tile_X0Y3_N4END[6] VPWR VGND sg13cmos5l_antennanp
X_1995_ _1995_/Q Tile_X0Y3_FrameData[8] Tile_X0Y3_FrameStrobe[1] VPWR VGND sg13cmos5l_dlhq_1
XFILLER_220_186 VPWR VGND sg13cmos5l_fill_2
XFILLER_20_225 VPWR VGND sg13cmos5l_decap_4
XANTENNA__0759__A0 Tile_X0Y0_W2MID[0] VPWR VGND sg13cmos5l_antennanp
XFILLER_158_271 VPWR VGND sg13cmos5l_decap_4
X_0946_ _0947_/A _0858_/X _0492_/X Tile_X0Y3_N4END[11] Tile_X0Y0_S4END[7] _1476_/Q
+ _1477_/Q VPWR VGND sg13cmos5l_mux4_1
XFILLER_220_197 VPWR VGND sg13cmos5l_fill_2
XANTENNA__1376__D Tile_X0Y0_FrameData[11] VPWR VGND sg13cmos5l_antennanp
XFILLER_158_293 VPWR VGND sg13cmos5l_fill_2
XANTENNA__2402__X Tile_X0Y0_FrameStrobe_O[8] VPWR VGND sg13cmos5l_antennanp
XFILLER_109_39 VPWR VGND sg13cmos5l_fill_2
X_0877_ _2467_/A AXIL_S_SOC_AWVALID _0784_/X _0786_/X _0646_/X _1288_/Q _1289_/Q VPWR
+ VGND sg13cmos5l_mux4_1
XANTENNA__1184__A0 Tile_X0Y3_W1END[1] VPWR VGND sg13cmos5l_antennanp
XFILLER_125_16 VPWR VGND sg13cmos5l_decap_4
X_2547_ Tile_X0Y3_FrameData_O[5] Tile_X0Y3_FrameData[5] VPWR VGND sg13cmos5l_buf_1
X_2478_ Tile_X0Y0_E2BEGb[4] _2478_/A VPWR VGND sg13cmos5l_buf_1
X_1429_ _1429_/Q Tile_X0Y0_FrameData[22] Tile_X0Y3_FrameStrobe[7] VPWR VGND sg13cmos5l_dlhq_1
XFILLER_87_269 VPWR VGND sg13cmos5l_decap_4
XANTENNA__2000__D Tile_X0Y3_FrameData[3] VPWR VGND sg13cmos5l_antennanp
XFILLER_55_100 VPWR VGND sg13cmos5l_decap_4
XFILLER_205_71 VPWR VGND sg13cmos5l_decap_8
XFILLER_141_59 VPWR VGND sg13cmos5l_decap_8
XFILLER_55_166 VPWR VGND sg13cmos5l_fill_1
XFILLER_18_69 VPWR VGND sg13cmos5l_decap_8
XANTENNA__2172__GATE Tile_X0Y3_FrameStrobe[7] VPWR VGND sg13cmos5l_antennanp
XANTENNA__0998__A0 AXIL_S_SOC_WDATA21 VPWR VGND sg13cmos5l_antennanp
XANTENNA__0462__A2 Tile_X0Y0_S1END[2] VPWR VGND sg13cmos5l_antennanp
XFILLER_11_236 VPWR VGND sg13cmos5l_decap_4
XFILLER_109_113 VPWR VGND sg13cmos5l_fill_2
XFILLER_149_271 VPWR VGND sg13cmos5l_decap_4
XFILLER_149_282 VPWR VGND sg13cmos5l_fill_2
XANTENNA__1286__D Tile_X0Y0_FrameData[5] VPWR VGND sg13cmos5l_antennanp
XANTENNA__2187__GATE Tile_X0Y3_FrameStrobe[7] VPWR VGND sg13cmos5l_antennanp
XFILLER_126_4 VPWR VGND sg13cmos5l_fill_1
XFILLER_149_293 VPWR VGND sg13cmos5l_fill_2
XANTENNA__2312__X Tile_X0Y2_EE4BEG[4] VPWR VGND sg13cmos5l_antennanp
XANTENNA__1175__A0 Tile_X0Y2_W2MID[4] VPWR VGND sg13cmos5l_antennanp
XANTENNA__2110__GATE Tile_X0Y3_FrameStrobe[5] VPWR VGND sg13cmos5l_antennanp
XFILLER_59_32 VPWR VGND sg13cmos5l_decap_4
XFILLER_182_11 VPWR VGND sg13cmos5l_fill_2
XFILLER_78_203 VPWR VGND sg13cmos5l_decap_8
XFILLER_78_269 VPWR VGND sg13cmos5l_decap_8
XANTENNA__2125__GATE Tile_X0Y3_FrameStrobe[5] VPWR VGND sg13cmos5l_antennanp
XFILLER_115_82 VPWR VGND sg13cmos5l_decap_8
XFILLER_93_217 VPWR VGND sg13cmos5l_decap_4
XFILLER_75_53 VPWR VGND sg13cmos5l_decap_8
XANTENNA__1381__GATE Tile_X0Y3_FrameStrobe[5] VPWR VGND sg13cmos5l_antennanp
XFILLER_131_81 VPWR VGND sg13cmos5l_fill_1
XFILLER_61_169 VPWR VGND sg13cmos5l_decap_8
XFILLER_98_8 VPWR VGND sg13cmos5l_decap_8
XANTENNA__1396__GATE Tile_X0Y3_FrameStrobe[6] VPWR VGND sg13cmos5l_antennanp
X_1780_ _1780_/Q Tile_X0Y2_FrameData[7] Tile_X0Y3_FrameStrobe[2] VPWR VGND sg13cmos5l_dlhq_1
X_0800_ _0800_/Y _0799_/Y _0800_/B VPWR VGND sg13cmos5l_nand2b_1
X_0731_ _0731_/X Tile_X0Y3_W2MID[2] Tile_X0Y3_W2END[2] Tile_X0Y3_W6END[2] _0594_/X
+ _2169_/Q _2168_/Q VPWR VGND sg13cmos5l_mux4_1
XANTENNA__2222__X Tile_X0Y1_E6BEG[7] VPWR VGND sg13cmos5l_antennanp
XFILLER_115_149 VPWR VGND sg13cmos5l_fill_1
X_0662_ _2503_/A AXIL_S_SOC_ARADDR0 AXIL_S_SOC_ARADDR8 _0483_/X _0594_/X _2097_/Q
+ _2096_/Q VPWR VGND sg13cmos5l_mux4_1
XANTENNA__1924__D Tile_X0Y2_FrameData[23] VPWR VGND sg13cmos5l_antennanp
X_2401_ Tile_X0Y0_FrameStrobe_O[7] Tile_X0Y3_FrameStrobe[7] VPWR VGND sg13cmos5l_buf_1
X_0593_ _0593_/X Tile_X0Y1_W1END[1] Tile_X0Y1_W2END[2] Tile_X0Y1_W2MID[2] _0865_/X
+ _1636_/Q _1637_/Q VPWR VGND sg13cmos5l_mux4_1
XANTENNA__0508__A3 Tile_X0Y0_S4END[15] VPWR VGND sg13cmos5l_antennanp
XANTENNA__1334__GATE Tile_X0Y3_FrameStrobe[4] VPWR VGND sg13cmos5l_antennanp
X_2332_ Tile_X0Y2_FrameData_O[8] Tile_X0Y2_FrameData[8] VPWR VGND sg13cmos5l_buf_1
XANTENNA__1964__GATE Tile_X0Y3_FrameStrobe[0] VPWR VGND sg13cmos5l_antennanp
XFILLER_123_193 VPWR VGND sg13cmos5l_decap_8
XFILLER_69_236 VPWR VGND sg13cmos5l_decap_4
X_2263_ Tile_X0Y1_FrameData_O[20] Tile_X0Y1_FrameData[20] VPWR VGND sg13cmos5l_buf_1
XFILLER_84_228 VPWR VGND sg13cmos5l_decap_8
X_1214_ _1214_/Q Tile_X0Y0_FrameData[13] Tile_X0Y3_FrameStrobe[0] VPWR VGND sg13cmos5l_dlhq_1
X_2194_ _2194_/Q Tile_X0Y3_FrameData[7] Tile_X0Y3_FrameStrobe[7] VPWR VGND sg13cmos5l_dlhq_1
XANTENNA__1349__GATE Tile_X0Y3_FrameStrobe[4] VPWR VGND sg13cmos5l_antennanp
X_1145_ _1146_/A _1049_/X _1051_/A _0554_/X _0732_/X _1876_/Q _1875_/Q VPWR VGND sg13cmos5l_mux4_1
XANTENNA__1979__GATE Tile_X0Y3_FrameStrobe[1] VPWR VGND sg13cmos5l_antennanp
XFILLER_111_18 VPWR VGND sg13cmos5l_fill_2
XFILLER_92_283 VPWR VGND sg13cmos5l_fill_1
XFILLER_52_114 VPWR VGND sg13cmos5l_decap_8
XFILLER_225_256 VPWR VGND sg13cmos5l_decap_4
XFILLER_225_245 VPWR VGND sg13cmos5l_fill_1
X_1076_ _2362_/A _1071_/Y _1075_/X _1066_/Y VPWR VGND sg13cmos5l_a21oi_1
XANTENNA__1902__GATE Tile_X0Y3_FrameStrobe[6] VPWR VGND sg13cmos5l_antennanp
X_1978_ _1978_/Q Tile_X0Y3_FrameData[25] Tile_X0Y3_FrameStrobe[1] VPWR VGND sg13cmos5l_dlhq_1
XANTENNA__1917__GATE Tile_X0Y3_FrameStrobe[7] VPWR VGND sg13cmos5l_antennanp
XFILLER_146_263 VPWR VGND sg13cmos5l_decap_8
X_0929_ _0929_/X _0860_/X _0466_/B Tile_X0Y3_N4END[10] Tile_X0Y0_S4END[6] _1494_/Q
+ _1495_/Q VPWR VGND sg13cmos5l_mux4_1
XFILLER_106_116 VPWR VGND sg13cmos5l_decap_4
XFILLER_106_127 VPWR VGND sg13cmos5l_decap_4
XANTENNA__1834__D Tile_X0Y2_FrameData[17] VPWR VGND sg13cmos5l_antennanp
XFILLER_136_48 VPWR VGND sg13cmos5l_fill_2
XANTENNA__0904__A0 AXIL_S_SOC_WSTRB1 VPWR VGND sg13cmos5l_antennanp
XFILLER_75_217 VPWR VGND sg13cmos5l_decap_8
XFILLER_29_46 VPWR VGND sg13cmos5l_fill_1
XFILLER_83_250 VPWR VGND sg13cmos5l_decap_8
XFILLER_45_45 VPWR VGND sg13cmos5l_fill_2
XFILLER_45_23 VPWR VGND sg13cmos5l_fill_2
XFILLER_45_89 VPWR VGND sg13cmos5l_decap_4
XFILLER_43_147 VPWR VGND sg13cmos5l_decap_8
XFILLER_216_278 VPWR VGND sg13cmos5l_fill_2
XANTENNA__2307__X Tile_X0Y2_E6BEG[11] VPWR VGND sg13cmos5l_antennanp
XFILLER_177_77 VPWR VGND sg13cmos5l_decap_4
XFILLER_117_0 VPWR VGND sg13cmos5l_fill_2
XFILLER_137_263 VPWR VGND sg13cmos5l_decap_8
XFILLER_177_99 VPWR VGND sg13cmos5l_decap_4
XANTENNA__1744__D Tile_X0Y2_FrameData[11] VPWR VGND sg13cmos5l_antennanp
XFILLER_193_43 VPWR VGND sg13cmos5l_fill_2
XFILLER_3_276 VPWR VGND sg13cmos5l_fill_2
XANTENNA__2064__GATE Tile_X0Y3_FrameStrobe[3] VPWR VGND sg13cmos5l_antennanp
XFILLER_86_85 VPWR VGND sg13cmos5l_decap_8
XFILLER_212_39 VPWR VGND sg13cmos5l_fill_2
XFILLER_212_28 VPWR VGND sg13cmos5l_decap_8
XFILLER_207_223 VPWR VGND sg13cmos5l_decap_4
XFILLER_19_144 VPWR VGND sg13cmos5l_decap_8
XANTENNA__2079__GATE Tile_X0Y3_FrameStrobe[4] VPWR VGND sg13cmos5l_antennanp
XFILLER_19_188 VPWR VGND sg13cmos5l_decap_8
XANTENNA__0674__A2 AXIL_S_SOC_ARADDR8 VPWR VGND sg13cmos5l_antennanp
XFILLER_74_294 VPWR VGND sg13cmos5l_fill_1
XFILLER_34_158 VPWR VGND sg13cmos5l_decap_8
XANTENNA__2217__X Tile_X0Y1_E6BEG[2] VPWR VGND sg13cmos5l_antennanp
XFILLER_34_169 VPWR VGND sg13cmos5l_fill_2
XANTENNA__1919__D Tile_X0Y2_FrameData[28] VPWR VGND sg13cmos5l_antennanp
XANTENNA__2002__GATE Tile_X0Y3_FrameStrobe[1] VPWR VGND sg13cmos5l_antennanp
X_1901_ _1901_/Q Tile_X0Y2_FrameData[14] Tile_X0Y3_FrameStrobe[6] VPWR VGND sg13cmos5l_dlhq_1
XFILLER_187_141 VPWR VGND sg13cmos5l_decap_8
X_1832_ _1832_/Q Tile_X0Y2_FrameData[19] Tile_X0Y3_FrameStrobe[4] VPWR VGND sg13cmos5l_dlhq_1
XANTENNA__2017__GATE Tile_X0Y3_FrameStrobe[2] VPWR VGND sg13cmos5l_antennanp
X_1763_ _1763_/Q Tile_X0Y2_FrameData[24] Tile_X0Y3_FrameStrobe[2] VPWR VGND sg13cmos5l_dlhq_1
X_1694_ _1694_/Q Tile_X0Y2_FrameData[29] Tile_X0Y3_FrameStrobe[0] VPWR VGND sg13cmos5l_dlhq_1
X_0714_ _0714_/X Tile_X0Y3_W2MID[6] Tile_X0Y3_W2END[6] Tile_X0Y3_W6END[6] _0584_/X
+ _2177_/Q _2176_/Q VPWR VGND sg13cmos5l_mux4_1
XANTENNA__1654__D Tile_X0Y1_FrameData[13] VPWR VGND sg13cmos5l_antennanp
XFILLER_143_255 VPWR VGND sg13cmos5l_fill_1
X_0645_ _0645_/X Tile_X0Y2_W2MID[6] Tile_X0Y2_W2END[6] Tile_X0Y2_W6END[6] _0715_/X
+ _1929_/Q _1928_/Q VPWR VGND sg13cmos5l_mux4_1
XANTENNA__1273__GATE Tile_X0Y3_FrameStrobe[2] VPWR VGND sg13cmos5l_antennanp
X_0576_ _2577_/A Tile_X0Y3_W1END[3] _0508_/X Tile_X0Y3_W6END[11] _0575_/Y _2144_/Q
+ _2145_/Q VPWR VGND sg13cmos5l_mux4_1
X_2315_ Tile_X0Y2_EE4BEG[7] _2315_/A VPWR VGND sg13cmos5l_buf_1
XANTENNA__1288__GATE Tile_X0Y3_FrameStrobe[2] VPWR VGND sg13cmos5l_antennanp
X_2246_ Tile_X0Y1_FrameData_O[3] Tile_X0Y1_FrameData[3] VPWR VGND sg13cmos5l_buf_1
XFILLER_122_39 VPWR VGND sg13cmos5l_fill_2
X_2177_ _2177_/Q Tile_X0Y3_FrameData[18] Tile_X0Y3_FrameStrobe[7] VPWR VGND sg13cmos5l_dlhq_1
XANTENNA__0665__A2 AXIL_S_SOC_ARADDR3 VPWR VGND sg13cmos5l_antennanp
XANTENNA__1211__GATE Tile_X0Y3_FrameStrobe[0] VPWR VGND sg13cmos5l_antennanp
X_1128_ _1128_/Y _1128_/A VPWR VGND sg13cmos5l_inv_1
XFILLER_65_294 VPWR VGND sg13cmos5l_fill_1
XANTENNA__1841__GATE Tile_X0Y3_FrameStrobe[4] VPWR VGND sg13cmos5l_antennanp
XFILLER_15_26 VPWR VGND sg13cmos5l_decap_8
X_1059_ _1060_/A _0889_/X _0528_/X Tile_X0Y3_N4END[4] Tile_X0Y0_S4END[8] _1746_/Q
+ _1747_/Q VPWR VGND sg13cmos5l_mux4_1
XFILLER_80_253 VPWR VGND sg13cmos5l_decap_4
XANTENNA__1829__D Tile_X0Y2_FrameData[22] VPWR VGND sg13cmos5l_antennanp
XANTENNA__1226__GATE Tile_X0Y3_FrameStrobe[0] VPWR VGND sg13cmos5l_antennanp
XFILLER_31_25 VPWR VGND sg13cmos5l_decap_4
XANTENNA__1856__GATE Tile_X0Y3_FrameStrobe[5] VPWR VGND sg13cmos5l_antennanp
XFILLER_193_166 VPWR VGND sg13cmos5l_fill_1
XANTENNA__1564__D Tile_X0Y1_FrameData[7] VPWR VGND sg13cmos5l_antennanp
XFILLER_134_277 VPWR VGND sg13cmos5l_decap_8
XFILLER_163_35 VPWR VGND sg13cmos5l_fill_1
XFILLER_0_268 VPWR VGND sg13cmos5l_fill_1
XFILLER_0_279 VPWR VGND sg13cmos5l_decap_4
XFILLER_102_196 VPWR VGND sg13cmos5l_decap_8
XFILLER_56_22 VPWR VGND sg13cmos5l_decap_8
XFILLER_56_11 VPWR VGND sg13cmos5l_fill_1
XFILLER_48_239 VPWR VGND sg13cmos5l_decap_8
XFILLER_48_228 VPWR VGND sg13cmos5l_fill_1
XFILLER_56_88 VPWR VGND sg13cmos5l_decap_8
XFILLER_56_77 VPWR VGND sg13cmos5l_fill_1
XFILLER_179_2 VPWR VGND sg13cmos5l_fill_1
XFILLER_56_294 VPWR VGND sg13cmos5l_fill_1
XANTENNA__1809__GATE Tile_X0Y3_FrameStrobe[3] VPWR VGND sg13cmos5l_antennanp
XFILLER_112_83 VPWR VGND sg13cmos5l_decap_8
XFILLER_204_259 VPWR VGND sg13cmos5l_decap_8
XFILLER_72_76 VPWR VGND sg13cmos5l_decap_8
XANTENNA__1739__D Tile_X0Y2_FrameData[16] VPWR VGND sg13cmos5l_antennanp
XFILLER_188_54 VPWR VGND sg13cmos5l_decap_8
XFILLER_184_188 VPWR VGND sg13cmos5l_fill_1
XFILLER_21_91 VPWR VGND sg13cmos5l_decap_4
XFILLER_207_28 VPWR VGND sg13cmos5l_fill_1
XANTENNA__0592__A1 Tile_X0Y2_W2END[2] VPWR VGND sg13cmos5l_antennanp
XANTENNA__1474__D Tile_X0Y1_FrameData[1] VPWR VGND sg13cmos5l_antennanp
XANTENNA__2500__X Tile_X0Y3_E2BEG[2] VPWR VGND sg13cmos5l_antennanp
X_0430_ _0430_/Y Tile_X0Y0_W6END[2] VPWR VGND sg13cmos5l_inv_1
XANTENNA__0895__A2 Tile_X0Y0_W6END[5] VPWR VGND sg13cmos5l_antennanp
X_2100_ _2100_/Q Tile_X0Y3_FrameData[31] Tile_X0Y3_FrameStrobe[5] VPWR VGND sg13cmos5l_dlhq_1
XFILLER_39_217 VPWR VGND sg13cmos5l_decap_8
X_2031_ _2031_/Q Tile_X0Y3_FrameData[4] Tile_X0Y3_FrameStrobe[2] VPWR VGND sg13cmos5l_dlhq_1
XFILLER_223_49 VPWR VGND sg13cmos5l_fill_2
XANTENNA__0647__A2 Tile_X0Y0_W6END[0] VPWR VGND sg13cmos5l_antennanp
XFILLER_62_275 VPWR VGND sg13cmos5l_fill_2
XFILLER_62_286 VPWR VGND sg13cmos5l_fill_1
XANTENNA__1649__D Tile_X0Y1_FrameData[18] VPWR VGND sg13cmos5l_antennanp
XFILLER_203_270 VPWR VGND sg13cmos5l_decap_8
XFILLER_175_133 VPWR VGND sg13cmos5l_fill_2
XFILLER_175_122 VPWR VGND sg13cmos5l_decap_8
X_1815_ _1815_/Q Tile_X0Y2_FrameData[4] Tile_X0Y3_FrameStrobe[3] VPWR VGND sg13cmos5l_dlhq_1
XFILLER_190_103 VPWR VGND sg13cmos5l_decap_8
X_1746_ _1746_/Q Tile_X0Y2_FrameData[9] Tile_X0Y3_FrameStrobe[1] VPWR VGND sg13cmos5l_dlhq_1
XFILLER_190_114 VPWR VGND sg13cmos5l_fill_1
XFILLER_116_233 VPWR VGND sg13cmos5l_decap_8
XFILLER_116_244 VPWR VGND sg13cmos5l_fill_2
XFILLER_190_147 VPWR VGND sg13cmos5l_decap_8
XANTENNA__0583__A1 Tile_X0Y2_W2END[6] VPWR VGND sg13cmos5l_antennanp
XANTENNA__1384__D Tile_X0Y0_FrameData[3] VPWR VGND sg13cmos5l_antennanp
XFILLER_116_277 VPWR VGND sg13cmos5l_fill_1
XFILLER_117_39 VPWR VGND sg13cmos5l_fill_1
X_1677_ _1677_/Q Tile_X0Y1_FrameData[22] Tile_X0Y3_FrameStrobe[7] VPWR VGND sg13cmos5l_dlhq_1
XFILLER_89_117 VPWR VGND sg13cmos5l_decap_4
XANTENNA__2410__X Tile_X0Y0_FrameStrobe_O[16] VPWR VGND sg13cmos5l_antennanp
X_0628_ _0628_/Y Tile_X0Y3_W6END[0] _2019_/Q _2018_/Q VPWR VGND sg13cmos5l_o21ai_1
X_0559_ _0559_/X _0553_/X _0555_/Y _0558_/Y VPWR VGND sg13cmos5l_a21o_1
X_2229_ Tile_X0Y1_EE4BEG[2] _2229_/A VPWR VGND sg13cmos5l_buf_1
XANTENNA__1780__GATE Tile_X0Y3_FrameStrobe[2] VPWR VGND sg13cmos5l_antennanp
XFILLER_38_294 VPWR VGND sg13cmos5l_fill_1
XFILLER_13_106 VPWR VGND sg13cmos5l_decap_8
XFILLER_53_275 VPWR VGND sg13cmos5l_fill_1
XFILLER_53_242 VPWR VGND sg13cmos5l_fill_1
XFILLER_198_269 VPWR VGND sg13cmos5l_decap_4
XANTENNA__1559__D Tile_X0Y1_FrameData[12] VPWR VGND sg13cmos5l_antennanp
XFILLER_42_35 VPWR VGND sg13cmos5l_decap_8
XFILLER_42_24 VPWR VGND sg13cmos5l_fill_1
XANTENNA__1795__GATE Tile_X0Y3_FrameStrobe[3] VPWR VGND sg13cmos5l_antennanp
XFILLER_21_161 VPWR VGND sg13cmos5l_fill_2
XFILLER_166_188 VPWR VGND sg13cmos5l_decap_8
XANTENNA__1294__D Tile_X0Y0_FrameData[29] VPWR VGND sg13cmos5l_antennanp
XFILLER_174_34 VPWR VGND sg13cmos5l_fill_2
XANTENNA__2320__X Tile_X0Y2_EE4BEG[12] VPWR VGND sg13cmos5l_antennanp
XANTENNA__1733__GATE Tile_X0Y3_FrameStrobe[1] VPWR VGND sg13cmos5l_antennanp
XANTENNA__1748__GATE Tile_X0Y3_FrameStrobe[1] VPWR VGND sg13cmos5l_antennanp
XFILLER_29_294 VPWR VGND sg13cmos5l_fill_1
XFILLER_29_283 VPWR VGND sg13cmos5l_fill_1
XFILLER_16_80 VPWR VGND sg13cmos5l_fill_2
XANTENNA__1469__D Tile_X0Y1_FrameData[6] VPWR VGND sg13cmos5l_antennanp
XANTENNA__0801__A2 Tile_X0Y3_N4END[15] VPWR VGND sg13cmos5l_antennanp
XFILLER_157_144 VPWR VGND sg13cmos5l_fill_1
XFILLER_157_166 VPWR VGND sg13cmos5l_decap_8
X_1600_ _1600_/Q Tile_X0Y1_FrameData[3] Tile_X0Y3_FrameStrobe[4] VPWR VGND sg13cmos5l_dlhq_1
X_2580_ Tile_X0Y3_S2BEG[2] _2580_/A VPWR VGND sg13cmos5l_buf_1
XFILLER_8_198 VPWR VGND sg13cmos5l_decap_8
X_1531_ _1531_/Q Tile_X0Y1_FrameData[8] Tile_X0Y3_FrameStrobe[2] VPWR VGND sg13cmos5l_dlhq_1
XANTENNA__2230__X Tile_X0Y1_EE4BEG[3] VPWR VGND sg13cmos5l_antennanp
X_1462_ _1462_/Q Tile_X0Y1_FrameData[13] Tile_X0Y3_FrameStrobe[0] VPWR VGND sg13cmos5l_dlhq_1
XANTENNA__1932__D Tile_X0Y2_FrameData[15] VPWR VGND sg13cmos5l_antennanp
X_1393_ _1393_/Q Tile_X0Y0_FrameData[26] Tile_X0Y3_FrameStrobe[6] VPWR VGND sg13cmos5l_dlhq_1
XFILLER_79_194 VPWR VGND sg13cmos5l_fill_1
X_2014_ _2014_/Q Tile_X0Y3_FrameData[21] Tile_X0Y3_FrameStrobe[2] VPWR VGND sg13cmos5l_dlhq_1
XANTENNA__1379__D Tile_X0Y0_FrameData[8] VPWR VGND sg13cmos5l_antennanp
XFILLER_195_217 VPWR VGND sg13cmos5l_fill_1
XANTENNA__2405__X Tile_X0Y0_FrameStrobe_O[11] VPWR VGND sg13cmos5l_antennanp
XFILLER_50_278 VPWR VGND sg13cmos5l_fill_1
XFILLER_195_239 VPWR VGND sg13cmos5l_fill_1
XFILLER_148_177 VPWR VGND sg13cmos5l_decap_4
XFILLER_163_125 VPWR VGND sg13cmos5l_fill_2
X_1729_ _1729_/Q Tile_X0Y2_FrameData[26] Tile_X0Y3_FrameStrobe[1] VPWR VGND sg13cmos5l_dlhq_1
XANTENNA__2003__D Tile_X0Y3_FrameData[0] VPWR VGND sg13cmos5l_antennanp
XFILLER_208_82 VPWR VGND sg13cmos5l_decap_8
XFILLER_144_37 VPWR VGND sg13cmos5l_fill_2
XANTENNA__1842__D Tile_X0Y2_FrameData[9] VPWR VGND sg13cmos5l_antennanp
XFILLER_144_59 VPWR VGND sg13cmos5l_decap_8
XANTENNA__0492__A0 Tile_X0Y0_W1END[3] VPWR VGND sg13cmos5l_antennanp
XFILLER_41_212 VPWR VGND sg13cmos5l_decap_8
XFILLER_26_286 VPWR VGND sg13cmos5l_fill_1
XANTENNA__1289__D Tile_X0Y0_FrameData[2] VPWR VGND sg13cmos5l_antennanp
XFILLER_53_78 VPWR VGND sg13cmos5l_fill_2
XANTENNA__2315__X Tile_X0Y2_EE4BEG[7] VPWR VGND sg13cmos5l_antennanp
XFILLER_139_111 VPWR VGND sg13cmos5l_decap_8
XFILLER_194_250 VPWR VGND sg13cmos5l_decap_4
XFILLER_5_113 VPWR VGND sg13cmos5l_decap_8
XFILLER_194_294 VPWR VGND sg13cmos5l_fill_1
XANTENNA__1672__GATE Tile_X0Y3_FrameStrobe[7] VPWR VGND sg13cmos5l_antennanp
XANTENNA__1752__D Tile_X0Y2_FrameData[3] VPWR VGND sg13cmos5l_antennanp
XFILLER_110_228 VPWR VGND sg13cmos5l_decap_8
XFILLER_204_18 VPWR VGND sg13cmos5l_fill_1
XANTENNA__1687__GATE Tile_X0Y3_FrameStrobe[7] VPWR VGND sg13cmos5l_antennanp
XFILLER_94_74 VPWR VGND sg13cmos5l_fill_1
XFILLER_91_156 VPWR VGND sg13cmos5l_decap_8
XANTENNA__0483__A0 Tile_X0Y3_N2MID[2] VPWR VGND sg13cmos5l_antennanp
XANTENNA__1610__GATE Tile_X0Y3_FrameStrobe[5] VPWR VGND sg13cmos5l_antennanp
XANTENNA__1199__D Tile_X0Y0_FrameData[28] VPWR VGND sg13cmos5l_antennanp
XANTENNA__1027__A2 Tile_X0Y0_S4END[4] VPWR VGND sg13cmos5l_antennanp
XANTENNA__2225__X Tile_X0Y1_E6BEG[10] VPWR VGND sg13cmos5l_antennanp
X_0962_ _2206_/A AXIL_S_SOC_WDATA23 AXIL_S_SOC_WDATA31 _0859_/X _0862_/X _1597_/Q
+ _1596_/Q VPWR VGND sg13cmos5l_mux4_1
XFILLER_32_278 VPWR VGND sg13cmos5l_fill_2
XANTENNA__0786__A1 Tile_X0Y3_N4END[14] VPWR VGND sg13cmos5l_antennanp
XANTENNA__1625__GATE Tile_X0Y3_FrameStrobe[5] VPWR VGND sg13cmos5l_antennanp
XANTENNA__1927__D Tile_X0Y2_FrameData[20] VPWR VGND sg13cmos5l_antennanp
X_0893_ AXIL_S_SOC_BVALID Tile_X0Y0_W2MID[7] Tile_X0Y0_W2END[7] Tile_X0Y0_W6END[7]
+ _0755_/X _1261_/Q _1260_/Q VPWR VGND sg13cmos5l_mux4_1
XFILLER_185_272 VPWR VGND sg13cmos5l_decap_8
XFILLER_145_136 VPWR VGND sg13cmos5l_decap_8
XFILLER_185_294 VPWR VGND sg13cmos5l_fill_1
XANTENNA__0538__A1 Tile_X0Y3_W6END[0] VPWR VGND sg13cmos5l_antennanp
XFILLER_160_117 VPWR VGND sg13cmos5l_fill_1
X_2563_ Tile_X0Y3_FrameData_O[21] Tile_X0Y3_FrameData[21] VPWR VGND sg13cmos5l_buf_1
XFILLER_99_201 VPWR VGND sg13cmos5l_fill_1
XANTENNA__2401__A Tile_X0Y3_FrameStrobe[7] VPWR VGND sg13cmos5l_antennanp
X_1514_ _1514_/Q Tile_X0Y1_FrameData[25] Tile_X0Y3_FrameStrobe[2] VPWR VGND sg13cmos5l_dlhq_1
X_2494_ Tile_X0Y3_E1BEG[0] _2494_/A VPWR VGND sg13cmos5l_buf_1
XFILLER_4_50 VPWR VGND sg13cmos5l_fill_2
XANTENNA__1662__D Tile_X0Y1_FrameData[5] VPWR VGND sg13cmos5l_antennanp
X_1445_ _1445_/Q Tile_X0Y1_FrameData[30] Tile_X0Y3_FrameStrobe[0] VPWR VGND sg13cmos5l_dlhq_1
XFILLER_4_72 VPWR VGND sg13cmos5l_decap_4
X_1376_ _1376_/Q Tile_X0Y0_FrameData[11] Tile_X0Y3_FrameStrobe[5] VPWR VGND sg13cmos5l_dlhq_1
XANTENNA__0710__A1 Tile_X0Y1_W2END[4] VPWR VGND sg13cmos5l_antennanp
XFILLER_82_112 VPWR VGND sg13cmos5l_decap_8
XFILLER_130_39 VPWR VGND sg13cmos5l_decap_8
XFILLER_168_217 VPWR VGND sg13cmos5l_decap_8
XANTENNA__1018__A2 AXIL_S_SOC_WDATA29 VPWR VGND sg13cmos5l_antennanp
XFILLER_139_15 VPWR VGND sg13cmos5l_decap_8
XFILLER_139_26 VPWR VGND sg13cmos5l_decap_8
XFILLER_210_94 VPWR VGND sg13cmos5l_decap_8
XANTENNA__1837__D Tile_X0Y2_FrameData[14] VPWR VGND sg13cmos5l_antennanp
XFILLER_136_103 VPWR VGND sg13cmos5l_decap_8
XFILLER_176_294 VPWR VGND sg13cmos5l_fill_1
XFILLER_155_25 VPWR VGND sg13cmos5l_fill_1
XANTENNA__1572__D Tile_X0Y1_FrameData[31] VPWR VGND sg13cmos5l_antennanp
XFILLER_58_131 VPWR VGND sg13cmos5l_decap_8
XANTENNA__0701__A1 Tile_X0Y3_W2END[4] VPWR VGND sg13cmos5l_antennanp
XFILLER_0_19 VPWR VGND sg13cmos5l_fill_2
XFILLER_104_40 VPWR VGND sg13cmos5l_decap_4
XFILLER_73_134 VPWR VGND sg13cmos5l_decap_4
XFILLER_73_156 VPWR VGND sg13cmos5l_fill_2
XFILLER_73_178 VPWR VGND sg13cmos5l_fill_1
XFILLER_214_140 VPWR VGND sg13cmos5l_decap_4
XFILLER_14_234 VPWR VGND sg13cmos5l_decap_8
XANTENNA__1009__A2 Tile_X0Y1_WW4END[13] VPWR VGND sg13cmos5l_antennanp
XFILLER_147_0 VPWR VGND sg13cmos5l_fill_2
XFILLER_159_228 VPWR VGND sg13cmos5l_fill_1
XANTENNA__0480__A3 Tile_X0Y0_S4END[14] VPWR VGND sg13cmos5l_antennanp
XFILLER_80_43 VPWR VGND sg13cmos5l_decap_8
XFILLER_196_32 VPWR VGND sg13cmos5l_decap_8
XFILLER_196_21 VPWR VGND sg13cmos5l_fill_1
XFILLER_196_10 VPWR VGND sg13cmos5l_decap_8
XANTENNA__1747__D Tile_X0Y2_FrameData[8] VPWR VGND sg13cmos5l_antennanp
XFILLER_167_272 VPWR VGND sg13cmos5l_fill_2
XFILLER_167_283 VPWR VGND sg13cmos5l_decap_4
XFILLER_167_294 VPWR VGND sg13cmos5l_fill_1
XFILLER_129_92 VPWR VGND sg13cmos5l_decap_8
XFILLER_142_117 VPWR VGND sg13cmos5l_fill_2
XFILLER_89_96 VPWR VGND sg13cmos5l_decap_8
XANTENNA__1482__D Tile_X0Y1_FrameData[25] VPWR VGND sg13cmos5l_antennanp
X_1230_ _1230_/Q Tile_X0Y0_FrameData[29] Tile_X0Y3_FrameStrobe[1] VPWR VGND sg13cmos5l_dlhq_1
X_1161_ _1161_/X _1108_/X _1101_/X _0471_/X _0725_/X _1909_/Q _1908_/Q VPWR VGND sg13cmos5l_mux4_1
X_1092_ _2292_/A AXIL_S_SOC_WDATA4 AXIL_S_SOC_WDATA12 _0746_/X _0742_/X _1835_/Q _1834_/Q
+ VPWR VGND sg13cmos5l_mux4_1
XFILLER_64_178 VPWR VGND sg13cmos5l_decap_8
XFILLER_220_132 VPWR VGND sg13cmos5l_fill_2
XFILLER_220_121 VPWR VGND sg13cmos5l_fill_1
XANTENNA__0471__A3 Tile_X0Y0_S4END[10] VPWR VGND sg13cmos5l_antennanp
XANTENNA__1564__GATE Tile_X0Y3_FrameStrobe[3] VPWR VGND sg13cmos5l_antennanp
X_1994_ _1994_/Q Tile_X0Y3_FrameData[9] Tile_X0Y3_FrameStrobe[1] VPWR VGND sg13cmos5l_dlhq_1
XANTENNA__0759__A1 Tile_X0Y0_W2END[0] VPWR VGND sg13cmos5l_antennanp
XANTENNA__1657__D Tile_X0Y1_FrameData[10] VPWR VGND sg13cmos5l_antennanp
X_0945_ _0945_/X _0858_/X _0492_/X Tile_X0Y3_N4END[11] Tile_X0Y0_S4END[7] _1484_/Q
+ _1485_/Q VPWR VGND sg13cmos5l_mux4_1
XFILLER_20_259 VPWR VGND sg13cmos5l_fill_1
X_0876_ _2468_/A AXIL_S_SOC_AWADDR0 _0772_/X _0778_/X _0653_/X _1286_/Q _1287_/Q VPWR
+ VGND sg13cmos5l_mux4_1
XFILLER_62_0 VPWR VGND sg13cmos5l_fill_2
XANTENNA__1579__GATE Tile_X0Y3_FrameStrobe[4] VPWR VGND sg13cmos5l_antennanp
XANTENNA__1184__A1 Tile_X0Y3_W6END[9] VPWR VGND sg13cmos5l_antennanp
X_2546_ Tile_X0Y3_FrameData_O[4] Tile_X0Y3_FrameData[4] VPWR VGND sg13cmos5l_buf_1
XANTENNA__1392__D Tile_X0Y0_FrameData[27] VPWR VGND sg13cmos5l_antennanp
XANTENNA__1502__GATE Tile_X0Y3_FrameStrobe[1] VPWR VGND sg13cmos5l_antennanp
XFILLER_125_39 VPWR VGND sg13cmos5l_decap_8
X_2477_ Tile_X0Y0_E2BEGb[3] _2477_/A VPWR VGND sg13cmos5l_buf_1
XFILLER_87_226 VPWR VGND sg13cmos5l_fill_2
X_1428_ _1428_/Q Tile_X0Y0_FrameData[23] Tile_X0Y3_FrameStrobe[7] VPWR VGND sg13cmos5l_dlhq_1
XFILLER_205_50 VPWR VGND sg13cmos5l_decap_8
XFILLER_18_26 VPWR VGND sg13cmos5l_decap_8
XFILLER_18_15 VPWR VGND sg13cmos5l_decap_8
XANTENNA__0695__A0 AXIL_S_SOC_ARADDR1 VPWR VGND sg13cmos5l_antennanp
X_1359_ _1359_/Q Tile_X0Y0_FrameData[28] Tile_X0Y3_FrameStrobe[5] VPWR VGND sg13cmos5l_dlhq_1
XFILLER_55_134 VPWR VGND sg13cmos5l_fill_1
XFILLER_55_123 VPWR VGND sg13cmos5l_decap_8
XFILLER_18_37 VPWR VGND sg13cmos5l_fill_1
XANTENNA__1517__GATE Tile_X0Y3_FrameStrobe[2] VPWR VGND sg13cmos5l_antennanp
XFILLER_70_148 VPWR VGND sg13cmos5l_fill_2
XFILLER_70_137 VPWR VGND sg13cmos5l_decap_8
XFILLER_221_82 VPWR VGND sg13cmos5l_fill_2
XFILLER_34_69 VPWR VGND sg13cmos5l_decap_8
XANTENNA__0462__A3 Tile_X0Y0_S4END[2] VPWR VGND sg13cmos5l_antennanp
XANTENNA__1567__D Tile_X0Y1_FrameData[4] VPWR VGND sg13cmos5l_antennanp
XFILLER_11_259 VPWR VGND sg13cmos5l_decap_8
XFILLER_149_261 VPWR VGND sg13cmos5l_decap_4
XFILLER_109_136 VPWR VGND sg13cmos5l_decap_8
XFILLER_109_147 VPWR VGND sg13cmos5l_fill_1
XFILLER_50_35 VPWR VGND sg13cmos5l_fill_1
XFILLER_109_169 VPWR VGND sg13cmos5l_decap_8
XANTENNA__1175__A1 Tile_X0Y2_W2END[4] VPWR VGND sg13cmos5l_antennanp
XFILLER_117_191 VPWR VGND sg13cmos5l_fill_2
XFILLER_75_32 VPWR VGND sg13cmos5l_decap_8
XFILLER_75_87 VPWR VGND sg13cmos5l_fill_1
XFILLER_46_134 VPWR VGND sg13cmos5l_decap_8
XFILLER_199_161 VPWR VGND sg13cmos5l_fill_2
XFILLER_202_121 VPWR VGND sg13cmos5l_decap_4
XANTENNA__1477__D Tile_X0Y1_FrameData[30] VPWR VGND sg13cmos5l_antennanp
XANTENNA__2503__X Tile_X0Y3_E2BEG[5] VPWR VGND sg13cmos5l_antennanp
X_0730_ _0730_/X Tile_X0Y0_W1END[1] Tile_X0Y0_W2END[2] Tile_X0Y0_W2MID[2] _0736_/X
+ _1388_/Q _1389_/Q VPWR VGND sg13cmos5l_mux4_1
XANTENNA__0610__A0 Tile_X0Y3_N1END[1] VPWR VGND sg13cmos5l_antennanp
X_2400_ Tile_X0Y0_FrameStrobe_O[6] Tile_X0Y3_FrameStrobe[6] VPWR VGND sg13cmos5l_buf_1
X_0661_ _2502_/A AXIL_S_SOC_ARVALID AXIL_S_SOC_ARADDR7 _0511_/X _0590_/X _2099_/Q
+ _2098_/Q VPWR VGND sg13cmos5l_mux4_1
X_0592_ _2591_/A Tile_X0Y2_W1END[1] Tile_X0Y2_W2END[2] Tile_X0Y2_W2MID[2] _0732_/X
+ _1884_/Q _1885_/Q VPWR VGND sg13cmos5l_mux4_1
X_2331_ Tile_X0Y2_FrameData_O[7] Tile_X0Y2_FrameData[7] VPWR VGND sg13cmos5l_buf_1
XFILLER_69_215 VPWR VGND sg13cmos5l_decap_8
XANTENNA__2101__D Tile_X0Y3_FrameData[30] VPWR VGND sg13cmos5l_antennanp
X_2262_ Tile_X0Y1_FrameData_O[19] Tile_X0Y1_FrameData[19] VPWR VGND sg13cmos5l_buf_1
X_1213_ _1213_/Q Tile_X0Y0_FrameData[14] Tile_X0Y3_FrameStrobe[0] VPWR VGND sg13cmos5l_dlhq_1
XANTENNA__0677__A0 AXIL_S_SOC_ARVALID VPWR VGND sg13cmos5l_antennanp
XANTENNA__1940__D Tile_X0Y2_FrameData[31] VPWR VGND sg13cmos5l_antennanp
X_2193_ _2193_/Q Tile_X0Y3_FrameData[6] Tile_X0Y3_FrameStrobe[7] VPWR VGND sg13cmos5l_dlhq_1
XFILLER_37_112 VPWR VGND sg13cmos5l_decap_4
XFILLER_225_202 VPWR VGND sg13cmos5l_decap_4
XFILLER_1_40 VPWR VGND sg13cmos5l_fill_1
X_1144_ _1144_/Y _1874_/Q _1144_/B _1144_/C VPWR VGND sg13cmos5l_nor3_1
XFILLER_225_213 VPWR VGND sg13cmos5l_fill_2
X_1075_ _1075_/X _1913_/Q _1075_/B VPWR VGND sg13cmos5l_and2_1
XFILLER_225_279 VPWR VGND sg13cmos5l_decap_4
XFILLER_60_170 VPWR VGND sg13cmos5l_decap_4
XANTENNA__1387__D Tile_X0Y0_FrameData[0] VPWR VGND sg13cmos5l_antennanp
XANTENNA__2413__X Tile_X0Y0_FrameStrobe_O[19] VPWR VGND sg13cmos5l_antennanp
X_1977_ _1977_/Q Tile_X0Y3_FrameData[26] Tile_X0Y3_FrameStrobe[1] VPWR VGND sg13cmos5l_dlhq_1
XANTENNA__0601__A0 Tile_X0Y1_W1END[3] VPWR VGND sg13cmos5l_antennanp
XFILLER_146_242 VPWR VGND sg13cmos5l_decap_8
X_0928_ _2367_/A _0924_/X _0927_/X _1662_/Q VPWR VGND sg13cmos5l_mux2_1
X_0859_ _0859_/X _0641_/X _0717_/X _0718_/X Tile_X0Y0_S2MID[0] _1466_/Q _1467_/Q VPWR
+ VGND sg13cmos5l_mux4_1
XFILLER_136_27 VPWR VGND sg13cmos5l_decap_8
XANTENNA__1441__GATE Tile_X0Y3_FrameStrobe[7] VPWR VGND sg13cmos5l_antennanp
XFILLER_121_109 VPWR VGND sg13cmos5l_decap_8
X_2529_ Tile_X0Y3_EE4BEG[3] _2529_/A VPWR VGND sg13cmos5l_buf_1
XANTENNA__2011__D Tile_X0Y3_FrameData[24] VPWR VGND sg13cmos5l_antennanp
XFILLER_29_69 VPWR VGND sg13cmos5l_decap_8
XFILLER_195_8 VPWR VGND sg13cmos5l_decap_8
XANTENNA__1456__GATE Tile_X0Y3_FrameStrobe[0] VPWR VGND sg13cmos5l_antennanp
XANTENNA__1850__D Tile_X0Y2_FrameData[1] VPWR VGND sg13cmos5l_antennanp
XANTENNA__0668__A0 AXIL_S_SOC_RREADY VPWR VGND sg13cmos5l_antennanp
XFILLER_45_13 VPWR VGND sg13cmos5l_decap_4
XFILLER_83_273 VPWR VGND sg13cmos5l_fill_1
XFILLER_43_115 VPWR VGND sg13cmos5l_decap_8
XFILLER_43_126 VPWR VGND sg13cmos5l_fill_1
XANTENNA__1093__A0 AXIL_S_SOC_WDATA3 VPWR VGND sg13cmos5l_antennanp
XFILLER_101_30 VPWR VGND sg13cmos5l_fill_2
XANTENNA__0840__A0 AXIL_S_SOC_WSTRB1 VPWR VGND sg13cmos5l_antennanp
XANTENNA__1297__D Tile_X0Y0_FrameData[26] VPWR VGND sg13cmos5l_antennanp
XFILLER_51_192 VPWR VGND sg13cmos5l_decap_8
XANTENNA__2323__X Tile_X0Y2_EE4BEG[15] VPWR VGND sg13cmos5l_antennanp
XFILLER_124_2 VPWR VGND sg13cmos5l_fill_1
XFILLER_61_78 VPWR VGND sg13cmos5l_decap_8
XFILLER_152_201 VPWR VGND sg13cmos5l_fill_2
XANTENNA__1409__GATE Tile_X0Y3_FrameStrobe[6] VPWR VGND sg13cmos5l_antennanp
XFILLER_152_234 VPWR VGND sg13cmos5l_decap_8
XFILLER_86_31 VPWR VGND sg13cmos5l_fill_2
XFILLER_120_164 VPWR VGND sg13cmos5l_fill_1
XFILLER_126_93 VPWR VGND sg13cmos5l_decap_8
XFILLER_86_64 VPWR VGND sg13cmos5l_decap_8
XANTENNA__1760__D Tile_X0Y2_FrameData[27] VPWR VGND sg13cmos5l_antennanp
XFILLER_120_186 VPWR VGND sg13cmos5l_decap_8
XFILLER_120_197 VPWR VGND sg13cmos5l_fill_1
XFILLER_212_18 VPWR VGND sg13cmos5l_fill_1
XFILLER_142_92 VPWR VGND sg13cmos5l_fill_1
XFILLER_34_115 VPWR VGND sg13cmos5l_fill_2
XFILLER_34_104 VPWR VGND sg13cmos5l_decap_8
XFILLER_207_268 VPWR VGND sg13cmos5l_fill_2
XFILLER_215_290 VPWR VGND sg13cmos5l_decap_4
XANTENNA__1084__A0 AXIL_S_SOC_WDATA0 VPWR VGND sg13cmos5l_antennanp
X_1900_ _1900_/Q Tile_X0Y2_FrameData[15] Tile_X0Y3_FrameStrobe[6] VPWR VGND sg13cmos5l_dlhq_1
X_1831_ _1831_/Q Tile_X0Y2_FrameData[20] Tile_X0Y3_FrameStrobe[4] VPWR VGND sg13cmos5l_dlhq_1
XFILLER_42_192 VPWR VGND sg13cmos5l_decap_4
XANTENNA__2233__X Tile_X0Y1_EE4BEG[6] VPWR VGND sg13cmos5l_antennanp
XFILLER_128_253 VPWR VGND sg13cmos5l_decap_8
X_1762_ _1762_/Q Tile_X0Y2_FrameData[25] Tile_X0Y3_FrameStrobe[2] VPWR VGND sg13cmos5l_dlhq_1
XANTENNA__1935__D Tile_X0Y2_FrameData[12] VPWR VGND sg13cmos5l_antennanp
XFILLER_143_212 VPWR VGND sg13cmos5l_fill_1
X_1693_ _1693_/Q Tile_X0Y2_FrameData[30] Tile_X0Y3_FrameStrobe[0] VPWR VGND sg13cmos5l_dlhq_1
X_0713_ _0713_/X Tile_X0Y0_W2MID[6] Tile_X0Y0_W2END[6] Tile_X0Y0_W6END[9] _0646_/X
+ _1397_/Q _1396_/Q VPWR VGND sg13cmos5l_mux4_1
XANTENNA__1139__A1 Tile_X0Y2_W6END[5] VPWR VGND sg13cmos5l_antennanp
X_0644_ _2375_/A Tile_X0Y1_W2MID[6] Tile_X0Y1_W2END[6] Tile_X0Y1_W6END[6] _0864_/X
+ _1681_/Q _1680_/Q VPWR VGND sg13cmos5l_mux4_1
XANTENNA__0898__A0 Tile_X0Y0_W1END[0] VPWR VGND sg13cmos5l_antennanp
XANTENNA__2171__GATE Tile_X0Y3_FrameStrobe[7] VPWR VGND sg13cmos5l_antennanp
X_0575_ _0575_/Y _2188_/Q _0573_/Y _0574_/Y VPWR VGND sg13cmos5l_o21ai_1
X_2314_ Tile_X0Y2_EE4BEG[6] _2314_/A VPWR VGND sg13cmos5l_buf_1
XFILLER_25_0 VPWR VGND sg13cmos5l_fill_2
XANTENNA__1670__D Tile_X0Y1_FrameData[29] VPWR VGND sg13cmos5l_antennanp
XFILLER_111_186 VPWR VGND sg13cmos5l_fill_1
X_2245_ Tile_X0Y1_FrameData_O[2] Tile_X0Y1_FrameData[2] VPWR VGND sg13cmos5l_buf_1
XANTENNA__2186__GATE Tile_X0Y3_FrameStrobe[7] VPWR VGND sg13cmos5l_antennanp
XFILLER_122_18 VPWR VGND sg13cmos5l_fill_2
X_2176_ _2176_/Q Tile_X0Y3_FrameData[19] Tile_X0Y3_FrameStrobe[7] VPWR VGND sg13cmos5l_dlhq_1
X_1127_ _1128_/A _1069_/X _1068_/A _0529_/X _0742_/X _1879_/Q _1878_/Q VPWR VGND sg13cmos5l_mux4_1
XFILLER_65_284 VPWR VGND sg13cmos5l_fill_2
XFILLER_65_251 VPWR VGND sg13cmos5l_decap_4
XANTENNA__2408__X Tile_X0Y0_FrameStrobe_O[14] VPWR VGND sg13cmos5l_antennanp
XFILLER_80_232 VPWR VGND sg13cmos5l_decap_8
X_1058_ _2363_/A _1053_/Y _1057_/X _1048_/Y VPWR VGND sg13cmos5l_a21oi_1
XFILLER_33_181 VPWR VGND sg13cmos5l_fill_1
XFILLER_178_142 VPWR VGND sg13cmos5l_fill_2
XFILLER_221_293 VPWR VGND sg13cmos5l_fill_2
XFILLER_221_260 VPWR VGND sg13cmos5l_fill_2
XANTENNA__2006__D Tile_X0Y3_FrameData[29] VPWR VGND sg13cmos5l_antennanp
XANTENNA__2124__GATE Tile_X0Y3_FrameStrobe[5] VPWR VGND sg13cmos5l_antennanp
XFILLER_147_15 VPWR VGND sg13cmos5l_decap_4
XFILLER_31_59 VPWR VGND sg13cmos5l_decap_8
XFILLER_193_145 VPWR VGND sg13cmos5l_decap_8
XANTENNA__1845__D Tile_X0Y2_FrameData[6] VPWR VGND sg13cmos5l_antennanp
XFILLER_119_275 VPWR VGND sg13cmos5l_decap_4
XANTENNA__1380__GATE Tile_X0Y3_FrameStrobe[5] VPWR VGND sg13cmos5l_antennanp
XANTENNA__2139__GATE Tile_X0Y3_FrameStrobe[6] VPWR VGND sg13cmos5l_antennanp
XANTENNA__0889__A0 Tile_X0Y3_W1END[0] VPWR VGND sg13cmos5l_antennanp
XANTENNA__1395__GATE Tile_X0Y3_FrameStrobe[6] VPWR VGND sg13cmos5l_antennanp
XFILLER_0_258 VPWR VGND sg13cmos5l_decap_4
XFILLER_102_142 VPWR VGND sg13cmos5l_decap_4
XFILLER_163_58 VPWR VGND sg13cmos5l_fill_2
XANTENNA__1580__D Tile_X0Y1_FrameData[23] VPWR VGND sg13cmos5l_antennanp
XFILLER_56_240 VPWR VGND sg13cmos5l_decap_8
XFILLER_186_4 VPWR VGND sg13cmos5l_fill_1
XFILLER_16_104 VPWR VGND sg13cmos5l_decap_8
XANTENNA__0656__A3 AXIL_S_SOC_ARVALID VPWR VGND sg13cmos5l_antennanp
XANTENNA__2318__X Tile_X0Y2_EE4BEG[10] VPWR VGND sg13cmos5l_antennanp
XFILLER_112_40 VPWR VGND sg13cmos5l_fill_1
XFILLER_112_51 VPWR VGND sg13cmos5l_fill_2
XFILLER_56_284 VPWR VGND sg13cmos5l_fill_2
XFILLER_72_11 VPWR VGND sg13cmos5l_fill_2
XFILLER_71_276 VPWR VGND sg13cmos5l_decap_8
XFILLER_204_238 VPWR VGND sg13cmos5l_decap_8
XFILLER_72_55 VPWR VGND sg13cmos5l_decap_8
XFILLER_31_129 VPWR VGND sg13cmos5l_decap_8
XFILLER_188_33 VPWR VGND sg13cmos5l_decap_8
XANTENNA__1333__GATE Tile_X0Y3_FrameStrobe[4] VPWR VGND sg13cmos5l_antennanp
XANTENNA__1963__GATE Tile_X0Y3_FrameStrobe[0] VPWR VGND sg13cmos5l_antennanp
XFILLER_169_197 VPWR VGND sg13cmos5l_fill_2
XFILLER_212_293 VPWR VGND sg13cmos5l_fill_2
XANTENNA__1755__D Tile_X0Y2_FrameData[0] VPWR VGND sg13cmos5l_antennanp
XANTENNA__1348__GATE Tile_X0Y3_FrameStrobe[4] VPWR VGND sg13cmos5l_antennanp
XANTENNA__1978__GATE Tile_X0Y3_FrameStrobe[1] VPWR VGND sg13cmos5l_antennanp
XFILLER_207_18 VPWR VGND sg13cmos5l_fill_1
XANTENNA__0592__A2 Tile_X0Y2_W2MID[2] VPWR VGND sg13cmos5l_antennanp
XANTENNA__1901__GATE Tile_X0Y3_FrameStrobe[6] VPWR VGND sg13cmos5l_antennanp
XANTENNA__1490__D Tile_X0Y1_FrameData[17] VPWR VGND sg13cmos5l_antennanp
X_2030_ _2030_/Q Tile_X0Y3_FrameData[5] Tile_X0Y3_FrameStrobe[2] VPWR VGND sg13cmos5l_dlhq_1
XANTENNA__1916__GATE Tile_X0Y3_FrameStrobe[7] VPWR VGND sg13cmos5l_antennanp
XANTENNA__2228__X Tile_X0Y1_EE4BEG[1] VPWR VGND sg13cmos5l_antennanp
XFILLER_203_293 VPWR VGND sg13cmos5l_fill_2
XANTENNA__2404__A Tile_X0Y3_FrameStrobe[10] VPWR VGND sg13cmos5l_antennanp
X_1814_ _1814_/Q Tile_X0Y2_FrameData[5] Tile_X0Y3_FrameStrobe[3] VPWR VGND sg13cmos5l_dlhq_1
XFILLER_175_156 VPWR VGND sg13cmos5l_fill_2
XANTENNA__1665__D Tile_X0Y1_FrameData[2] VPWR VGND sg13cmos5l_antennanp
XFILLER_116_212 VPWR VGND sg13cmos5l_decap_8
X_1745_ _1745_/Q Tile_X0Y2_FrameData[10] Tile_X0Y3_FrameStrobe[1] VPWR VGND sg13cmos5l_dlhq_1
XFILLER_190_126 VPWR VGND sg13cmos5l_decap_8
XFILLER_117_18 VPWR VGND sg13cmos5l_decap_8
XANTENNA__0583__A2 Tile_X0Y2_W6END[9] VPWR VGND sg13cmos5l_antennanp
X_1676_ _1676_/Q Tile_X0Y1_FrameData[23] Tile_X0Y3_FrameStrobe[7] VPWR VGND sg13cmos5l_dlhq_1
X_0627_ _0627_/Y _0626_/X _0627_/B VPWR VGND sg13cmos5l_nand2b_1
X_0558_ _0558_/Y _1696_/Q _0558_/B _0558_/C VPWR VGND sg13cmos5l_nor3_1
XFILLER_97_140 VPWR VGND sg13cmos5l_decap_8
XFILLER_133_39 VPWR VGND sg13cmos5l_decap_8
X_0489_ _0489_/Y _1197_/Q Tile_X0Y0_S1END[3] VPWR VGND sg13cmos5l_nand2b_1
X_2228_ Tile_X0Y1_EE4BEG[1] _2228_/A VPWR VGND sg13cmos5l_buf_1
X_2159_ _2159_/Q Tile_X0Y3_FrameData[4] Tile_X0Y3_FrameStrobe[6] VPWR VGND sg13cmos5l_dlhq_1
XFILLER_26_26 VPWR VGND sg13cmos5l_fill_2
XFILLER_158_8 VPWR VGND sg13cmos5l_fill_2
XFILLER_198_248 VPWR VGND sg13cmos5l_decap_8
XANTENNA__2063__GATE Tile_X0Y3_FrameStrobe[3] VPWR VGND sg13cmos5l_antennanp
XFILLER_158_47 VPWR VGND sg13cmos5l_fill_1
XFILLER_166_145 VPWR VGND sg13cmos5l_fill_2
XANTENNA__1575__D Tile_X0Y1_FrameData[28] VPWR VGND sg13cmos5l_antennanp
XFILLER_166_178 VPWR VGND sg13cmos5l_decap_8
XANTENNA__2601__X Tile_X0Y3_S4BEG[7] VPWR VGND sg13cmos5l_antennanp
XFILLER_181_148 VPWR VGND sg13cmos5l_decap_8
XANTENNA__2078__GATE Tile_X0Y3_FrameStrobe[4] VPWR VGND sg13cmos5l_antennanp
XFILLER_3_19 VPWR VGND sg13cmos5l_decap_4
XANTENNA__2001__GATE Tile_X0Y3_FrameStrobe[1] VPWR VGND sg13cmos5l_antennanp
XFILLER_67_11 VPWR VGND sg13cmos5l_fill_2
XFILLER_67_99 VPWR VGND sg13cmos5l_fill_1
XFILLER_190_89 VPWR VGND sg13cmos5l_decap_8
XANTENNA__2016__GATE Tile_X0Y3_FrameStrobe[2] VPWR VGND sg13cmos5l_antennanp
XFILLER_177_0 VPWR VGND sg13cmos5l_fill_2
XFILLER_199_32 VPWR VGND sg13cmos5l_fill_2
XANTENNA__1039__A0 AXIL_S_SOC_WDATA19 VPWR VGND sg13cmos5l_antennanp
XANTENNA__1272__GATE Tile_X0Y3_FrameStrobe[2] VPWR VGND sg13cmos5l_antennanp
XFILLER_12_151 VPWR VGND sg13cmos5l_decap_8
XFILLER_197_270 VPWR VGND sg13cmos5l_decap_8
XANTENNA__0801__A3 Tile_X0Y0_S4END[3] VPWR VGND sg13cmos5l_antennanp
XANTENNA__1287__GATE Tile_X0Y3_FrameStrobe[2] VPWR VGND sg13cmos5l_antennanp
XANTENNA__1485__D Tile_X0Y1_FrameData[22] VPWR VGND sg13cmos5l_antennanp
XFILLER_8_177 VPWR VGND sg13cmos5l_decap_8
XANTENNA__2511__X Tile_X0Y3_E2BEGb[5] VPWR VGND sg13cmos5l_antennanp
X_1530_ _1530_/Q Tile_X0Y1_FrameData[9] Tile_X0Y3_FrameStrobe[2] VPWR VGND sg13cmos5l_dlhq_1
XANTENNA__1210__GATE Tile_X0Y3_FrameStrobe[0] VPWR VGND sg13cmos5l_antennanp
X_1461_ _1461_/Q Tile_X0Y1_FrameData[14] Tile_X0Y3_FrameStrobe[0] VPWR VGND sg13cmos5l_dlhq_1
XANTENNA__1840__GATE Tile_X0Y3_FrameStrobe[4] VPWR VGND sg13cmos5l_antennanp
X_1392_ _1392_/Q Tile_X0Y0_FrameData[27] Tile_X0Y3_FrameStrobe[6] VPWR VGND sg13cmos5l_dlhq_1
XANTENNA__0868__A3 Tile_X0Y0_S2MID[3] VPWR VGND sg13cmos5l_antennanp
XANTENNA__1225__GATE Tile_X0Y3_FrameStrobe[0] VPWR VGND sg13cmos5l_antennanp
XFILLER_94_143 VPWR VGND sg13cmos5l_decap_4
XANTENNA__1855__GATE Tile_X0Y3_FrameStrobe[5] VPWR VGND sg13cmos5l_antennanp
X_2013_ _2013_/Q Tile_X0Y3_FrameData[22] Tile_X0Y3_FrameStrobe[2] VPWR VGND sg13cmos5l_dlhq_1
XFILLER_92_0 VPWR VGND sg13cmos5l_fill_1
XFILLER_128_17 VPWR VGND sg13cmos5l_fill_1
XANTENNA__1395__D Tile_X0Y0_FrameData[24] VPWR VGND sg13cmos5l_antennanp
XANTENNA__2421__X Tile_X0Y0_FrameData_O[7] VPWR VGND sg13cmos5l_antennanp
X_1728_ _1728_/Q Tile_X0Y2_FrameData[27] Tile_X0Y3_FrameStrobe[1] VPWR VGND sg13cmos5l_dlhq_1
XANTENNA__1808__GATE Tile_X0Y3_FrameStrobe[3] VPWR VGND sg13cmos5l_antennanp
XFILLER_171_181 VPWR VGND sg13cmos5l_fill_2
X_1659_ _1659_/Q Tile_X0Y1_FrameData[8] Tile_X0Y3_FrameStrobe[6] VPWR VGND sg13cmos5l_dlhq_1
XFILLER_104_259 VPWR VGND sg13cmos5l_decap_8
XFILLER_144_16 VPWR VGND sg13cmos5l_fill_1
XFILLER_112_270 VPWR VGND sg13cmos5l_decap_8
XANTENNA__0859__A3 Tile_X0Y0_S2MID[0] VPWR VGND sg13cmos5l_antennanp
XFILLER_37_14 VPWR VGND sg13cmos5l_decap_4
XFILLER_160_26 VPWR VGND sg13cmos5l_fill_2
XANTENNA__0492__A1 Tile_X0Y0_W6END[11] VPWR VGND sg13cmos5l_antennanp
XFILLER_185_12 VPWR VGND sg13cmos5l_fill_1
XANTENNA__0547__A2 Tile_X0Y3_N4END[9] VPWR VGND sg13cmos5l_antennanp
XANTENNA__2331__X Tile_X0Y2_FrameData_O[7] VPWR VGND sg13cmos5l_antennanp
XFILLER_5_158 VPWR VGND sg13cmos5l_decap_4
XFILLER_162_181 VPWR VGND sg13cmos5l_fill_1
XFILLER_78_32 VPWR VGND sg13cmos5l_fill_2
XFILLER_78_10 VPWR VGND sg13cmos5l_decap_4
XFILLER_134_60 VPWR VGND sg13cmos5l_decap_8
XFILLER_91_113 VPWR VGND sg13cmos5l_fill_1
XFILLER_17_254 VPWR VGND sg13cmos5l_decap_4
XFILLER_17_232 VPWR VGND sg13cmos5l_fill_1
XANTENNA__0483__A1 Tile_X0Y3_N2END[2] VPWR VGND sg13cmos5l_antennanp
XANTENNA__2506__X Tile_X0Y3_E2BEGb[0] VPWR VGND sg13cmos5l_antennanp
XFILLER_32_224 VPWR VGND sg13cmos5l_decap_4
X_0961_ _2207_/A AXIL_S_SOC_WDATA16 AXIL_S_SOC_WDATA24 _0859_/X _0862_/X _1595_/Q
+ _1594_/Q VPWR VGND sg13cmos5l_mux4_1
XANTENNA__0786__A2 Tile_X0Y0_S1END[2] VPWR VGND sg13cmos5l_antennanp
XFILLER_145_115 VPWR VGND sg13cmos5l_decap_4
X_0892_ AXIL_S_SOC_WREADY Tile_X0Y0_W1END[2] Tile_X0Y0_W6END[10] Tile_X0Y0_WW4END[13]
+ _0461_/Y _1254_/Q _1255_/Q VPWR VGND sg13cmos5l_mux4_1
XFILLER_40_290 VPWR VGND sg13cmos5l_decap_4
XANTENNA__2104__D Tile_X0Y3_FrameData[27] VPWR VGND sg13cmos5l_antennanp
XANTENNA__2241__X Tile_X0Y1_EE4BEG[14] VPWR VGND sg13cmos5l_antennanp
X_2562_ Tile_X0Y3_FrameData_O[20] Tile_X0Y3_FrameData[20] VPWR VGND sg13cmos5l_buf_1
XANTENNA__1943__D Tile_X0Y3_FrameData[28] VPWR VGND sg13cmos5l_antennanp
XFILLER_153_170 VPWR VGND sg13cmos5l_decap_4
X_1513_ _1513_/Q Tile_X0Y1_FrameData[26] Tile_X0Y3_FrameStrobe[2] VPWR VGND sg13cmos5l_dlhq_1
X_2493_ Tile_X0Y0_E1BEG[3] _2493_/A VPWR VGND sg13cmos5l_buf_1
XFILLER_99_246 VPWR VGND sg13cmos5l_fill_1
XFILLER_101_229 VPWR VGND sg13cmos5l_decap_8
X_1444_ _1444_/Q Tile_X0Y0_FrameData[31] Tile_X0Y3_FrameStrobe[0] VPWR VGND sg13cmos5l_dlhq_1
XANTENNA__1794__GATE Tile_X0Y3_FrameStrobe[3] VPWR VGND sg13cmos5l_antennanp
X_1375_ _1375_/Q Tile_X0Y0_FrameData[12] Tile_X0Y3_FrameStrobe[5] VPWR VGND sg13cmos5l_dlhq_1
XANTENNA__0710__A2 Tile_X0Y1_W6END[4] VPWR VGND sg13cmos5l_antennanp
XFILLER_223_141 VPWR VGND sg13cmos5l_fill_2
XANTENNA__2416__X Tile_X0Y0_FrameData_O[2] VPWR VGND sg13cmos5l_antennanp
XFILLER_23_27 VPWR VGND sg13cmos5l_fill_1
XANTENNA__1732__GATE Tile_X0Y3_FrameStrobe[1] VPWR VGND sg13cmos5l_antennanp
XANTENNA__2014__D Tile_X0Y3_FrameData[21] VPWR VGND sg13cmos5l_antennanp
XFILLER_219_93 VPWR VGND sg13cmos5l_fill_1
XFILLER_219_82 VPWR VGND sg13cmos5l_decap_8
XANTENNA__0529__A2 Tile_X0Y3_N4END[4] VPWR VGND sg13cmos5l_antennanp
XANTENNA__1747__GATE Tile_X0Y3_FrameStrobe[1] VPWR VGND sg13cmos5l_antennanp
XANTENNA__1853__D Tile_X0Y2_FrameData[30] VPWR VGND sg13cmos5l_antennanp
XFILLER_155_48 VPWR VGND sg13cmos5l_fill_2
XFILLER_2_117 VPWR VGND sg13cmos5l_fill_1
XFILLER_2_106 VPWR VGND sg13cmos5l_decap_8
XFILLER_58_110 VPWR VGND sg13cmos5l_decap_8
XFILLER_171_36 VPWR VGND sg13cmos5l_decap_8
XFILLER_171_47 VPWR VGND sg13cmos5l_fill_2
XANTENNA__0701__A2 Tile_X0Y3_W6END[4] VPWR VGND sg13cmos5l_antennanp
XFILLER_73_124 VPWR VGND sg13cmos5l_decap_4
XFILLER_73_102 VPWR VGND sg13cmos5l_fill_1
XFILLER_104_74 VPWR VGND sg13cmos5l_fill_1
XFILLER_104_85 VPWR VGND sg13cmos5l_fill_2
XFILLER_14_213 VPWR VGND sg13cmos5l_decap_8
XFILLER_64_56 VPWR VGND sg13cmos5l_decap_4
XANTENNA__2326__X Tile_X0Y2_FrameData_O[2] VPWR VGND sg13cmos5l_antennanp
XFILLER_9_18 VPWR VGND sg13cmos5l_fill_1
XFILLER_64_89 VPWR VGND sg13cmos5l_fill_1
XFILLER_120_51 VPWR VGND sg13cmos5l_decap_8
XFILLER_127_137 VPWR VGND sg13cmos5l_decap_4
XFILLER_127_159 VPWR VGND sg13cmos5l_fill_2
XFILLER_129_71 VPWR VGND sg13cmos5l_decap_8
XFILLER_182_265 VPWR VGND sg13cmos5l_decap_8
XFILLER_135_170 VPWR VGND sg13cmos5l_decap_8
XFILLER_135_181 VPWR VGND sg13cmos5l_fill_1
XANTENNA__1763__D Tile_X0Y2_FrameData[24] VPWR VGND sg13cmos5l_antennanp
XFILLER_145_70 VPWR VGND sg13cmos5l_decap_8
XFILLER_96_216 VPWR VGND sg13cmos5l_decap_4
XFILLER_150_184 VPWR VGND sg13cmos5l_fill_2
XFILLER_96_249 VPWR VGND sg13cmos5l_decap_4
X_1160_ _1160_/X Tile_X0Y2_W1END[2] Tile_X0Y2_W6END[10] Tile_X0Y2_WW4END[2] _1110_/X
+ _1908_/Q _1909_/Q VPWR VGND sg13cmos5l_mux4_1
X_1091_ _2293_/A AXIL_S_SOC_WDATA5 AXIL_S_SOC_WDATA13 _0725_/X _0732_/X _1833_/Q _1832_/Q
+ VPWR VGND sg13cmos5l_mux4_1
XFILLER_64_157 VPWR VGND sg13cmos5l_decap_8
XANTENNA__2236__X Tile_X0Y1_EE4BEG[9] VPWR VGND sg13cmos5l_antennanp
XFILLER_220_111 VPWR VGND sg13cmos5l_fill_2
XANTENNA__1938__D Tile_X0Y2_FrameData[9] VPWR VGND sg13cmos5l_antennanp
X_1993_ _1993_/Q Tile_X0Y3_FrameData[10] Tile_X0Y3_FrameStrobe[1] VPWR VGND sg13cmos5l_dlhq_1
XANTENNA__0759__A2 Tile_X0Y0_W6END[0] VPWR VGND sg13cmos5l_antennanp
X_0944_ _2598_/A _0941_/Y _0943_/Y _0939_/Y VPWR VGND sg13cmos5l_a21oi_1
XFILLER_220_199 VPWR VGND sg13cmos5l_fill_1
X_0875_ _2461_/A AXIL_S_SOC_WSTRB2 AXIL_S_SOC_AWADDR9 _0761_/X _0643_/X _1301_/Q _1300_/Q
+ VPWR VGND sg13cmos5l_mux4_1
XFILLER_9_294 VPWR VGND sg13cmos5l_fill_1
XFILLER_173_210 VPWR VGND sg13cmos5l_fill_2
XANTENNA__2412__A Tile_X0Y3_FrameStrobe[18] VPWR VGND sg13cmos5l_antennanp
XFILLER_173_276 VPWR VGND sg13cmos5l_decap_8
XFILLER_173_243 VPWR VGND sg13cmos5l_decap_8
XFILLER_55_0 VPWR VGND sg13cmos5l_decap_4
XANTENNA__1184__A2 Tile_X0Y3_WW4END[1] VPWR VGND sg13cmos5l_antennanp
XANTENNA__1673__D Tile_X0Y1_FrameData[26] VPWR VGND sg13cmos5l_antennanp
X_2545_ Tile_X0Y3_FrameData_O[3] Tile_X0Y3_FrameData[3] VPWR VGND sg13cmos5l_buf_1
X_2476_ Tile_X0Y0_E2BEGb[2] _2476_/A VPWR VGND sg13cmos5l_buf_1
XANTENNA__0931__A2 Tile_X0Y3_N4END[10] VPWR VGND sg13cmos5l_antennanp
X_1427_ _1427_/Q Tile_X0Y0_FrameData[24] Tile_X0Y3_FrameStrobe[7] VPWR VGND sg13cmos5l_dlhq_1
XFILLER_87_249 VPWR VGND sg13cmos5l_fill_2
XFILLER_141_28 VPWR VGND sg13cmos5l_decap_8
X_1358_ _1358_/Q Tile_X0Y0_FrameData[29] Tile_X0Y3_FrameStrobe[5] VPWR VGND sg13cmos5l_dlhq_1
XFILLER_95_293 VPWR VGND sg13cmos5l_fill_2
X_1289_ _1289_/Q Tile_X0Y0_FrameData[2] Tile_X0Y3_FrameStrobe[2] VPWR VGND sg13cmos5l_dlhq_1
XFILLER_70_105 VPWR VGND sg13cmos5l_decap_8
XFILLER_221_50 VPWR VGND sg13cmos5l_fill_1
XANTENNA__2009__D Tile_X0Y3_FrameData[26] VPWR VGND sg13cmos5l_antennanp
XANTENNA__1671__GATE Tile_X0Y3_FrameStrobe[7] VPWR VGND sg13cmos5l_antennanp
XANTENNA__1848__D Tile_X0Y2_FrameData[3] VPWR VGND sg13cmos5l_antennanp
XFILLER_149_240 VPWR VGND sg13cmos5l_decap_8
XFILLER_50_14 VPWR VGND sg13cmos5l_fill_2
XANTENNA__1686__GATE Tile_X0Y3_FrameStrobe[7] VPWR VGND sg13cmos5l_antennanp
XFILLER_124_107 VPWR VGND sg13cmos5l_decap_4
XFILLER_124_129 VPWR VGND sg13cmos5l_decap_8
XANTENNA__1175__A2 Tile_X0Y2_W6END[4] VPWR VGND sg13cmos5l_antennanp
XANTENNA__1583__D Tile_X0Y1_FrameData[20] VPWR VGND sg13cmos5l_antennanp
XFILLER_59_23 VPWR VGND sg13cmos5l_fill_2
XANTENNA__0922__A2 Tile_X0Y3_N4END[9] VPWR VGND sg13cmos5l_antennanp
XFILLER_75_11 VPWR VGND sg13cmos5l_decap_8
XANTENNA__1624__GATE Tile_X0Y3_FrameStrobe[5] VPWR VGND sg13cmos5l_antennanp
XFILLER_86_293 VPWR VGND sg13cmos5l_fill_2
XFILLER_86_271 VPWR VGND sg13cmos5l_decap_8
XFILLER_46_113 VPWR VGND sg13cmos5l_decap_8
XFILLER_131_72 VPWR VGND sg13cmos5l_decap_8
XFILLER_54_190 VPWR VGND sg13cmos5l_decap_8
XANTENNA__1639__GATE Tile_X0Y3_FrameStrobe[6] VPWR VGND sg13cmos5l_antennanp
XANTENNA__1758__D Tile_X0Y2_FrameData[29] VPWR VGND sg13cmos5l_antennanp
XFILLER_202_144 VPWR VGND sg13cmos5l_decap_8
XFILLER_24_92 VPWR VGND sg13cmos5l_decap_8
XANTENNA__0610__A1 Tile_X0Y3_N4END[1] VPWR VGND sg13cmos5l_antennanp
XFILLER_10_293 VPWR VGND sg13cmos5l_fill_2
X_0660_ _2501_/A AXIL_S_SOC_RREADY AXIL_S_SOC_ARADDR6 _0511_/X _0590_/X _2101_/Q _2100_/Q
+ VPWR VGND sg13cmos5l_mux4_1
XFILLER_6_286 VPWR VGND sg13cmos5l_fill_1
XANTENNA__1493__D Tile_X0Y1_FrameData[14] VPWR VGND sg13cmos5l_antennanp
XFILLER_108_192 VPWR VGND sg13cmos5l_fill_1
X_0591_ _2582_/A Tile_X0Y3_W1END[0] Tile_X0Y3_W2MID[3] Tile_X0Y3_W2END[3] _0590_/X
+ _2135_/Q _2134_/Q VPWR VGND sg13cmos5l_mux4_1
X_2330_ Tile_X0Y2_FrameData_O[6] Tile_X0Y2_FrameData[6] VPWR VGND sg13cmos5l_buf_1
XANTENNA__0913__A2 Tile_X0Y3_N4END[8] VPWR VGND sg13cmos5l_antennanp
XFILLER_123_173 VPWR VGND sg13cmos5l_fill_2
X_2261_ Tile_X0Y1_FrameData_O[18] Tile_X0Y1_FrameData[18] VPWR VGND sg13cmos5l_buf_1
X_1212_ _1212_/Q Tile_X0Y0_FrameData[15] Tile_X0Y3_FrameStrobe[0] VPWR VGND sg13cmos5l_dlhq_1
X_2192_ _2192_/Q Tile_X0Y3_FrameData[5] Tile_X0Y3_FrameStrobe[7] VPWR VGND sg13cmos5l_dlhq_1
XFILLER_77_282 VPWR VGND sg13cmos5l_fill_2
XANTENNA__0677__A1 AXIL_S_SOC_ARADDR3 VPWR VGND sg13cmos5l_antennanp
X_1143_ _1144_/C _1875_/Q _1143_/B _1143_/C VPWR VGND sg13cmos5l_nor3_1
XFILLER_77_293 VPWR VGND sg13cmos5l_fill_2
XFILLER_37_135 VPWR VGND sg13cmos5l_decap_8
X_1074_ _1075_/B _1915_/Q _0529_/X _1073_/X VPWR VGND sg13cmos5l_o21ai_1
XFILLER_225_236 VPWR VGND sg13cmos5l_decap_8
XANTENNA__2407__A Tile_X0Y3_FrameStrobe[13] VPWR VGND sg13cmos5l_antennanp
XANTENNA__1668__D Tile_X0Y1_FrameData[31] VPWR VGND sg13cmos5l_antennanp
X_1976_ _1976_/Q Tile_X0Y3_FrameData[27] Tile_X0Y3_FrameStrobe[1] VPWR VGND sg13cmos5l_dlhq_1
X_0927_ _0927_/X _0926_/X _0925_/X _0547_/X _0864_/X _1664_/Q _1663_/Q VPWR VGND sg13cmos5l_mux4_1
XANTENNA__0601__A1 Tile_X0Y1_W2MID[0] VPWR VGND sg13cmos5l_antennanp
XFILLER_161_202 VPWR VGND sg13cmos5l_decap_4
X_0858_ _0858_/X Tile_X0Y2_W1END[3] _0500_/X Tile_X0Y2_W6END[7] _0504_/Y _1932_/Q
+ _1933_/Q VPWR VGND sg13cmos5l_mux4_1
XFILLER_161_246 VPWR VGND sg13cmos5l_decap_8
XFILLER_161_257 VPWR VGND sg13cmos5l_fill_2
X_0789_ _2372_/A _0787_/X _0788_/X _1411_/Q VPWR VGND sg13cmos5l_mux2_1
XFILLER_161_279 VPWR VGND sg13cmos5l_decap_4
X_2528_ Tile_X0Y3_EE4BEG[2] _2528_/A VPWR VGND sg13cmos5l_buf_1
XFILLER_216_83 VPWR VGND sg13cmos5l_fill_2
XFILLER_216_50 VPWR VGND sg13cmos5l_fill_1
X_2459_ Tile_X0Y0_EE4BEG[13] _2459_/A VPWR VGND sg13cmos5l_buf_1
XFILLER_68_282 VPWR VGND sg13cmos5l_fill_2
XANTENNA__0668__A1 AXIL_S_SOC_ARADDR6 VPWR VGND sg13cmos5l_antennanp
XFILLER_68_293 VPWR VGND sg13cmos5l_fill_2
XFILLER_28_124 VPWR VGND sg13cmos5l_decap_8
XFILLER_45_47 VPWR VGND sg13cmos5l_fill_1
XFILLER_45_25 VPWR VGND sg13cmos5l_fill_1
XANTENNA__1093__A1 AXIL_S_SOC_WDATA11 VPWR VGND sg13cmos5l_antennanp
XANTENNA__1578__D Tile_X0Y1_FrameData[25] VPWR VGND sg13cmos5l_antennanp
XFILLER_101_64 VPWR VGND sg13cmos5l_decap_8
XFILLER_101_75 VPWR VGND sg13cmos5l_fill_1
XFILLER_51_171 VPWR VGND sg13cmos5l_decap_8
XFILLER_196_143 VPWR VGND sg13cmos5l_fill_2
XFILLER_196_132 VPWR VGND sg13cmos5l_decap_8
XANTENNA__0840__A1 AXIL_S_SOC_AWADDR4 VPWR VGND sg13cmos5l_antennanp
XANTENNA__2604__X Tile_X0Y3_S4BEG[10] VPWR VGND sg13cmos5l_antennanp
XFILLER_101_86 VPWR VGND sg13cmos5l_decap_8
XFILLER_196_176 VPWR VGND sg13cmos5l_decap_8
XFILLER_137_243 VPWR VGND sg13cmos5l_fill_2
XFILLER_3_234 VPWR VGND sg13cmos5l_fill_1
XANTENNA__1148__A2 AXIL_S_SOC_WDATA0 VPWR VGND sg13cmos5l_antennanp
XFILLER_105_184 VPWR VGND sg13cmos5l_decap_8
XFILLER_120_110 VPWR VGND sg13cmos5l_decap_4
XFILLER_126_72 VPWR VGND sg13cmos5l_decap_8
XFILLER_120_132 VPWR VGND sg13cmos5l_fill_1
XANTENNA__1563__GATE Tile_X0Y3_FrameStrobe[3] VPWR VGND sg13cmos5l_antennanp
XFILLER_74_230 VPWR VGND sg13cmos5l_decap_8
XFILLER_59_293 VPWR VGND sg13cmos5l_fill_2
XANTENNA__1578__GATE Tile_X0Y3_FrameStrobe[4] VPWR VGND sg13cmos5l_antennanp
XANTENNA__1131__A Tile_X0Y2_WW4END[12] VPWR VGND sg13cmos5l_antennanp
XANTENNA__1084__A1 AXIL_S_SOC_WDATA8 VPWR VGND sg13cmos5l_antennanp
XANTENNA__1488__D Tile_X0Y1_FrameData[19] VPWR VGND sg13cmos5l_antennanp
XFILLER_187_110 VPWR VGND sg13cmos5l_decap_8
XANTENNA__1501__GATE Tile_X0Y3_FrameStrobe[1] VPWR VGND sg13cmos5l_antennanp
XANTENNA__2514__X Tile_X0Y3_E6BEG[0] VPWR VGND sg13cmos5l_antennanp
X_1830_ _1830_/Q Tile_X0Y2_FrameData[21] Tile_X0Y3_FrameStrobe[4] VPWR VGND sg13cmos5l_dlhq_1
X_1761_ _1761_/Q Tile_X0Y2_FrameData[26] Tile_X0Y3_FrameStrobe[2] VPWR VGND sg13cmos5l_dlhq_1
XANTENNA__0595__A0 Tile_X0Y3_W1END[1] VPWR VGND sg13cmos5l_antennanp
X_1692_ _1692_/Q Tile_X0Y1_FrameData[31] Tile_X0Y3_FrameStrobe[0] VPWR VGND sg13cmos5l_dlhq_1
X_0712_ _0712_/X _2377_/A _0711_/X Tile_X0Y0_S2MID[3] Tile_X0Y0_S2END[3] _1213_/Q
+ _1212_/Q VPWR VGND sg13cmos5l_mux4_1
XANTENNA__1516__GATE Tile_X0Y3_FrameStrobe[2] VPWR VGND sg13cmos5l_antennanp
X_0643_ _0643_/X _2374_/A _0641_/X Tile_X0Y0_S2MID[0] Tile_X0Y0_S2END[0] _1219_/Q
+ _1218_/Q VPWR VGND sg13cmos5l_mux4_1
XANTENNA__2112__D Tile_X0Y3_FrameData[19] VPWR VGND sg13cmos5l_antennanp
XANTENNA__0898__A1 Tile_X0Y0_W6END[8] VPWR VGND sg13cmos5l_antennanp
X_2313_ Tile_X0Y2_EE4BEG[5] _2313_/A VPWR VGND sg13cmos5l_buf_1
X_0574_ _0574_/Y _1941_/Q _0574_/B _2188_/Q VPWR VGND sg13cmos5l_nand3b_1
XANTENNA__1951__D Tile_X0Y3_FrameData[20] VPWR VGND sg13cmos5l_antennanp
X_2244_ Tile_X0Y1_FrameData_O[1] Tile_X0Y1_FrameData[1] VPWR VGND sg13cmos5l_buf_1
X_2175_ _2175_/Q Tile_X0Y3_FrameData[20] Tile_X0Y3_FrameStrobe[7] VPWR VGND sg13cmos5l_dlhq_1
XFILLER_18_0 VPWR VGND sg13cmos5l_decap_4
X_1126_ _2303_/A AXIL_S_SOC_WDATA7 _1068_/A _1069_/X _0746_/X _1780_/Q _1781_/Q VPWR
+ VGND sg13cmos5l_mux4_1
XFILLER_80_211 VPWR VGND sg13cmos5l_decap_8
XFILLER_15_39 VPWR VGND sg13cmos5l_decap_8
X_1057_ _1057_/X _1910_/Q _1057_/B VPWR VGND sg13cmos5l_and2_1
XFILLER_202_63 VPWR VGND sg13cmos5l_decap_8
XANTENNA__1398__D Tile_X0Y0_FrameData[21] VPWR VGND sg13cmos5l_antennanp
XANTENNA__2424__X Tile_X0Y0_FrameData_O[10] VPWR VGND sg13cmos5l_antennanp
XFILLER_193_124 VPWR VGND sg13cmos5l_decap_4
XFILLER_119_232 VPWR VGND sg13cmos5l_decap_8
X_1959_ _1959_/Q Tile_X0Y3_FrameData[12] Tile_X0Y3_FrameStrobe[0] VPWR VGND sg13cmos5l_dlhq_1
XANTENNA__0586__A0 Tile_X0Y3_W2MID[5] VPWR VGND sg13cmos5l_antennanp
XFILLER_134_246 VPWR VGND sg13cmos5l_decap_8
XANTENNA__2022__D Tile_X0Y3_FrameData[13] VPWR VGND sg13cmos5l_antennanp
XFILLER_0_237 VPWR VGND sg13cmos5l_decap_8
XANTENNA__0889__A1 Tile_X0Y3_W6END[4] VPWR VGND sg13cmos5l_antennanp
XANTENNA__1861__D Tile_X0Y2_FrameData[22] VPWR VGND sg13cmos5l_antennanp
XFILLER_102_121 VPWR VGND sg13cmos5l_decap_8
XFILLER_102_165 VPWR VGND sg13cmos5l_decap_8
XANTENNA__0510__A0 Tile_X0Y1_W2MID[4] VPWR VGND sg13cmos5l_antennanp
XFILLER_16_138 VPWR VGND sg13cmos5l_decap_4
XFILLER_204_206 VPWR VGND sg13cmos5l_decap_8
XFILLER_72_34 VPWR VGND sg13cmos5l_decap_8
XFILLER_71_255 VPWR VGND sg13cmos5l_decap_8
XFILLER_31_108 VPWR VGND sg13cmos5l_decap_8
XANTENNA__2334__X Tile_X0Y2_FrameData_O[10] VPWR VGND sg13cmos5l_antennanp
XFILLER_169_165 VPWR VGND sg13cmos5l_decap_4
XFILLER_122_0 VPWR VGND sg13cmos5l_fill_2
XANTENNA__0577__A0 Tile_X0Y1_W2MID[7] VPWR VGND sg13cmos5l_antennanp
XFILLER_125_257 VPWR VGND sg13cmos5l_fill_1
XFILLER_125_279 VPWR VGND sg13cmos5l_fill_1
XFILLER_140_249 VPWR VGND sg13cmos5l_decap_8
XANTENNA__1771__D Tile_X0Y2_FrameData[16] VPWR VGND sg13cmos5l_antennanp
XANTENNA__2509__X Tile_X0Y3_E2BEGb[3] VPWR VGND sg13cmos5l_antennanp
XFILLER_47_230 VPWR VGND sg13cmos5l_decap_8
XFILLER_47_274 VPWR VGND sg13cmos5l_decap_4
XFILLER_47_241 VPWR VGND sg13cmos5l_decap_4
XANTENNA__1440__GATE Tile_X0Y3_FrameStrobe[7] VPWR VGND sg13cmos5l_antennanp
XFILLER_62_277 VPWR VGND sg13cmos5l_fill_1
XANTENNA__2107__D Tile_X0Y3_FrameData[24] VPWR VGND sg13cmos5l_antennanp
XANTENNA__2244__X Tile_X0Y1_FrameData_O[1] VPWR VGND sg13cmos5l_antennanp
XFILLER_203_250 VPWR VGND sg13cmos5l_fill_2
XANTENNA__1946__D Tile_X0Y3_FrameData[25] VPWR VGND sg13cmos5l_antennanp
X_1813_ _1813_/Q Tile_X0Y2_FrameData[6] Tile_X0Y3_FrameStrobe[3] VPWR VGND sg13cmos5l_dlhq_1
XANTENNA__1455__GATE Tile_X0Y3_FrameStrobe[0] VPWR VGND sg13cmos5l_antennanp
X_1744_ _1744_/Q Tile_X0Y2_FrameData[11] Tile_X0Y3_FrameStrobe[1] VPWR VGND sg13cmos5l_dlhq_1
XFILLER_7_51 VPWR VGND sg13cmos5l_decap_4
XFILLER_7_40 VPWR VGND sg13cmos5l_fill_1
XANTENNA__2420__A Tile_X0Y0_FrameData[6] VPWR VGND sg13cmos5l_antennanp
X_1675_ _1675_/Q Tile_X0Y1_FrameData[24] Tile_X0Y3_FrameStrobe[7] VPWR VGND sg13cmos5l_dlhq_1
X_0626_ _0626_/X Tile_X0Y3_W2MID[1] Tile_X0Y3_W2END[1] Tile_X0Y3_W6END[1] _0584_/X
+ _2017_/Q _2016_/Q VPWR VGND sg13cmos5l_mux4_1
XANTENNA__1681__D Tile_X0Y1_FrameData[18] VPWR VGND sg13cmos5l_antennanp
XFILLER_131_249 VPWR VGND sg13cmos5l_decap_8
X_0557_ _0558_/C _1697_/Q _0888_/X VPWR VGND sg13cmos5l_nor2_1
XANTENNA__0740__A0 Tile_X0Y0_W1END[0] VPWR VGND sg13cmos5l_antennanp
XFILLER_97_185 VPWR VGND sg13cmos5l_decap_8
XANTENNA__2419__X Tile_X0Y0_FrameData_O[5] VPWR VGND sg13cmos5l_antennanp
X_2227_ Tile_X0Y1_EE4BEG[0] _2227_/A VPWR VGND sg13cmos5l_buf_1
X_0488_ _0488_/X _0771_/X Tile_X0Y0_S1END[3] Tile_X0Y3_N4END[15] Tile_X0Y0_S4END[3]
+ _1220_/Q _1221_/Q VPWR VGND sg13cmos5l_mux4_1
XFILLER_213_40 VPWR VGND sg13cmos5l_fill_1
X_2158_ _2158_/Q Tile_X0Y3_FrameData[5] Tile_X0Y3_FrameStrobe[6] VPWR VGND sg13cmos5l_dlhq_1
X_1109_ _2317_/A AXIL_S_SOC_WDATA5 AXIL_S_SOC_WDATA9 _1108_/X _0729_/X _1809_/Q _1808_/Q
+ VPWR VGND sg13cmos5l_mux4_1
X_2089_ _2089_/Q Tile_X0Y3_FrameData[10] Tile_X0Y3_FrameStrobe[4] VPWR VGND sg13cmos5l_dlhq_1
XFILLER_53_233 VPWR VGND sg13cmos5l_decap_8
XFILLER_198_205 VPWR VGND sg13cmos5l_decap_8
XANTENNA__1408__GATE Tile_X0Y3_FrameStrobe[6] VPWR VGND sg13cmos5l_antennanp
XFILLER_201_209 VPWR VGND sg13cmos5l_decap_8
XANTENNA__2017__D Tile_X0Y3_FrameData[18] VPWR VGND sg13cmos5l_antennanp
XFILLER_166_102 VPWR VGND sg13cmos5l_decap_8
XFILLER_166_113 VPWR VGND sg13cmos5l_fill_1
XFILLER_166_124 VPWR VGND sg13cmos5l_decap_8
XANTENNA__1856__D Tile_X0Y2_FrameData[27] VPWR VGND sg13cmos5l_antennanp
XFILLER_166_157 VPWR VGND sg13cmos5l_decap_8
XFILLER_107_202 VPWR VGND sg13cmos5l_fill_1
XFILLER_174_36 VPWR VGND sg13cmos5l_fill_1
XANTENNA__2330__A Tile_X0Y2_FrameData[6] VPWR VGND sg13cmos5l_antennanp
XANTENNA__1591__D Tile_X0Y1_FrameData[12] VPWR VGND sg13cmos5l_antennanp
XFILLER_122_249 VPWR VGND sg13cmos5l_decap_8
XANTENNA__0731__A0 Tile_X0Y3_W2MID[2] VPWR VGND sg13cmos5l_antennanp
XFILLER_130_271 VPWR VGND sg13cmos5l_decap_8
XFILLER_88_163 VPWR VGND sg13cmos5l_decap_8
XFILLER_130_282 VPWR VGND sg13cmos5l_fill_2
XANTENNA__2329__X Tile_X0Y2_FrameData_O[5] VPWR VGND sg13cmos5l_antennanp
XFILLER_123_95 VPWR VGND sg13cmos5l_decap_8
XFILLER_44_200 VPWR VGND sg13cmos5l_decap_8
XFILLER_83_55 VPWR VGND sg13cmos5l_decap_8
XANTENNA__1039__A1 AXIL_S_SOC_WDATA31 VPWR VGND sg13cmos5l_antennanp
XFILLER_83_88 VPWR VGND sg13cmos5l_decap_8
XFILLER_199_77 VPWR VGND sg13cmos5l_decap_8
XANTENNA__2170__GATE Tile_X0Y3_FrameStrobe[7] VPWR VGND sg13cmos5l_antennanp
XFILLER_16_82 VPWR VGND sg13cmos5l_fill_1
XFILLER_197_293 VPWR VGND sg13cmos5l_fill_2
XANTENNA__1766__D Tile_X0Y2_FrameData[21] VPWR VGND sg13cmos5l_antennanp
XFILLER_157_135 VPWR VGND sg13cmos5l_decap_8
XFILLER_200_264 VPWR VGND sg13cmos5l_fill_1
XFILLER_200_286 VPWR VGND sg13cmos5l_fill_1
XANTENNA__2185__GATE Tile_X0Y3_FrameStrobe[7] VPWR VGND sg13cmos5l_antennanp
XFILLER_148_92 VPWR VGND sg13cmos5l_decap_8
XFILLER_165_190 VPWR VGND sg13cmos5l_decap_8
XFILLER_66_8 VPWR VGND sg13cmos5l_fill_2
XFILLER_172_127 VPWR VGND sg13cmos5l_decap_8
X_1460_ _1460_/Q Tile_X0Y1_FrameData[15] Tile_X0Y3_FrameStrobe[0] VPWR VGND sg13cmos5l_dlhq_1
X_1391_ _1391_/Q Tile_X0Y0_FrameData[28] Tile_X0Y3_FrameStrobe[6] VPWR VGND sg13cmos5l_dlhq_1
XFILLER_79_174 VPWR VGND sg13cmos5l_fill_1
XANTENNA__0722__A0 Tile_X0Y0_W1END[2] VPWR VGND sg13cmos5l_antennanp
XFILLER_121_282 VPWR VGND sg13cmos5l_fill_1
XANTENNA__2123__GATE Tile_X0Y3_FrameStrobe[5] VPWR VGND sg13cmos5l_antennanp
XANTENNA__2239__X Tile_X0Y1_EE4BEG[12] VPWR VGND sg13cmos5l_antennanp
XFILLER_94_177 VPWR VGND sg13cmos5l_decap_4
X_2012_ _2012_/Q Tile_X0Y3_FrameData[23] Tile_X0Y3_FrameStrobe[2] VPWR VGND sg13cmos5l_dlhq_1
XFILLER_35_222 VPWR VGND sg13cmos5l_decap_8
XANTENNA__2138__GATE Tile_X0Y3_FrameStrobe[6] VPWR VGND sg13cmos5l_antennanp
XFILLER_50_236 VPWR VGND sg13cmos5l_fill_2
XANTENNA__2415__A Tile_X0Y0_FrameData[1] VPWR VGND sg13cmos5l_antennanp
XFILLER_148_113 VPWR VGND sg13cmos5l_fill_1
XFILLER_85_0 VPWR VGND sg13cmos5l_fill_2
XFILLER_188_271 VPWR VGND sg13cmos5l_decap_8
XANTENNA__1394__GATE Tile_X0Y3_FrameStrobe[6] VPWR VGND sg13cmos5l_antennanp
XANTENNA__1676__D Tile_X0Y1_FrameData[23] VPWR VGND sg13cmos5l_antennanp
XFILLER_188_293 VPWR VGND sg13cmos5l_fill_2
XFILLER_163_127 VPWR VGND sg13cmos5l_fill_1
X_1727_ _1727_/Q Tile_X0Y2_FrameData[28] Tile_X0Y3_FrameStrobe[1] VPWR VGND sg13cmos5l_dlhq_1
XFILLER_208_51 VPWR VGND sg13cmos5l_decap_8
XANTENNA__0961__A0 AXIL_S_SOC_WDATA16 VPWR VGND sg13cmos5l_antennanp
X_1658_ _1658_/Q Tile_X0Y1_FrameData[9] Tile_X0Y3_FrameStrobe[6] VPWR VGND sg13cmos5l_dlhq_1
X_0609_ _2606_/A _0608_/X _0606_/X _2125_/Q VPWR VGND sg13cmos5l_mux2_1
X_1589_ _1589_/Q Tile_X0Y1_FrameData[14] Tile_X0Y3_FrameStrobe[4] VPWR VGND sg13cmos5l_dlhq_1
XANTENNA__0713__A0 Tile_X0Y0_W2MID[6] VPWR VGND sg13cmos5l_antennanp
XANTENNA__1332__GATE Tile_X0Y3_FrameStrobe[4] VPWR VGND sg13cmos5l_antennanp
XANTENNA__1962__GATE Tile_X0Y3_FrameStrobe[0] VPWR VGND sg13cmos5l_antennanp
XFILLER_112_293 VPWR VGND sg13cmos5l_fill_2
XFILLER_218_117 VPWR VGND sg13cmos5l_fill_2
XFILLER_85_155 VPWR VGND sg13cmos5l_fill_2
XANTENNA__0892__X AXIL_S_SOC_WREADY VPWR VGND sg13cmos5l_antennanp
XANTENNA__1347__GATE Tile_X0Y3_FrameStrobe[4] VPWR VGND sg13cmos5l_antennanp
XANTENNA__1977__GATE Tile_X0Y3_FrameStrobe[1] VPWR VGND sg13cmos5l_antennanp
XANTENNA__2325__A Tile_X0Y2_FrameData[1] VPWR VGND sg13cmos5l_antennanp
XFILLER_41_269 VPWR VGND sg13cmos5l_decap_4
XFILLER_179_282 VPWR VGND sg13cmos5l_fill_2
XANTENNA__1586__D Tile_X0Y1_FrameData[17] VPWR VGND sg13cmos5l_antennanp
XANTENNA__1900__GATE Tile_X0Y3_FrameStrobe[6] VPWR VGND sg13cmos5l_antennanp
XFILLER_154_105 VPWR VGND sg13cmos5l_fill_2
XFILLER_194_285 VPWR VGND sg13cmos5l_fill_1
XFILLER_154_127 VPWR VGND sg13cmos5l_decap_4
XFILLER_185_35 VPWR VGND sg13cmos5l_decap_8
XANTENNA__0547__A3 Tile_X0Y0_S4END[5] VPWR VGND sg13cmos5l_antennanp
XANTENNA__0952__A0 AXIL_S_SOC_WDATA17 VPWR VGND sg13cmos5l_antennanp
XANTENNA__1915__GATE Tile_X0Y3_FrameStrobe[6] VPWR VGND sg13cmos5l_antennanp
XFILLER_162_160 VPWR VGND sg13cmos5l_decap_8
XFILLER_162_171 VPWR VGND sg13cmos5l_fill_2
XFILLER_78_55 VPWR VGND sg13cmos5l_decap_4
XFILLER_78_44 VPWR VGND sg13cmos5l_decap_4
XANTENNA__0704__A0 Tile_X0Y3_W2MID[7] VPWR VGND sg13cmos5l_antennanp
XFILLER_103_293 VPWR VGND sg13cmos5l_fill_2
XFILLER_134_50 VPWR VGND sg13cmos5l_fill_1
XFILLER_94_10 VPWR VGND sg13cmos5l_decap_4
XFILLER_76_166 VPWR VGND sg13cmos5l_fill_1
XFILLER_91_136 VPWR VGND sg13cmos5l_fill_2
X_0960_ _2198_/A _0858_/X _0492_/X AXIL_S_SOC_WDATA17 AXIL_S_SOC_WDATA20 _1613_/Q
+ _1612_/Q VPWR VGND sg13cmos5l_mux4_1
XANTENNA__1496__D Tile_X0Y1_FrameData[11] VPWR VGND sg13cmos5l_antennanp
XANTENNA__0786__A3 Tile_X0Y0_S4END[2] VPWR VGND sg13cmos5l_antennanp
XANTENNA__2522__X Tile_X0Y3_E6BEG[8] VPWR VGND sg13cmos5l_antennanp
X_0891_ _2452_/A AXIL_S_SOC_AWADDR0 AXIL_S_SOC_AWADDR4 _0772_/X _0646_/X _1319_/Q
+ _1318_/Q VPWR VGND sg13cmos5l_mux4_1
XANTENNA__1196__A0 Tile_X0Y2_W1END[3] VPWR VGND sg13cmos5l_antennanp
X_2561_ Tile_X0Y3_FrameData_O[19] Tile_X0Y3_FrameData[19] VPWR VGND sg13cmos5l_buf_1
X_1512_ _1512_/Q Tile_X0Y1_FrameData[27] Tile_X0Y3_FrameStrobe[2] VPWR VGND sg13cmos5l_dlhq_1
X_2492_ Tile_X0Y0_E1BEG[2] _2492_/A VPWR VGND sg13cmos5l_buf_1
XFILLER_99_214 VPWR VGND sg13cmos5l_decap_8
X_1443_ _1443_/Q Tile_X0Y0_FrameData[8] Tile_X0Y3_FrameStrobe[7] VPWR VGND sg13cmos5l_dlhq_1
XFILLER_4_41 VPWR VGND sg13cmos5l_fill_2
XFILLER_175_90 VPWR VGND sg13cmos5l_decap_4
XANTENNA__2120__D Tile_X0Y3_FrameData[11] VPWR VGND sg13cmos5l_antennanp
XFILLER_4_85 VPWR VGND sg13cmos5l_decap_4
X_1374_ _1374_/Q Tile_X0Y0_FrameData[13] Tile_X0Y3_FrameStrobe[5] VPWR VGND sg13cmos5l_dlhq_1
XANTENNA__2062__GATE Tile_X0Y3_FrameStrobe[3] VPWR VGND sg13cmos5l_antennanp
XFILLER_67_166 VPWR VGND sg13cmos5l_fill_1
XFILLER_215_109 VPWR VGND sg13cmos5l_decap_4
XANTENNA__1120__A0 AXIL_S_SOC_WDATA3 VPWR VGND sg13cmos5l_antennanp
XANTENNA__2077__GATE Tile_X0Y3_FrameStrobe[4] VPWR VGND sg13cmos5l_antennanp
XFILLER_23_214 VPWR VGND sg13cmos5l_decap_4
XFILLER_223_153 VPWR VGND sg13cmos5l_fill_2
XANTENNA__2000__GATE Tile_X0Y3_FrameStrobe[1] VPWR VGND sg13cmos5l_antennanp
XANTENNA__2432__X Tile_X0Y0_FrameData_O[18] VPWR VGND sg13cmos5l_antennanp
XFILLER_129_190 VPWR VGND sg13cmos5l_fill_2
XANTENNA__0529__A3 Tile_X0Y0_S4END[8] VPWR VGND sg13cmos5l_antennanp
XANTENNA__2015__GATE Tile_X0Y3_FrameStrobe[2] VPWR VGND sg13cmos5l_antennanp
XFILLER_144_171 VPWR VGND sg13cmos5l_decap_8
XANTENNA__1271__GATE Tile_X0Y3_FrameStrobe[2] VPWR VGND sg13cmos5l_antennanp
XANTENNA__2030__D Tile_X0Y3_FrameData[5] VPWR VGND sg13cmos5l_antennanp
XFILLER_171_59 VPWR VGND sg13cmos5l_decap_8
XANTENNA__1286__GATE Tile_X0Y3_FrameStrobe[2] VPWR VGND sg13cmos5l_antennanp
XFILLER_58_188 VPWR VGND sg13cmos5l_fill_2
XFILLER_73_158 VPWR VGND sg13cmos5l_fill_1
XANTENNA__1111__A0 AXIL_S_SOC_WDATA1 VPWR VGND sg13cmos5l_antennanp
XANTENNA__2607__X Tile_X0Y3_S4BEG[13] VPWR VGND sg13cmos5l_antennanp
XANTENNA__0465__A2 Tile_X0Y3_N4END[10] VPWR VGND sg13cmos5l_antennanp
XFILLER_81_191 VPWR VGND sg13cmos5l_decap_8
XFILLER_214_175 VPWR VGND sg13cmos5l_decap_4
XFILLER_120_96 VPWR VGND sg13cmos5l_decap_8
XFILLER_167_230 VPWR VGND sg13cmos5l_decap_4
XFILLER_167_274 VPWR VGND sg13cmos5l_fill_1
XFILLER_196_56 VPWR VGND sg13cmos5l_decap_4
XANTENNA__0502__A_N Tile_X0Y2_W6END[3] VPWR VGND sg13cmos5l_antennanp
XANTENNA__1224__GATE Tile_X0Y3_FrameStrobe[0] VPWR VGND sg13cmos5l_antennanp
XANTENNA__2342__X Tile_X0Y2_FrameData_O[18] VPWR VGND sg13cmos5l_antennanp
XANTENNA__1178__A0 AXIL_S_SOC_WDATA2 VPWR VGND sg13cmos5l_antennanp
XANTENNA__1854__GATE Tile_X0Y3_FrameStrobe[5] VPWR VGND sg13cmos5l_antennanp
XFILLER_202_0 VPWR VGND sg13cmos5l_fill_2
XFILLER_182_244 VPWR VGND sg13cmos5l_decap_8
XFILLER_89_54 VPWR VGND sg13cmos5l_decap_8
XANTENNA__1239__GATE Tile_X0Y3_FrameStrobe[1] VPWR VGND sg13cmos5l_antennanp
XANTENNA__1869__GATE Tile_X0Y3_FrameStrobe[5] VPWR VGND sg13cmos5l_antennanp
XFILLER_150_141 VPWR VGND sg13cmos5l_fill_1
XFILLER_150_152 VPWR VGND sg13cmos5l_fill_1
XFILLER_49_155 VPWR VGND sg13cmos5l_decap_4
XFILLER_64_125 VPWR VGND sg13cmos5l_decap_8
XFILLER_161_81 VPWR VGND sg13cmos5l_decap_4
XFILLER_161_92 VPWR VGND sg13cmos5l_fill_2
X_1090_ _2294_/A AXIL_S_SOC_WDATA6 AXIL_S_SOC_WDATA14 _0715_/X _0729_/X _1831_/Q _1830_/Q
+ VPWR VGND sg13cmos5l_mux4_1
XANTENNA__1102__A0 AXIL_S_SOC_WDATA5 VPWR VGND sg13cmos5l_antennanp
XANTENNA__2517__X Tile_X0Y3_E6BEG[3] VPWR VGND sg13cmos5l_antennanp
XANTENNA__1807__GATE Tile_X0Y3_FrameStrobe[3] VPWR VGND sg13cmos5l_antennanp
XFILLER_220_134 VPWR VGND sg13cmos5l_fill_1
X_1992_ _1992_/Q Tile_X0Y3_FrameData[11] Tile_X0Y3_FrameStrobe[1] VPWR VGND sg13cmos5l_dlhq_1
XANTENNA__2115__D Tile_X0Y3_FrameData[16] VPWR VGND sg13cmos5l_antennanp
X_0943_ _0943_/Y _1630_/Q _0942_/X _0449_/Y VPWR VGND sg13cmos5l_a21oi_1
XANTENNA__2252__X Tile_X0Y1_FrameData_O[9] VPWR VGND sg13cmos5l_antennanp
X_0874_ _2462_/A Tile_X0Y3_N4END[12] Tile_X0Y0_S4END[0] _0796_/X _0488_/X _1299_/Q
+ _1298_/Q VPWR VGND sg13cmos5l_mux4_1
XFILLER_173_222 VPWR VGND sg13cmos5l_decap_8
XANTENNA__1169__A0 Tile_X0Y2_W1END[3] VPWR VGND sg13cmos5l_antennanp
XANTENNA__1954__D Tile_X0Y3_FrameData[17] VPWR VGND sg13cmos5l_antennanp
XFILLER_173_255 VPWR VGND sg13cmos5l_decap_8
X_2544_ Tile_X0Y3_FrameData_O[2] Tile_X0Y3_FrameData[2] VPWR VGND sg13cmos5l_buf_1
X_2475_ Tile_X0Y0_E2BEGb[1] _2475_/A VPWR VGND sg13cmos5l_buf_1
XANTENNA__0931__A3 Tile_X0Y0_S4END[6] VPWR VGND sg13cmos5l_antennanp
X_1426_ _1426_/Q Tile_X0Y0_FrameData[25] Tile_X0Y3_FrameStrobe[7] VPWR VGND sg13cmos5l_dlhq_1
X_1357_ _1357_/Q Tile_X0Y0_FrameData[30] Tile_X0Y3_FrameStrobe[5] VPWR VGND sg13cmos5l_dlhq_1
X_1288_ _1288_/Q Tile_X0Y0_FrameData[3] Tile_X0Y3_FrameStrobe[2] VPWR VGND sg13cmos5l_dlhq_1
XANTENNA__2427__X Tile_X0Y0_FrameData_O[13] VPWR VGND sg13cmos5l_antennanp
XFILLER_221_84 VPWR VGND sg13cmos5l_fill_1
XFILLER_211_156 VPWR VGND sg13cmos5l_decap_8
XANTENNA__2025__D Tile_X0Y3_FrameData[10] VPWR VGND sg13cmos5l_antennanp
XFILLER_109_105 VPWR VGND sg13cmos5l_fill_1
XFILLER_164_233 VPWR VGND sg13cmos5l_fill_2
XFILLER_50_48 VPWR VGND sg13cmos5l_fill_1
XANTENNA__1864__D Tile_X0Y2_FrameData[19] VPWR VGND sg13cmos5l_antennanp
XFILLER_164_244 VPWR VGND sg13cmos5l_fill_2
XFILLER_50_59 VPWR VGND sg13cmos5l_decap_4
XFILLER_132_163 VPWR VGND sg13cmos5l_decap_8
XFILLER_59_46 VPWR VGND sg13cmos5l_fill_2
XFILLER_182_25 VPWR VGND sg13cmos5l_fill_2
XANTENNA__0922__A3 Tile_X0Y0_S4END[5] VPWR VGND sg13cmos5l_antennanp
XFILLER_132_174 VPWR VGND sg13cmos5l_fill_1
XFILLER_78_239 VPWR VGND sg13cmos5l_decap_8
XFILLER_115_63 VPWR VGND sg13cmos5l_fill_2
XFILLER_86_250 VPWR VGND sg13cmos5l_decap_4
XFILLER_86_261 VPWR VGND sg13cmos5l_fill_1
XANTENNA__0686__A2 AXIL_S_SOC_ARADDR8 VPWR VGND sg13cmos5l_antennanp
XFILLER_75_67 VPWR VGND sg13cmos5l_fill_1
XANTENNA__2337__X Tile_X0Y2_FrameData_O[13] VPWR VGND sg13cmos5l_antennanp
XFILLER_61_106 VPWR VGND sg13cmos5l_decap_8
XFILLER_91_22 VPWR VGND sg13cmos5l_fill_2
XFILLER_152_0 VPWR VGND sg13cmos5l_fill_1
XFILLER_199_163 VPWR VGND sg13cmos5l_fill_1
XANTENNA__1793__GATE Tile_X0Y3_FrameStrobe[3] VPWR VGND sg13cmos5l_antennanp
XANTENNA__1774__D Tile_X0Y2_FrameData[13] VPWR VGND sg13cmos5l_antennanp
XFILLER_115_119 VPWR VGND sg13cmos5l_decap_8
XFILLER_6_254 VPWR VGND sg13cmos5l_fill_2
XFILLER_108_171 VPWR VGND sg13cmos5l_decap_4
XFILLER_170_236 VPWR VGND sg13cmos5l_decap_8
X_0590_ _0590_/X Tile_X0Y3_N2MID[4] Tile_X0Y3_N2END[4] _2590_/A _0588_/X _1955_/Q
+ _1954_/Q VPWR VGND sg13cmos5l_mux4_1
XFILLER_123_141 VPWR VGND sg13cmos5l_decap_8
XANTENNA__0913__A3 Tile_X0Y0_S4END[4] VPWR VGND sg13cmos5l_antennanp
X_2260_ Tile_X0Y1_FrameData_O[17] Tile_X0Y1_FrameData[17] VPWR VGND sg13cmos5l_buf_1
X_1211_ _1211_/Q Tile_X0Y0_FrameData[16] Tile_X0Y3_FrameStrobe[0] VPWR VGND sg13cmos5l_dlhq_1
XANTENNA__1731__GATE Tile_X0Y3_FrameStrobe[1] VPWR VGND sg13cmos5l_antennanp
X_2191_ _2191_/Q Tile_X0Y3_FrameData[4] Tile_X0Y3_FrameStrobe[7] VPWR VGND sg13cmos5l_dlhq_1
XFILLER_172_91 VPWR VGND sg13cmos5l_fill_1
X_1142_ _1143_/C Tile_X0Y2_W1END[1] _1876_/Q VPWR VGND sg13cmos5l_nor2_1
XFILLER_225_226 VPWR VGND sg13cmos5l_decap_8
XFILLER_225_215 VPWR VGND sg13cmos5l_fill_1
XANTENNA__2247__X Tile_X0Y1_FrameData_O[4] VPWR VGND sg13cmos5l_antennanp
X_1073_ _1073_/X _1914_/Q _1073_/B VPWR VGND sg13cmos5l_and2_1
XFILLER_52_106 VPWR VGND sg13cmos5l_fill_2
XANTENNA__1746__GATE Tile_X0Y3_FrameStrobe[1] VPWR VGND sg13cmos5l_antennanp
XANTENNA__1949__D Tile_X0Y3_FrameData[22] VPWR VGND sg13cmos5l_antennanp
XFILLER_60_161 VPWR VGND sg13cmos5l_decap_4
X_1975_ _1975_/Q Tile_X0Y3_FrameData[28] Tile_X0Y3_FrameStrobe[1] VPWR VGND sg13cmos5l_dlhq_1
XANTENNA__2423__A Tile_X0Y0_FrameData[9] VPWR VGND sg13cmos5l_antennanp
X_0926_ _0926_/X _0871_/X _0546_/X Tile_X0Y3_N4END[9] Tile_X0Y0_S4END[5] _1488_/Q
+ _1489_/Q VPWR VGND sg13cmos5l_mux4_1
XANTENNA__0601__A2 Tile_X0Y1_W2END[0] VPWR VGND sg13cmos5l_antennanp
XANTENNA__1684__D Tile_X0Y1_FrameData[15] VPWR VGND sg13cmos5l_antennanp
XFILLER_106_108 VPWR VGND sg13cmos5l_fill_2
XFILLER_146_277 VPWR VGND sg13cmos5l_decap_8
X_0857_ _2480_/A AXIL_S_SOC_AWADDR0 AXIL_S_SOC_AWADDR8 _0646_/X _0751_/X _1335_/Q
+ _1334_/Q VPWR VGND sg13cmos5l_mux4_1
XFILLER_20_29 VPWR VGND sg13cmos5l_decap_8
XFILLER_161_225 VPWR VGND sg13cmos5l_decap_8
X_0788_ _0788_/X _0786_/X _0784_/X _0463_/A _0653_/X _1413_/Q _1412_/Q VPWR VGND sg13cmos5l_mux4_1
X_2527_ Tile_X0Y3_EE4BEG[1] _2527_/A VPWR VGND sg13cmos5l_buf_1
X_2458_ Tile_X0Y0_EE4BEG[12] _2458_/A VPWR VGND sg13cmos5l_buf_1
XFILLER_152_17 VPWR VGND sg13cmos5l_decap_4
X_1409_ _1409_/Q Tile_X0Y0_FrameData[10] Tile_X0Y3_FrameStrobe[6] VPWR VGND sg13cmos5l_dlhq_1
XFILLER_29_27 VPWR VGND sg13cmos5l_fill_1
XFILLER_216_95 VPWR VGND sg13cmos5l_decap_4
X_2389_ Tile_X0Y0_N2BEG[7] _2389_/A VPWR VGND sg13cmos5l_buf_1
XFILLER_216_204 VPWR VGND sg13cmos5l_fill_1
XFILLER_83_264 VPWR VGND sg13cmos5l_decap_8
XANTENNA__1859__D Tile_X0Y2_FrameData[24] VPWR VGND sg13cmos5l_antennanp
XFILLER_61_14 VPWR VGND sg13cmos5l_decap_8
XFILLER_196_111 VPWR VGND sg13cmos5l_decap_8
XANTENNA__2333__A Tile_X0Y2_FrameData[9] VPWR VGND sg13cmos5l_antennanp
XFILLER_137_222 VPWR VGND sg13cmos5l_decap_8
XANTENNA__1594__D Tile_X0Y1_FrameData[9] VPWR VGND sg13cmos5l_antennanp
XFILLER_137_277 VPWR VGND sg13cmos5l_decap_8
XFILLER_152_247 VPWR VGND sg13cmos5l_fill_1
XANTENNA__1148__A3 AXIL_S_SOC_WDATA5 VPWR VGND sg13cmos5l_antennanp
XFILLER_152_269 VPWR VGND sg13cmos5l_fill_2
XFILLER_126_51 VPWR VGND sg13cmos5l_decap_8
XFILLER_86_33 VPWR VGND sg13cmos5l_fill_1
XFILLER_19_103 VPWR VGND sg13cmos5l_decap_4
XANTENNA__0659__A2 AXIL_S_SOC_ARADDR5 VPWR VGND sg13cmos5l_antennanp
XFILLER_74_275 VPWR VGND sg13cmos5l_decap_8
XFILLER_19_158 VPWR VGND sg13cmos5l_fill_1
XANTENNA__1769__D Tile_X0Y2_FrameData[18] VPWR VGND sg13cmos5l_antennanp
XANTENNA__2243__A Tile_X0Y1_FrameData[0] VPWR VGND sg13cmos5l_antennanp
XFILLER_128_211 VPWR VGND sg13cmos5l_fill_1
X_1760_ _1760_/Q Tile_X0Y2_FrameData[27] Tile_X0Y3_FrameStrobe[2] VPWR VGND sg13cmos5l_dlhq_1
XFILLER_187_188 VPWR VGND sg13cmos5l_decap_8
XANTENNA__0990__A_N Tile_X0Y1_WW4END[13] VPWR VGND sg13cmos5l_antennanp
X_0711_ _0711_/X Tile_X0Y2_W2MID[4] Tile_X0Y2_W2END[4] Tile_X0Y2_W6END[4] _0746_/X
+ _1925_/Q _1924_/Q VPWR VGND sg13cmos5l_mux4_1
XANTENNA__0595__A1 Tile_X0Y3_W2MID[2] VPWR VGND sg13cmos5l_antennanp
XFILLER_143_203 VPWR VGND sg13cmos5l_decap_8
X_1691_ _1691_/Q Tile_X0Y1_FrameData[8] Tile_X0Y3_FrameStrobe[7] VPWR VGND sg13cmos5l_dlhq_1
XANTENNA__2530__X Tile_X0Y3_EE4BEG[4] VPWR VGND sg13cmos5l_antennanp
X_0642_ _2374_/A Tile_X0Y1_W2MID[7] Tile_X0Y1_W2END[7] Tile_X0Y1_W6END[7] _0859_/X
+ _1683_/Q _1682_/Q VPWR VGND sg13cmos5l_mux4_1
X_0573_ _0573_/Y Tile_X0Y3_W6END[3] _1941_/Q _0572_/Y VPWR VGND sg13cmos5l_a21oi_1
X_2312_ Tile_X0Y2_EE4BEG[4] _2312_/A VPWR VGND sg13cmos5l_buf_1
XANTENNA__0898__A2 Tile_X0Y0_WW4END[15] VPWR VGND sg13cmos5l_antennanp
XANTENNA__1670__GATE Tile_X0Y3_FrameStrobe[7] VPWR VGND sg13cmos5l_antennanp
XFILLER_151_291 VPWR VGND sg13cmos5l_decap_4
X_2243_ Tile_X0Y1_FrameData_O[0] Tile_X0Y1_FrameData[0] VPWR VGND sg13cmos5l_buf_1
X_2174_ _2174_/Q Tile_X0Y3_FrameData[21] Tile_X0Y3_FrameStrobe[7] VPWR VGND sg13cmos5l_dlhq_1
XANTENNA__1685__GATE Tile_X0Y3_FrameStrobe[7] VPWR VGND sg13cmos5l_antennanp
XANTENNA__2418__A Tile_X0Y0_FrameData[4] VPWR VGND sg13cmos5l_antennanp
X_1125_ _2304_/A AXIL_S_SOC_WDATA0 _1103_/X _1112_/X _0742_/X _1778_/Q _1779_/Q VPWR
+ VGND sg13cmos5l_mux4_1
XFILLER_65_286 VPWR VGND sg13cmos5l_fill_1
XFILLER_25_128 VPWR VGND sg13cmos5l_decap_4
XFILLER_202_42 VPWR VGND sg13cmos5l_decap_8
XFILLER_202_31 VPWR VGND sg13cmos5l_fill_1
XANTENNA__1679__D Tile_X0Y1_FrameData[20] VPWR VGND sg13cmos5l_antennanp
XFILLER_15_18 VPWR VGND sg13cmos5l_decap_4
X_1056_ _1057_/B _1912_/Q _0554_/X _1055_/X VPWR VGND sg13cmos5l_o21ai_1
XFILLER_206_270 VPWR VGND sg13cmos5l_decap_4
XFILLER_80_278 VPWR VGND sg13cmos5l_decap_8
XFILLER_33_172 VPWR VGND sg13cmos5l_decap_8
XFILLER_221_262 VPWR VGND sg13cmos5l_fill_1
XFILLER_178_144 VPWR VGND sg13cmos5l_fill_1
X_1958_ _1958_/Q Tile_X0Y3_FrameData[13] Tile_X0Y3_FrameStrobe[0] VPWR VGND sg13cmos5l_dlhq_1
XANTENNA__0586__A1 Tile_X0Y3_W2END[5] VPWR VGND sg13cmos5l_antennanp
XANTENNA__1623__GATE Tile_X0Y3_FrameStrobe[5] VPWR VGND sg13cmos5l_antennanp
X_1889_ _1889_/Q Tile_X0Y2_FrameData[26] Tile_X0Y3_FrameStrobe[6] VPWR VGND sg13cmos5l_dlhq_1
X_0909_ _0909_/Y Tile_X0Y1_WW4END[0] _1667_/Q VPWR VGND sg13cmos5l_nand2b_1
XANTENNA__2440__X Tile_X0Y0_FrameData_O[26] VPWR VGND sg13cmos5l_antennanp
XFILLER_134_225 VPWR VGND sg13cmos5l_decap_8
XANTENNA__1638__GATE Tile_X0Y3_FrameStrobe[6] VPWR VGND sg13cmos5l_antennanp
XFILLER_0_216 VPWR VGND sg13cmos5l_decap_8
XANTENNA__0895__X AXIL_S_SOC_RRESP1 VPWR VGND sg13cmos5l_antennanp
XFILLER_56_36 VPWR VGND sg13cmos5l_decap_8
XANTENNA__2328__A Tile_X0Y2_FrameData[4] VPWR VGND sg13cmos5l_antennanp
XANTENNA__0510__A1 Tile_X0Y1_W2END[4] VPWR VGND sg13cmos5l_antennanp
XFILLER_112_31 VPWR VGND sg13cmos5l_decap_8
XFILLER_71_212 VPWR VGND sg13cmos5l_decap_8
XFILLER_56_286 VPWR VGND sg13cmos5l_fill_1
XANTENNA__1589__D Tile_X0Y1_FrameData[14] VPWR VGND sg13cmos5l_antennanp
XFILLER_112_64 VPWR VGND sg13cmos5l_decap_8
XFILLER_72_13 VPWR VGND sg13cmos5l_fill_1
XFILLER_112_97 VPWR VGND sg13cmos5l_decap_8
XFILLER_24_172 VPWR VGND sg13cmos5l_fill_1
XFILLER_212_273 VPWR VGND sg13cmos5l_fill_2
XFILLER_188_68 VPWR VGND sg13cmos5l_decap_4
XFILLER_184_114 VPWR VGND sg13cmos5l_fill_1
XANTENNA__0577__A1 Tile_X0Y1_W2END[7] VPWR VGND sg13cmos5l_antennanp
XANTENNA__2350__X Tile_X0Y2_FrameData_O[26] VPWR VGND sg13cmos5l_antennanp
XFILLER_115_0 VPWR VGND sg13cmos5l_fill_2
XFILLER_192_191 VPWR VGND sg13cmos5l_decap_4
XFILLER_137_72 VPWR VGND sg13cmos5l_decap_8
XFILLER_133_280 VPWR VGND sg13cmos5l_decap_4
XFILLER_153_60 VPWR VGND sg13cmos5l_decap_8
XANTENNA__1142__A Tile_X0Y2_W1END[1] VPWR VGND sg13cmos5l_antennanp
XANTENNA__1499__D Tile_X0Y1_FrameData[8] VPWR VGND sg13cmos5l_antennanp
XFILLER_62_256 VPWR VGND sg13cmos5l_fill_2
XANTENNA__2525__X Tile_X0Y3_E6BEG[11] VPWR VGND sg13cmos5l_antennanp
X_1812_ _1812_/Q Tile_X0Y2_FrameData[7] Tile_X0Y3_FrameStrobe[3] VPWR VGND sg13cmos5l_dlhq_1
XANTENNA__0568__A1 Tile_X0Y3_W6END[2] VPWR VGND sg13cmos5l_antennanp
X_1743_ _1743_/Q Tile_X0Y2_FrameData[12] Tile_X0Y3_FrameStrobe[1] VPWR VGND sg13cmos5l_dlhq_1
XANTENNA__2123__D Tile_X0Y3_FrameData[8] VPWR VGND sg13cmos5l_antennanp
XANTENNA__2260__X Tile_X0Y1_FrameData_O[17] VPWR VGND sg13cmos5l_antennanp
X_1674_ _1674_/Q Tile_X0Y1_FrameData[25] Tile_X0Y3_FrameStrobe[7] VPWR VGND sg13cmos5l_dlhq_1
X_0625_ _2609_/A _0624_/X _0623_/X _2116_/Q VPWR VGND sg13cmos5l_mux2_1
XANTENNA__1962__D Tile_X0Y3_FrameData[9] VPWR VGND sg13cmos5l_antennanp
XFILLER_131_228 VPWR VGND sg13cmos5l_decap_8
X_0556_ _0558_/B Tile_X0Y2_W6END[1] _1697_/Q VPWR VGND sg13cmos5l_nor2b_1
XFILLER_30_0 VPWR VGND sg13cmos5l_fill_2
XFILLER_133_19 VPWR VGND sg13cmos5l_decap_4
X_0487_ _2360_/A _0486_/X _0484_/X _2155_/Q VPWR VGND sg13cmos5l_mux2_1
XFILLER_97_164 VPWR VGND sg13cmos5l_decap_8
XANTENNA__0740__A1 Tile_X0Y0_W2END[3] VPWR VGND sg13cmos5l_antennanp
X_2226_ Tile_X0Y1_E6BEG[11] _2226_/A VPWR VGND sg13cmos5l_buf_1
XFILLER_38_220 VPWR VGND sg13cmos5l_fill_2
X_2157_ _2157_/Q Tile_X0Y3_FrameData[6] Tile_X0Y3_FrameStrobe[6] VPWR VGND sg13cmos5l_dlhq_1
XFILLER_53_212 VPWR VGND sg13cmos5l_decap_8
XFILLER_38_275 VPWR VGND sg13cmos5l_fill_1
X_1108_ _1108_/X _0936_/X _0470_/X Tile_X0Y3_N4END[6] Tile_X0Y0_S4END[10] _1734_/Q
+ _1735_/Q VPWR VGND sg13cmos5l_mux4_1
X_2088_ _2088_/Q Tile_X0Y3_FrameData[11] Tile_X0Y3_FrameStrobe[4] VPWR VGND sg13cmos5l_dlhq_1
XANTENNA__1202__D Tile_X0Y0_FrameData[25] VPWR VGND sg13cmos5l_antennanp
XANTENNA__2435__X Tile_X0Y0_FrameData_O[21] VPWR VGND sg13cmos5l_antennanp
X_1039_ _2230_/A AXIL_S_SOC_WDATA19 AXIL_S_SOC_WDATA31 _0522_/X _0869_/X _1573_/Q
+ _1572_/Q VPWR VGND sg13cmos5l_mux4_1
XFILLER_158_16 VPWR VGND sg13cmos5l_decap_8
XFILLER_42_49 VPWR VGND sg13cmos5l_decap_4
XANTENNA__1562__GATE Tile_X0Y3_FrameStrobe[3] VPWR VGND sg13cmos5l_antennanp
XFILLER_158_38 VPWR VGND sg13cmos5l_fill_1
XANTENNA__2033__D Tile_X0Y3_FrameData[2] VPWR VGND sg13cmos5l_antennanp
XANTENNA__1577__GATE Tile_X0Y3_FrameStrobe[4] VPWR VGND sg13cmos5l_antennanp
XANTENNA__1872__D Tile_X0Y2_FrameData[11] VPWR VGND sg13cmos5l_antennanp
XFILLER_122_206 VPWR VGND sg13cmos5l_decap_8
XFILLER_67_13 VPWR VGND sg13cmos5l_fill_1
XFILLER_190_14 VPWR VGND sg13cmos5l_fill_1
XANTENNA__0731__A1 Tile_X0Y3_W2END[2] VPWR VGND sg13cmos5l_antennanp
XANTENNA__1500__GATE Tile_X0Y3_FrameStrobe[1] VPWR VGND sg13cmos5l_antennanp
XFILLER_130_294 VPWR VGND sg13cmos5l_fill_1
XFILLER_29_220 VPWR VGND sg13cmos5l_fill_1
XFILLER_123_30 VPWR VGND sg13cmos5l_fill_2
XFILLER_177_2 VPWR VGND sg13cmos5l_fill_1
XANTENNA__1515__GATE Tile_X0Y3_FrameStrobe[2] VPWR VGND sg13cmos5l_antennanp
XFILLER_44_234 VPWR VGND sg13cmos5l_decap_8
XFILLER_199_34 VPWR VGND sg13cmos5l_fill_1
XFILLER_199_12 VPWR VGND sg13cmos5l_decap_8
XANTENNA__2345__X Tile_X0Y2_FrameData_O[21] VPWR VGND sg13cmos5l_antennanp
XFILLER_12_175 VPWR VGND sg13cmos5l_decap_8
XANTENNA__1782__D Tile_X0Y2_FrameData[5] VPWR VGND sg13cmos5l_antennanp
XFILLER_113_206 VPWR VGND sg13cmos5l_decap_8
XFILLER_164_70 VPWR VGND sg13cmos5l_decap_4
X_1390_ _1390_/Q Tile_X0Y0_FrameData[29] Tile_X0Y3_FrameStrobe[6] VPWR VGND sg13cmos5l_dlhq_1
XFILLER_121_250 VPWR VGND sg13cmos5l_decap_8
XANTENNA__0722__A1 Tile_X0Y0_W6END[6] VPWR VGND sg13cmos5l_antennanp
XFILLER_121_294 VPWR VGND sg13cmos5l_fill_1
X_2011_ _2011_/Q Tile_X0Y3_FrameData[24] Tile_X0Y3_FrameStrobe[2] VPWR VGND sg13cmos5l_dlhq_1
XFILLER_35_201 VPWR VGND sg13cmos5l_decap_8
XANTENNA__0486__A0 Tile_X0Y3_W1END[2] VPWR VGND sg13cmos5l_antennanp
XANTENNA__2118__D Tile_X0Y3_FrameData[13] VPWR VGND sg13cmos5l_antennanp
XANTENNA__2255__X Tile_X0Y1_FrameData_O[12] VPWR VGND sg13cmos5l_antennanp
XFILLER_50_215 VPWR VGND sg13cmos5l_decap_8
XFILLER_35_278 VPWR VGND sg13cmos5l_fill_2
XFILLER_188_250 VPWR VGND sg13cmos5l_decap_8
XANTENNA__1957__D Tile_X0Y3_FrameData[14] VPWR VGND sg13cmos5l_antennanp
XFILLER_50_259 VPWR VGND sg13cmos5l_decap_4
XFILLER_148_158 VPWR VGND sg13cmos5l_decap_4
XFILLER_78_0 VPWR VGND sg13cmos5l_decap_4
XANTENNA__2431__A Tile_X0Y0_FrameData[17] VPWR VGND sg13cmos5l_antennanp
X_1726_ _1726_/Q Tile_X0Y2_FrameData[29] Tile_X0Y3_FrameStrobe[1] VPWR VGND sg13cmos5l_dlhq_1
XANTENNA__0961__A1 AXIL_S_SOC_WDATA24 VPWR VGND sg13cmos5l_antennanp
XANTENNA__1692__D Tile_X0Y1_FrameData[31] VPWR VGND sg13cmos5l_antennanp
XFILLER_171_150 VPWR VGND sg13cmos5l_decap_4
X_1657_ _1657_/Q Tile_X0Y1_FrameData[10] Tile_X0Y3_FrameStrobe[6] VPWR VGND sg13cmos5l_dlhq_1
XFILLER_144_29 VPWR VGND sg13cmos5l_fill_1
X_1588_ _1588_/Q Tile_X0Y1_FrameData[15] Tile_X0Y3_FrameStrobe[4] VPWR VGND sg13cmos5l_dlhq_1
X_0608_ _0608_/X Tile_X0Y3_W1END[0] Tile_X0Y3_W6END[4] Tile_X0Y3_WW4END[12] _0607_/X
+ _2126_/Q _2127_/Q VPWR VGND sg13cmos5l_mux4_1
XFILLER_112_261 VPWR VGND sg13cmos5l_decap_4
X_0539_ _0539_/Y _1947_/Q _0539_/B _1946_/Q VPWR VGND sg13cmos5l_nand3b_1
XANTENNA__0713__A1 Tile_X0Y0_W2END[6] VPWR VGND sg13cmos5l_antennanp
XFILLER_85_134 VPWR VGND sg13cmos5l_decap_8
X_2209_ Tile_X0Y1_E2BEGb[2] _2209_/A VPWR VGND sg13cmos5l_buf_1
XFILLER_26_201 VPWR VGND sg13cmos5l_fill_2
XANTENNA__0477__A0 Tile_X0Y2_W1END[2] VPWR VGND sg13cmos5l_antennanp
XANTENNA__2028__D Tile_X0Y3_FrameData[7] VPWR VGND sg13cmos5l_antennanp
XFILLER_53_59 VPWR VGND sg13cmos5l_decap_4
XFILLER_41_226 VPWR VGND sg13cmos5l_fill_2
XANTENNA__1867__D Tile_X0Y2_FrameData[16] VPWR VGND sg13cmos5l_antennanp
XFILLER_139_125 VPWR VGND sg13cmos5l_fill_1
XFILLER_179_294 VPWR VGND sg13cmos5l_fill_1
XANTENNA__2341__A Tile_X0Y2_FrameData[17] VPWR VGND sg13cmos5l_antennanp
XFILLER_185_25 VPWR VGND sg13cmos5l_fill_1
XANTENNA__0952__A1 AXIL_S_SOC_WDATA25 VPWR VGND sg13cmos5l_antennanp
XFILLER_118_85 VPWR VGND sg13cmos5l_decap_4
XFILLER_78_89 VPWR VGND sg13cmos5l_decap_8
XFILLER_78_78 VPWR VGND sg13cmos5l_decap_4
XANTENNA__0704__A1 Tile_X0Y3_W2END[7] VPWR VGND sg13cmos5l_antennanp
XFILLER_103_283 VPWR VGND sg13cmos5l_fill_1
XFILLER_76_112 VPWR VGND sg13cmos5l_fill_1
XFILLER_182_0 VPWR VGND sg13cmos5l_fill_2
XANTENNA__1454__GATE Tile_X0Y3_FrameStrobe[0] VPWR VGND sg13cmos5l_antennanp
XFILLER_217_151 VPWR VGND sg13cmos5l_decap_8
XFILLER_150_61 VPWR VGND sg13cmos5l_decap_8
XFILLER_150_72 VPWR VGND sg13cmos5l_fill_1
XANTENNA__1469__GATE Tile_X0Y3_FrameStrobe[0] VPWR VGND sg13cmos5l_antennanp
XANTENNA__1777__D Tile_X0Y2_FrameData[10] VPWR VGND sg13cmos5l_antennanp
X_0890_ AXIL_S_SOC_AWREADY Tile_X0Y0_W1END[3] Tile_X0Y0_WW4END[12] Tile_X0Y0_W6END[11]
+ _0491_/Y _1253_/Q _1252_/Q VPWR VGND sg13cmos5l_mux4_1
XANTENNA__0640__A0 Tile_X0Y3_N1END[1] VPWR VGND sg13cmos5l_antennanp
XFILLER_159_81 VPWR VGND sg13cmos5l_fill_1
XFILLER_185_286 VPWR VGND sg13cmos5l_fill_1
XANTENNA__1196__A1 Tile_X0Y2_W6END[11] VPWR VGND sg13cmos5l_antennanp
XANTENNA__2251__A Tile_X0Y1_FrameData[8] VPWR VGND sg13cmos5l_antennanp
XFILLER_160_109 VPWR VGND sg13cmos5l_decap_4
X_2560_ Tile_X0Y3_FrameData_O[18] Tile_X0Y3_FrameData[18] VPWR VGND sg13cmos5l_buf_1
X_1511_ _1511_/Q Tile_X0Y1_FrameData[28] Tile_X0Y3_FrameStrobe[2] VPWR VGND sg13cmos5l_dlhq_1
X_2491_ Tile_X0Y0_E1BEG[1] _2491_/A VPWR VGND sg13cmos5l_buf_1
XANTENNA__1407__GATE Tile_X0Y3_FrameStrobe[6] VPWR VGND sg13cmos5l_antennanp
X_1442_ _1442_/Q Tile_X0Y0_FrameData[9] Tile_X0Y3_FrameStrobe[7] VPWR VGND sg13cmos5l_dlhq_1
X_1373_ _1373_/Q Tile_X0Y0_FrameData[14] Tile_X0Y3_FrameStrobe[5] VPWR VGND sg13cmos5l_dlhq_1
XFILLER_82_126 VPWR VGND sg13cmos5l_decap_8
XANTENNA__1120__A1 AXIL_S_SOC_WDATA15 VPWR VGND sg13cmos5l_antennanp
XANTENNA__2426__A Tile_X0Y0_FrameData[12] VPWR VGND sg13cmos5l_antennanp
XFILLER_223_165 VPWR VGND sg13cmos5l_fill_2
XANTENNA__1687__D Tile_X0Y1_FrameData[12] VPWR VGND sg13cmos5l_antennanp
XFILLER_223_198 VPWR VGND sg13cmos5l_decap_4
XFILLER_136_117 VPWR VGND sg13cmos5l_fill_1
XFILLER_136_139 VPWR VGND sg13cmos5l_decap_8
XFILLER_219_51 VPWR VGND sg13cmos5l_decap_8
XFILLER_176_286 VPWR VGND sg13cmos5l_fill_1
XFILLER_155_39 VPWR VGND sg13cmos5l_fill_2
X_1709_ _1709_/Q Tile_X0Y2_FrameData[14] Tile_X0Y3_FrameStrobe[0] VPWR VGND sg13cmos5l_dlhq_1
XFILLER_191_278 VPWR VGND sg13cmos5l_decap_4
XFILLER_100_275 VPWR VGND sg13cmos5l_fill_2
XANTENNA__2184__GATE Tile_X0Y3_FrameStrobe[7] VPWR VGND sg13cmos5l_antennanp
XANTENNA__0465__A3 Tile_X0Y0_S4END[6] VPWR VGND sg13cmos5l_antennanp
XANTENNA__2336__A Tile_X0Y2_FrameData[12] VPWR VGND sg13cmos5l_antennanp
XFILLER_120_20 VPWR VGND sg13cmos5l_fill_2
XANTENNA__0870__A0 Tile_X0Y2_W1END[0] VPWR VGND sg13cmos5l_antennanp
XANTENNA__1597__D Tile_X0Y1_FrameData[6] VPWR VGND sg13cmos5l_antennanp
XFILLER_120_75 VPWR VGND sg13cmos5l_decap_8
XFILLER_14_248 VPWR VGND sg13cmos5l_decap_8
XFILLER_14_259 VPWR VGND sg13cmos5l_fill_1
XFILLER_80_57 VPWR VGND sg13cmos5l_fill_1
XANTENNA__2122__GATE Tile_X0Y3_FrameStrobe[5] VPWR VGND sg13cmos5l_antennanp
XFILLER_89_33 VPWR VGND sg13cmos5l_decap_8
XFILLER_8_0 VPWR VGND sg13cmos5l_fill_2
XANTENNA__2137__GATE Tile_X0Y3_FrameStrobe[6] VPWR VGND sg13cmos5l_antennanp
XFILLER_145_50 VPWR VGND sg13cmos5l_fill_2
XFILLER_49_101 VPWR VGND sg13cmos5l_decap_8
XANTENNA__0689__A0 Tile_X0Y3_N4END[0] VPWR VGND sg13cmos5l_antennanp
XFILLER_49_134 VPWR VGND sg13cmos5l_decap_8
XANTENNA__1393__GATE Tile_X0Y3_FrameStrobe[6] VPWR VGND sg13cmos5l_antennanp
XANTENNA__1102__A1 AXIL_S_SOC_WDATA9 VPWR VGND sg13cmos5l_antennanp
XANTENNA__2246__A Tile_X0Y1_FrameData[3] VPWR VGND sg13cmos5l_antennanp
XANTENNA__0861__A0 Tile_X0Y0_W1END[1] VPWR VGND sg13cmos5l_antennanp
XFILLER_220_113 VPWR VGND sg13cmos5l_fill_1
XANTENNA__1300__D Tile_X0Y0_FrameData[23] VPWR VGND sg13cmos5l_antennanp
XANTENNA__2533__X Tile_X0Y3_EE4BEG[7] VPWR VGND sg13cmos5l_antennanp
XFILLER_158_231 VPWR VGND sg13cmos5l_fill_2
X_1991_ _1991_/Q Tile_X0Y3_FrameData[12] Tile_X0Y3_FrameStrobe[1] VPWR VGND sg13cmos5l_dlhq_1
XANTENNA__1331__GATE Tile_X0Y3_FrameStrobe[4] VPWR VGND sg13cmos5l_antennanp
X_0942_ _0942_/X _0522_/X _0869_/X _1631_/Q VPWR VGND sg13cmos5l_mux2_1
XFILLER_220_179 VPWR VGND sg13cmos5l_decap_8
XANTENNA__1961__GATE Tile_X0Y3_FrameStrobe[0] VPWR VGND sg13cmos5l_antennanp
XFILLER_118_106 VPWR VGND sg13cmos5l_fill_2
X_0873_ _2463_/A Tile_X0Y3_N4END[13] Tile_X0Y0_S4END[1] _0784_/X _0463_/A _1297_/Q
+ _1296_/Q VPWR VGND sg13cmos5l_mux4_1
XFILLER_9_285 VPWR VGND sg13cmos5l_fill_2
XANTENNA__1169__A1 Tile_X0Y2_W6END[11] VPWR VGND sg13cmos5l_antennanp
XFILLER_126_150 VPWR VGND sg13cmos5l_decap_4
X_2543_ Tile_X0Y3_FrameData_O[1] Tile_X0Y3_FrameData[1] VPWR VGND sg13cmos5l_buf_1
XANTENNA__1346__GATE Tile_X0Y3_FrameStrobe[4] VPWR VGND sg13cmos5l_antennanp
XANTENNA__2131__D Tile_X0Y3_FrameData[0] VPWR VGND sg13cmos5l_antennanp
XFILLER_141_131 VPWR VGND sg13cmos5l_fill_1
XANTENNA__1976__GATE Tile_X0Y3_FrameStrobe[1] VPWR VGND sg13cmos5l_antennanp
X_2474_ Tile_X0Y0_E2BEGb[0] _2474_/A VPWR VGND sg13cmos5l_buf_1
XANTENNA__1970__D Tile_X0Y3_FrameData[1] VPWR VGND sg13cmos5l_antennanp
X_1425_ _1425_/Q Tile_X0Y0_FrameData[26] Tile_X0Y3_FrameStrobe[7] VPWR VGND sg13cmos5l_dlhq_1
XFILLER_205_31 VPWR VGND sg13cmos5l_fill_2
X_1356_ _1356_/Q Tile_X0Y0_FrameData[31] Tile_X0Y3_FrameStrobe[5] VPWR VGND sg13cmos5l_dlhq_1
XFILLER_205_64 VPWR VGND sg13cmos5l_decap_8
X_1287_ _1287_/Q Tile_X0Y0_FrameData[4] Tile_X0Y3_FrameStrobe[2] VPWR VGND sg13cmos5l_dlhq_1
XFILLER_55_159 VPWR VGND sg13cmos5l_decap_8
XANTENNA__1914__GATE Tile_X0Y3_FrameStrobe[6] VPWR VGND sg13cmos5l_antennanp
XANTENNA__0852__A0 AXIL_S_SOC_WSTRB2 VPWR VGND sg13cmos5l_antennanp
XANTENNA__2443__X Tile_X0Y0_FrameData_O[29] VPWR VGND sg13cmos5l_antennanp
XFILLER_11_207 VPWR VGND sg13cmos5l_fill_1
XFILLER_11_229 VPWR VGND sg13cmos5l_decap_8
XANTENNA__0604__A0 Tile_X0Y3_N1END[0] VPWR VGND sg13cmos5l_antennanp
XANTENNA__1210__D Tile_X0Y0_FrameData[17] VPWR VGND sg13cmos5l_antennanp
XANTENNA__1929__GATE Tile_X0Y3_FrameStrobe[7] VPWR VGND sg13cmos5l_antennanp
XFILLER_109_128 VPWR VGND sg13cmos5l_decap_4
XFILLER_126_8 VPWR VGND sg13cmos5l_fill_2
XFILLER_149_275 VPWR VGND sg13cmos5l_fill_1
XFILLER_166_16 VPWR VGND sg13cmos5l_decap_4
XANTENNA__0898__X AXIL_S_SOC_BRESP0 VPWR VGND sg13cmos5l_antennanp
XFILLER_117_150 VPWR VGND sg13cmos5l_decap_8
XANTENNA__0907__A1 Tile_X0Y1_W6END[8] VPWR VGND sg13cmos5l_antennanp
XANTENNA__2041__D Tile_X0Y3_FrameData[26] VPWR VGND sg13cmos5l_antennanp
XFILLER_59_25 VPWR VGND sg13cmos5l_fill_1
XFILLER_59_14 VPWR VGND sg13cmos5l_decap_4
XANTENNA__1880__D Tile_X0Y2_FrameData[3] VPWR VGND sg13cmos5l_antennanp
XFILLER_75_46 VPWR VGND sg13cmos5l_decap_8
XFILLER_46_159 VPWR VGND sg13cmos5l_fill_2
XFILLER_54_170 VPWR VGND sg13cmos5l_decap_8
XANTENNA__0843__A0 AXIL_S_SOC_AWVALID VPWR VGND sg13cmos5l_antennanp
XANTENNA__2353__X Tile_X0Y2_FrameData_O[29] VPWR VGND sg13cmos5l_antennanp
XFILLER_199_197 VPWR VGND sg13cmos5l_fill_1
XANTENNA__2061__GATE Tile_X0Y3_FrameStrobe[3] VPWR VGND sg13cmos5l_antennanp
XANTENNA__0610__A3 Tile_X0Y0_S4END[13] VPWR VGND sg13cmos5l_antennanp
XFILLER_6_277 VPWR VGND sg13cmos5l_fill_1
XANTENNA__1020__A0 AXIL_S_SOC_WDATA22 VPWR VGND sg13cmos5l_antennanp
XANTENNA__2076__GATE Tile_X0Y3_FrameStrobe[4] VPWR VGND sg13cmos5l_antennanp
XANTENNA__1790__D Tile_X0Y2_FrameData[29] VPWR VGND sg13cmos5l_antennanp
XFILLER_123_175 VPWR VGND sg13cmos5l_fill_1
XFILLER_69_229 VPWR VGND sg13cmos5l_decap_8
X_1210_ _1210_/Q Tile_X0Y0_FrameData[17] Tile_X0Y3_FrameStrobe[0] VPWR VGND sg13cmos5l_dlhq_1
X_2190_ _2190_/Q Tile_X0Y3_FrameData[3] Tile_X0Y3_FrameStrobe[7] VPWR VGND sg13cmos5l_dlhq_1
X_1141_ _1143_/B Tile_X0Y2_WW4END[13] _1876_/Q VPWR VGND sg13cmos5l_nor2b_1
XANTENNA__2528__X Tile_X0Y3_EE4BEG[2] VPWR VGND sg13cmos5l_antennanp
X_1072_ _1073_/B _0719_/X _1915_/Q VPWR VGND sg13cmos5l_nand2b_1
XFILLER_92_243 VPWR VGND sg13cmos5l_decap_8
XFILLER_225_249 VPWR VGND sg13cmos5l_decap_8
XANTENNA__1087__A0 AXIL_S_SOC_WDATA7 VPWR VGND sg13cmos5l_antennanp
XANTENNA__2014__GATE Tile_X0Y3_FrameStrobe[2] VPWR VGND sg13cmos5l_antennanp
XANTENNA__1270__GATE Tile_X0Y3_FrameStrobe[2] VPWR VGND sg13cmos5l_antennanp
XANTENNA__2126__D Tile_X0Y3_FrameData[5] VPWR VGND sg13cmos5l_antennanp
XANTENNA__2263__X Tile_X0Y1_FrameData_O[20] VPWR VGND sg13cmos5l_antennanp
X_1974_ _1974_/Q Tile_X0Y3_FrameData[29] Tile_X0Y3_FrameStrobe[1] VPWR VGND sg13cmos5l_dlhq_1
XANTENNA__1965__D Tile_X0Y3_FrameData[6] VPWR VGND sg13cmos5l_antennanp
XANTENNA__2029__GATE Tile_X0Y3_FrameStrobe[2] VPWR VGND sg13cmos5l_antennanp
XFILLER_146_212 VPWR VGND sg13cmos5l_fill_2
X_0925_ _0925_/X _0871_/X _0546_/X Tile_X0Y3_N4END[9] Tile_X0Y0_S4END[5] _1480_/Q
+ _1481_/Q VPWR VGND sg13cmos5l_mux4_1
XFILLER_146_256 VPWR VGND sg13cmos5l_decap_8
XANTENNA__1285__GATE Tile_X0Y3_FrameStrobe[2] VPWR VGND sg13cmos5l_antennanp
X_0856_ _2481_/A AXIL_S_SOC_AWADDR1 AXIL_S_SOC_AWADDR9 _0643_/X _0755_/X _1333_/Q
+ _1332_/Q VPWR VGND sg13cmos5l_mux4_1
XFILLER_60_0 VPWR VGND sg13cmos5l_decap_4
XANTENNA__1011__A0 Tile_X0Y1_W2MID[7] VPWR VGND sg13cmos5l_antennanp
XFILLER_136_19 VPWR VGND sg13cmos5l_fill_2
X_0787_ _0787_/X Tile_X0Y0_W1END[2] Tile_X0Y0_W6END[10] Tile_X0Y0_WW4END[2] _0785_/X
+ _1412_/Q _1413_/Q VPWR VGND sg13cmos5l_mux4_1
X_2526_ Tile_X0Y3_EE4BEG[0] _2526_/A VPWR VGND sg13cmos5l_buf_1
X_2457_ Tile_X0Y0_EE4BEG[11] _2457_/A VPWR VGND sg13cmos5l_buf_1
XFILLER_216_41 VPWR VGND sg13cmos5l_fill_1
X_1408_ _1408_/Q Tile_X0Y0_FrameData[11] Tile_X0Y3_FrameStrobe[6] VPWR VGND sg13cmos5l_dlhq_1
XFILLER_216_85 VPWR VGND sg13cmos5l_fill_1
X_2388_ Tile_X0Y0_N2BEG[6] _2388_/A VPWR VGND sg13cmos5l_buf_1
XANTENNA__1205__D Tile_X0Y0_FrameData[22] VPWR VGND sg13cmos5l_antennanp
XANTENNA__1223__GATE Tile_X0Y3_FrameStrobe[0] VPWR VGND sg13cmos5l_antennanp
XANTENNA__2438__X Tile_X0Y0_FrameData_O[24] VPWR VGND sg13cmos5l_antennanp
X_1339_ _1339_/Q Tile_X0Y0_FrameData[16] Tile_X0Y3_FrameStrobe[4] VPWR VGND sg13cmos5l_dlhq_1
XANTENNA__1853__GATE Tile_X0Y3_FrameStrobe[5] VPWR VGND sg13cmos5l_antennanp
XFILLER_83_243 VPWR VGND sg13cmos5l_decap_8
XFILLER_45_38 VPWR VGND sg13cmos5l_decap_8
XANTENNA__1078__A0 AXIL_S_SOC_WDATA6 VPWR VGND sg13cmos5l_antennanp
XFILLER_101_11 VPWR VGND sg13cmos5l_fill_1
XFILLER_101_22 VPWR VGND sg13cmos5l_fill_1
XFILLER_36_192 VPWR VGND sg13cmos5l_fill_1
XANTENNA__1238__GATE Tile_X0Y3_FrameStrobe[1] VPWR VGND sg13cmos5l_antennanp
XANTENNA__2036__D Tile_X0Y3_FrameData[31] VPWR VGND sg13cmos5l_antennanp
XANTENNA__1868__GATE Tile_X0Y3_FrameStrobe[5] VPWR VGND sg13cmos5l_antennanp
XANTENNA__1875__D Tile_X0Y2_FrameData[8] VPWR VGND sg13cmos5l_antennanp
XFILLER_177_37 VPWR VGND sg13cmos5l_fill_2
XFILLER_177_26 VPWR VGND sg13cmos5l_fill_1
XFILLER_137_245 VPWR VGND sg13cmos5l_fill_1
XANTENNA__1002__A0 Tile_X0Y1_W2MID[3] VPWR VGND sg13cmos5l_antennanp
XFILLER_193_36 VPWR VGND sg13cmos5l_decap_8
XFILLER_193_14 VPWR VGND sg13cmos5l_decap_4
XFILLER_126_30 VPWR VGND sg13cmos5l_decap_8
XFILLER_3_269 VPWR VGND sg13cmos5l_decap_8
XANTENNA__1806__GATE Tile_X0Y3_FrameStrobe[3] VPWR VGND sg13cmos5l_antennanp
XFILLER_86_78 VPWR VGND sg13cmos5l_decap_8
XFILLER_59_251 VPWR VGND sg13cmos5l_fill_2
XANTENNA__2348__X Tile_X0Y2_FrameData_O[24] VPWR VGND sg13cmos5l_antennanp
XFILLER_207_216 VPWR VGND sg13cmos5l_decap_8
XFILLER_19_61 VPWR VGND sg13cmos5l_decap_4
XFILLER_19_137 VPWR VGND sg13cmos5l_decap_8
XFILLER_207_227 VPWR VGND sg13cmos5l_fill_1
XFILLER_27_181 VPWR VGND sg13cmos5l_decap_8
XFILLER_42_140 VPWR VGND sg13cmos5l_fill_1
XFILLER_35_82 VPWR VGND sg13cmos5l_decap_8
XANTENNA__1785__D Tile_X0Y2_FrameData[2] VPWR VGND sg13cmos5l_antennanp
X_0710_ _2377_/A Tile_X0Y1_W2MID[4] Tile_X0Y1_W2END[4] Tile_X0Y1_W6END[4] _0868_/X
+ _1677_/Q _1676_/Q VPWR VGND sg13cmos5l_mux4_1
XANTENNA__0595__A2 Tile_X0Y3_W2END[2] VPWR VGND sg13cmos5l_antennanp
X_1690_ _1690_/Q Tile_X0Y1_FrameData[9] Tile_X0Y3_FrameStrobe[7] VPWR VGND sg13cmos5l_dlhq_1
X_0641_ _0641_/X Tile_X0Y2_W2MID[7] Tile_X0Y2_W2END[7] Tile_X0Y2_W6END[7] _0719_/X
+ _1931_/Q _1930_/Q VPWR VGND sg13cmos5l_mux4_1
X_0572_ _0572_/Y _1941_/Q Tile_X0Y3_N1END[3] VPWR VGND sg13cmos5l_nor2b_1
XFILLER_111_112 VPWR VGND sg13cmos5l_decap_8
X_2311_ Tile_X0Y2_EE4BEG[3] _2311_/A VPWR VGND sg13cmos5l_buf_1
X_2242_ Tile_X0Y1_EE4BEG[15] _2242_/A VPWR VGND sg13cmos5l_buf_1
XANTENNA__2258__X Tile_X0Y1_FrameData_O[15] VPWR VGND sg13cmos5l_antennanp
X_2173_ _2173_/Q Tile_X0Y3_FrameData[22] Tile_X0Y3_FrameStrobe[7] VPWR VGND sg13cmos5l_dlhq_1
X_1124_ _2305_/A AXIL_S_SOC_WDATA1 _1108_/X _1110_/X _0732_/X _1776_/Q _1777_/Q VPWR
+ VGND sg13cmos5l_mux4_1
X_1055_ _1055_/X _1911_/Q _1055_/B VPWR VGND sg13cmos5l_and2_1
XFILLER_80_246 VPWR VGND sg13cmos5l_decap_8
XFILLER_33_140 VPWR VGND sg13cmos5l_fill_1
XFILLER_206_293 VPWR VGND sg13cmos5l_fill_2
XFILLER_178_123 VPWR VGND sg13cmos5l_fill_2
XFILLER_178_112 VPWR VGND sg13cmos5l_decap_8
XANTENNA__2434__A Tile_X0Y0_FrameData[20] VPWR VGND sg13cmos5l_antennanp
XANTENNA__1695__D Tile_X0Y2_FrameData[28] VPWR VGND sg13cmos5l_antennanp
XFILLER_221_285 VPWR VGND sg13cmos5l_fill_2
X_1957_ _1957_/Q Tile_X0Y3_FrameData[14] Tile_X0Y3_FrameStrobe[0] VPWR VGND sg13cmos5l_dlhq_1
XFILLER_193_159 VPWR VGND sg13cmos5l_decap_8
XANTENNA__0586__A2 Tile_X0Y3_W6END[10] VPWR VGND sg13cmos5l_antennanp
X_1888_ _1888_/Q Tile_X0Y2_FrameData[27] Tile_X0Y3_FrameStrobe[6] VPWR VGND sg13cmos5l_dlhq_1
X_0908_ _0912_/A _1667_/Q _0906_/Y _0907_/Y VPWR VGND sg13cmos5l_a21oi_1
X_0839_ _2482_/A AXIL_S_SOC_WVALID AXIL_S_SOC_AWADDR2 _0643_/X _0755_/X _1363_/Q _1362_/Q
+ VPWR VGND sg13cmos5l_mux4_1
XFILLER_163_28 VPWR VGND sg13cmos5l_fill_1
X_2509_ Tile_X0Y3_E2BEGb[3] _2509_/A VPWR VGND sg13cmos5l_buf_1
XFILLER_163_39 VPWR VGND sg13cmos5l_decap_8
XFILLER_56_15 VPWR VGND sg13cmos5l_decap_8
XANTENNA__1792__GATE Tile_X0Y3_FrameStrobe[3] VPWR VGND sg13cmos5l_antennanp
XFILLER_56_254 VPWR VGND sg13cmos5l_decap_4
XANTENNA__0510__A2 Tile_X0Y1_W6END[11] VPWR VGND sg13cmos5l_antennanp
XFILLER_112_21 VPWR VGND sg13cmos5l_decap_4
XFILLER_112_76 VPWR VGND sg13cmos5l_decap_8
XFILLER_212_230 VPWR VGND sg13cmos5l_fill_1
XFILLER_188_14 VPWR VGND sg13cmos5l_fill_2
XANTENNA__2344__A Tile_X0Y2_FrameData[20] VPWR VGND sg13cmos5l_antennanp
XFILLER_72_69 VPWR VGND sg13cmos5l_decap_8
XFILLER_212_252 VPWR VGND sg13cmos5l_fill_2
XFILLER_212_241 VPWR VGND sg13cmos5l_decap_8
XFILLER_188_47 VPWR VGND sg13cmos5l_decap_8
XANTENNA__1730__GATE Tile_X0Y3_FrameStrobe[1] VPWR VGND sg13cmos5l_antennanp
XANTENNA__0577__A2 Tile_X0Y1_W6END[8] VPWR VGND sg13cmos5l_antennanp
XFILLER_125_215 VPWR VGND sg13cmos5l_fill_1
XFILLER_21_73 VPWR VGND sg13cmos5l_fill_1
XFILLER_192_170 VPWR VGND sg13cmos5l_decap_8
XFILLER_137_51 VPWR VGND sg13cmos5l_decap_8
XFILLER_21_95 VPWR VGND sg13cmos5l_fill_2
XANTENNA__1745__GATE Tile_X0Y3_FrameStrobe[1] VPWR VGND sg13cmos5l_antennanp
XFILLER_62_224 VPWR VGND sg13cmos5l_decap_4
XFILLER_46_70 VPWR VGND sg13cmos5l_decap_4
XANTENNA__2254__A Tile_X0Y1_FrameData[11] VPWR VGND sg13cmos5l_antennanp
XFILLER_203_263 VPWR VGND sg13cmos5l_decap_8
XFILLER_203_252 VPWR VGND sg13cmos5l_fill_1
X_1811_ _1811_/Q Tile_X0Y2_FrameData[8] Tile_X0Y3_FrameStrobe[3] VPWR VGND sg13cmos5l_dlhq_1
XFILLER_175_115 VPWR VGND sg13cmos5l_decap_8
XANTENNA__2541__X Tile_X0Y3_EE4BEG[15] VPWR VGND sg13cmos5l_antennanp
X_1742_ _1742_/Q Tile_X0Y2_FrameData[13] Tile_X0Y3_FrameStrobe[1] VPWR VGND sg13cmos5l_dlhq_1
XFILLER_116_226 VPWR VGND sg13cmos5l_decap_8
X_1673_ _1673_/Q Tile_X0Y1_FrameData[26] Tile_X0Y3_FrameStrobe[7] VPWR VGND sg13cmos5l_dlhq_1
X_0624_ _0624_/X Tile_X0Y3_W1END[3] Tile_X0Y3_W6END[7] Tile_X0Y3_WW4END[15] _0513_/X
+ _2117_/Q _2118_/Q VPWR VGND sg13cmos5l_mux4_1
XFILLER_131_207 VPWR VGND sg13cmos5l_decap_4
X_0555_ _0555_/Y _1697_/Q _1696_/Q VPWR VGND sg13cmos5l_nor2b_1
X_0486_ _0486_/X Tile_X0Y3_W1END[2] Tile_X0Y3_WW4END[2] Tile_X0Y3_W6END[10] _0485_/X
+ _2157_/Q _2156_/Q VPWR VGND sg13cmos5l_mux4_1
XFILLER_23_0 VPWR VGND sg13cmos5l_fill_2
XANTENNA__0740__A2 Tile_X0Y0_W2MID[3] VPWR VGND sg13cmos5l_antennanp
XANTENNA__2429__A Tile_X0Y0_FrameData[15] VPWR VGND sg13cmos5l_antennanp
X_2225_ Tile_X0Y1_E6BEG[10] _2225_/A VPWR VGND sg13cmos5l_buf_1
X_2156_ _2156_/Q Tile_X0Y3_FrameData[7] Tile_X0Y3_FrameStrobe[6] VPWR VGND sg13cmos5l_dlhq_1
X_1107_ _2314_/A AXIL_S_SOC_WDATA6 AXIL_S_SOC_WDATA10 _1051_/A _0715_/X _1815_/Q _1814_/Q
+ VPWR VGND sg13cmos5l_mux4_1
X_2087_ _2087_/Q Tile_X0Y3_FrameData[12] Tile_X0Y3_FrameStrobe[4] VPWR VGND sg13cmos5l_dlhq_1
X_1038_ _2227_/A AXIL_S_SOC_WDATA16 _0493_/X AXIL_S_SOC_WDATA28 _0862_/X _1578_/Q
+ _1579_/Q VPWR VGND sg13cmos5l_mux4_1
XFILLER_53_279 VPWR VGND sg13cmos5l_fill_1
XFILLER_42_28 VPWR VGND sg13cmos5l_decap_8
XANTENNA__2451__X Tile_X0Y0_EE4BEG[5] VPWR VGND sg13cmos5l_antennanp
XFILLER_107_259 VPWR VGND sg13cmos5l_fill_2
XFILLER_174_27 VPWR VGND sg13cmos5l_decap_8
XFILLER_174_16 VPWR VGND sg13cmos5l_decap_4
XANTENNA__0731__A2 Tile_X0Y3_W6END[2] VPWR VGND sg13cmos5l_antennanp
XANTENNA__2339__A Tile_X0Y2_FrameData[15] VPWR VGND sg13cmos5l_antennanp
XFILLER_88_198 VPWR VGND sg13cmos5l_decap_8
XFILLER_29_276 VPWR VGND sg13cmos5l_decap_8
XFILLER_16_73 VPWR VGND sg13cmos5l_decap_8
XFILLER_225_0 VPWR VGND sg13cmos5l_fill_2
XANTENNA__2361__X Tile_X0Y0_N4BEG[3] VPWR VGND sg13cmos5l_antennanp
XFILLER_165_170 VPWR VGND sg13cmos5l_fill_1
XANTENNA__1684__GATE Tile_X0Y3_FrameStrobe[7] VPWR VGND sg13cmos5l_antennanp
XFILLER_106_281 VPWR VGND sg13cmos5l_decap_4
XFILLER_106_292 VPWR VGND sg13cmos5l_fill_2
XANTENNA__1699__GATE Tile_X0Y3_FrameStrobe[0] VPWR VGND sg13cmos5l_antennanp
XFILLER_164_93 VPWR VGND sg13cmos5l_fill_1
XANTENNA__2249__A Tile_X0Y1_FrameData[6] VPWR VGND sg13cmos5l_antennanp
X_2010_ _2010_/Q Tile_X0Y3_FrameData[25] Tile_X0Y3_FrameStrobe[2] VPWR VGND sg13cmos5l_dlhq_1
XANTENNA__1622__GATE Tile_X0Y3_FrameStrobe[5] VPWR VGND sg13cmos5l_antennanp
XANTENNA__0486__A1 Tile_X0Y3_WW4END[2] VPWR VGND sg13cmos5l_antennanp
XANTENNA__1303__D Tile_X0Y0_FrameData[20] VPWR VGND sg13cmos5l_antennanp
XANTENNA__2536__X Tile_X0Y3_EE4BEG[10] VPWR VGND sg13cmos5l_antennanp
XANTENNA__1637__GATE Tile_X0Y3_FrameStrobe[6] VPWR VGND sg13cmos5l_antennanp
XANTENNA__2134__D Tile_X0Y3_FrameData[29] VPWR VGND sg13cmos5l_antennanp
XANTENNA__2271__X Tile_X0Y1_FrameData_O[28] VPWR VGND sg13cmos5l_antennanp
XANTENNA__1973__D Tile_X0Y3_FrameData[30] VPWR VGND sg13cmos5l_antennanp
X_1725_ _1725_/Q Tile_X0Y2_FrameData[30] Tile_X0Y3_FrameStrobe[1] VPWR VGND sg13cmos5l_dlhq_1
X_1656_ _1656_/Q Tile_X0Y1_FrameData[11] Tile_X0Y3_FrameStrobe[6] VPWR VGND sg13cmos5l_dlhq_1
XFILLER_208_75 VPWR VGND sg13cmos5l_decap_8
X_1587_ _1587_/Q Tile_X0Y1_FrameData[16] Tile_X0Y3_FrameStrobe[4] VPWR VGND sg13cmos5l_dlhq_1
X_0607_ _0607_/X Tile_X0Y3_N1END[0] Tile_X0Y3_N4END[0] _0539_/B Tile_X0Y0_S4END[12]
+ _1995_/Q _1994_/Q VPWR VGND sg13cmos5l_mux4_1
X_0538_ _0538_/Y Tile_X0Y3_W6END[0] _1947_/Q _0537_/Y VPWR VGND sg13cmos5l_a21oi_1
XANTENNA__0713__A2 Tile_X0Y0_W6END[9] VPWR VGND sg13cmos5l_antennanp
XFILLER_85_102 VPWR VGND sg13cmos5l_decap_8
XFILLER_218_108 VPWR VGND sg13cmos5l_decap_4
XANTENNA__1063__A Tile_X0Y2_WW4END[0] VPWR VGND sg13cmos5l_antennanp
X_0469_ _0469_/Y _1446_/Q _0468_/Y _0466_/Y VPWR VGND sg13cmos5l_o21ai_1
XFILLER_85_157 VPWR VGND sg13cmos5l_fill_1
XFILLER_218_119 VPWR VGND sg13cmos5l_fill_1
X_2208_ Tile_X0Y1_E2BEGb[1] _2208_/A VPWR VGND sg13cmos5l_buf_1
XANTENNA__0477__A1 Tile_X0Y2_W6END[10] VPWR VGND sg13cmos5l_antennanp
XANTENNA__1213__D Tile_X0Y0_FrameData[14] VPWR VGND sg13cmos5l_antennanp
XANTENNA__2446__X Tile_X0Y0_EE4BEG[0] VPWR VGND sg13cmos5l_antennanp
X_2139_ _2139_/Q Tile_X0Y3_FrameData[24] Tile_X0Y3_FrameStrobe[6] VPWR VGND sg13cmos5l_dlhq_1
XFILLER_41_205 VPWR VGND sg13cmos5l_decap_8
XFILLER_26_279 VPWR VGND sg13cmos5l_fill_2
XFILLER_26_257 VPWR VGND sg13cmos5l_decap_4
XFILLER_169_27 VPWR VGND sg13cmos5l_fill_1
XFILLER_53_38 VPWR VGND sg13cmos5l_fill_2
XANTENNA__2044__D Tile_X0Y3_FrameData[23] VPWR VGND sg13cmos5l_antennanp
XFILLER_194_276 VPWR VGND sg13cmos5l_decap_4
XFILLER_194_254 VPWR VGND sg13cmos5l_fill_1
XFILLER_194_243 VPWR VGND sg13cmos5l_decap_8
XFILLER_5_106 VPWR VGND sg13cmos5l_decap_8
XANTENNA__1883__D Tile_X0Y2_FrameData[0] VPWR VGND sg13cmos5l_antennanp
XANTENNA__0704__A2 Tile_X0Y3_W6END[7] VPWR VGND sg13cmos5l_antennanp
XFILLER_134_30 VPWR VGND sg13cmos5l_fill_1
XFILLER_134_74 VPWR VGND sg13cmos5l_decap_8
XFILLER_217_130 VPWR VGND sg13cmos5l_decap_4
XANTENNA__2356__X Tile_X0Y2_UserCLKo VPWR VGND sg13cmos5l_antennanp
XFILLER_91_138 VPWR VGND sg13cmos5l_fill_1
XFILLER_27_72 VPWR VGND sg13cmos5l_decap_4
XFILLER_27_61 VPWR VGND sg13cmos5l_decap_4
XFILLER_17_213 VPWR VGND sg13cmos5l_fill_2
XFILLER_43_71 VPWR VGND sg13cmos5l_decap_4
XFILLER_185_265 VPWR VGND sg13cmos5l_decap_8
XANTENNA__1196__A2 Tile_X0Y2_WW4END[12] VPWR VGND sg13cmos5l_antennanp
XANTENNA__1793__D Tile_X0Y2_FrameData[26] VPWR VGND sg13cmos5l_antennanp
XFILLER_138_192 VPWR VGND sg13cmos5l_decap_8
X_1510_ _1510_/Q Tile_X0Y1_FrameData[29] Tile_X0Y3_FrameStrobe[2] VPWR VGND sg13cmos5l_dlhq_1
X_2490_ Tile_X0Y0_E1BEG[0] _2490_/A VPWR VGND sg13cmos5l_buf_1
XFILLER_153_195 VPWR VGND sg13cmos5l_decap_4
X_1441_ _1441_/Q Tile_X0Y0_FrameData[10] Tile_X0Y3_FrameStrobe[7] VPWR VGND sg13cmos5l_dlhq_1
X_1372_ _1372_/Q Tile_X0Y0_FrameData[15] Tile_X0Y3_FrameStrobe[5] VPWR VGND sg13cmos5l_dlhq_1
XFILLER_67_135 VPWR VGND sg13cmos5l_decap_8
XANTENNA__1561__GATE Tile_X0Y3_FrameStrobe[3] VPWR VGND sg13cmos5l_antennanp
XFILLER_82_105 VPWR VGND sg13cmos5l_decap_8
XANTENNA__2129__D Tile_X0Y3_FrameData[2] VPWR VGND sg13cmos5l_antennanp
XANTENNA__2266__X Tile_X0Y1_FrameData_O[23] VPWR VGND sg13cmos5l_antennanp
XANTENNA__1576__GATE Tile_X0Y3_FrameStrobe[4] VPWR VGND sg13cmos5l_antennanp
XANTENNA__1968__D Tile_X0Y3_FrameData[3] VPWR VGND sg13cmos5l_antennanp
XFILLER_210_32 VPWR VGND sg13cmos5l_fill_1
XFILLER_210_10 VPWR VGND sg13cmos5l_decap_8
XFILLER_90_0 VPWR VGND sg13cmos5l_fill_2
XANTENNA__0631__A1 Tile_X0Y3_W2END[0] VPWR VGND sg13cmos5l_antennanp
XANTENNA__2442__A Tile_X0Y0_FrameData[28] VPWR VGND sg13cmos5l_antennanp
XFILLER_191_257 VPWR VGND sg13cmos5l_decap_4
XFILLER_191_235 VPWR VGND sg13cmos5l_decap_4
XFILLER_155_29 VPWR VGND sg13cmos5l_fill_1
X_1708_ _1708_/Q Tile_X0Y2_FrameData[15] Tile_X0Y3_FrameStrobe[0] VPWR VGND sg13cmos5l_dlhq_1
XANTENNA__1208__D Tile_X0Y0_FrameData[19] VPWR VGND sg13cmos5l_antennanp
XANTENNA__1514__GATE Tile_X0Y3_FrameStrobe[2] VPWR VGND sg13cmos5l_antennanp
X_1639_ _1639_/Q Tile_X0Y1_FrameData[28] Tile_X0Y3_FrameStrobe[6] VPWR VGND sg13cmos5l_dlhq_1
XFILLER_58_124 VPWR VGND sg13cmos5l_decap_8
XANTENNA__1529__GATE Tile_X0Y3_FrameStrobe[2] VPWR VGND sg13cmos5l_antennanp
XFILLER_171_28 VPWR VGND sg13cmos5l_fill_1
XFILLER_98_293 VPWR VGND sg13cmos5l_fill_2
XFILLER_104_33 VPWR VGND sg13cmos5l_decap_8
XANTENNA__2039__D Tile_X0Y3_FrameData[28] VPWR VGND sg13cmos5l_antennanp
XFILLER_73_138 VPWR VGND sg13cmos5l_fill_1
XFILLER_64_15 VPWR VGND sg13cmos5l_fill_2
XANTENNA__1111__A2 AXIL_S_SOC_WDATA13 VPWR VGND sg13cmos5l_antennanp
XFILLER_214_133 VPWR VGND sg13cmos5l_decap_8
XANTENNA__1878__D Tile_X0Y2_FrameData[5] VPWR VGND sg13cmos5l_antennanp
XFILLER_14_227 VPWR VGND sg13cmos5l_decap_8
XFILLER_80_14 VPWR VGND sg13cmos5l_fill_2
XANTENNA__2352__A Tile_X0Y2_FrameData[28] VPWR VGND sg13cmos5l_antennanp
XFILLER_22_293 VPWR VGND sg13cmos5l_fill_2
XFILLER_196_25 VPWR VGND sg13cmos5l_decap_8
XFILLER_13_63 VPWR VGND sg13cmos5l_decap_4
XFILLER_129_85 VPWR VGND sg13cmos5l_decap_8
XFILLER_182_279 VPWR VGND sg13cmos5l_fill_2
XANTENNA__0925__A2 Tile_X0Y3_N4END[9] VPWR VGND sg13cmos5l_antennanp
XFILLER_89_89 VPWR VGND sg13cmos5l_decap_8
XFILLER_150_132 VPWR VGND sg13cmos5l_decap_8
XFILLER_1_142 VPWR VGND sg13cmos5l_fill_1
XFILLER_145_95 VPWR VGND sg13cmos5l_fill_2
XANTENNA__0689__A1 Tile_X0Y0_S4END[12] VPWR VGND sg13cmos5l_antennanp
XFILLER_89_293 VPWR VGND sg13cmos5l_fill_2
XFILLER_161_72 VPWR VGND sg13cmos5l_fill_2
XANTENNA__1788__D Tile_X0Y2_FrameData[31] VPWR VGND sg13cmos5l_antennanp
XFILLER_72_182 VPWR VGND sg13cmos5l_fill_2
X_1990_ _1990_/Q Tile_X0Y3_FrameData[13] Tile_X0Y3_FrameStrobe[1] VPWR VGND sg13cmos5l_dlhq_1
XFILLER_220_125 VPWR VGND sg13cmos5l_decap_8
X_0941_ _0941_/Y _1631_/Q _0916_/B _0940_/Y VPWR VGND sg13cmos5l_o21ai_1
XANTENNA__2262__A Tile_X0Y1_FrameData[19] VPWR VGND sg13cmos5l_antennanp
XFILLER_13_293 VPWR VGND sg13cmos5l_fill_2
X_0872_ _2464_/A Tile_X0Y3_N4END[14] _0772_/X Tile_X0Y0_S4END[2] _0542_/X _1294_/Q
+ _1295_/Q VPWR VGND sg13cmos5l_mux4_1
XFILLER_9_275 VPWR VGND sg13cmos5l_decap_4
XFILLER_70_80 VPWR VGND sg13cmos5l_decap_4
XANTENNA__1169__A2 Tile_X0Y2_WW4END[3] VPWR VGND sg13cmos5l_antennanp
X_2542_ Tile_X0Y3_FrameData_O[0] Tile_X0Y3_FrameData[0] VPWR VGND sg13cmos5l_buf_1
X_2473_ Tile_X0Y0_E6BEG[11] _2473_/A VPWR VGND sg13cmos5l_buf_1
X_1424_ _1424_/Q Tile_X0Y0_FrameData[27] Tile_X0Y3_FrameStrobe[7] VPWR VGND sg13cmos5l_dlhq_1
XFILLER_87_219 VPWR VGND sg13cmos5l_decap_8
X_1355_ _1355_/Q Tile_X0Y0_FrameData[0] Tile_X0Y3_FrameStrobe[4] VPWR VGND sg13cmos5l_dlhq_1
XFILLER_205_43 VPWR VGND sg13cmos5l_decap_8
XFILLER_95_274 VPWR VGND sg13cmos5l_decap_4
XFILLER_55_116 VPWR VGND sg13cmos5l_decap_8
X_1286_ _1286_/Q Tile_X0Y0_FrameData[5] Tile_X0Y3_FrameStrobe[2] VPWR VGND sg13cmos5l_dlhq_1
XANTENNA__2437__A Tile_X0Y0_FrameData[23] VPWR VGND sg13cmos5l_antennanp
XFILLER_221_31 VPWR VGND sg13cmos5l_decap_4
XANTENNA__1698__D Tile_X0Y2_FrameData[25] VPWR VGND sg13cmos5l_antennanp
XFILLER_70_119 VPWR VGND sg13cmos5l_fill_1
XFILLER_221_75 VPWR VGND sg13cmos5l_fill_1
XANTENNA__0852__A1 AXIL_S_SOC_AWADDR9 VPWR VGND sg13cmos5l_antennanp
XFILLER_221_97 VPWR VGND sg13cmos5l_fill_2
XANTENNA__0604__A1 Tile_X0Y3_N4END[0] VPWR VGND sg13cmos5l_antennanp
XFILLER_149_254 VPWR VGND sg13cmos5l_decap_8
XFILLER_149_265 VPWR VGND sg13cmos5l_fill_1
XFILLER_164_235 VPWR VGND sg13cmos5l_fill_1
XANTENNA__1453__GATE Tile_X0Y3_FrameStrobe[0] VPWR VGND sg13cmos5l_antennanp
XFILLER_59_48 VPWR VGND sg13cmos5l_fill_1
XANTENNA__1468__GATE Tile_X0Y3_FrameStrobe[0] VPWR VGND sg13cmos5l_antennanp
XFILLER_75_25 VPWR VGND sg13cmos5l_decap_8
XFILLER_46_127 VPWR VGND sg13cmos5l_decap_8
XANTENNA__2347__A Tile_X0Y2_FrameData[23] VPWR VGND sg13cmos5l_antennanp
XFILLER_39_190 VPWR VGND sg13cmos5l_fill_2
XFILLER_91_24 VPWR VGND sg13cmos5l_fill_1
XANTENNA__0843__A1 AXIL_S_SOC_AWADDR7 VPWR VGND sg13cmos5l_antennanp
XANTENNA__1401__D Tile_X0Y0_FrameData[18] VPWR VGND sg13cmos5l_antennanp
XFILLER_202_114 VPWR VGND sg13cmos5l_decap_8
XFILLER_199_154 VPWR VGND sg13cmos5l_decap_8
XANTENNA__1406__GATE Tile_X0Y3_FrameStrobe[6] VPWR VGND sg13cmos5l_antennanp
XFILLER_202_158 VPWR VGND sg13cmos5l_decap_4
XFILLER_202_125 VPWR VGND sg13cmos5l_fill_2
XFILLER_138_0 VPWR VGND sg13cmos5l_fill_2
XFILLER_10_274 VPWR VGND sg13cmos5l_fill_2
XANTENNA__1020__A1 AXIL_S_SOC_WDATA26 VPWR VGND sg13cmos5l_antennanp
XFILLER_69_208 VPWR VGND sg13cmos5l_decap_8
XFILLER_77_230 VPWR VGND sg13cmos5l_decap_8
XFILLER_49_70 VPWR VGND sg13cmos5l_decap_8
X_1140_ _1144_/B _1876_/Q _1042_/Y _1139_/Y VPWR VGND sg13cmos5l_a21oi_1
XFILLER_37_116 VPWR VGND sg13cmos5l_fill_2
XFILLER_225_206 VPWR VGND sg13cmos5l_fill_1
XANTENNA__2257__A Tile_X0Y1_FrameData[14] VPWR VGND sg13cmos5l_antennanp
X_1071_ _1071_/Y _1915_/Q _1069_/X _1070_/Y VPWR VGND sg13cmos5l_o21ai_1
XFILLER_37_149 VPWR VGND sg13cmos5l_fill_2
XANTENNA__1087__A1 AXIL_S_SOC_WDATA15 VPWR VGND sg13cmos5l_antennanp
XFILLER_52_108 VPWR VGND sg13cmos5l_fill_1
XANTENNA__1311__D Tile_X0Y0_FrameData[12] VPWR VGND sg13cmos5l_antennanp
XANTENNA__2544__X Tile_X0Y3_FrameData_O[2] VPWR VGND sg13cmos5l_antennanp
XFILLER_60_174 VPWR VGND sg13cmos5l_fill_2
X_1973_ _1973_/Q Tile_X0Y3_FrameData[30] Tile_X0Y3_FrameStrobe[1] VPWR VGND sg13cmos5l_dlhq_1
XANTENNA__0598__A0 Tile_X0Y3_N2MID[6] VPWR VGND sg13cmos5l_antennanp
X_0924_ _0924_/X Tile_X0Y1_W1END[1] Tile_X0Y1_W6END[9] Tile_X0Y1_WW4END[1] _0923_/A
+ _1663_/Q _1664_/Q VPWR VGND sg13cmos5l_mux4_1
XFILLER_201_180 VPWR VGND sg13cmos5l_fill_1
XFILLER_146_235 VPWR VGND sg13cmos5l_decap_8
X_0855_ _2446_/A AXIL_S_SOC_WVALID AXIL_S_SOC_AWADDR6 _0488_/X _0755_/X _1331_/Q _1330_/Q
+ VPWR VGND sg13cmos5l_mux4_1
XANTENNA__2142__D Tile_X0Y3_FrameData[21] VPWR VGND sg13cmos5l_antennanp
XANTENNA__1011__A1 Tile_X0Y1_W2END[7] VPWR VGND sg13cmos5l_antennanp
XANTENNA__2183__GATE Tile_X0Y3_FrameStrobe[7] VPWR VGND sg13cmos5l_antennanp
X_0786_ _0786_/X _0770_/X Tile_X0Y3_N4END[14] Tile_X0Y0_S1END[2] Tile_X0Y0_S4END[2]
+ _1239_/Q _1238_/Q VPWR VGND sg13cmos5l_mux4_1
XFILLER_53_0 VPWR VGND sg13cmos5l_fill_2
XANTENNA__1981__D Tile_X0Y3_FrameData[22] VPWR VGND sg13cmos5l_antennanp
X_2525_ Tile_X0Y3_E6BEG[11] _2525_/A VPWR VGND sg13cmos5l_buf_1
XANTENNA__0770__A0 Tile_X0Y1_W1END[2] VPWR VGND sg13cmos5l_antennanp
X_2456_ Tile_X0Y0_EE4BEG[10] _2456_/A VPWR VGND sg13cmos5l_buf_1
XFILLER_216_64 VPWR VGND sg13cmos5l_fill_2
X_1407_ _1407_/Q Tile_X0Y0_FrameData[12] Tile_X0Y3_FrameStrobe[6] VPWR VGND sg13cmos5l_dlhq_1
X_2387_ Tile_X0Y0_N2BEG[5] _2387_/A VPWR VGND sg13cmos5l_buf_1
X_1338_ _1338_/Q Tile_X0Y0_FrameData[17] Tile_X0Y3_FrameStrobe[4] VPWR VGND sg13cmos5l_dlhq_1
XFILLER_83_200 VPWR VGND sg13cmos5l_fill_2
XFILLER_28_138 VPWR VGND sg13cmos5l_decap_4
XANTENNA__2121__GATE Tile_X0Y3_FrameStrobe[5] VPWR VGND sg13cmos5l_antennanp
X_1269_ _1269_/Q Tile_X0Y0_FrameData[22] Tile_X0Y3_FrameStrobe[2] VPWR VGND sg13cmos5l_dlhq_1
XFILLER_216_239 VPWR VGND sg13cmos5l_decap_4
XANTENNA__1078__A1 AXIL_S_SOC_WDATA14 VPWR VGND sg13cmos5l_antennanp
XFILLER_36_160 VPWR VGND sg13cmos5l_decap_8
XANTENNA__1221__D Tile_X0Y0_FrameData[6] VPWR VGND sg13cmos5l_antennanp
XANTENNA__2454__X Tile_X0Y0_EE4BEG[8] VPWR VGND sg13cmos5l_antennanp
XFILLER_101_56 VPWR VGND sg13cmos5l_fill_2
XFILLER_224_294 VPWR VGND sg13cmos5l_fill_1
XANTENNA__2136__GATE Tile_X0Y3_FrameStrobe[6] VPWR VGND sg13cmos5l_antennanp
XFILLER_51_185 VPWR VGND sg13cmos5l_decap_8
XFILLER_177_16 VPWR VGND sg13cmos5l_fill_1
XANTENNA__0589__A0 Tile_X0Y2_W1END[0] VPWR VGND sg13cmos5l_antennanp
XANTENNA__1392__GATE Tile_X0Y3_FrameStrobe[6] VPWR VGND sg13cmos5l_antennanp
XANTENNA__0702__X AXIL_S_SOC_RDATA1 VPWR VGND sg13cmos5l_antennanp
XANTENNA__2052__D Tile_X0Y3_FrameData[15] VPWR VGND sg13cmos5l_antennanp
XFILLER_152_227 VPWR VGND sg13cmos5l_decap_8
XANTENNA__1002__A1 Tile_X0Y1_W2END[3] VPWR VGND sg13cmos5l_antennanp
XANTENNA__1891__D Tile_X0Y2_FrameData[24] VPWR VGND sg13cmos5l_antennanp
XFILLER_105_121 VPWR VGND sg13cmos5l_decap_8
XFILLER_10_86 VPWR VGND sg13cmos5l_fill_1
XFILLER_105_198 VPWR VGND sg13cmos5l_decap_8
XFILLER_126_86 VPWR VGND sg13cmos5l_decap_8
XFILLER_160_293 VPWR VGND sg13cmos5l_fill_2
XFILLER_86_46 VPWR VGND sg13cmos5l_fill_1
XFILLER_120_157 VPWR VGND sg13cmos5l_decap_8
XANTENNA__0513__A0 Tile_X0Y3_N1END[3] VPWR VGND sg13cmos5l_antennanp
XANTENNA__1330__GATE Tile_X0Y3_FrameStrobe[4] VPWR VGND sg13cmos5l_antennanp
XFILLER_142_30 VPWR VGND sg13cmos5l_fill_1
XFILLER_142_41 VPWR VGND sg13cmos5l_decap_8
XFILLER_59_274 VPWR VGND sg13cmos5l_fill_2
XANTENNA__1960__GATE Tile_X0Y3_FrameStrobe[0] VPWR VGND sg13cmos5l_antennanp
XFILLER_142_74 VPWR VGND sg13cmos5l_fill_1
XANTENNA__0467__A_N Tile_X0Y1_W6END[2] VPWR VGND sg13cmos5l_antennanp
XANTENNA__0816__A1 AXIL_S_SOC_WSTRB0 VPWR VGND sg13cmos5l_antennanp
XANTENNA__1345__GATE Tile_X0Y3_FrameStrobe[4] VPWR VGND sg13cmos5l_antennanp
XANTENNA__2364__X Tile_X0Y0_N4BEG[6] VPWR VGND sg13cmos5l_antennanp
XFILLER_35_61 VPWR VGND sg13cmos5l_decap_8
XANTENNA__1975__GATE Tile_X0Y3_FrameStrobe[1] VPWR VGND sg13cmos5l_antennanp
XFILLER_215_294 VPWR VGND sg13cmos5l_fill_1
XFILLER_128_202 VPWR VGND sg13cmos5l_decap_8
XFILLER_128_246 VPWR VGND sg13cmos5l_decap_8
XFILLER_167_60 VPWR VGND sg13cmos5l_fill_1
XFILLER_167_71 VPWR VGND sg13cmos5l_decap_8
XFILLER_167_82 VPWR VGND sg13cmos5l_fill_2
X_0640_ _2495_/A Tile_X0Y3_N1END[1] _0564_/B AXIL_S_SOC_RREADY AXIL_S_SOC_ARADDR1
+ _2113_/Q _2112_/Q VPWR VGND sg13cmos5l_mux4_1
X_0571_ _2576_/A Tile_X0Y3_W1END[2] _0480_/X Tile_X0Y3_W6END[10] _0570_/Y _2146_/Q
+ _2147_/Q VPWR VGND sg13cmos5l_mux4_1
XANTENNA__0752__A0 Tile_X0Y1_W1END[1] VPWR VGND sg13cmos5l_antennanp
XANTENNA__1913__GATE Tile_X0Y3_FrameStrobe[6] VPWR VGND sg13cmos5l_antennanp
X_2310_ Tile_X0Y2_EE4BEG[2] _2310_/A VPWR VGND sg13cmos5l_buf_1
XANTENNA__2539__X Tile_X0Y3_EE4BEG[13] VPWR VGND sg13cmos5l_antennanp
X_2241_ Tile_X0Y1_EE4BEG[14] _2241_/A VPWR VGND sg13cmos5l_buf_1
XFILLER_2_270 VPWR VGND sg13cmos5l_fill_1
XANTENNA__1306__D Tile_X0Y0_FrameData[17] VPWR VGND sg13cmos5l_antennanp
XANTENNA__1928__GATE Tile_X0Y3_FrameStrobe[7] VPWR VGND sg13cmos5l_antennanp
X_2172_ _2172_/Q Tile_X0Y3_FrameData[23] Tile_X0Y3_FrameStrobe[7] VPWR VGND sg13cmos5l_dlhq_1
X_1123_ _2302_/A AXIL_S_SOC_WDATA6 _1049_/X _1051_/A _0725_/X _1783_/Q _1782_/Q VPWR
+ VGND sg13cmos5l_mux4_1
XFILLER_65_255 VPWR VGND sg13cmos5l_fill_1
XFILLER_65_244 VPWR VGND sg13cmos5l_decap_8
X_1054_ _1055_/B _0715_/X _1912_/Q VPWR VGND sg13cmos5l_nand2b_1
XFILLER_80_225 VPWR VGND sg13cmos5l_decap_8
XFILLER_65_277 VPWR VGND sg13cmos5l_decap_8
XFILLER_202_11 VPWR VGND sg13cmos5l_decap_8
XANTENNA__2137__D Tile_X0Y3_FrameData[26] VPWR VGND sg13cmos5l_antennanp
XANTENNA__2274__X Tile_X0Y1_FrameData_O[31] VPWR VGND sg13cmos5l_antennanp
XFILLER_202_77 VPWR VGND sg13cmos5l_fill_2
XFILLER_206_283 VPWR VGND sg13cmos5l_fill_1
XFILLER_178_102 VPWR VGND sg13cmos5l_decap_4
XANTENNA__1976__D Tile_X0Y3_FrameData[27] VPWR VGND sg13cmos5l_antennanp
XFILLER_221_253 VPWR VGND sg13cmos5l_decap_8
XFILLER_221_242 VPWR VGND sg13cmos5l_fill_1
X_1956_ _1956_/Q Tile_X0Y3_FrameData[15] Tile_X0Y3_FrameStrobe[0] VPWR VGND sg13cmos5l_dlhq_1
X_0907_ _0907_/Y Tile_X0Y1_W6END[8] _1667_/Q _1666_/Q VPWR VGND sg13cmos5l_o21ai_1
X_1887_ _1887_/Q Tile_X0Y2_FrameData[28] Tile_X0Y3_FrameStrobe[6] VPWR VGND sg13cmos5l_dlhq_1
X_0838_ _2483_/A AXIL_S_SOC_WSTRB0 AXIL_S_SOC_AWADDR3 _0646_/X _0751_/X _1361_/Q _1360_/Q
+ VPWR VGND sg13cmos5l_mux4_1
X_0769_ _2370_/A _0764_/Y _0766_/Y _0768_/Y VPWR VGND sg13cmos5l_a21oi_1
XANTENNA__0743__A0 Tile_X0Y0_W2MID[3] VPWR VGND sg13cmos5l_antennanp
X_2508_ Tile_X0Y3_E2BEGb[2] _2508_/A VPWR VGND sg13cmos5l_buf_1
XFILLER_102_135 VPWR VGND sg13cmos5l_decap_8
XFILLER_142_293 VPWR VGND sg13cmos5l_fill_2
XANTENNA__1216__D Tile_X0Y0_FrameData[11] VPWR VGND sg13cmos5l_antennanp
XANTENNA__2449__X Tile_X0Y0_EE4BEG[3] VPWR VGND sg13cmos5l_antennanp
XFILLER_102_146 VPWR VGND sg13cmos5l_fill_2
X_2439_ Tile_X0Y0_FrameData_O[25] Tile_X0Y0_FrameData[25] VPWR VGND sg13cmos5l_buf_1
XFILLER_186_8 VPWR VGND sg13cmos5l_fill_1
XANTENNA__2060__GATE Tile_X0Y3_FrameStrobe[3] VPWR VGND sg13cmos5l_antennanp
XFILLER_56_233 VPWR VGND sg13cmos5l_decap_8
XFILLER_56_277 VPWR VGND sg13cmos5l_decap_8
XANTENNA__2047__D Tile_X0Y3_FrameData[20] VPWR VGND sg13cmos5l_antennanp
XFILLER_112_44 VPWR VGND sg13cmos5l_decap_4
XANTENNA__2075__GATE Tile_X0Y3_FrameStrobe[4] VPWR VGND sg13cmos5l_antennanp
XFILLER_72_48 VPWR VGND sg13cmos5l_decap_8
XFILLER_71_269 VPWR VGND sg13cmos5l_decap_8
XANTENNA__1886__D Tile_X0Y2_FrameData[29] VPWR VGND sg13cmos5l_antennanp
XFILLER_212_264 VPWR VGND sg13cmos5l_fill_2
XFILLER_212_275 VPWR VGND sg13cmos5l_fill_1
XANTENNA__2013__GATE Tile_X0Y3_FrameStrobe[2] VPWR VGND sg13cmos5l_antennanp
XFILLER_97_34 VPWR VGND sg13cmos5l_fill_2
XANTENNA__0734__A0 Tile_X0Y2_W2MID[2] VPWR VGND sg13cmos5l_antennanp
XFILLER_133_293 VPWR VGND sg13cmos5l_fill_2
XANTENNA__2359__X Tile_X0Y0_N4BEG[1] VPWR VGND sg13cmos5l_antennanp
XANTENNA__2028__GATE Tile_X0Y3_FrameStrobe[2] VPWR VGND sg13cmos5l_antennanp
XFILLER_47_255 VPWR VGND sg13cmos5l_decap_4
XANTENNA__1284__GATE Tile_X0Y3_FrameStrobe[2] VPWR VGND sg13cmos5l_antennanp
XANTENNA__1796__D Tile_X0Y2_FrameData[23] VPWR VGND sg13cmos5l_antennanp
XANTENNA__1299__GATE Tile_X0Y3_FrameStrobe[3] VPWR VGND sg13cmos5l_antennanp
X_1810_ _1810_/Q Tile_X0Y2_FrameData[9] Tile_X0Y3_FrameStrobe[3] VPWR VGND sg13cmos5l_dlhq_1
X_1741_ _1741_/Q Tile_X0Y2_FrameData[14] Tile_X0Y3_FrameStrobe[1] VPWR VGND sg13cmos5l_dlhq_1
XANTENNA__1222__GATE Tile_X0Y3_FrameStrobe[0] VPWR VGND sg13cmos5l_antennanp
XANTENNA__2270__A Tile_X0Y1_FrameData[27] VPWR VGND sg13cmos5l_antennanp
XFILLER_116_205 VPWR VGND sg13cmos5l_decap_8
X_1672_ _1672_/Q Tile_X0Y1_FrameData[27] Tile_X0Y3_FrameStrobe[7] VPWR VGND sg13cmos5l_dlhq_1
XFILLER_7_76 VPWR VGND sg13cmos5l_fill_2
XFILLER_190_119 VPWR VGND sg13cmos5l_decap_8
XFILLER_183_182 VPWR VGND sg13cmos5l_decap_8
XANTENNA__1852__GATE Tile_X0Y3_FrameStrobe[5] VPWR VGND sg13cmos5l_antennanp
X_0623_ _0623_/X _0506_/X _0507_/X _0508_/X _0602_/X _2118_/Q _2117_/Q VPWR VGND sg13cmos5l_mux4_1
XFILLER_194_91 VPWR VGND sg13cmos5l_decap_8
X_0554_ _0554_/X _0888_/X _0553_/X Tile_X0Y3_N4END[5] Tile_X0Y0_S4END[9] _1720_/Q
+ _1721_/Q VPWR VGND sg13cmos5l_mux4_1
XFILLER_97_111 VPWR VGND sg13cmos5l_decap_8
XANTENNA__1173__X AXIL_S_SOC_RDATA14 VPWR VGND sg13cmos5l_antennanp
XANTENNA__1237__GATE Tile_X0Y3_FrameStrobe[1] VPWR VGND sg13cmos5l_antennanp
XANTENNA__2269__X Tile_X0Y1_FrameData_O[26] VPWR VGND sg13cmos5l_antennanp
X_0485_ _0485_/X Tile_X0Y3_N1END[2] Tile_X0Y3_N4END[2] _0569_/B Tile_X0Y0_S4END[14]
+ _1991_/Q _1990_/Q VPWR VGND sg13cmos5l_mux4_1
XANTENNA__1867__GATE Tile_X0Y3_FrameStrobe[5] VPWR VGND sg13cmos5l_antennanp
X_2224_ Tile_X0Y1_E6BEG[9] _2224_/A VPWR VGND sg13cmos5l_buf_1
XFILLER_97_199 VPWR VGND sg13cmos5l_decap_8
XFILLER_16_0 VPWR VGND sg13cmos5l_fill_2
X_2155_ _2155_/Q Tile_X0Y3_FrameData[8] Tile_X0Y3_FrameStrobe[6] VPWR VGND sg13cmos5l_dlhq_1
XFILLER_38_244 VPWR VGND sg13cmos5l_decap_4
XFILLER_38_222 VPWR VGND sg13cmos5l_fill_1
XFILLER_213_21 VPWR VGND sg13cmos5l_decap_8
X_1106_ _2315_/A AXIL_S_SOC_WDATA7 _1068_/A AXIL_S_SOC_WDATA11 _0719_/X _1812_/Q _1813_/Q
+ VPWR VGND sg13cmos5l_mux4_1
XFILLER_213_54 VPWR VGND sg13cmos5l_fill_1
X_2086_ _2086_/Q Tile_X0Y3_FrameData[13] Tile_X0Y3_FrameStrobe[4] VPWR VGND sg13cmos5l_dlhq_1
XANTENNA__2445__A Tile_X0Y0_FrameData[31] VPWR VGND sg13cmos5l_antennanp
X_1037_ _2213_/A AXIL_S_SOC_WDATA22 AXIL_S_SOC_WDATA30 _0864_/X _0866_/X _1583_/Q
+ _1582_/Q VPWR VGND sg13cmos5l_mux4_1
XFILLER_198_219 VPWR VGND sg13cmos5l_fill_1
XANTENNA__1805__GATE Tile_X0Y3_FrameStrobe[3] VPWR VGND sg13cmos5l_antennanp
XFILLER_21_122 VPWR VGND sg13cmos5l_fill_1
XFILLER_158_29 VPWR VGND sg13cmos5l_fill_2
XFILLER_166_138 VPWR VGND sg13cmos5l_decap_8
X_1939_ _1939_/Q Tile_X0Y2_FrameData[8] Tile_X0Y3_FrameStrobe[7] VPWR VGND sg13cmos5l_dlhq_1
XFILLER_107_227 VPWR VGND sg13cmos5l_decap_4
XFILLER_206_9 VPWR VGND sg13cmos5l_fill_2
XANTENNA__0716__A0 Tile_X0Y0_W2MID[6] VPWR VGND sg13cmos5l_antennanp
XFILLER_115_293 VPWR VGND sg13cmos5l_fill_2
XFILLER_107_77 VPWR VGND sg13cmos5l_fill_2
XFILLER_88_177 VPWR VGND sg13cmos5l_decap_4
XFILLER_123_32 VPWR VGND sg13cmos5l_fill_1
XFILLER_83_69 VPWR VGND sg13cmos5l_fill_2
XFILLER_199_25 VPWR VGND sg13cmos5l_decap_8
XANTENNA__2355__A Tile_X0Y2_FrameData[31] VPWR VGND sg13cmos5l_antennanp
XFILLER_12_144 VPWR VGND sg13cmos5l_decap_8
XFILLER_157_105 VPWR VGND sg13cmos5l_decap_4
XFILLER_120_0 VPWR VGND sg13cmos5l_fill_2
XANTENNA__0955__A0 AXIL_S_SOC_WDATA20 VPWR VGND sg13cmos5l_antennanp
XFILLER_218_0 VPWR VGND sg13cmos5l_fill_2
XFILLER_180_174 VPWR VGND sg13cmos5l_decap_4
XANTENNA__0707__A0 Tile_X0Y3_W1END[2] VPWR VGND sg13cmos5l_antennanp
XFILLER_94_147 VPWR VGND sg13cmos5l_fill_2
XFILLER_94_136 VPWR VGND sg13cmos5l_decap_8
XANTENNA__0486__A2 Tile_X0Y3_W6END[10] VPWR VGND sg13cmos5l_antennanp
XFILLER_35_236 VPWR VGND sg13cmos5l_decap_4
XANTENNA__2265__A Tile_X0Y1_FrameData[22] VPWR VGND sg13cmos5l_antennanp
XANTENNA__2552__X Tile_X0Y3_FrameData_O[10] VPWR VGND sg13cmos5l_antennanp
XANTENNA__1791__GATE Tile_X0Y3_FrameStrobe[3] VPWR VGND sg13cmos5l_antennanp
X_1724_ _1724_/Q Tile_X0Y2_FrameData[31] Tile_X0Y3_FrameStrobe[1] VPWR VGND sg13cmos5l_dlhq_1
XFILLER_156_193 VPWR VGND sg13cmos5l_decap_4
XANTENNA__2150__D Tile_X0Y3_FrameData[13] VPWR VGND sg13cmos5l_antennanp
X_1655_ _1655_/Q Tile_X0Y1_FrameData[12] Tile_X0Y3_FrameStrobe[6] VPWR VGND sg13cmos5l_dlhq_1
XFILLER_208_65 VPWR VGND sg13cmos5l_decap_4
X_1586_ _1586_/Q Tile_X0Y1_FrameData[17] Tile_X0Y3_FrameStrobe[4] VPWR VGND sg13cmos5l_dlhq_1
X_0606_ _0606_/X _0605_/X _0604_/X _0536_/X _0590_/X _2127_/Q _2126_/Q VPWR VGND sg13cmos5l_mux4_1
X_0537_ _0537_/Y _1947_/Q Tile_X0Y3_N1END[0] VPWR VGND sg13cmos5l_nor2b_1
X_2207_ Tile_X0Y1_E2BEGb[0] _2207_/A VPWR VGND sg13cmos5l_buf_1
X_0468_ _0468_/Y _1447_/Q _0860_/X _0467_/Y VPWR VGND sg13cmos5l_o21ai_1
XANTENNA__1123__A0 AXIL_S_SOC_WDATA6 VPWR VGND sg13cmos5l_antennanp
XFILLER_26_203 VPWR VGND sg13cmos5l_fill_1
X_2138_ _2138_/Q Tile_X0Y3_FrameData[25] Tile_X0Y3_FrameStrobe[6] VPWR VGND sg13cmos5l_dlhq_1
X_2069_ _2069_/Q Tile_X0Y3_FrameData[30] Tile_X0Y3_FrameStrobe[4] VPWR VGND sg13cmos5l_dlhq_1
XANTENNA__1744__GATE Tile_X0Y3_FrameStrobe[1] VPWR VGND sg13cmos5l_antennanp
XANTENNA__2462__X Tile_X0Y0_E6BEG[0] VPWR VGND sg13cmos5l_antennanp
XFILLER_194_222 VPWR VGND sg13cmos5l_decap_8
XANTENNA__1759__GATE Tile_X0Y3_FrameStrobe[2] VPWR VGND sg13cmos5l_antennanp
XFILLER_147_160 VPWR VGND sg13cmos5l_fill_1
XANTENNA__0937__A0 Tile_X0Y3_W1END[3] VPWR VGND sg13cmos5l_antennanp
XFILLER_147_182 VPWR VGND sg13cmos5l_fill_1
XFILLER_185_49 VPWR VGND sg13cmos5l_decap_4
XANTENNA__2060__D Tile_X0Y3_FrameData[7] VPWR VGND sg13cmos5l_antennanp
XFILLER_78_14 VPWR VGND sg13cmos5l_fill_1
XANTENNA__1114__A0 AXIL_S_SOC_WDATA7 VPWR VGND sg13cmos5l_antennanp
XANTENNA__1404__D Tile_X0Y0_FrameData[15] VPWR VGND sg13cmos5l_antennanp
XFILLER_27_40 VPWR VGND sg13cmos5l_decap_8
XFILLER_168_0 VPWR VGND sg13cmos5l_fill_2
XFILLER_27_95 VPWR VGND sg13cmos5l_decap_8
XFILLER_17_258 VPWR VGND sg13cmos5l_fill_1
XFILLER_32_228 VPWR VGND sg13cmos5l_fill_1
XFILLER_32_217 VPWR VGND sg13cmos5l_decap_8
XANTENNA__2372__X Tile_X0Y0_N4BEG[14] VPWR VGND sg13cmos5l_antennanp
XANTENNA__0640__A2 AXIL_S_SOC_RREADY VPWR VGND sg13cmos5l_antennanp
XFILLER_40_294 VPWR VGND sg13cmos5l_fill_1
XFILLER_138_171 VPWR VGND sg13cmos5l_decap_8
XFILLER_145_108 VPWR VGND sg13cmos5l_decap_8
XFILLER_175_60 VPWR VGND sg13cmos5l_fill_2
X_1440_ _1440_/Q Tile_X0Y0_FrameData[11] Tile_X0Y3_FrameStrobe[7] VPWR VGND sg13cmos5l_dlhq_1
X_1371_ _1371_/Q Tile_X0Y0_FrameData[16] Tile_X0Y3_FrameStrobe[5] VPWR VGND sg13cmos5l_dlhq_1
XFILLER_191_92 VPWR VGND sg13cmos5l_fill_2
XFILLER_191_81 VPWR VGND sg13cmos5l_decap_8
XANTENNA__1105__A0 AXIL_S_SOC_WDATA6 VPWR VGND sg13cmos5l_antennanp
XANTENNA__1314__D Tile_X0Y0_FrameData[9] VPWR VGND sg13cmos5l_antennanp
XANTENNA__2547__X Tile_X0Y3_FrameData_O[5] VPWR VGND sg13cmos5l_antennanp
XFILLER_90_150 VPWR VGND sg13cmos5l_fill_2
XFILLER_208_175 VPWR VGND sg13cmos5l_fill_1
XFILLER_223_134 VPWR VGND sg13cmos5l_fill_2
XANTENNA__2145__D Tile_X0Y3_FrameData[18] VPWR VGND sg13cmos5l_antennanp
XFILLER_16_280 VPWR VGND sg13cmos5l_fill_2
XANTENNA__2282__X Tile_X0Y2_E2BEG[2] VPWR VGND sg13cmos5l_antennanp
XANTENNA__1984__D Tile_X0Y3_FrameData[19] VPWR VGND sg13cmos5l_antennanp
XFILLER_176_233 VPWR VGND sg13cmos5l_decap_8
XFILLER_176_277 VPWR VGND sg13cmos5l_decap_4
XFILLER_219_75 VPWR VGND sg13cmos5l_decap_8
X_1707_ _1707_/Q Tile_X0Y2_FrameData[16] Tile_X0Y3_FrameStrobe[0] VPWR VGND sg13cmos5l_dlhq_1
XFILLER_219_97 VPWR VGND sg13cmos5l_fill_1
X_1638_ _1638_/Q Tile_X0Y1_FrameData[29] Tile_X0Y3_FrameStrobe[6] VPWR VGND sg13cmos5l_dlhq_1
X_1569_ _1569_/Q Tile_X0Y1_FrameData[2] Tile_X0Y3_FrameStrobe[3] VPWR VGND sg13cmos5l_dlhq_1
XFILLER_98_272 VPWR VGND sg13cmos5l_fill_2
XFILLER_48_39 VPWR VGND sg13cmos5l_fill_2
XANTENNA__1224__D Tile_X0Y0_FrameData[3] VPWR VGND sg13cmos5l_antennanp
XANTENNA__2457__X Tile_X0Y0_EE4BEG[11] VPWR VGND sg13cmos5l_antennanp
XFILLER_104_23 VPWR VGND sg13cmos5l_fill_2
XFILLER_104_78 VPWR VGND sg13cmos5l_decap_8
XFILLER_73_128 VPWR VGND sg13cmos5l_fill_2
XANTENNA__1683__GATE Tile_X0Y3_FrameStrobe[7] VPWR VGND sg13cmos5l_antennanp
XFILLER_64_49 VPWR VGND sg13cmos5l_decap_8
XFILLER_214_101 VPWR VGND sg13cmos5l_decap_8
XFILLER_120_11 VPWR VGND sg13cmos5l_fill_2
XFILLER_14_206 VPWR VGND sg13cmos5l_decap_8
XFILLER_81_172 VPWR VGND sg13cmos5l_fill_1
XANTENNA__0870__A2 Tile_X0Y2_W6END[4] VPWR VGND sg13cmos5l_antennanp
XFILLER_120_44 VPWR VGND sg13cmos5l_decap_8
XANTENNA__0705__X AXIL_S_SOC_RDATA4 VPWR VGND sg13cmos5l_antennanp
XANTENNA__2055__D Tile_X0Y3_FrameData[12] VPWR VGND sg13cmos5l_antennanp
XANTENNA__1698__GATE Tile_X0Y3_FrameStrobe[0] VPWR VGND sg13cmos5l_antennanp
XANTENNA__1894__D Tile_X0Y2_FrameData[21] VPWR VGND sg13cmos5l_antennanp
XFILLER_13_42 VPWR VGND sg13cmos5l_decap_8
XFILLER_22_283 VPWR VGND sg13cmos5l_fill_1
XFILLER_22_272 VPWR VGND sg13cmos5l_decap_8
XFILLER_182_203 VPWR VGND sg13cmos5l_decap_8
XFILLER_182_258 VPWR VGND sg13cmos5l_decap_8
XANTENNA__1621__GATE Tile_X0Y3_FrameStrobe[5] VPWR VGND sg13cmos5l_antennanp
XFILLER_135_141 VPWR VGND sg13cmos5l_decap_8
XFILLER_135_152 VPWR VGND sg13cmos5l_fill_1
XANTENNA__0925__A3 Tile_X0Y0_S4END[5] VPWR VGND sg13cmos5l_antennanp
XFILLER_150_111 VPWR VGND sg13cmos5l_decap_8
XFILLER_145_52 VPWR VGND sg13cmos5l_fill_1
XFILLER_96_209 VPWR VGND sg13cmos5l_decap_8
XFILLER_150_177 VPWR VGND sg13cmos5l_decap_8
XFILLER_89_283 VPWR VGND sg13cmos5l_fill_1
XANTENNA__1636__GATE Tile_X0Y3_FrameStrobe[6] VPWR VGND sg13cmos5l_antennanp
XANTENNA__2367__X Tile_X0Y0_N4BEG[9] VPWR VGND sg13cmos5l_antennanp
XANTENNA__0861__A2 Tile_X0Y0_W6END[5] VPWR VGND sg13cmos5l_antennanp
XFILLER_205_167 VPWR VGND sg13cmos5l_fill_2
XANTENNA__2543__A Tile_X0Y3_FrameData[1] VPWR VGND sg13cmos5l_antennanp
X_0940_ _0940_/Y _1631_/Q _0914_/Y _1630_/Q VPWR VGND sg13cmos5l_a21oi_1
XFILLER_118_108 VPWR VGND sg13cmos5l_fill_1
XFILLER_158_266 VPWR VGND sg13cmos5l_fill_2
X_0871_ _0871_/X Tile_X0Y2_W1END[1] _0554_/X Tile_X0Y2_W6END[5] _0559_/X _1936_/Q
+ _1937_/Q VPWR VGND sg13cmos5l_mux4_1
X_2610_ Tile_X0Y3_UserCLKo Tile_X0Y3_UserCLK VPWR VGND sg13cmos5l_buf_1
XFILLER_173_236 VPWR VGND sg13cmos5l_decap_8
XANTENNA__1309__D Tile_X0Y0_FrameData[14] VPWR VGND sg13cmos5l_antennanp
X_2541_ Tile_X0Y3_EE4BEG[15] _2541_/A VPWR VGND sg13cmos5l_buf_1
XFILLER_173_269 VPWR VGND sg13cmos5l_decap_8
X_2472_ Tile_X0Y0_E6BEG[10] _2472_/A VPWR VGND sg13cmos5l_buf_1
XFILLER_141_122 VPWR VGND sg13cmos5l_decap_8
X_1423_ _1423_/Q Tile_X0Y0_FrameData[28] Tile_X0Y3_FrameStrobe[7] VPWR VGND sg13cmos5l_dlhq_1
XFILLER_205_11 VPWR VGND sg13cmos5l_decap_8
X_1354_ _1354_/Q Tile_X0Y0_FrameData[1] Tile_X0Y3_FrameStrobe[4] VPWR VGND sg13cmos5l_dlhq_1
XANTENNA__1181__X AXIL_S_SOC_RDATA9 VPWR VGND sg13cmos5l_antennanp
XANTENNA__2277__X Tile_X0Y2_E1BEG[1] VPWR VGND sg13cmos5l_antennanp
X_1285_ _1285_/Q Tile_X0Y0_FrameData[6] Tile_X0Y3_FrameStrobe[2] VPWR VGND sg13cmos5l_dlhq_1
XANTENNA__1979__D Tile_X0Y3_FrameData[24] VPWR VGND sg13cmos5l_antennanp
XFILLER_221_21 VPWR VGND sg13cmos5l_decap_8
XFILLER_221_43 VPWR VGND sg13cmos5l_decap_8
XFILLER_63_194 VPWR VGND sg13cmos5l_decap_4
XFILLER_211_137 VPWR VGND sg13cmos5l_fill_2
XANTENNA__1219__D Tile_X0Y0_FrameData[8] VPWR VGND sg13cmos5l_antennanp
XFILLER_115_11 VPWR VGND sg13cmos5l_fill_1
XFILLER_182_39 VPWR VGND sg13cmos5l_fill_2
XFILLER_132_199 VPWR VGND sg13cmos5l_decap_8
XFILLER_219_204 VPWR VGND sg13cmos5l_fill_2
XANTENNA__1889__D Tile_X0Y2_FrameData[26] VPWR VGND sg13cmos5l_antennanp
XFILLER_131_32 VPWR VGND sg13cmos5l_decap_8
XANTENNA__1096__A2 Tile_X0Y3_N4END[7] VPWR VGND sg13cmos5l_antennanp
XFILLER_131_65 VPWR VGND sg13cmos5l_decap_8
XFILLER_24_41 VPWR VGND sg13cmos5l_fill_2
XFILLER_24_85 VPWR VGND sg13cmos5l_decap_8
XFILLER_155_203 VPWR VGND sg13cmos5l_decap_4
XFILLER_210_181 VPWR VGND sg13cmos5l_decap_8
XANTENNA__1560__GATE Tile_X0Y3_FrameStrobe[3] VPWR VGND sg13cmos5l_antennanp
XFILLER_6_224 VPWR VGND sg13cmos5l_fill_2
XFILLER_200_0 VPWR VGND sg13cmos5l_fill_1
XANTENNA__1575__GATE Tile_X0Y3_FrameStrobe[4] VPWR VGND sg13cmos5l_antennanp
XFILLER_123_166 VPWR VGND sg13cmos5l_decap_8
XFILLER_34_9 VPWR VGND sg13cmos5l_fill_1
XFILLER_172_83 VPWR VGND sg13cmos5l_decap_4
XFILLER_77_275 VPWR VGND sg13cmos5l_decap_8
XANTENNA__1799__D Tile_X0Y2_FrameData[20] VPWR VGND sg13cmos5l_antennanp
X_1070_ _1070_/Y _1915_/Q _1068_/Y _1914_/Q VPWR VGND sg13cmos5l_a21oi_1
XFILLER_92_267 VPWR VGND sg13cmos5l_decap_4
XANTENNA__1513__GATE Tile_X0Y3_FrameStrobe[2] VPWR VGND sg13cmos5l_antennanp
XFILLER_60_120 VPWR VGND sg13cmos5l_fill_2
XANTENNA__2273__A Tile_X0Y1_FrameData[30] VPWR VGND sg13cmos5l_antennanp
X_1972_ _1972_/Q Tile_X0Y3_FrameData[31] Tile_X0Y3_FrameStrobe[1] VPWR VGND sg13cmos5l_dlhq_1
XFILLER_60_197 VPWR VGND sg13cmos5l_decap_8
XANTENNA__0598__A1 Tile_X0Y3_N2END[6] VPWR VGND sg13cmos5l_antennanp
X_0923_ _0923_/Y _0923_/A VPWR VGND sg13cmos5l_inv_1
XANTENNA__1528__GATE Tile_X0Y3_FrameStrobe[2] VPWR VGND sg13cmos5l_antennanp
XANTENNA__2560__X Tile_X0Y3_FrameData_O[18] VPWR VGND sg13cmos5l_antennanp
X_0854_ _2447_/A AXIL_S_SOC_WSTRB0 AXIL_S_SOC_AWADDR7 _0463_/A _0751_/X _1329_/Q _1328_/Q
+ VPWR VGND sg13cmos5l_mux4_1
XFILLER_161_206 VPWR VGND sg13cmos5l_fill_2
XANTENNA__1176__X AXIL_S_SOC_RDATA16 VPWR VGND sg13cmos5l_antennanp
XFILLER_114_111 VPWR VGND sg13cmos5l_decap_8
XFILLER_161_239 VPWR VGND sg13cmos5l_decap_8
X_0785_ _0785_/X _0770_/X Tile_X0Y3_N4END[14] Tile_X0Y0_S1END[2] Tile_X0Y0_S4END[2]
+ _1247_/Q _1246_/Q VPWR VGND sg13cmos5l_mux4_1
XANTENNA__1011__A2 Tile_X0Y1_W6END[7] VPWR VGND sg13cmos5l_antennanp
XFILLER_114_122 VPWR VGND sg13cmos5l_fill_1
XFILLER_114_144 VPWR VGND sg13cmos5l_fill_2
X_2524_ Tile_X0Y3_E6BEG[10] _2524_/A VPWR VGND sg13cmos5l_buf_1
XFILLER_46_0 VPWR VGND sg13cmos5l_fill_2
XFILLER_216_21 VPWR VGND sg13cmos5l_fill_1
X_2455_ Tile_X0Y0_EE4BEG[9] _2455_/A VPWR VGND sg13cmos5l_buf_1
XFILLER_216_32 VPWR VGND sg13cmos5l_fill_2
X_1406_ _1406_/Q Tile_X0Y0_FrameData[13] Tile_X0Y3_FrameStrobe[6] VPWR VGND sg13cmos5l_dlhq_1
X_2386_ Tile_X0Y0_N2BEG[4] _2386_/A VPWR VGND sg13cmos5l_buf_1
XFILLER_216_76 VPWR VGND sg13cmos5l_decap_4
X_1337_ _1337_/Q Tile_X0Y0_FrameData[18] Tile_X0Y3_FrameStrobe[4] VPWR VGND sg13cmos5l_dlhq_1
XFILLER_68_253 VPWR VGND sg13cmos5l_fill_1
XFILLER_68_242 VPWR VGND sg13cmos5l_decap_8
XFILLER_68_275 VPWR VGND sg13cmos5l_decap_8
XFILLER_28_117 VPWR VGND sg13cmos5l_decap_8
X_1268_ _1268_/Q Tile_X0Y0_FrameData[23] Tile_X0Y3_FrameStrobe[2] VPWR VGND sg13cmos5l_dlhq_1
XANTENNA__1502__D Tile_X0Y1_FrameData[5] VPWR VGND sg13cmos5l_antennanp
X_1199_ _1199_/Q Tile_X0Y0_FrameData[28] Tile_X0Y3_FrameStrobe[0] VPWR VGND sg13cmos5l_dlhq_1
XFILLER_51_164 VPWR VGND sg13cmos5l_decap_8
XFILLER_196_125 VPWR VGND sg13cmos5l_decap_8
XFILLER_101_79 VPWR VGND sg13cmos5l_decap_8
XANTENNA__0589__A1 Tile_X0Y2_W2END[3] VPWR VGND sg13cmos5l_antennanp
XFILLER_196_169 VPWR VGND sg13cmos5l_decap_8
XANTENNA__2470__X Tile_X0Y0_E6BEG[8] VPWR VGND sg13cmos5l_antennanp
XFILLER_137_236 VPWR VGND sg13cmos5l_decap_8
XANTENNA__0431__A Tile_X0Y0_S1END[0] VPWR VGND sg13cmos5l_antennanp
XANTENNA__1002__A2 Tile_X0Y1_W6END[3] VPWR VGND sg13cmos5l_antennanp
XANTENNA__0761__A1 Tile_X0Y0_S1END[0] VPWR VGND sg13cmos5l_antennanp
XFILLER_105_177 VPWR VGND sg13cmos5l_decap_8
XFILLER_120_103 VPWR VGND sg13cmos5l_decap_8
XFILLER_120_125 VPWR VGND sg13cmos5l_decap_8
XFILLER_126_65 VPWR VGND sg13cmos5l_decap_8
XFILLER_160_283 VPWR VGND sg13cmos5l_fill_1
XFILLER_59_253 VPWR VGND sg13cmos5l_fill_1
XANTENNA__0513__A1 Tile_X0Y3_N4END[3] VPWR VGND sg13cmos5l_antennanp
XANTENNA__1069__A2 Tile_X0Y3_N4END[4] VPWR VGND sg13cmos5l_antennanp
XANTENNA__1412__D Tile_X0Y0_FrameData[7] VPWR VGND sg13cmos5l_antennanp
XANTENNA__0816__A2 Tile_X0Y0_S1END[3] VPWR VGND sg13cmos5l_antennanp
XFILLER_42_120 VPWR VGND sg13cmos5l_decap_8
XFILLER_215_251 VPWR VGND sg13cmos5l_fill_2
XFILLER_150_0 VPWR VGND sg13cmos5l_fill_2
XFILLER_42_131 VPWR VGND sg13cmos5l_fill_1
XFILLER_187_103 VPWR VGND sg13cmos5l_decap_8
XFILLER_187_169 VPWR VGND sg13cmos5l_fill_2
XANTENNA__2380__X Tile_X0Y0_N2BEGb[6] VPWR VGND sg13cmos5l_antennanp
XFILLER_167_94 VPWR VGND sg13cmos5l_decap_4
X_0570_ _0570_/Y _1942_/Q _0568_/Y _0569_/Y VPWR VGND sg13cmos5l_o21ai_1
XFILLER_151_272 VPWR VGND sg13cmos5l_decap_8
XFILLER_151_283 VPWR VGND sg13cmos5l_fill_2
X_2240_ Tile_X0Y1_EE4BEG[13] _2240_/A VPWR VGND sg13cmos5l_buf_1
XFILLER_2_293 VPWR VGND sg13cmos5l_fill_2
XANTENNA__2268__A Tile_X0Y1_FrameData[25] VPWR VGND sg13cmos5l_antennanp
X_2171_ _2171_/Q Tile_X0Y3_FrameData[24] Tile_X0Y3_FrameStrobe[7] VPWR VGND sg13cmos5l_dlhq_1
XFILLER_18_4 VPWR VGND sg13cmos5l_fill_2
X_1122_ _2300_/A AXIL_S_SOC_WDATA4 _1097_/A _1103_/X _0719_/X _1786_/Q _1787_/Q VPWR
+ VGND sg13cmos5l_mux4_1
XFILLER_76_91 VPWR VGND sg13cmos5l_decap_8
XANTENNA__1322__D Tile_X0Y0_FrameData[1] VPWR VGND sg13cmos5l_antennanp
XANTENNA__2555__X Tile_X0Y3_FrameData_O[13] VPWR VGND sg13cmos5l_antennanp
X_1053_ _1053_/Y _1912_/Q _1049_/X _1052_/Y VPWR VGND sg13cmos5l_o21ai_1
XFILLER_18_150 VPWR VGND sg13cmos5l_decap_8
XANTENNA__1452__GATE Tile_X0Y3_FrameStrobe[0] VPWR VGND sg13cmos5l_antennanp
XFILLER_202_56 VPWR VGND sg13cmos5l_decap_8
XANTENNA__1467__GATE Tile_X0Y3_FrameStrobe[0] VPWR VGND sg13cmos5l_antennanp
X_1955_ _1955_/Q Tile_X0Y3_FrameData[16] Tile_X0Y3_FrameStrobe[0] VPWR VGND sg13cmos5l_dlhq_1
XFILLER_221_276 VPWR VGND sg13cmos5l_decap_4
XFILLER_193_117 VPWR VGND sg13cmos5l_decap_8
XANTENNA__2153__D Tile_X0Y3_FrameData[10] VPWR VGND sg13cmos5l_antennanp
XANTENNA__2290__X Tile_X0Y2_E2BEGb[2] VPWR VGND sg13cmos5l_antennanp
XFILLER_119_225 VPWR VGND sg13cmos5l_decap_8
X_0906_ _0906_/Y _0906_/A VPWR VGND sg13cmos5l_inv_1
X_1886_ _1886_/Q Tile_X0Y2_FrameData[29] Tile_X0Y3_FrameStrobe[6] VPWR VGND sg13cmos5l_dlhq_1
XANTENNA__0991__A1 Tile_X0Y1_W1END[1] VPWR VGND sg13cmos5l_antennanp
XANTENNA__1992__D Tile_X0Y3_FrameData[11] VPWR VGND sg13cmos5l_antennanp
X_0837_ _2596_/A _0830_/Y _0831_/Y _0835_/Y _0836_/Y VPWR VGND sg13cmos5l_a22oi_1
XFILLER_127_280 VPWR VGND sg13cmos5l_fill_2
XFILLER_134_239 VPWR VGND sg13cmos5l_decap_8
X_0768_ _0768_/Y _1417_/Q _0768_/B VPWR VGND sg13cmos5l_nor2_1
XFILLER_0_208 VPWR VGND sg13cmos5l_fill_2
X_2507_ Tile_X0Y3_E2BEGb[1] _2507_/A VPWR VGND sg13cmos5l_buf_1
XANTENNA__0743__A1 Tile_X0Y0_W2END[3] VPWR VGND sg13cmos5l_antennanp
XFILLER_142_272 VPWR VGND sg13cmos5l_decap_8
XFILLER_142_283 VPWR VGND sg13cmos5l_fill_1
X_0699_ _2524_/A _0638_/Y _0616_/X _0610_/X _0598_/X _2023_/Q _2022_/Q VPWR VGND sg13cmos5l_mux4_1
XANTENNA__1405__GATE Tile_X0Y3_FrameStrobe[6] VPWR VGND sg13cmos5l_antennanp
X_2438_ Tile_X0Y0_FrameData_O[24] Tile_X0Y0_FrameData[24] VPWR VGND sg13cmos5l_buf_1
X_2369_ Tile_X0Y0_N4BEG[11] _2369_/A VPWR VGND sg13cmos5l_buf_1
XANTENNA__1232__D Tile_X0Y0_FrameData[27] VPWR VGND sg13cmos5l_antennanp
XANTENNA__2465__X Tile_X0Y0_E6BEG[3] VPWR VGND sg13cmos5l_antennanp
XFILLER_112_56 VPWR VGND sg13cmos5l_decap_4
XFILLER_71_248 VPWR VGND sg13cmos5l_decap_8
XFILLER_71_226 VPWR VGND sg13cmos5l_fill_1
XFILLER_72_27 VPWR VGND sg13cmos5l_decap_8
XANTENNA__2063__D Tile_X0Y3_FrameData[4] VPWR VGND sg13cmos5l_antennanp
XFILLER_177_180 VPWR VGND sg13cmos5l_decap_8
XANTENNA__1407__D Tile_X0Y0_FrameData[12] VPWR VGND sg13cmos5l_antennanp
XFILLER_137_86 VPWR VGND sg13cmos5l_decap_4
XANTENNA__0734__A1 Tile_X0Y2_W2END[2] VPWR VGND sg13cmos5l_antennanp
XFILLER_153_74 VPWR VGND sg13cmos5l_decap_8
XFILLER_198_0 VPWR VGND sg13cmos5l_fill_2
XFILLER_47_223 VPWR VGND sg13cmos5l_decap_8
XANTENNA__2375__X Tile_X0Y0_N2BEGb[1] VPWR VGND sg13cmos5l_antennanp
XFILLER_47_278 VPWR VGND sg13cmos5l_fill_2
XANTENNA__2182__GATE Tile_X0Y3_FrameStrobe[7] VPWR VGND sg13cmos5l_antennanp
XFILLER_15_175 VPWR VGND sg13cmos5l_decap_4
XFILLER_203_243 VPWR VGND sg13cmos5l_decap_8
XANTENNA__0670__A0 AXIL_S_SOC_ARADDR0 VPWR VGND sg13cmos5l_antennanp
XFILLER_15_197 VPWR VGND sg13cmos5l_decap_4
XFILLER_62_71 VPWR VGND sg13cmos5l_decap_8
XFILLER_30_134 VPWR VGND sg13cmos5l_decap_4
XANTENNA__2551__A Tile_X0Y3_FrameData[9] VPWR VGND sg13cmos5l_antennanp
XFILLER_168_191 VPWR VGND sg13cmos5l_fill_1
X_1740_ _1740_/Q Tile_X0Y2_FrameData[15] Tile_X0Y3_FrameStrobe[1] VPWR VGND sg13cmos5l_dlhq_1
XFILLER_7_44 VPWR VGND sg13cmos5l_decap_8
XFILLER_7_33 VPWR VGND sg13cmos5l_fill_1
X_1671_ _1671_/Q Tile_X0Y1_FrameData[28] Tile_X0Y3_FrameStrobe[7] VPWR VGND sg13cmos5l_dlhq_1
XANTENNA__2120__GATE Tile_X0Y3_FrameStrobe[5] VPWR VGND sg13cmos5l_antennanp
X_0622_ _2608_/A _0621_/X _0620_/X _2119_/Q VPWR VGND sg13cmos5l_mux2_1
XFILLER_194_70 VPWR VGND sg13cmos5l_decap_8
X_0553_ _0553_/X Tile_X0Y1_W1END[1] Tile_X0Y1_W6END[9] _0547_/X _0552_/X _1653_/Q
+ _1652_/Q VPWR VGND sg13cmos5l_mux4_1
XANTENNA__1317__D Tile_X0Y0_FrameData[6] VPWR VGND sg13cmos5l_antennanp
XFILLER_124_294 VPWR VGND sg13cmos5l_fill_1
X_0484_ _0484_/X _0478_/X _0479_/X _0480_/X _0483_/X _2157_/Q _2156_/Q VPWR VGND sg13cmos5l_mux4_1
XANTENNA__2135__GATE Tile_X0Y3_FrameStrobe[6] VPWR VGND sg13cmos5l_antennanp
X_2223_ Tile_X0Y1_E6BEG[8] _2223_/A VPWR VGND sg13cmos5l_buf_1
XFILLER_97_178 VPWR VGND sg13cmos5l_decap_8
X_2154_ _2154_/Q Tile_X0Y3_FrameData[9] Tile_X0Y3_FrameStrobe[6] VPWR VGND sg13cmos5l_dlhq_1
XFILLER_213_44 VPWR VGND sg13cmos5l_fill_1
XANTENNA__1391__GATE Tile_X0Y3_FrameStrobe[6] VPWR VGND sg13cmos5l_antennanp
XANTENNA__2148__D Tile_X0Y3_FrameData[15] VPWR VGND sg13cmos5l_antennanp
XANTENNA__2285__X Tile_X0Y2_E2BEG[5] VPWR VGND sg13cmos5l_antennanp
X_1105_ _2318_/A AXIL_S_SOC_WDATA6 AXIL_S_SOC_WDATA10 _1049_/X _0732_/X _1807_/Q _1806_/Q
+ VPWR VGND sg13cmos5l_mux4_1
X_2085_ _2085_/Q Tile_X0Y3_FrameData[14] Tile_X0Y3_FrameStrobe[4] VPWR VGND sg13cmos5l_dlhq_1
XFILLER_53_226 VPWR VGND sg13cmos5l_decap_8
XANTENNA__1987__D Tile_X0Y3_FrameData[16] VPWR VGND sg13cmos5l_antennanp
X_1036_ _2214_/A AXIL_S_SOC_WDATA23 AXIL_S_SOC_WDATA31 _0859_/X _0862_/X _1581_/Q
+ _1580_/Q VPWR VGND sg13cmos5l_mux4_1
XFILLER_61_270 VPWR VGND sg13cmos5l_decap_8
XANTENNA__0661__A0 AXIL_S_SOC_ARVALID VPWR VGND sg13cmos5l_antennanp
XFILLER_166_117 VPWR VGND sg13cmos5l_decap_8
XFILLER_159_191 VPWR VGND sg13cmos5l_decap_8
X_1938_ _1938_/Q Tile_X0Y2_FrameData[9] Tile_X0Y3_FrameStrobe[7] VPWR VGND sg13cmos5l_dlhq_1
X_1869_ _1869_/Q Tile_X0Y2_FrameData[14] Tile_X0Y3_FrameStrobe[5] VPWR VGND sg13cmos5l_dlhq_1
XANTENNA__0716__A1 Tile_X0Y0_W2END[6] VPWR VGND sg13cmos5l_antennanp
XANTENNA__1227__D Tile_X0Y0_FrameData[0] VPWR VGND sg13cmos5l_antennanp
XANTENNA__1344__GATE Tile_X0Y3_FrameStrobe[4] VPWR VGND sg13cmos5l_antennanp
XFILLER_88_123 VPWR VGND sg13cmos5l_decap_4
XANTENNA__1974__GATE Tile_X0Y3_FrameStrobe[1] VPWR VGND sg13cmos5l_antennanp
XFILLER_88_156 VPWR VGND sg13cmos5l_decap_8
XFILLER_130_264 VPWR VGND sg13cmos5l_decap_8
XANTENNA__1359__GATE Tile_X0Y3_FrameStrobe[5] VPWR VGND sg13cmos5l_antennanp
XANTENNA__1989__GATE Tile_X0Y3_FrameStrobe[1] VPWR VGND sg13cmos5l_antennanp
XANTENNA__2058__D Tile_X0Y3_FrameData[9] VPWR VGND sg13cmos5l_antennanp
XANTENNA__2195__X Tile_X0Y1_E1BEG[0] VPWR VGND sg13cmos5l_antennanp
XANTENNA__0708__X AXIL_S_SOC_RDATA7 VPWR VGND sg13cmos5l_antennanp
XFILLER_123_88 VPWR VGND sg13cmos5l_decap_8
XFILLER_83_48 VPWR VGND sg13cmos5l_decap_8
XANTENNA__1897__D Tile_X0Y2_FrameData[18] VPWR VGND sg13cmos5l_antennanp
XFILLER_44_248 VPWR VGND sg13cmos5l_decap_4
XFILLER_199_59 VPWR VGND sg13cmos5l_fill_1
XANTENNA__1912__GATE Tile_X0Y3_FrameStrobe[6] VPWR VGND sg13cmos5l_antennanp
XFILLER_197_231 VPWR VGND sg13cmos5l_decap_8
XANTENNA__0652__A0 Tile_X0Y1_W2MID[5] VPWR VGND sg13cmos5l_antennanp
XFILLER_157_128 VPWR VGND sg13cmos5l_decap_8
XFILLER_8_116 VPWR VGND sg13cmos5l_decap_4
XFILLER_32_30 VPWR VGND sg13cmos5l_fill_2
XFILLER_12_189 VPWR VGND sg13cmos5l_decap_4
XFILLER_8_138 VPWR VGND sg13cmos5l_fill_1
XFILLER_32_63 VPWR VGND sg13cmos5l_decap_4
XFILLER_200_257 VPWR VGND sg13cmos5l_decap_8
XANTENNA__1927__GATE Tile_X0Y3_FrameStrobe[7] VPWR VGND sg13cmos5l_antennanp
XFILLER_165_161 VPWR VGND sg13cmos5l_fill_2
XANTENNA__0955__A1 AXIL_S_SOC_WDATA28 VPWR VGND sg13cmos5l_antennanp
XFILLER_113_0 VPWR VGND sg13cmos5l_decap_4
XFILLER_148_85 VPWR VGND sg13cmos5l_decap_8
XFILLER_165_183 VPWR VGND sg13cmos5l_decap_8
XANTENNA__0707__A1 Tile_X0Y3_WW4END[13] VPWR VGND sg13cmos5l_antennanp
XFILLER_106_294 VPWR VGND sg13cmos5l_fill_1
XFILLER_164_62 VPWR VGND sg13cmos5l_fill_1
XFILLER_57_71 VPWR VGND sg13cmos5l_fill_2
XFILLER_57_60 VPWR VGND sg13cmos5l_decap_8
XANTENNA__2546__A Tile_X0Y3_FrameData[4] VPWR VGND sg13cmos5l_antennanp
XFILLER_35_215 VPWR VGND sg13cmos5l_decap_8
XANTENNA__0891__A0 AXIL_S_SOC_AWADDR0 VPWR VGND sg13cmos5l_antennanp
XANTENNA__1600__D Tile_X0Y1_FrameData[3] VPWR VGND sg13cmos5l_antennanp
XFILLER_73_81 VPWR VGND sg13cmos5l_decap_8
XFILLER_188_231 VPWR VGND sg13cmos5l_fill_2
XFILLER_188_220 VPWR VGND sg13cmos5l_decap_8
XFILLER_148_106 VPWR VGND sg13cmos5l_decap_8
XFILLER_189_92 VPWR VGND sg13cmos5l_decap_4
XFILLER_188_264 VPWR VGND sg13cmos5l_decap_8
XFILLER_163_109 VPWR VGND sg13cmos5l_decap_4
X_1723_ _1723_/Q Tile_X0Y2_FrameData[0] Tile_X0Y3_FrameStrobe[0] VPWR VGND sg13cmos5l_dlhq_1
XFILLER_208_11 VPWR VGND sg13cmos5l_decap_8
X_1654_ _1654_/Q Tile_X0Y1_FrameData[13] Tile_X0Y3_FrameStrobe[6] VPWR VGND sg13cmos5l_dlhq_1
XFILLER_208_44 VPWR VGND sg13cmos5l_decap_8
X_1585_ _1585_/Q Tile_X0Y1_FrameData[18] Tile_X0Y3_FrameStrobe[4] VPWR VGND sg13cmos5l_dlhq_1
X_0605_ _0605_/X Tile_X0Y3_N1END[0] Tile_X0Y3_N4END[0] _0539_/B Tile_X0Y0_S4END[12]
+ _1987_/Q _1986_/Q VPWR VGND sg13cmos5l_mux4_1
XANTENNA__2074__GATE Tile_X0Y3_FrameStrobe[4] VPWR VGND sg13cmos5l_antennanp
X_0536_ _0536_/X Tile_X0Y3_N1END[0] Tile_X0Y3_N4END[0] _0539_/B Tile_X0Y0_S4END[12]
+ _1971_/Q _1970_/Q VPWR VGND sg13cmos5l_mux4_1
X_0467_ _0467_/Y Tile_X0Y1_W6END[2] _1447_/Q VPWR VGND sg13cmos5l_nand2b_1
X_2206_ Tile_X0Y1_E2BEG[7] _2206_/A VPWR VGND sg13cmos5l_buf_1
XFILLER_85_148 VPWR VGND sg13cmos5l_decap_8
XFILLER_224_76 VPWR VGND sg13cmos5l_fill_1
XANTENNA__2089__GATE Tile_X0Y3_FrameStrobe[4] VPWR VGND sg13cmos5l_antennanp
X_2137_ _2137_/Q Tile_X0Y3_FrameData[26] Tile_X0Y3_FrameStrobe[6] VPWR VGND sg13cmos5l_dlhq_1
XANTENNA__0882__A0 AXIL_S_SOC_WSTRB3 VPWR VGND sg13cmos5l_antennanp
X_2068_ _2068_/Q Tile_X0Y3_FrameData[31] Tile_X0Y3_FrameStrobe[4] VPWR VGND sg13cmos5l_dlhq_1
XANTENNA__1510__D Tile_X0Y1_FrameData[29] VPWR VGND sg13cmos5l_antennanp
XANTENNA__2012__GATE Tile_X0Y3_FrameStrobe[2] VPWR VGND sg13cmos5l_antennanp
XFILLER_169_18 VPWR VGND sg13cmos5l_decap_4
X_1019_ _2232_/A AXIL_S_SOC_WDATA21 AXIL_S_SOC_WDATA25 _0932_/A _0867_/X _1569_/Q
+ _1568_/Q VPWR VGND sg13cmos5l_mux4_1
XANTENNA__0634__A0 Tile_X0Y3_W2MID[2] VPWR VGND sg13cmos5l_antennanp
XANTENNA__2027__GATE Tile_X0Y3_FrameStrobe[2] VPWR VGND sg13cmos5l_antennanp
XANTENNA__0937__A1 Tile_X0Y3_W6END[7] VPWR VGND sg13cmos5l_antennanp
XFILLER_162_131 VPWR VGND sg13cmos5l_fill_1
XANTENNA__1283__GATE Tile_X0Y3_FrameStrobe[2] VPWR VGND sg13cmos5l_antennanp
XFILLER_162_153 VPWR VGND sg13cmos5l_decap_8
XFILLER_78_48 VPWR VGND sg13cmos5l_fill_2
XFILLER_78_59 VPWR VGND sg13cmos5l_fill_2
XANTENNA__1298__GATE Tile_X0Y3_FrameStrobe[3] VPWR VGND sg13cmos5l_antennanp
XFILLER_94_14 VPWR VGND sg13cmos5l_fill_1
XFILLER_76_137 VPWR VGND sg13cmos5l_decap_4
XANTENNA__0873__A0 Tile_X0Y3_N4END[13] VPWR VGND sg13cmos5l_antennanp
XANTENNA__1221__GATE Tile_X0Y3_FrameStrobe[0] VPWR VGND sg13cmos5l_antennanp
XANTENNA__1420__D Tile_X0Y0_FrameData[31] VPWR VGND sg13cmos5l_antennanp
XANTENNA__1851__GATE Tile_X0Y3_FrameStrobe[4] VPWR VGND sg13cmos5l_antennanp
XANTENNA__1236__GATE Tile_X0Y3_FrameStrobe[1] VPWR VGND sg13cmos5l_antennanp
XFILLER_40_251 VPWR VGND sg13cmos5l_fill_1
XANTENNA__0640__A3 AXIL_S_SOC_ARADDR1 VPWR VGND sg13cmos5l_antennanp
XANTENNA__1866__GATE Tile_X0Y3_FrameStrobe[5] VPWR VGND sg13cmos5l_antennanp
XFILLER_159_62 VPWR VGND sg13cmos5l_fill_1
XFILLER_159_73 VPWR VGND sg13cmos5l_fill_2
XFILLER_159_95 VPWR VGND sg13cmos5l_decap_4
XFILLER_153_131 VPWR VGND sg13cmos5l_fill_1
XFILLER_4_174 VPWR VGND sg13cmos5l_fill_2
XFILLER_175_83 VPWR VGND sg13cmos5l_decap_8
X_1370_ _1370_/Q Tile_X0Y0_FrameData[17] Tile_X0Y3_FrameStrobe[5] VPWR VGND sg13cmos5l_dlhq_1
XFILLER_4_89 VPWR VGND sg13cmos5l_fill_2
XANTENNA__1804__GATE Tile_X0Y3_FrameStrobe[3] VPWR VGND sg13cmos5l_antennanp
XFILLER_191_60 VPWR VGND sg13cmos5l_decap_8
XANTENNA__1105__A1 AXIL_S_SOC_WDATA10 VPWR VGND sg13cmos5l_antennanp
XFILLER_67_159 VPWR VGND sg13cmos5l_decap_8
XANTENNA__1819__GATE Tile_X0Y3_FrameStrobe[3] VPWR VGND sg13cmos5l_antennanp
XANTENNA__2563__X Tile_X0Y3_FrameData_O[21] VPWR VGND sg13cmos5l_antennanp
XFILLER_90_173 VPWR VGND sg13cmos5l_fill_2
XANTENNA__0616__A0 Tile_X0Y3_N1END[1] VPWR VGND sg13cmos5l_antennanp
XANTENNA__1330__D Tile_X0Y0_FrameData[25] VPWR VGND sg13cmos5l_antennanp
XANTENNA__1179__X AXIL_S_SOC_RDATA11 VPWR VGND sg13cmos5l_antennanp
XANTENNA__0524__A Tile_X0Y1_W6END[0] VPWR VGND sg13cmos5l_antennanp
XFILLER_76_0 VPWR VGND sg13cmos5l_fill_2
XANTENNA__2161__D Tile_X0Y3_FrameData[2] VPWR VGND sg13cmos5l_antennanp
XFILLER_129_183 VPWR VGND sg13cmos5l_decap_8
XFILLER_219_65 VPWR VGND sg13cmos5l_decap_8
X_1706_ _1706_/Q Tile_X0Y2_FrameData[17] Tile_X0Y3_FrameStrobe[0] VPWR VGND sg13cmos5l_dlhq_1
X_1637_ _1637_/Q Tile_X0Y1_FrameData[30] Tile_X0Y3_FrameStrobe[6] VPWR VGND sg13cmos5l_dlhq_1
X_1568_ _1568_/Q Tile_X0Y1_FrameData[3] Tile_X0Y3_FrameStrobe[3] VPWR VGND sg13cmos5l_dlhq_1
XANTENNA__1505__D Tile_X0Y1_FrameData[2] VPWR VGND sg13cmos5l_antennanp
X_1499_ _1499_/Q Tile_X0Y1_FrameData[8] Tile_X0Y3_FrameStrobe[1] VPWR VGND sg13cmos5l_dlhq_1
X_0519_ _0520_/A _0709_/X Tile_X0Y0_S1END[0] Tile_X0Y3_N4END[12] Tile_X0Y0_S4END[0]
+ _1226_/Q _1227_/Q VPWR VGND sg13cmos5l_mux4_1
XFILLER_64_17 VPWR VGND sg13cmos5l_fill_1
XANTENNA__0855__A0 AXIL_S_SOC_WVALID VPWR VGND sg13cmos5l_antennanp
XFILLER_64_28 VPWR VGND sg13cmos5l_decap_4
XANTENNA__2473__X Tile_X0Y0_E6BEG[11] VPWR VGND sg13cmos5l_antennanp
XFILLER_161_8 VPWR VGND sg13cmos5l_decap_4
XFILLER_81_151 VPWR VGND sg13cmos5l_decap_8
XANTENNA__0607__A0 Tile_X0Y3_N1END[0] VPWR VGND sg13cmos5l_antennanp
XANTENNA__1240__D Tile_X0Y0_FrameData[19] VPWR VGND sg13cmos5l_antennanp
XFILLER_120_34 VPWR VGND sg13cmos5l_decap_8
XFILLER_81_184 VPWR VGND sg13cmos5l_decap_8
XFILLER_214_168 VPWR VGND sg13cmos5l_decap_8
XFILLER_120_89 VPWR VGND sg13cmos5l_decap_8
XFILLER_167_201 VPWR VGND sg13cmos5l_decap_8
XFILLER_167_212 VPWR VGND sg13cmos5l_fill_1
XFILLER_22_251 VPWR VGND sg13cmos5l_decap_8
XANTENNA__0434__A Tile_X0Y0_S1END[1] VPWR VGND sg13cmos5l_antennanp
XFILLER_129_32 VPWR VGND sg13cmos5l_decap_8
XANTENNA__1032__A0 AXIL_S_SOC_WDATA20 VPWR VGND sg13cmos5l_antennanp
XANTENNA__2071__D Tile_X0Y3_FrameData[28] VPWR VGND sg13cmos5l_antennanp
XFILLER_135_120 VPWR VGND sg13cmos5l_decap_4
XFILLER_89_14 VPWR VGND sg13cmos5l_fill_2
XFILLER_89_47 VPWR VGND sg13cmos5l_decap_8
XANTENNA__1415__D Tile_X0Y0_FrameData[4] VPWR VGND sg13cmos5l_antennanp
XFILLER_49_148 VPWR VGND sg13cmos5l_decap_8
XFILLER_49_159 VPWR VGND sg13cmos5l_fill_2
XFILLER_38_51 VPWR VGND sg13cmos5l_decap_8
XANTENNA__1099__A0 AXIL_S_SOC_WDATA3 VPWR VGND sg13cmos5l_antennanp
XFILLER_64_118 VPWR VGND sg13cmos5l_decap_8
XFILLER_180_0 VPWR VGND sg13cmos5l_fill_2
XANTENNA__0846__A0 AXIL_S_SOC_AWVALID VPWR VGND sg13cmos5l_antennanp
XANTENNA__1790__GATE Tile_X0Y3_FrameStrobe[3] VPWR VGND sg13cmos5l_antennanp
XFILLER_161_85 VPWR VGND sg13cmos5l_fill_1
XFILLER_57_192 VPWR VGND sg13cmos5l_decap_4
XFILLER_205_113 VPWR VGND sg13cmos5l_decap_4
XFILLER_205_102 VPWR VGND sg13cmos5l_fill_1
XANTENNA__2383__X Tile_X0Y0_N2BEG[1] VPWR VGND sg13cmos5l_antennanp
XFILLER_158_212 VPWR VGND sg13cmos5l_fill_1
XFILLER_158_223 VPWR VGND sg13cmos5l_fill_1
XFILLER_158_256 VPWR VGND sg13cmos5l_decap_8
XFILLER_158_278 VPWR VGND sg13cmos5l_fill_2
X_0870_ _0870_/X Tile_X0Y2_W1END[0] _0529_/X Tile_X0Y2_W6END[4] _0534_/X _1938_/Q
+ _1939_/Q VPWR VGND sg13cmos5l_mux4_1
XFILLER_173_215 VPWR VGND sg13cmos5l_decap_8
XANTENNA__1023__A0 AXIL_S_SOC_WDATA23 VPWR VGND sg13cmos5l_antennanp
X_2540_ Tile_X0Y3_EE4BEG[14] _2540_/A VPWR VGND sg13cmos5l_buf_1
XFILLER_186_82 VPWR VGND sg13cmos5l_decap_8
XFILLER_141_101 VPWR VGND sg13cmos5l_decap_8
X_2471_ Tile_X0Y0_E6BEG[9] _2471_/A VPWR VGND sg13cmos5l_buf_1
X_1422_ _1422_/Q Tile_X0Y0_FrameData[29] Tile_X0Y3_FrameStrobe[7] VPWR VGND sg13cmos5l_dlhq_1
XANTENNA__1743__GATE Tile_X0Y3_FrameStrobe[1] VPWR VGND sg13cmos5l_antennanp
XANTENNA__1325__D Tile_X0Y0_FrameData[30] VPWR VGND sg13cmos5l_antennanp
XANTENNA__2558__X Tile_X0Y3_FrameData_O[16] VPWR VGND sg13cmos5l_antennanp
X_1353_ _1353_/Q Tile_X0Y0_FrameData[2] Tile_X0Y3_FrameStrobe[4] VPWR VGND sg13cmos5l_dlhq_1
X_1284_ _1284_/Q Tile_X0Y0_FrameData[7] Tile_X0Y3_FrameStrobe[2] VPWR VGND sg13cmos5l_dlhq_1
XFILLER_205_78 VPWR VGND sg13cmos5l_fill_2
XANTENNA__1758__GATE Tile_X0Y3_FrameStrobe[2] VPWR VGND sg13cmos5l_antennanp
XANTENNA__2156__D Tile_X0Y3_FrameData[7] VPWR VGND sg13cmos5l_antennanp
XANTENNA__2293__X Tile_X0Y2_E2BEGb[5] VPWR VGND sg13cmos5l_antennanp
XFILLER_221_99 VPWR VGND sg13cmos5l_fill_1
XANTENNA__1995__D Tile_X0Y3_FrameData[8] VPWR VGND sg13cmos5l_antennanp
XFILLER_149_201 VPWR VGND sg13cmos5l_fill_1
XANTENNA__0604__A3 Tile_X0Y0_S4END[12] VPWR VGND sg13cmos5l_antennanp
XFILLER_109_109 VPWR VGND sg13cmos5l_decap_4
XANTENNA__1014__A0 Tile_X0Y1_W2MID[4] VPWR VGND sg13cmos5l_antennanp
X_0999_ _2222_/A AXIL_S_SOC_WDATA23 _0914_/A _0916_/B _0868_/X _1532_/Q _1533_/Q VPWR
+ VGND sg13cmos5l_mux4_1
XFILLER_117_164 VPWR VGND sg13cmos5l_decap_4
XFILLER_132_101 VPWR VGND sg13cmos5l_fill_1
XFILLER_59_39 VPWR VGND sg13cmos5l_decap_8
XANTENNA__1235__D Tile_X0Y0_FrameData[24] VPWR VGND sg13cmos5l_antennanp
XANTENNA__2468__X Tile_X0Y0_E6BEG[6] VPWR VGND sg13cmos5l_antennanp
XFILLER_86_221 VPWR VGND sg13cmos5l_fill_1
XFILLER_115_56 VPWR VGND sg13cmos5l_decap_8
XFILLER_86_243 VPWR VGND sg13cmos5l_decap_8
XFILLER_115_89 VPWR VGND sg13cmos5l_decap_4
XFILLER_39_192 VPWR VGND sg13cmos5l_fill_1
XANTENNA__1096__A3 Tile_X0Y0_S4END[11] VPWR VGND sg13cmos5l_antennanp
XANTENNA__2066__D Tile_X0Y3_FrameData[1] VPWR VGND sg13cmos5l_antennanp
XFILLER_91_15 VPWR VGND sg13cmos5l_decap_8
XFILLER_54_184 VPWR VGND sg13cmos5l_fill_1
XANTENNA__1005__A0 AXIL_S_SOC_WDATA18 VPWR VGND sg13cmos5l_antennanp
XFILLER_155_226 VPWR VGND sg13cmos5l_fill_2
XFILLER_108_120 VPWR VGND sg13cmos5l_fill_1
XFILLER_6_247 VPWR VGND sg13cmos5l_decap_8
XFILLER_108_153 VPWR VGND sg13cmos5l_fill_1
XFILLER_123_134 VPWR VGND sg13cmos5l_decap_8
XFILLER_6_0 VPWR VGND sg13cmos5l_fill_2
XANTENNA__2378__X Tile_X0Y0_N2BEGb[4] VPWR VGND sg13cmos5l_antennanp
XFILLER_225_219 VPWR VGND sg13cmos5l_decap_8
XFILLER_65_93 VPWR VGND sg13cmos5l_decap_8
XFILLER_218_293 VPWR VGND sg13cmos5l_fill_2
XANTENNA__2554__A Tile_X0Y3_FrameData[12] VPWR VGND sg13cmos5l_antennanp
XFILLER_60_165 VPWR VGND sg13cmos5l_fill_1
X_1971_ _1971_/Q Tile_X0Y3_FrameData[0] Tile_X0Y3_FrameStrobe[0] VPWR VGND sg13cmos5l_dlhq_1
X_0922_ _0923_/A _0871_/X _0546_/X Tile_X0Y3_N4END[9] Tile_X0Y0_S4END[5] _1496_/Q
+ _1497_/Q VPWR VGND sg13cmos5l_mux4_1
XFILLER_197_81 VPWR VGND sg13cmos5l_decap_8
X_0853_ _2448_/A AXIL_S_SOC_WSTRB1 AXIL_S_SOC_AWADDR8 _0542_/X _0736_/X _1327_/Q _1326_/Q
+ VPWR VGND sg13cmos5l_mux4_1
XFILLER_154_270 VPWR VGND sg13cmos5l_fill_1
X_2523_ Tile_X0Y3_E6BEG[9] _2523_/A VPWR VGND sg13cmos5l_buf_1
X_0784_ _0784_/X _0770_/X Tile_X0Y3_N4END[14] Tile_X0Y0_S1END[2] Tile_X0Y0_S4END[2]
+ _1231_/Q _1230_/Q VPWR VGND sg13cmos5l_mux4_1
XANTENNA__1682__GATE Tile_X0Y3_FrameStrobe[7] VPWR VGND sg13cmos5l_antennanp
X_2454_ Tile_X0Y0_EE4BEG[8] _2454_/A VPWR VGND sg13cmos5l_buf_1
XANTENNA__0770__A2 Tile_X0Y1_W6END[6] VPWR VGND sg13cmos5l_antennanp
XANTENNA__2288__X Tile_X0Y2_E2BEGb[0] VPWR VGND sg13cmos5l_antennanp
X_1405_ _1405_/Q Tile_X0Y0_FrameData[14] Tile_X0Y3_FrameStrobe[6] VPWR VGND sg13cmos5l_dlhq_1
X_2385_ Tile_X0Y0_N2BEG[3] _2385_/A VPWR VGND sg13cmos5l_buf_1
XFILLER_39_0 VPWR VGND sg13cmos5l_fill_2
XFILLER_216_66 VPWR VGND sg13cmos5l_fill_1
X_1336_ _1336_/Q Tile_X0Y0_FrameData[19] Tile_X0Y3_FrameStrobe[4] VPWR VGND sg13cmos5l_dlhq_1
XFILLER_216_99 VPWR VGND sg13cmos5l_fill_1
XANTENNA__0522__A2 Tile_X0Y3_N4END[8] VPWR VGND sg13cmos5l_antennanp
XANTENNA__1697__GATE Tile_X0Y3_FrameStrobe[0] VPWR VGND sg13cmos5l_antennanp
X_1267_ _1267_/Q Tile_X0Y0_FrameData[24] Tile_X0Y3_FrameStrobe[2] VPWR VGND sg13cmos5l_dlhq_1
XFILLER_83_257 VPWR VGND sg13cmos5l_decap_8
X_1198_ _1198_/Q Tile_X0Y0_FrameData[29] Tile_X0Y3_FrameStrobe[0] VPWR VGND sg13cmos5l_dlhq_1
XANTENNA__1620__GATE Tile_X0Y3_FrameStrobe[5] VPWR VGND sg13cmos5l_antennanp
XFILLER_91_290 VPWR VGND sg13cmos5l_decap_4
XFILLER_224_274 VPWR VGND sg13cmos5l_fill_2
XFILLER_196_104 VPWR VGND sg13cmos5l_decap_8
XANTENNA__0589__A2 Tile_X0Y2_W2MID[3] VPWR VGND sg13cmos5l_antennanp
XANTENNA__1635__GATE Tile_X0Y3_FrameStrobe[5] VPWR VGND sg13cmos5l_antennanp
XFILLER_137_215 VPWR VGND sg13cmos5l_decap_8
XFILLER_10_11 VPWR VGND sg13cmos5l_fill_1
XFILLER_126_44 VPWR VGND sg13cmos5l_decap_8
XFILLER_160_262 VPWR VGND sg13cmos5l_decap_8
XANTENNA__0761__A2 Tile_X0Y3_N4END[12] VPWR VGND sg13cmos5l_antennanp
XANTENNA__2198__X Tile_X0Y1_E1BEG[3] VPWR VGND sg13cmos5l_antennanp
XFILLER_59_210 VPWR VGND sg13cmos5l_decap_8
XFILLER_59_243 VPWR VGND sg13cmos5l_decap_4
XFILLER_142_21 VPWR VGND sg13cmos5l_fill_2
XFILLER_74_202 VPWR VGND sg13cmos5l_decap_8
XFILLER_59_276 VPWR VGND sg13cmos5l_fill_1
XFILLER_19_107 VPWR VGND sg13cmos5l_fill_2
XANTENNA__1069__A3 Tile_X0Y0_S4END[8] VPWR VGND sg13cmos5l_antennanp
XFILLER_27_162 VPWR VGND sg13cmos5l_decap_8
XANTENNA__0816__A3 AXIL_S_SOC_WSTRB3 VPWR VGND sg13cmos5l_antennanp
XFILLER_215_285 VPWR VGND sg13cmos5l_fill_2
XFILLER_215_274 VPWR VGND sg13cmos5l_fill_2
XFILLER_143_0 VPWR VGND sg13cmos5l_decap_4
XFILLER_35_96 VPWR VGND sg13cmos5l_decap_8
XFILLER_51_62 VPWR VGND sg13cmos5l_decap_4
XFILLER_136_281 VPWR VGND sg13cmos5l_fill_1
XFILLER_151_251 VPWR VGND sg13cmos5l_decap_8
XANTENNA__0752__A2 Tile_X0Y1_W6END[5] VPWR VGND sg13cmos5l_antennanp
XANTENNA__2549__A Tile_X0Y3_FrameData[7] VPWR VGND sg13cmos5l_antennanp
XFILLER_2_261 VPWR VGND sg13cmos5l_fill_2
X_2170_ _2170_/Q Tile_X0Y3_FrameData[25] Tile_X0Y3_FrameStrobe[7] VPWR VGND sg13cmos5l_dlhq_1
XFILLER_65_202 VPWR VGND sg13cmos5l_decap_8
XANTENNA__1603__D Tile_X0Y1_FrameData[0] VPWR VGND sg13cmos5l_antennanp
X_1121_ _2301_/A AXIL_S_SOC_WDATA5 _1101_/X _1108_/X _0715_/X _1784_/Q _1785_/Q VPWR
+ VGND sg13cmos5l_mux4_1
X_1052_ _1052_/Y _1912_/Q _1051_/Y _1911_/Q VPWR VGND sg13cmos5l_a21oi_1
XFILLER_202_35 VPWR VGND sg13cmos5l_decap_8
XFILLER_206_263 VPWR VGND sg13cmos5l_decap_8
XFILLER_206_252 VPWR VGND sg13cmos5l_fill_1
XFILLER_206_274 VPWR VGND sg13cmos5l_fill_2
XFILLER_202_79 VPWR VGND sg13cmos5l_fill_1
XANTENNA__0516__B Tile_X0Y0_W6END[0] VPWR VGND sg13cmos5l_antennanp
XANTENNA__2571__X Tile_X0Y3_FrameData_O[29] VPWR VGND sg13cmos5l_antennanp
X_1954_ _1954_/Q Tile_X0Y3_FrameData[17] Tile_X0Y3_FrameStrobe[0] VPWR VGND sg13cmos5l_dlhq_1
X_0905_ _0906_/A _0870_/X _0521_/X Tile_X0Y3_N4END[8] Tile_X0Y0_S4END[4] _1498_/Q
+ _1499_/Q VPWR VGND sg13cmos5l_mux4_1
X_1885_ _1885_/Q Tile_X0Y2_FrameData[30] Tile_X0Y3_FrameStrobe[6] VPWR VGND sg13cmos5l_dlhq_1
X_0836_ _0836_/Y _1377_/Q _0836_/B VPWR VGND sg13cmos5l_nor2_1
X_0767_ _0768_/B Tile_X0Y0_W1END[0] Tile_X0Y0_W6END[8] Tile_X0Y0_WW4END[0] _0761_/X
+ _1418_/Q _1419_/Q VPWR VGND sg13cmos5l_mux4_1
XFILLER_142_251 VPWR VGND sg13cmos5l_decap_8
X_2506_ Tile_X0Y3_E2BEGb[0] _2506_/A VPWR VGND sg13cmos5l_buf_1
XANTENNA__0743__A2 Tile_X0Y0_W6END[3] VPWR VGND sg13cmos5l_antennanp
X_2437_ Tile_X0Y0_FrameData_O[23] Tile_X0Y0_FrameData[23] VPWR VGND sg13cmos5l_buf_1
X_0698_ _2523_/A _0655_/X _0485_/X _0478_/X _0594_/X _2025_/Q _2024_/Q VPWR VGND sg13cmos5l_mux4_1
X_2368_ Tile_X0Y0_N4BEG[10] _2368_/A VPWR VGND sg13cmos5l_buf_1
XFILLER_56_29 VPWR VGND sg13cmos5l_decap_8
XANTENNA__1513__D Tile_X0Y1_FrameData[26] VPWR VGND sg13cmos5l_antennanp
XFILLER_110_181 VPWR VGND sg13cmos5l_decap_8
X_1319_ _1319_/Q Tile_X0Y0_FrameData[4] Tile_X0Y3_FrameStrobe[3] VPWR VGND sg13cmos5l_dlhq_1
X_2299_ Tile_X0Y2_E6BEG[3] _2299_/A VPWR VGND sg13cmos5l_buf_1
XFILLER_24_143 VPWR VGND sg13cmos5l_decap_4
XANTENNA__1574__GATE Tile_X0Y3_FrameStrobe[4] VPWR VGND sg13cmos5l_antennanp
XFILLER_188_28 VPWR VGND sg13cmos5l_fill_2
XANTENNA__2481__X Tile_X0Y0_E2BEGb[7] VPWR VGND sg13cmos5l_antennanp
XFILLER_212_266 VPWR VGND sg13cmos5l_fill_1
XANTENNA__1589__GATE Tile_X0Y3_FrameStrobe[4] VPWR VGND sg13cmos5l_antennanp
XFILLER_118_281 VPWR VGND sg13cmos5l_fill_2
XFILLER_137_32 VPWR VGND sg13cmos5l_fill_2
XFILLER_137_65 VPWR VGND sg13cmos5l_decap_8
XFILLER_192_195 VPWR VGND sg13cmos5l_fill_1
XFILLER_192_184 VPWR VGND sg13cmos5l_decap_8
XANTENNA__0734__A2 Tile_X0Y2_W6END[2] VPWR VGND sg13cmos5l_antennanp
XANTENNA__1512__GATE Tile_X0Y3_FrameStrobe[2] VPWR VGND sg13cmos5l_antennanp
XFILLER_133_273 VPWR VGND sg13cmos5l_decap_8
XFILLER_153_53 VPWR VGND sg13cmos5l_decap_8
XFILLER_47_202 VPWR VGND sg13cmos5l_decap_8
XANTENNA__1423__D Tile_X0Y0_FrameData[28] VPWR VGND sg13cmos5l_antennanp
XANTENNA__1527__GATE Tile_X0Y3_FrameStrobe[2] VPWR VGND sg13cmos5l_antennanp
XFILLER_101_181 VPWR VGND sg13cmos5l_decap_8
XFILLER_62_249 VPWR VGND sg13cmos5l_decap_8
XFILLER_30_102 VPWR VGND sg13cmos5l_decap_4
XANTENNA__0670__A1 AXIL_S_SOC_ARADDR8 VPWR VGND sg13cmos5l_antennanp
XANTENNA__2391__X Tile_X0Y0_N1BEG[1] VPWR VGND sg13cmos5l_antennanp
XFILLER_70_293 VPWR VGND sg13cmos5l_fill_2
XFILLER_203_277 VPWR VGND sg13cmos5l_decap_8
XFILLER_87_8 VPWR VGND sg13cmos5l_decap_8
XFILLER_178_50 VPWR VGND sg13cmos5l_decap_8
XFILLER_175_129 VPWR VGND sg13cmos5l_decap_4
X_1670_ _1670_/Q Tile_X0Y1_FrameData[29] Tile_X0Y3_FrameStrobe[7] VPWR VGND sg13cmos5l_dlhq_1
XFILLER_183_173 VPWR VGND sg13cmos5l_decap_4
X_0621_ _0621_/X Tile_X0Y3_W1END[2] Tile_X0Y3_W6END[6] Tile_X0Y3_WW4END[14] _0485_/X
+ _2120_/Q _2121_/Q VPWR VGND sg13cmos5l_mux4_1
X_0552_ _0552_/X _0546_/X _0548_/Y _0551_/Y VPWR VGND sg13cmos5l_a21o_1
XANTENNA__0725__A2 Tile_X0Y3_N2MID[2] VPWR VGND sg13cmos5l_antennanp
XFILLER_124_262 VPWR VGND sg13cmos5l_fill_1
X_0483_ _0483_/X Tile_X0Y3_N2MID[2] Tile_X0Y3_N2END[2] _2588_/A _0482_/X _1959_/Q
+ _1958_/Q VPWR VGND sg13cmos5l_mux4_1
X_2222_ Tile_X0Y1_E6BEG[7] _2222_/A VPWR VGND sg13cmos5l_buf_1
XANTENNA__1333__D Tile_X0Y0_FrameData[22] VPWR VGND sg13cmos5l_antennanp
XANTENNA__2566__X Tile_X0Y3_FrameData_O[24] VPWR VGND sg13cmos5l_antennanp
X_2153_ _2153_/Q Tile_X0Y3_FrameData[10] Tile_X0Y3_FrameStrobe[6] VPWR VGND sg13cmos5l_dlhq_1
XFILLER_38_213 VPWR VGND sg13cmos5l_decap_8
X_1104_ _2316_/A AXIL_S_SOC_WDATA4 AXIL_S_SOC_WDATA8 _1103_/X _0758_/X _1811_/Q _1810_/Q
+ VPWR VGND sg13cmos5l_mux4_1
XFILLER_53_205 VPWR VGND sg13cmos5l_decap_8
X_2084_ _2084_/Q Tile_X0Y3_FrameData[15] Tile_X0Y3_FrameStrobe[4] VPWR VGND sg13cmos5l_dlhq_1
X_1035_ _2229_/A AXIL_S_SOC_WDATA18 _0547_/X AXIL_S_SOC_WDATA30 _0865_/X _1574_/Q
+ _1575_/Q VPWR VGND sg13cmos5l_mux4_1
XANTENNA__0661__A1 AXIL_S_SOC_ARADDR7 VPWR VGND sg13cmos5l_antennanp
XANTENNA__2164__D Tile_X0Y3_FrameData[31] VPWR VGND sg13cmos5l_antennanp
X_1937_ _1937_/Q Tile_X0Y2_FrameData[10] Tile_X0Y3_FrameStrobe[7] VPWR VGND sg13cmos5l_dlhq_1
X_1868_ _1868_/Q Tile_X0Y2_FrameData[15] Tile_X0Y3_FrameStrobe[5] VPWR VGND sg13cmos5l_dlhq_1
XFILLER_174_140 VPWR VGND sg13cmos5l_decap_4
XANTENNA__0964__A2 AXIL_S_SOC_WDATA18 VPWR VGND sg13cmos5l_antennanp
XANTENNA__1508__D Tile_X0Y1_FrameData[31] VPWR VGND sg13cmos5l_antennanp
X_0819_ _2490_/A _0709_/X AXIL_S_SOC_WSTRB1 Tile_X0Y0_S1END[0] AXIL_S_SOC_AWADDR1
+ _1370_/Q _1371_/Q VPWR VGND sg13cmos5l_mux4_1
X_1799_ _1799_/Q Tile_X0Y2_FrameData[20] Tile_X0Y3_FrameStrobe[3] VPWR VGND sg13cmos5l_dlhq_1
XANTENNA__0716__A2 Tile_X0Y0_W6END[6] VPWR VGND sg13cmos5l_antennanp
XFILLER_130_210 VPWR VGND sg13cmos5l_decap_8
XFILLER_29_202 VPWR VGND sg13cmos5l_decap_8
XANTENNA__1243__D Tile_X0Y0_FrameData[16] VPWR VGND sg13cmos5l_antennanp
XANTENNA__2476__X Tile_X0Y0_E2BEGb[2] VPWR VGND sg13cmos5l_antennanp
XFILLER_44_227 VPWR VGND sg13cmos5l_decap_8
XFILLER_197_210 VPWR VGND sg13cmos5l_decap_8
XANTENNA__0652__A1 Tile_X0Y1_W2END[5] VPWR VGND sg13cmos5l_antennanp
XANTENNA__2074__D Tile_X0Y3_FrameData[25] VPWR VGND sg13cmos5l_antennanp
XFILLER_200_203 VPWR VGND sg13cmos5l_decap_4
XFILLER_200_225 VPWR VGND sg13cmos5l_decap_4
XFILLER_32_86 VPWR VGND sg13cmos5l_fill_2
XANTENNA__1418__D Tile_X0Y0_FrameData[1] VPWR VGND sg13cmos5l_antennanp
XANTENNA__1451__GATE Tile_X0Y3_FrameStrobe[0] VPWR VGND sg13cmos5l_antennanp
XFILLER_106_0 VPWR VGND sg13cmos5l_fill_1
XANTENNA__0707__A2 Tile_X0Y3_W6END[10] VPWR VGND sg13cmos5l_antennanp
XFILLER_164_41 VPWR VGND sg13cmos5l_fill_1
XFILLER_164_74 VPWR VGND sg13cmos5l_fill_2
XFILLER_79_135 VPWR VGND sg13cmos5l_fill_1
XANTENNA__1466__GATE Tile_X0Y3_FrameStrobe[0] VPWR VGND sg13cmos5l_antennanp
XANTENNA__2386__X Tile_X0Y0_N2BEG[4] VPWR VGND sg13cmos5l_antennanp
XFILLER_57_94 VPWR VGND sg13cmos5l_decap_4
XANTENNA__0891__A1 AXIL_S_SOC_AWADDR4 VPWR VGND sg13cmos5l_antennanp
XFILLER_73_60 VPWR VGND sg13cmos5l_decap_8
XANTENNA__2562__A Tile_X0Y3_FrameData[20] VPWR VGND sg13cmos5l_antennanp
XFILLER_43_293 VPWR VGND sg13cmos5l_fill_2
XANTENNA__1404__GATE Tile_X0Y3_FrameStrobe[6] VPWR VGND sg13cmos5l_antennanp
X_1722_ _1722_/Q Tile_X0Y2_FrameData[1] Tile_X0Y3_FrameStrobe[0] VPWR VGND sg13cmos5l_dlhq_1
XANTENNA__0946__A2 Tile_X0Y3_N4END[11] VPWR VGND sg13cmos5l_antennanp
XANTENNA__1328__D Tile_X0Y0_FrameData[27] VPWR VGND sg13cmos5l_antennanp
X_1653_ _1653_/Q Tile_X0Y1_FrameData[14] Tile_X0Y3_FrameStrobe[6] VPWR VGND sg13cmos5l_dlhq_1
XANTENNA__1419__GATE Tile_X0Y3_FrameStrobe[6] VPWR VGND sg13cmos5l_antennanp
XFILLER_171_143 VPWR VGND sg13cmos5l_decap_8
XFILLER_171_154 VPWR VGND sg13cmos5l_fill_2
X_0604_ _0604_/X Tile_X0Y3_N1END[0] Tile_X0Y3_N4END[0] _0539_/B Tile_X0Y0_S4END[12]
+ _1979_/Q _1978_/Q VPWR VGND sg13cmos5l_mux4_1
X_1584_ _1584_/Q Tile_X0Y1_FrameData[19] Tile_X0Y3_FrameStrobe[4] VPWR VGND sg13cmos5l_dlhq_1
XFILLER_208_89 VPWR VGND sg13cmos5l_fill_2
X_0535_ _0539_/B Tile_X0Y2_W1END[0] Tile_X0Y2_W6END[8] _0529_/X _0534_/X _1903_/Q
+ _1902_/Q VPWR VGND sg13cmos5l_mux4_1
XFILLER_112_265 VPWR VGND sg13cmos5l_fill_1
X_0466_ _0466_/Y _1447_/Q _0466_/B _1446_/Q VPWR VGND sg13cmos5l_nand3b_1
XFILLER_21_0 VPWR VGND sg13cmos5l_fill_2
XANTENNA__2159__D Tile_X0Y3_FrameData[4] VPWR VGND sg13cmos5l_antennanp
XANTENNA__2296__X Tile_X0Y2_E6BEG[0] VPWR VGND sg13cmos5l_antennanp
X_2205_ Tile_X0Y1_E2BEG[6] _2205_/A VPWR VGND sg13cmos5l_buf_1
XFILLER_85_127 VPWR VGND sg13cmos5l_decap_8
XANTENNA__1998__D Tile_X0Y3_FrameData[5] VPWR VGND sg13cmos5l_antennanp
X_2136_ _2136_/Q Tile_X0Y3_FrameData[27] Tile_X0Y3_FrameStrobe[6] VPWR VGND sg13cmos5l_dlhq_1
X_2067_ _2067_/Q Tile_X0Y3_FrameData[0] Tile_X0Y3_FrameStrobe[3] VPWR VGND sg13cmos5l_dlhq_1
XFILLER_26_238 VPWR VGND sg13cmos5l_fill_2
X_1018_ _2240_/A AXIL_S_SOC_WDATA17 _0929_/X AXIL_S_SOC_WDATA29 _0867_/X _1552_/Q
+ _1553_/Q VPWR VGND sg13cmos5l_mux4_1
XFILLER_41_219 VPWR VGND sg13cmos5l_decap_8
XANTENNA__0634__A1 Tile_X0Y3_W2END[2] VPWR VGND sg13cmos5l_antennanp
XFILLER_34_293 VPWR VGND sg13cmos5l_fill_2
XFILLER_139_118 VPWR VGND sg13cmos5l_decap_8
XFILLER_162_110 VPWR VGND sg13cmos5l_decap_4
XANTENNA__1238__D Tile_X0Y0_FrameData[21] VPWR VGND sg13cmos5l_antennanp
XANTENNA__2181__GATE Tile_X0Y3_FrameStrobe[7] VPWR VGND sg13cmos5l_antennanp
XFILLER_118_78 VPWR VGND sg13cmos5l_decap_8
XFILLER_76_105 VPWR VGND sg13cmos5l_decap_8
XANTENNA__2069__D Tile_X0Y3_FrameData[30] VPWR VGND sg13cmos5l_antennanp
XFILLER_94_26 VPWR VGND sg13cmos5l_fill_2
XANTENNA__1114__A2 AXIL_S_SOC_WDATA11 VPWR VGND sg13cmos5l_antennanp
XFILLER_69_190 VPWR VGND sg13cmos5l_fill_1
XFILLER_27_20 VPWR VGND sg13cmos5l_decap_4
XFILLER_84_171 VPWR VGND sg13cmos5l_decap_8
XFILLER_27_53 VPWR VGND sg13cmos5l_decap_4
XFILLER_217_144 VPWR VGND sg13cmos5l_decap_8
XANTENNA__0873__A1 Tile_X0Y0_S4END[1] VPWR VGND sg13cmos5l_antennanp
XANTENNA__1701__D Tile_X0Y2_FrameData[22] VPWR VGND sg13cmos5l_antennanp
XFILLER_150_43 VPWR VGND sg13cmos5l_fill_1
XFILLER_217_177 VPWR VGND sg13cmos5l_fill_2
XFILLER_25_271 VPWR VGND sg13cmos5l_decap_4
XFILLER_185_213 VPWR VGND sg13cmos5l_decap_8
XANTENNA__2134__GATE Tile_X0Y3_FrameStrobe[6] VPWR VGND sg13cmos5l_antennanp
XFILLER_40_285 VPWR VGND sg13cmos5l_fill_2
XFILLER_159_85 VPWR VGND sg13cmos5l_fill_1
XFILLER_223_0 VPWR VGND sg13cmos5l_fill_2
XFILLER_185_279 VPWR VGND sg13cmos5l_decap_8
XANTENNA__1390__GATE Tile_X0Y3_FrameStrobe[6] VPWR VGND sg13cmos5l_antennanp
XFILLER_4_120 VPWR VGND sg13cmos5l_decap_8
XANTENNA__2149__GATE Tile_X0Y3_FrameStrobe[6] VPWR VGND sg13cmos5l_antennanp
XFILLER_4_46 VPWR VGND sg13cmos5l_decap_4
XANTENNA__0561__A0 Tile_X0Y3_N1END[1] VPWR VGND sg13cmos5l_antennanp
XANTENNA__2557__A Tile_X0Y3_FrameData[15] VPWR VGND sg13cmos5l_antennanp
XFILLER_82_119 VPWR VGND sg13cmos5l_decap_8
XFILLER_208_133 VPWR VGND sg13cmos5l_fill_1
XANTENNA__1611__D Tile_X0Y1_FrameData[24] VPWR VGND sg13cmos5l_antennanp
XFILLER_75_182 VPWR VGND sg13cmos5l_decap_8
XFILLER_223_136 VPWR VGND sg13cmos5l_fill_1
XANTENNA__0616__A1 Tile_X0Y3_N4END[1] VPWR VGND sg13cmos5l_antennanp
XANTENNA__1343__GATE Tile_X0Y3_FrameStrobe[4] VPWR VGND sg13cmos5l_antennanp
XFILLER_16_293 VPWR VGND sg13cmos5l_fill_2
XANTENNA__1973__GATE Tile_X0Y3_FrameStrobe[1] VPWR VGND sg13cmos5l_antennanp
XFILLER_176_257 VPWR VGND sg13cmos5l_fill_2
XFILLER_219_33 VPWR VGND sg13cmos5l_fill_2
XFILLER_191_205 VPWR VGND sg13cmos5l_fill_2
XANTENNA__1358__GATE Tile_X0Y3_FrameStrobe[5] VPWR VGND sg13cmos5l_antennanp
X_1705_ _1705_/Q Tile_X0Y2_FrameData[18] Tile_X0Y3_FrameStrobe[0] VPWR VGND sg13cmos5l_dlhq_1
XANTENNA__1195__X AXIL_S_SOC_RDATA17 VPWR VGND sg13cmos5l_antennanp
XANTENNA__1988__GATE Tile_X0Y3_FrameStrobe[1] VPWR VGND sg13cmos5l_antennanp
XFILLER_184_290 VPWR VGND sg13cmos5l_decap_4
X_1636_ _1636_/Q Tile_X0Y1_FrameData[31] Tile_X0Y3_FrameStrobe[6] VPWR VGND sg13cmos5l_dlhq_1
X_1567_ _1567_/Q Tile_X0Y1_FrameData[4] Tile_X0Y3_FrameStrobe[3] VPWR VGND sg13cmos5l_dlhq_1
XANTENNA__1911__GATE Tile_X0Y3_FrameStrobe[6] VPWR VGND sg13cmos5l_antennanp
X_0518_ _0518_/Y _0431_/Y _1202_/Q _1203_/Q _0516_/Y _0517_/Y VPWR VGND sg13cmos5l_a221oi_1
X_1498_ _1498_/Q Tile_X0Y1_FrameData[9] Tile_X0Y3_FrameStrobe[1] VPWR VGND sg13cmos5l_dlhq_1
XFILLER_58_138 VPWR VGND sg13cmos5l_fill_2
X_0449_ _0449_/Y _1629_/Q VPWR VGND sg13cmos5l_inv_1
XANTENNA__1926__GATE Tile_X0Y3_FrameStrobe[7] VPWR VGND sg13cmos5l_antennanp
XFILLER_104_47 VPWR VGND sg13cmos5l_decap_8
XFILLER_104_69 VPWR VGND sg13cmos5l_fill_2
XANTENNA__0855__A1 AXIL_S_SOC_AWADDR6 VPWR VGND sg13cmos5l_antennanp
XANTENNA__1521__D Tile_X0Y1_FrameData[18] VPWR VGND sg13cmos5l_antennanp
X_2119_ _2119_/Q Tile_X0Y3_FrameData[12] Tile_X0Y3_FrameStrobe[5] VPWR VGND sg13cmos5l_dlhq_1
XANTENNA__0607__A1 Tile_X0Y3_N4END[0] VPWR VGND sg13cmos5l_antennanp
XFILLER_22_230 VPWR VGND sg13cmos5l_decap_8
XFILLER_222_191 VPWR VGND sg13cmos5l_decap_8
XFILLER_196_17 VPWR VGND sg13cmos5l_decap_4
XFILLER_129_11 VPWR VGND sg13cmos5l_decap_8
XFILLER_129_22 VPWR VGND sg13cmos5l_fill_2
XANTENNA__1032__A1 AXIL_S_SOC_WDATA28 VPWR VGND sg13cmos5l_antennanp
XFILLER_129_99 VPWR VGND sg13cmos5l_decap_8
XFILLER_89_26 VPWR VGND sg13cmos5l_decap_8
XANTENNA__0791__A0 Tile_X0Y0_W1END[0] VPWR VGND sg13cmos5l_antennanp
XFILLER_145_43 VPWR VGND sg13cmos5l_decap_8
XFILLER_190_293 VPWR VGND sg13cmos5l_fill_2
XFILLER_89_263 VPWR VGND sg13cmos5l_fill_1
XFILLER_49_127 VPWR VGND sg13cmos5l_decap_8
XFILLER_38_30 VPWR VGND sg13cmos5l_decap_8
XANTENNA__1099__A1 AXIL_S_SOC_WDATA15 VPWR VGND sg13cmos5l_antennanp
XFILLER_161_53 VPWR VGND sg13cmos5l_decap_4
XFILLER_57_171 VPWR VGND sg13cmos5l_decap_8
XANTENNA__0846__A1 AXIL_S_SOC_AWADDR7 VPWR VGND sg13cmos5l_antennanp
XANTENNA__1431__D Tile_X0Y0_FrameData[20] VPWR VGND sg13cmos5l_antennanp
XFILLER_205_136 VPWR VGND sg13cmos5l_decap_8
XANTENNA__2073__GATE Tile_X0Y3_FrameStrobe[4] VPWR VGND sg13cmos5l_antennanp
XFILLER_220_117 VPWR VGND sg13cmos5l_fill_1
XFILLER_13_274 VPWR VGND sg13cmos5l_decap_4
XFILLER_9_201 VPWR VGND sg13cmos5l_decap_8
XFILLER_186_61 VPWR VGND sg13cmos5l_decap_8
XANTENNA__2088__GATE Tile_X0Y3_FrameStrobe[4] VPWR VGND sg13cmos5l_antennanp
XFILLER_126_121 VPWR VGND sg13cmos5l_decap_4
XFILLER_126_143 VPWR VGND sg13cmos5l_decap_8
XFILLER_126_154 VPWR VGND sg13cmos5l_fill_1
XFILLER_126_176 VPWR VGND sg13cmos5l_decap_4
X_2470_ Tile_X0Y0_E6BEG[8] _2470_/A VPWR VGND sg13cmos5l_buf_1
X_1421_ _1421_/Q Tile_X0Y0_FrameData[30] Tile_X0Y3_FrameStrobe[7] VPWR VGND sg13cmos5l_dlhq_1
XFILLER_79_70 VPWR VGND sg13cmos5l_decap_8
XFILLER_181_293 VPWR VGND sg13cmos5l_fill_2
XANTENNA__1606__D Tile_X0Y1_FrameData[29] VPWR VGND sg13cmos5l_antennanp
XANTENNA__2011__GATE Tile_X0Y3_FrameStrobe[2] VPWR VGND sg13cmos5l_antennanp
X_1352_ _1352_/Q Tile_X0Y0_FrameData[3] Tile_X0Y3_FrameStrobe[4] VPWR VGND sg13cmos5l_dlhq_1
XFILLER_205_24 VPWR VGND sg13cmos5l_decap_8
X_1283_ _1283_/Q Tile_X0Y0_FrameData[8] Tile_X0Y3_FrameStrobe[2] VPWR VGND sg13cmos5l_dlhq_1
XFILLER_205_57 VPWR VGND sg13cmos5l_decap_8
XANTENNA__2026__GATE Tile_X0Y3_FrameStrobe[2] VPWR VGND sg13cmos5l_antennanp
XANTENNA__1341__D Tile_X0Y0_FrameData[14] VPWR VGND sg13cmos5l_antennanp
XANTENNA__2574__X Tile_X0Y3_S1BEG[0] VPWR VGND sg13cmos5l_antennanp
XFILLER_48_193 VPWR VGND sg13cmos5l_decap_8
XANTENNA__1282__GATE Tile_X0Y3_FrameStrobe[2] VPWR VGND sg13cmos5l_antennanp
XANTENNA__1297__GATE Tile_X0Y3_FrameStrobe[3] VPWR VGND sg13cmos5l_antennanp
XANTENNA__2172__D Tile_X0Y3_FrameData[23] VPWR VGND sg13cmos5l_antennanp
X_0998_ _2220_/A AXIL_S_SOC_WDATA21 _0932_/A _0933_/X _0864_/X _1536_/Q _1537_/Q VPWR
+ VGND sg13cmos5l_mux4_1
XANTENNA__1014__A1 Tile_X0Y1_W2END[4] VPWR VGND sg13cmos5l_antennanp
XFILLER_117_143 VPWR VGND sg13cmos5l_decap_8
XFILLER_157_290 VPWR VGND sg13cmos5l_decap_4
XANTENNA__1220__GATE Tile_X0Y3_FrameStrobe[0] VPWR VGND sg13cmos5l_antennanp
XANTENNA__1850__GATE Tile_X0Y3_FrameStrobe[4] VPWR VGND sg13cmos5l_antennanp
XFILLER_117_187 VPWR VGND sg13cmos5l_decap_4
X_1619_ _1619_/Q Tile_X0Y1_FrameData[16] Tile_X0Y3_FrameStrobe[5] VPWR VGND sg13cmos5l_dlhq_1
XFILLER_59_18 VPWR VGND sg13cmos5l_fill_2
XFILLER_172_293 VPWR VGND sg13cmos5l_fill_2
XANTENNA__1516__D Tile_X0Y1_FrameData[23] VPWR VGND sg13cmos5l_antennanp
X_2599_ Tile_X0Y3_S4BEG[5] _2599_/A VPWR VGND sg13cmos5l_buf_1
XFILLER_115_24 VPWR VGND sg13cmos5l_fill_1
XFILLER_219_206 VPWR VGND sg13cmos5l_fill_1
XANTENNA__1235__GATE Tile_X0Y3_FrameStrobe[1] VPWR VGND sg13cmos5l_antennanp
XANTENNA__1865__GATE Tile_X0Y3_FrameStrobe[5] VPWR VGND sg13cmos5l_antennanp
XFILLER_75_39 VPWR VGND sg13cmos5l_decap_8
XANTENNA__2484__X Tile_X0Y0_E2BEG[2] VPWR VGND sg13cmos5l_antennanp
XANTENNA__1251__D Tile_X0Y0_FrameData[8] VPWR VGND sg13cmos5l_antennanp
XFILLER_54_141 VPWR VGND sg13cmos5l_decap_8
XFILLER_24_21 VPWR VGND sg13cmos5l_decap_4
XFILLER_24_43 VPWR VGND sg13cmos5l_fill_1
XANTENNA__1803__GATE Tile_X0Y3_FrameStrobe[3] VPWR VGND sg13cmos5l_antennanp
XANTENNA__2082__D Tile_X0Y3_FrameData[17] VPWR VGND sg13cmos5l_antennanp
XFILLER_10_255 VPWR VGND sg13cmos5l_fill_2
XFILLER_123_102 VPWR VGND sg13cmos5l_decap_4
XANTENNA__1818__GATE Tile_X0Y3_FrameStrobe[3] VPWR VGND sg13cmos5l_antennanp
XFILLER_163_293 VPWR VGND sg13cmos5l_fill_2
XANTENNA__1426__D Tile_X0Y0_FrameData[25] VPWR VGND sg13cmos5l_antennanp
XANTENNA__0630__B_N Tile_X0Y3_W2MID[0] VPWR VGND sg13cmos5l_antennanp
XFILLER_1_47 VPWR VGND sg13cmos5l_fill_2
XANTENNA__0819__A1 AXIL_S_SOC_WSTRB1 VPWR VGND sg13cmos5l_antennanp
XANTENNA__2394__X Tile_X0Y0_FrameStrobe_O[0] VPWR VGND sg13cmos5l_antennanp
XFILLER_92_225 VPWR VGND sg13cmos5l_fill_1
XFILLER_65_72 VPWR VGND sg13cmos5l_decap_8
XFILLER_60_122 VPWR VGND sg13cmos5l_fill_1
X_1970_ _1970_/Q Tile_X0Y3_FrameData[1] Tile_X0Y3_FrameStrobe[0] VPWR VGND sg13cmos5l_dlhq_1
X_0921_ _2366_/A _0918_/Y _0920_/Y _0912_/Y VPWR VGND sg13cmos5l_a21oi_1
XANTENNA__2570__A Tile_X0Y3_FrameData[28] VPWR VGND sg13cmos5l_antennanp
XFILLER_146_205 VPWR VGND sg13cmos5l_decap_8
X_0852_ _2449_/A AXIL_S_SOC_WSTRB2 AXIL_S_SOC_AWADDR9 _0520_/A _0739_/X _1325_/Q _1324_/Q
+ VPWR VGND sg13cmos5l_mux4_1
XFILLER_146_249 VPWR VGND sg13cmos5l_decap_8
X_0783_ _2371_/A _0774_/Y _0777_/Y _0780_/Y _0782_/Y VPWR VGND sg13cmos5l_a22oi_1
XFILLER_60_4 VPWR VGND sg13cmos5l_fill_1
X_2522_ Tile_X0Y3_E6BEG[8] _2522_/A VPWR VGND sg13cmos5l_buf_1
XFILLER_154_293 VPWR VGND sg13cmos5l_fill_2
XANTENNA__1336__D Tile_X0Y0_FrameData[19] VPWR VGND sg13cmos5l_antennanp
XANTENNA__2569__X Tile_X0Y3_FrameData_O[27] VPWR VGND sg13cmos5l_antennanp
X_2453_ Tile_X0Y0_EE4BEG[7] _2453_/A VPWR VGND sg13cmos5l_buf_1
XANTENNA__0507__A0 Tile_X0Y3_N1END[3] VPWR VGND sg13cmos5l_antennanp
X_1404_ _1404_/Q Tile_X0Y0_FrameData[15] Tile_X0Y3_FrameStrobe[6] VPWR VGND sg13cmos5l_dlhq_1
X_2384_ Tile_X0Y0_N2BEG[2] _2384_/A VPWR VGND sg13cmos5l_buf_1
XANTENNA__1180__A0 Tile_X0Y2_W2MID[2] VPWR VGND sg13cmos5l_antennanp
X_1335_ _1335_/Q Tile_X0Y0_FrameData[20] Tile_X0Y3_FrameStrobe[4] VPWR VGND sg13cmos5l_dlhq_1
XANTENNA__0522__A3 Tile_X0Y0_S4END[4] VPWR VGND sg13cmos5l_antennanp
XANTENNA__2167__D Tile_X0Y3_FrameData[28] VPWR VGND sg13cmos5l_antennanp
X_1266_ _1266_/Q Tile_X0Y0_FrameData[25] Tile_X0Y3_FrameStrobe[2] VPWR VGND sg13cmos5l_dlhq_1
XFILLER_83_236 VPWR VGND sg13cmos5l_decap_8
X_1197_ _1197_/Q Tile_X0Y0_FrameData[30] Tile_X0Y3_FrameStrobe[0] VPWR VGND sg13cmos5l_dlhq_1
XFILLER_209_283 VPWR VGND sg13cmos5l_fill_2
XFILLER_101_26 VPWR VGND sg13cmos5l_decap_4
XFILLER_51_199 VPWR VGND sg13cmos5l_decap_8
XFILLER_117_8 VPWR VGND sg13cmos5l_decap_4
XFILLER_193_18 VPWR VGND sg13cmos5l_fill_2
XFILLER_105_135 VPWR VGND sg13cmos5l_decap_4
XFILLER_10_45 VPWR VGND sg13cmos5l_fill_2
XFILLER_193_29 VPWR VGND sg13cmos5l_decap_8
XANTENNA__1246__D Tile_X0Y0_FrameData[13] VPWR VGND sg13cmos5l_antennanp
XANTENNA__2479__X Tile_X0Y0_E2BEGb[5] VPWR VGND sg13cmos5l_antennanp
XANTENNA__0761__A3 Tile_X0Y0_S4END[0] VPWR VGND sg13cmos5l_antennanp
XANTENNA__0513__A3 Tile_X0Y0_S4END[15] VPWR VGND sg13cmos5l_antennanp
XANTENNA__2077__D Tile_X0Y3_FrameData[22] VPWR VGND sg13cmos5l_antennanp
XFILLER_142_55 VPWR VGND sg13cmos5l_fill_2
XFILLER_207_209 VPWR VGND sg13cmos5l_decap_8
XFILLER_35_31 VPWR VGND sg13cmos5l_decap_8
XFILLER_27_174 VPWR VGND sg13cmos5l_decap_8
XFILLER_215_253 VPWR VGND sg13cmos5l_fill_1
XFILLER_35_75 VPWR VGND sg13cmos5l_decap_8
XANTENNA__1742__GATE Tile_X0Y3_FrameStrobe[1] VPWR VGND sg13cmos5l_antennanp
XFILLER_136_0 VPWR VGND sg13cmos5l_fill_2
XANTENNA__1757__GATE Tile_X0Y3_FrameStrobe[2] VPWR VGND sg13cmos5l_antennanp
XANTENNA__0737__A0 Tile_X0Y2_W2MID[3] VPWR VGND sg13cmos5l_antennanp
XANTENNA__2389__X Tile_X0Y0_N2BEG[7] VPWR VGND sg13cmos5l_antennanp
XFILLER_183_51 VPWR VGND sg13cmos5l_decap_8
X_1120_ _2323_/A AXIL_S_SOC_WDATA3 AXIL_S_SOC_WDATA15 _1060_/A _0719_/X _1797_/Q _1796_/Q
+ VPWR VGND sg13cmos5l_mux4_1
XFILLER_76_82 VPWR VGND sg13cmos5l_decap_4
XANTENNA__2565__A Tile_X0Y3_FrameData[23] VPWR VGND sg13cmos5l_antennanp
X_1051_ _1051_/Y _1051_/A VPWR VGND sg13cmos5l_inv_1
XFILLER_80_239 VPWR VGND sg13cmos5l_decap_8
XFILLER_73_280 VPWR VGND sg13cmos5l_fill_1
X_1953_ _1953_/Q Tile_X0Y3_FrameData[18] Tile_X0Y3_FrameStrobe[0] VPWR VGND sg13cmos5l_dlhq_1
XFILLER_33_199 VPWR VGND sg13cmos5l_fill_2
XFILLER_221_267 VPWR VGND sg13cmos5l_fill_2
XFILLER_119_205 VPWR VGND sg13cmos5l_fill_2
X_1884_ _1884_/Q Tile_X0Y2_FrameData[31] Tile_X0Y3_FrameStrobe[6] VPWR VGND sg13cmos5l_dlhq_1
X_0904_ _2472_/A AXIL_S_SOC_WSTRB1 _0775_/X _0778_/X _0751_/X _1279_/Q _1278_/Q VPWR
+ VGND sg13cmos5l_mux4_1
XFILLER_186_171 VPWR VGND sg13cmos5l_decap_8
X_0835_ _0835_/Y _0828_/S _0786_/X _0834_/Y VPWR VGND sg13cmos5l_o21ai_1
XANTENNA__0728__A0 Tile_X0Y3_W2MID[1] VPWR VGND sg13cmos5l_antennanp
XFILLER_127_293 VPWR VGND sg13cmos5l_fill_2
X_0766_ _0766_/Y _1419_/Q _0765_/X _0436_/Y VPWR VGND sg13cmos5l_a21oi_1
XFILLER_51_0 VPWR VGND sg13cmos5l_fill_2
XANTENNA__2299__X Tile_X0Y2_E6BEG[3] VPWR VGND sg13cmos5l_antennanp
X_2505_ Tile_X0Y3_E2BEG[7] _2505_/A VPWR VGND sg13cmos5l_buf_1
X_0697_ _2522_/A _0649_/X _0513_/X _0506_/X _0590_/X _2027_/Q _2026_/Q VPWR VGND sg13cmos5l_mux4_1
X_2436_ Tile_X0Y0_FrameData_O[22] Tile_X0Y0_FrameData[22] VPWR VGND sg13cmos5l_buf_1
X_2367_ Tile_X0Y0_N4BEG[9] _2367_/A VPWR VGND sg13cmos5l_buf_1
XANTENNA__0900__A0 AXIL_S_SOC_WVALID VPWR VGND sg13cmos5l_antennanp
X_1318_ _1318_/Q Tile_X0Y0_FrameData[5] Tile_X0Y3_FrameStrobe[3] VPWR VGND sg13cmos5l_dlhq_1
X_2298_ Tile_X0Y2_E6BEG[2] _2298_/A VPWR VGND sg13cmos5l_buf_1
XFILLER_56_247 VPWR VGND sg13cmos5l_decap_8
XFILLER_112_14 VPWR VGND sg13cmos5l_decap_4
X_1249_ _1249_/Q Tile_X0Y0_FrameData[10] Tile_X0Y3_FrameStrobe[1] VPWR VGND sg13cmos5l_dlhq_1
XFILLER_56_258 VPWR VGND sg13cmos5l_fill_2
XFILLER_24_122 VPWR VGND sg13cmos5l_decap_8
XFILLER_169_116 VPWR VGND sg13cmos5l_fill_2
XFILLER_212_234 VPWR VGND sg13cmos5l_decap_8
XFILLER_21_11 VPWR VGND sg13cmos5l_fill_2
XFILLER_125_208 VPWR VGND sg13cmos5l_decap_8
XFILLER_192_163 VPWR VGND sg13cmos5l_decap_8
XFILLER_118_293 VPWR VGND sg13cmos5l_fill_2
XANTENNA__1704__D Tile_X0Y2_FrameData[19] VPWR VGND sg13cmos5l_antennanp
XFILLER_62_217 VPWR VGND sg13cmos5l_decap_8
XFILLER_46_74 VPWR VGND sg13cmos5l_fill_1
XFILLER_46_63 VPWR VGND sg13cmos5l_decap_8
XANTENNA__1681__GATE Tile_X0Y3_FrameStrobe[7] VPWR VGND sg13cmos5l_antennanp
XFILLER_62_40 VPWR VGND sg13cmos5l_decap_8
XANTENNA__0958__A0 AXIL_S_SOC_WDATA17 VPWR VGND sg13cmos5l_antennanp
XANTENNA__1696__GATE Tile_X0Y3_FrameStrobe[0] VPWR VGND sg13cmos5l_antennanp
XFILLER_116_219 VPWR VGND sg13cmos5l_decap_8
XFILLER_183_141 VPWR VGND sg13cmos5l_decap_8
XFILLER_109_293 VPWR VGND sg13cmos5l_fill_2
X_0620_ _0620_/X _0478_/X _0479_/X _0480_/X _0598_/X _2121_/Q _2120_/Q VPWR VGND sg13cmos5l_mux4_1
XFILLER_183_196 VPWR VGND sg13cmos5l_decap_8
X_0551_ _0551_/Y _1448_/Q _0551_/B _0551_/C VPWR VGND sg13cmos5l_nor3_1
X_2221_ Tile_X0Y1_E6BEG[6] _2221_/A VPWR VGND sg13cmos5l_buf_1
X_0482_ _0482_/X Tile_X0Y1_W2MID[5] Tile_X0Y1_W2END[5] Tile_X0Y1_W6END[10] _0867_/X
+ _1643_/Q _1642_/Q VPWR VGND sg13cmos5l_mux4_1
XANTENNA__1614__D Tile_X0Y1_FrameData[21] VPWR VGND sg13cmos5l_antennanp
XANTENNA__1634__GATE Tile_X0Y3_FrameStrobe[5] VPWR VGND sg13cmos5l_antennanp
X_2152_ _2152_/Q Tile_X0Y3_FrameData[11] Tile_X0Y3_FrameStrobe[6] VPWR VGND sg13cmos5l_dlhq_1
X_1103_ _1103_/X _0937_/X _0501_/B Tile_X0Y3_N4END[7] Tile_X0Y0_S4END[11] _1732_/Q
+ _1733_/Q VPWR VGND sg13cmos5l_mux4_1
X_2083_ _2083_/Q Tile_X0Y3_FrameData[16] Tile_X0Y3_FrameStrobe[4] VPWR VGND sg13cmos5l_dlhq_1
X_1034_ _2228_/A AXIL_S_SOC_WDATA17 _0465_/X AXIL_S_SOC_WDATA29 _0866_/X _1576_/Q
+ _1577_/Q VPWR VGND sg13cmos5l_mux4_1
XANTENNA__1649__GATE Tile_X0Y3_FrameStrobe[6] VPWR VGND sg13cmos5l_antennanp
XFILLER_46_280 VPWR VGND sg13cmos5l_fill_2
XANTENNA__2582__X Tile_X0Y3_S2BEG[4] VPWR VGND sg13cmos5l_antennanp
XFILLER_99_0 VPWR VGND sg13cmos5l_fill_1
XFILLER_61_294 VPWR VGND sg13cmos5l_fill_1
XFILLER_21_114 VPWR VGND sg13cmos5l_decap_4
X_1936_ _1936_/Q Tile_X0Y2_FrameData[11] Tile_X0Y3_FrameStrobe[7] VPWR VGND sg13cmos5l_dlhq_1
XANTENNA__2180__D Tile_X0Y3_FrameData[15] VPWR VGND sg13cmos5l_antennanp
X_1867_ _1867_/Q Tile_X0Y2_FrameData[16] Tile_X0Y3_FrameStrobe[5] VPWR VGND sg13cmos5l_dlhq_1
XANTENNA__0964__A3 AXIL_S_SOC_WDATA23 VPWR VGND sg13cmos5l_antennanp
X_1798_ _1798_/Q Tile_X0Y2_FrameData[21] Tile_X0Y3_FrameStrobe[3] VPWR VGND sg13cmos5l_dlhq_1
X_0818_ _2491_/A _0752_/X AXIL_S_SOC_WSTRB2 Tile_X0Y0_S1END[1] AXIL_S_SOC_AWADDR0
+ _1368_/Q _1369_/Q VPWR VGND sg13cmos5l_mux4_1
XFILLER_174_174 VPWR VGND sg13cmos5l_decap_4
XFILLER_107_25 VPWR VGND sg13cmos5l_fill_1
X_0749_ _2380_/A Tile_X0Y1_W2MID[1] Tile_X0Y1_W2END[1] Tile_X0Y1_W6END[1] _0866_/X
+ _1671_/Q _1670_/Q VPWR VGND sg13cmos5l_mux4_1
XANTENNA__1126__A0 AXIL_S_SOC_WDATA7 VPWR VGND sg13cmos5l_antennanp
XANTENNA__1524__D Tile_X0Y1_FrameData[15] VPWR VGND sg13cmos5l_antennanp
X_2419_ Tile_X0Y0_FrameData_O[5] Tile_X0Y0_FrameData[5] VPWR VGND sg13cmos5l_buf_1
XANTENNA__2492__X Tile_X0Y0_E1BEG[2] VPWR VGND sg13cmos5l_antennanp
XFILLER_16_66 VPWR VGND sg13cmos5l_decap_8
XANTENNA__0652__A2 Tile_X0Y1_W6END[5] VPWR VGND sg13cmos5l_antennanp
XFILLER_197_277 VPWR VGND sg13cmos5l_decap_4
XFILLER_32_32 VPWR VGND sg13cmos5l_fill_1
XANTENNA__2090__D Tile_X0Y3_FrameData[9] VPWR VGND sg13cmos5l_antennanp
XFILLER_165_174 VPWR VGND sg13cmos5l_fill_2
XFILLER_180_122 VPWR VGND sg13cmos5l_decap_8
XFILLER_106_274 VPWR VGND sg13cmos5l_decap_8
XFILLER_106_285 VPWR VGND sg13cmos5l_fill_1
XFILLER_164_86 VPWR VGND sg13cmos5l_decap_8
XANTENNA__1117__A0 Tile_X0Y3_N4END[5] VPWR VGND sg13cmos5l_antennanp
XANTENNA__1434__D Tile_X0Y0_FrameData[17] VPWR VGND sg13cmos5l_antennanp
XFILLER_87_180 VPWR VGND sg13cmos5l_decap_8
XFILLER_57_40 VPWR VGND sg13cmos5l_fill_2
XANTENNA__0643__A2 Tile_X0Y0_S2MID[0] VPWR VGND sg13cmos5l_antennanp
XFILLER_43_283 VPWR VGND sg13cmos5l_fill_1
XANTENNA__1609__D Tile_X0Y1_FrameData[26] VPWR VGND sg13cmos5l_antennanp
X_1721_ _1721_/Q Tile_X0Y2_FrameData[2] Tile_X0Y3_FrameStrobe[0] VPWR VGND sg13cmos5l_dlhq_1
XANTENNA__0946__A3 Tile_X0Y0_S4END[7] VPWR VGND sg13cmos5l_antennanp
X_1652_ _1652_/Q Tile_X0Y1_FrameData[15] Tile_X0Y3_FrameStrobe[6] VPWR VGND sg13cmos5l_dlhq_1
XFILLER_7_151 VPWR VGND sg13cmos5l_decap_8
X_0603_ _2585_/A Tile_X0Y3_W1END[3] Tile_X0Y3_W2MID[0] Tile_X0Y3_W2END[0] _0602_/X
+ _2129_/Q _2128_/Q VPWR VGND sg13cmos5l_mux4_1
XFILLER_171_177 VPWR VGND sg13cmos5l_decap_4
X_1583_ _1583_/Q Tile_X0Y1_FrameData[20] Tile_X0Y3_FrameStrobe[4] VPWR VGND sg13cmos5l_dlhq_1
X_0534_ _0534_/X _0528_/X _0530_/Y _0533_/Y VPWR VGND sg13cmos5l_a21o_1
XANTENNA__1344__D Tile_X0Y0_FrameData[11] VPWR VGND sg13cmos5l_antennanp
XANTENNA__1573__GATE Tile_X0Y3_FrameStrobe[4] VPWR VGND sg13cmos5l_antennanp
XANTENNA__2577__X Tile_X0Y3_S1BEG[3] VPWR VGND sg13cmos5l_antennanp
X_0465_ _0465_/X _0860_/X _0466_/B Tile_X0Y3_N4END[10] Tile_X0Y0_S4END[6] _1470_/Q
+ _1471_/Q VPWR VGND sg13cmos5l_mux4_1
X_2204_ Tile_X0Y1_E2BEG[5] _2204_/A VPWR VGND sg13cmos5l_buf_1
X_2135_ _2135_/Q Tile_X0Y3_FrameData[28] Tile_X0Y3_FrameStrobe[6] VPWR VGND sg13cmos5l_dlhq_1
XANTENNA__0882__A2 AXIL_S_SOC_AWADDR2 VPWR VGND sg13cmos5l_antennanp
XANTENNA__1588__GATE Tile_X0Y3_FrameStrobe[4] VPWR VGND sg13cmos5l_antennanp
X_2066_ _2066_/Q Tile_X0Y3_FrameData[1] Tile_X0Y3_FrameStrobe[3] VPWR VGND sg13cmos5l_dlhq_1
XFILLER_19_280 VPWR VGND sg13cmos5l_fill_1
XANTENNA__2175__D Tile_X0Y3_FrameData[20] VPWR VGND sg13cmos5l_antennanp
X_1017_ _2239_/A AXIL_S_SOC_WDATA16 _0949_/X AXIL_S_SOC_WDATA28 _0868_/X _1554_/Q
+ _1555_/Q VPWR VGND sg13cmos5l_mux4_1
XFILLER_34_261 VPWR VGND sg13cmos5l_fill_1
XFILLER_34_250 VPWR VGND sg13cmos5l_decap_8
XFILLER_179_222 VPWR VGND sg13cmos5l_decap_8
XFILLER_179_200 VPWR VGND sg13cmos5l_decap_8
XANTENNA__0634__A2 Tile_X0Y3_W6END[2] VPWR VGND sg13cmos5l_antennanp
XANTENNA__1511__GATE Tile_X0Y3_FrameStrobe[2] VPWR VGND sg13cmos5l_antennanp
XFILLER_194_236 VPWR VGND sg13cmos5l_decap_8
XANTENNA__1519__D Tile_X0Y1_FrameData[20] VPWR VGND sg13cmos5l_antennanp
X_1919_ _1919_/Q Tile_X0Y2_FrameData[28] Tile_X0Y3_FrameStrobe[7] VPWR VGND sg13cmos5l_dlhq_1
XANTENNA__1526__GATE Tile_X0Y3_FrameStrobe[2] VPWR VGND sg13cmos5l_antennanp
XFILLER_162_100 VPWR VGND sg13cmos5l_fill_1
XFILLER_162_122 VPWR VGND sg13cmos5l_decap_8
XFILLER_118_35 VPWR VGND sg13cmos5l_fill_2
XFILLER_162_177 VPWR VGND sg13cmos5l_decap_4
XFILLER_103_211 VPWR VGND sg13cmos5l_decap_4
XANTENNA__1254__D Tile_X0Y0_FrameData[5] VPWR VGND sg13cmos5l_antennanp
XANTENNA__2487__X Tile_X0Y0_E2BEG[5] VPWR VGND sg13cmos5l_antennanp
XFILLER_103_266 VPWR VGND sg13cmos5l_fill_1
XFILLER_134_67 VPWR VGND sg13cmos5l_decap_8
XFILLER_150_11 VPWR VGND sg13cmos5l_fill_2
XFILLER_27_76 VPWR VGND sg13cmos5l_fill_2
XFILLER_27_65 VPWR VGND sg13cmos5l_fill_1
XANTENNA__2085__D Tile_X0Y3_FrameData[14] VPWR VGND sg13cmos5l_antennanp
XFILLER_159_31 VPWR VGND sg13cmos5l_decap_4
XFILLER_43_64 VPWR VGND sg13cmos5l_decap_8
XFILLER_40_242 VPWR VGND sg13cmos5l_decap_8
XFILLER_159_42 VPWR VGND sg13cmos5l_fill_1
XFILLER_43_75 VPWR VGND sg13cmos5l_fill_2
XANTENNA__1429__D Tile_X0Y0_FrameData[22] VPWR VGND sg13cmos5l_antennanp
XFILLER_185_258 VPWR VGND sg13cmos5l_decap_8
XANTENNA__1050__A2 Tile_X0Y3_N4END[5] VPWR VGND sg13cmos5l_antennanp
XFILLER_138_185 VPWR VGND sg13cmos5l_decap_8
XFILLER_216_0 VPWR VGND sg13cmos5l_decap_4
XFILLER_4_14 VPWR VGND sg13cmos5l_fill_2
XFILLER_153_199 VPWR VGND sg13cmos5l_fill_2
XANTENNA__2397__X Tile_X0Y0_FrameStrobe_O[3] VPWR VGND sg13cmos5l_antennanp
XFILLER_68_50 VPWR VGND sg13cmos5l_fill_1
XANTENNA__0561__A1 Tile_X0Y3_N4END[1] VPWR VGND sg13cmos5l_antennanp
XFILLER_67_117 VPWR VGND sg13cmos5l_fill_1
XFILLER_208_112 VPWR VGND sg13cmos5l_decap_8
XFILLER_75_161 VPWR VGND sg13cmos5l_decap_8
XFILLER_84_82 VPWR VGND sg13cmos5l_fill_1
XANTENNA__2573__A Tile_X0Y3_FrameData[31] VPWR VGND sg13cmos5l_antennanp
XFILLER_31_242 VPWR VGND sg13cmos5l_fill_2
XANTENNA__1339__D Tile_X0Y0_FrameData[16] VPWR VGND sg13cmos5l_antennanp
XANTENNA__1041__A2 Tile_X0Y3_N4END[5] VPWR VGND sg13cmos5l_antennanp
X_1704_ _1704_/Q Tile_X0Y2_FrameData[19] Tile_X0Y3_FrameStrobe[0] VPWR VGND sg13cmos5l_dlhq_1
XFILLER_191_239 VPWR VGND sg13cmos5l_fill_1
XFILLER_191_228 VPWR VGND sg13cmos5l_decap_8
XFILLER_144_122 VPWR VGND sg13cmos5l_decap_8
XFILLER_219_89 VPWR VGND sg13cmos5l_fill_1
X_1635_ _1635_/Q Tile_X0Y1_FrameData[0] Tile_X0Y3_FrameStrobe[5] VPWR VGND sg13cmos5l_dlhq_1
X_1566_ _1566_/Q Tile_X0Y1_FrameData[5] Tile_X0Y3_FrameStrobe[3] VPWR VGND sg13cmos5l_dlhq_1
X_0517_ _0517_/Y _1202_/Q _1203_/Q _0709_/X VPWR VGND sg13cmos5l_nor3_1
X_1497_ _1497_/Q Tile_X0Y1_FrameData[10] Tile_X0Y3_FrameStrobe[1] VPWR VGND sg13cmos5l_dlhq_1
XFILLER_98_286 VPWR VGND sg13cmos5l_fill_1
XFILLER_58_117 VPWR VGND sg13cmos5l_decap_8
X_0448_ _0448_/Y _1665_/Q VPWR VGND sg13cmos5l_inv_1
XANTENNA__1802__D Tile_X0Y2_FrameData[17] VPWR VGND sg13cmos5l_antennanp
X_2118_ _2118_/Q Tile_X0Y3_FrameData[13] Tile_X0Y3_FrameStrobe[5] VPWR VGND sg13cmos5l_dlhq_1
XFILLER_81_120 VPWR VGND sg13cmos5l_decap_8
XFILLER_66_183 VPWR VGND sg13cmos5l_fill_1
X_2049_ _2049_/Q Tile_X0Y3_FrameData[18] Tile_X0Y3_FrameStrobe[3] VPWR VGND sg13cmos5l_dlhq_1
XANTENNA__1450__GATE Tile_X0Y3_FrameStrobe[0] VPWR VGND sg13cmos5l_antennanp
XFILLER_120_25 VPWR VGND sg13cmos5l_decap_4
XFILLER_222_181 VPWR VGND sg13cmos5l_fill_1
XANTENNA__1249__D Tile_X0Y0_FrameData[10] VPWR VGND sg13cmos5l_antennanp
XANTENNA__1465__GATE Tile_X0Y3_FrameStrobe[0] VPWR VGND sg13cmos5l_antennanp
XFILLER_13_56 VPWR VGND sg13cmos5l_decap_8
XFILLER_129_56 VPWR VGND sg13cmos5l_fill_2
XFILLER_13_67 VPWR VGND sg13cmos5l_fill_1
XFILLER_129_78 VPWR VGND sg13cmos5l_decap_8
XANTENNA__0791__A1 Tile_X0Y0_WW4END[12] VPWR VGND sg13cmos5l_antennanp
XFILLER_135_177 VPWR VGND sg13cmos5l_decap_4
XFILLER_135_199 VPWR VGND sg13cmos5l_fill_1
XFILLER_145_33 VPWR VGND sg13cmos5l_decap_8
XFILLER_150_125 VPWR VGND sg13cmos5l_decap_8
XFILLER_89_220 VPWR VGND sg13cmos5l_decap_4
XFILLER_190_283 VPWR VGND sg13cmos5l_fill_1
XFILLER_145_77 VPWR VGND sg13cmos5l_fill_1
XFILLER_1_168 VPWR VGND sg13cmos5l_fill_1
XANTENNA__1403__GATE Tile_X0Y3_FrameStrobe[6] VPWR VGND sg13cmos5l_antennanp
XFILLER_161_32 VPWR VGND sg13cmos5l_fill_1
XANTENNA__1712__D Tile_X0Y2_FrameData[11] VPWR VGND sg13cmos5l_antennanp
XFILLER_57_150 VPWR VGND sg13cmos5l_decap_8
XFILLER_38_97 VPWR VGND sg13cmos5l_decap_8
XFILLER_38_75 VPWR VGND sg13cmos5l_decap_4
XANTENNA__1418__GATE Tile_X0Y3_FrameStrobe[6] VPWR VGND sg13cmos5l_antennanp
XFILLER_166_0 VPWR VGND sg13cmos5l_fill_1
XFILLER_72_175 VPWR VGND sg13cmos5l_decap_8
XFILLER_13_253 VPWR VGND sg13cmos5l_decap_4
XFILLER_173_206 VPWR VGND sg13cmos5l_decap_4
XFILLER_126_100 VPWR VGND sg13cmos5l_decap_4
XFILLER_9_279 VPWR VGND sg13cmos5l_fill_2
XANTENNA__1023__A2 AXIL_S_SOC_WDATA27 VPWR VGND sg13cmos5l_antennanp
XFILLER_181_272 VPWR VGND sg13cmos5l_decap_8
XFILLER_181_250 VPWR VGND sg13cmos5l_fill_1
X_1420_ _1420_/Q Tile_X0Y0_FrameData[31] Tile_X0Y3_FrameStrobe[7] VPWR VGND sg13cmos5l_dlhq_1
XFILLER_181_283 VPWR VGND sg13cmos5l_fill_1
X_1351_ _1351_/Q Tile_X0Y0_FrameData[4] Tile_X0Y3_FrameStrobe[4] VPWR VGND sg13cmos5l_dlhq_1
XANTENNA__2568__A Tile_X0Y3_FrameData[26] VPWR VGND sg13cmos5l_antennanp
XFILLER_205_36 VPWR VGND sg13cmos5l_decap_8
X_1282_ _1282_/Q Tile_X0Y0_FrameData[9] Tile_X0Y3_FrameStrobe[2] VPWR VGND sg13cmos5l_dlhq_1
XANTENNA__1622__D Tile_X0Y1_FrameData[13] VPWR VGND sg13cmos5l_antennanp
XFILLER_95_267 VPWR VGND sg13cmos5l_decap_8
XFILLER_55_109 VPWR VGND sg13cmos5l_decap_8
XFILLER_48_172 VPWR VGND sg13cmos5l_decap_8
XFILLER_221_35 VPWR VGND sg13cmos5l_fill_1
XANTENNA__2180__GATE Tile_X0Y3_FrameStrobe[7] VPWR VGND sg13cmos5l_antennanp
XANTENNA__2590__X Tile_X0Y3_S2BEGb[4] VPWR VGND sg13cmos5l_antennanp
XANTENNA__0470__A0 Tile_X0Y1_W1END[2] VPWR VGND sg13cmos5l_antennanp
XFILLER_149_247 VPWR VGND sg13cmos5l_decap_8
XFILLER_81_0 VPWR VGND sg13cmos5l_fill_2
X_0997_ _2217_/A Tile_X0Y3_N4END[10] _0925_/X Tile_X0Y0_S4END[6] _0547_/X _1542_/Q
+ _1543_/Q VPWR VGND sg13cmos5l_mux4_1
XANTENNA__1014__A2 Tile_X0Y1_W6END[4] VPWR VGND sg13cmos5l_antennanp
XFILLER_117_111 VPWR VGND sg13cmos5l_decap_8
X_1618_ _1618_/Q Tile_X0Y1_FrameData[17] Tile_X0Y3_FrameStrobe[5] VPWR VGND sg13cmos5l_dlhq_1
X_2598_ Tile_X0Y3_S4BEG[4] _2598_/A VPWR VGND sg13cmos5l_buf_1
X_1549_ _1549_/Q Tile_X0Y1_FrameData[22] Tile_X0Y3_FrameStrobe[3] VPWR VGND sg13cmos5l_dlhq_1
XFILLER_86_201 VPWR VGND sg13cmos5l_fill_1
XFILLER_75_18 VPWR VGND sg13cmos5l_decap_8
XANTENNA__1532__D Tile_X0Y1_FrameData[7] VPWR VGND sg13cmos5l_antennanp
XANTENNA__2133__GATE Tile_X0Y3_FrameStrobe[6] VPWR VGND sg13cmos5l_antennanp
XFILLER_39_172 VPWR VGND sg13cmos5l_fill_1
XANTENNA__2148__GATE Tile_X0Y3_FrameStrobe[6] VPWR VGND sg13cmos5l_antennanp
XFILLER_131_79 VPWR VGND sg13cmos5l_fill_2
XFILLER_91_28 VPWR VGND sg13cmos5l_decap_4
XFILLER_54_197 VPWR VGND sg13cmos5l_fill_1
XFILLER_199_147 VPWR VGND sg13cmos5l_decap_8
XFILLER_24_99 VPWR VGND sg13cmos5l_decap_4
XFILLER_155_228 VPWR VGND sg13cmos5l_fill_1
XFILLER_156_21 VPWR VGND sg13cmos5l_fill_1
XANTENNA__1707__D Tile_X0Y2_FrameData[16] VPWR VGND sg13cmos5l_antennanp
XFILLER_163_283 VPWR VGND sg13cmos5l_fill_1
XANTENNA__1342__GATE Tile_X0Y3_FrameStrobe[4] VPWR VGND sg13cmos5l_antennanp
XFILLER_77_223 VPWR VGND sg13cmos5l_decap_8
XFILLER_49_63 VPWR VGND sg13cmos5l_decap_8
XFILLER_172_31 VPWR VGND sg13cmos5l_fill_2
XANTENNA__1972__GATE Tile_X0Y3_FrameStrobe[1] VPWR VGND sg13cmos5l_antennanp
XANTENNA__1442__D Tile_X0Y0_FrameData[9] VPWR VGND sg13cmos5l_antennanp
XFILLER_65_51 VPWR VGND sg13cmos5l_decap_8
XFILLER_218_262 VPWR VGND sg13cmos5l_decap_4
XANTENNA__0819__A2 Tile_X0Y0_S1END[0] VPWR VGND sg13cmos5l_antennanp
XANTENNA__1357__GATE Tile_X0Y3_FrameStrobe[5] VPWR VGND sg13cmos5l_antennanp
XANTENNA__1987__GATE Tile_X0Y3_FrameStrobe[1] VPWR VGND sg13cmos5l_antennanp
XANTENNA__1910__GATE Tile_X0Y3_FrameStrobe[6] VPWR VGND sg13cmos5l_antennanp
X_0920_ _0920_/Y _1666_/Q _0919_/X _0448_/Y VPWR VGND sg13cmos5l_a21oi_1
XFILLER_201_162 VPWR VGND sg13cmos5l_fill_1
XFILLER_201_140 VPWR VGND sg13cmos5l_fill_1
XFILLER_198_191 VPWR VGND sg13cmos5l_decap_4
X_0851_ _2450_/A AXIL_S_SOC_WSTRB3 _0796_/X AXIL_S_SOC_AWADDR2 _0712_/X _1322_/Q _1323_/Q
+ VPWR VGND sg13cmos5l_mux4_1
XFILLER_201_184 VPWR VGND sg13cmos5l_decap_4
X_0782_ _0782_/Y _1415_/Q _0781_/X _1416_/Q VPWR VGND sg13cmos5l_a21oi_1
XANTENNA__1617__D Tile_X0Y1_FrameData[18] VPWR VGND sg13cmos5l_antennanp
XANTENNA__1925__GATE Tile_X0Y3_FrameStrobe[7] VPWR VGND sg13cmos5l_antennanp
XFILLER_154_261 VPWR VGND sg13cmos5l_decap_8
X_2521_ Tile_X0Y3_E6BEG[7] _2521_/A VPWR VGND sg13cmos5l_buf_1
XFILLER_5_282 VPWR VGND sg13cmos5l_fill_2
XFILLER_5_260 VPWR VGND sg13cmos5l_decap_8
X_2452_ Tile_X0Y0_EE4BEG[6] _2452_/A VPWR VGND sg13cmos5l_buf_1
XFILLER_5_293 VPWR VGND sg13cmos5l_fill_2
XANTENNA__0507__A1 Tile_X0Y3_N4END[3] VPWR VGND sg13cmos5l_antennanp
X_1403_ _1403_/Q Tile_X0Y0_FrameData[16] Tile_X0Y3_FrameStrobe[6] VPWR VGND sg13cmos5l_dlhq_1
X_2383_ Tile_X0Y0_N2BEG[1] _2383_/A VPWR VGND sg13cmos5l_buf_1
XFILLER_216_57 VPWR VGND sg13cmos5l_decap_8
XFILLER_122_180 VPWR VGND sg13cmos5l_fill_2
X_1334_ _1334_/Q Tile_X0Y0_FrameData[21] Tile_X0Y3_FrameStrobe[4] VPWR VGND sg13cmos5l_dlhq_1
XANTENNA__1180__A1 Tile_X0Y2_W2END[2] VPWR VGND sg13cmos5l_antennanp
XANTENNA__1352__D Tile_X0Y0_FrameData[3] VPWR VGND sg13cmos5l_antennanp
XANTENNA__2585__X Tile_X0Y3_S2BEG[7] VPWR VGND sg13cmos5l_antennanp
X_1265_ _1265_/Q Tile_X0Y0_FrameData[26] Tile_X0Y3_FrameStrobe[2] VPWR VGND sg13cmos5l_dlhq_1
XFILLER_36_120 VPWR VGND sg13cmos5l_decap_4
XFILLER_209_240 VPWR VGND sg13cmos5l_decap_4
X_1196_ AXIL_S_SOC_RDATA19 Tile_X0Y2_W1END[3] Tile_X0Y2_W6END[11] Tile_X0Y2_WW4END[12]
+ _0504_/Y _1748_/Q _1749_/Q VPWR VGND sg13cmos5l_mux4_1
XFILLER_36_153 VPWR VGND sg13cmos5l_decap_8
XANTENNA__0691__A0 Tile_X0Y3_N4END[2] VPWR VGND sg13cmos5l_antennanp
XANTENNA__2183__D Tile_X0Y3_FrameData[12] VPWR VGND sg13cmos5l_antennanp
XFILLER_51_178 VPWR VGND sg13cmos5l_decap_8
XFILLER_196_139 VPWR VGND sg13cmos5l_decap_4
XANTENNA__1527__D Tile_X0Y1_FrameData[12] VPWR VGND sg13cmos5l_antennanp
XFILLER_145_294 VPWR VGND sg13cmos5l_fill_1
XFILLER_160_220 VPWR VGND sg13cmos5l_fill_2
XFILLER_126_79 VPWR VGND sg13cmos5l_decap_8
XANTENNA__2072__GATE Tile_X0Y3_FrameStrobe[4] VPWR VGND sg13cmos5l_antennanp
XFILLER_86_39 VPWR VGND sg13cmos5l_decap_8
XANTENNA__1262__D Tile_X0Y0_FrameData[29] VPWR VGND sg13cmos5l_antennanp
XANTENNA__2495__X Tile_X0Y3_E1BEG[1] VPWR VGND sg13cmos5l_antennanp
XFILLER_142_23 VPWR VGND sg13cmos5l_fill_1
XFILLER_142_34 VPWR VGND sg13cmos5l_decap_8
XFILLER_27_142 VPWR VGND sg13cmos5l_fill_2
XFILLER_215_210 VPWR VGND sg13cmos5l_decap_8
XANTENNA__2087__GATE Tile_X0Y3_FrameStrobe[4] VPWR VGND sg13cmos5l_antennanp
XANTENNA__0682__A0 AXIL_S_SOC_ARADDR0 VPWR VGND sg13cmos5l_antennanp
XFILLER_215_276 VPWR VGND sg13cmos5l_fill_1
XANTENNA__2010__GATE Tile_X0Y3_FrameStrobe[2] VPWR VGND sg13cmos5l_antennanp
XANTENNA__2093__D Tile_X0Y3_FrameData[6] VPWR VGND sg13cmos5l_antennanp
XFILLER_187_117 VPWR VGND sg13cmos5l_decap_8
XFILLER_129_0 VPWR VGND sg13cmos5l_decap_4
XFILLER_167_64 VPWR VGND sg13cmos5l_decap_8
XANTENNA__2025__GATE Tile_X0Y3_FrameStrobe[2] VPWR VGND sg13cmos5l_antennanp
XANTENNA__0737__A1 Tile_X0Y2_W2END[3] VPWR VGND sg13cmos5l_antennanp
XANTENNA__1437__D Tile_X0Y0_FrameData[14] VPWR VGND sg13cmos5l_antennanp
XFILLER_136_294 VPWR VGND sg13cmos5l_fill_1
XANTENNA__1281__GATE Tile_X0Y3_FrameStrobe[2] VPWR VGND sg13cmos5l_antennanp
XFILLER_111_106 VPWR VGND sg13cmos5l_fill_2
XFILLER_2_263 VPWR VGND sg13cmos5l_fill_1
XFILLER_104_180 VPWR VGND sg13cmos5l_decap_8
XANTENNA__1296__GATE Tile_X0Y3_FrameStrobe[3] VPWR VGND sg13cmos5l_antennanp
X_1050_ _1051_/A _0888_/X _0553_/X Tile_X0Y3_N4END[5] Tile_X0Y0_S4END[9] _1728_/Q
+ _1729_/Q VPWR VGND sg13cmos5l_mux4_1
XANTENNA__1900__D Tile_X0Y2_FrameData[15] VPWR VGND sg13cmos5l_antennanp
XFILLER_80_218 VPWR VGND sg13cmos5l_decap_8
XFILLER_206_232 VPWR VGND sg13cmos5l_fill_1
XFILLER_18_164 VPWR VGND sg13cmos5l_fill_2
XFILLER_92_71 VPWR VGND sg13cmos5l_decap_4
XFILLER_178_106 VPWR VGND sg13cmos5l_fill_2
X_1952_ _1952_/Q Tile_X0Y3_FrameData[19] Tile_X0Y3_FrameStrobe[0] VPWR VGND sg13cmos5l_dlhq_1
XANTENNA__1234__GATE Tile_X0Y3_FrameStrobe[1] VPWR VGND sg13cmos5l_antennanp
X_1883_ _1883_/Q Tile_X0Y2_FrameData[0] Tile_X0Y3_FrameStrobe[5] VPWR VGND sg13cmos5l_dlhq_1
X_0903_ _2473_/A AXIL_S_SOC_WSTRB2 _0761_/X _0762_/X _0755_/X _1277_/Q _1276_/Q VPWR
+ VGND sg13cmos5l_mux4_1
XANTENNA__1864__GATE Tile_X0Y3_FrameStrobe[5] VPWR VGND sg13cmos5l_antennanp
XFILLER_119_239 VPWR VGND sg13cmos5l_fill_2
X_0834_ _0834_/Y _0432_/Y _0828_/S _1376_/Q VPWR VGND sg13cmos5l_a21oi_1
XANTENNA__0728__A1 Tile_X0Y3_W2END[1] VPWR VGND sg13cmos5l_antennanp
XANTENNA__1347__D Tile_X0Y0_FrameData[8] VPWR VGND sg13cmos5l_antennanp
X_0765_ _0765_/X _0760_/X _0643_/X _1418_/Q VPWR VGND sg13cmos5l_mux2_1
XANTENNA__1249__GATE Tile_X0Y3_FrameStrobe[1] VPWR VGND sg13cmos5l_antennanp
XFILLER_142_242 VPWR VGND sg13cmos5l_decap_4
X_2504_ Tile_X0Y3_E2BEG[6] _2504_/A VPWR VGND sg13cmos5l_buf_1
X_0696_ _2521_/A AXIL_S_SOC_ARADDR2 _0604_/X _0605_/X _0511_/X _2028_/Q _2029_/Q VPWR
+ VGND sg13cmos5l_mux4_1
XFILLER_44_0 VPWR VGND sg13cmos5l_fill_2
XANTENNA__1879__GATE Tile_X0Y3_FrameStrobe[5] VPWR VGND sg13cmos5l_antennanp
X_2435_ Tile_X0Y0_FrameData_O[21] Tile_X0Y0_FrameData[21] VPWR VGND sg13cmos5l_buf_1
XFILLER_102_128 VPWR VGND sg13cmos5l_decap_8
XANTENNA__2178__D Tile_X0Y3_FrameData[17] VPWR VGND sg13cmos5l_antennanp
XFILLER_110_150 VPWR VGND sg13cmos5l_decap_8
X_2366_ Tile_X0Y0_N4BEG[8] _2366_/A VPWR VGND sg13cmos5l_buf_1
XANTENNA__1802__GATE Tile_X0Y3_FrameStrobe[3] VPWR VGND sg13cmos5l_antennanp
X_1317_ _1317_/Q Tile_X0Y0_FrameData[6] Tile_X0Y3_FrameStrobe[3] VPWR VGND sg13cmos5l_dlhq_1
X_2297_ Tile_X0Y2_E6BEG[1] _2297_/A VPWR VGND sg13cmos5l_buf_1
XFILLER_56_226 VPWR VGND sg13cmos5l_decap_8
X_1248_ _1248_/Q Tile_X0Y0_FrameData[11] Tile_X0Y3_FrameStrobe[1] VPWR VGND sg13cmos5l_dlhq_1
XANTENNA__1810__D Tile_X0Y2_FrameData[9] VPWR VGND sg13cmos5l_antennanp
XANTENNA__0664__A0 AXIL_S_SOC_ARADDR2 VPWR VGND sg13cmos5l_antennanp
XANTENNA__1817__GATE Tile_X0Y3_FrameStrobe[3] VPWR VGND sg13cmos5l_antennanp
X_1179_ AXIL_S_SOC_RDATA11 Tile_X0Y2_W2MID[3] Tile_X0Y2_W2END[3] Tile_X0Y2_W6END[3]
+ _0746_/X _1765_/Q _1764_/Q VPWR VGND sg13cmos5l_mux4_1
XFILLER_137_12 VPWR VGND sg13cmos5l_fill_1
XANTENNA__1257__D Tile_X0Y0_FrameData[2] VPWR VGND sg13cmos5l_antennanp
XANTENNA__2088__D Tile_X0Y3_FrameData[11] VPWR VGND sg13cmos5l_antennanp
XFILLER_47_259 VPWR VGND sg13cmos5l_fill_2
XFILLER_47_248 VPWR VGND sg13cmos5l_decap_8
XANTENNA__1720__D Tile_X0Y2_FrameData[3] VPWR VGND sg13cmos5l_antennanp
XFILLER_62_85 VPWR VGND sg13cmos5l_fill_2
XANTENNA__0958__A1 AXIL_S_SOC_WDATA25 VPWR VGND sg13cmos5l_antennanp
XANTENNA__1080__A0 AXIL_S_SOC_WDATA4 VPWR VGND sg13cmos5l_antennanp
XFILLER_183_120 VPWR VGND sg13cmos5l_decap_8
XFILLER_109_261 VPWR VGND sg13cmos5l_decap_8
XFILLER_124_231 VPWR VGND sg13cmos5l_decap_8
X_0550_ _0551_/C _1449_/Q _0871_/X VPWR VGND sg13cmos5l_nor2_1
XFILLER_194_84 VPWR VGND sg13cmos5l_decap_8
XFILLER_97_104 VPWR VGND sg13cmos5l_decap_8
X_2220_ Tile_X0Y1_E6BEG[5] _2220_/A VPWR VGND sg13cmos5l_buf_1
X_0481_ _2588_/A Tile_X0Y2_W2MID[5] Tile_X0Y2_W2END[5] Tile_X0Y2_W6END[10] _0725_/X
+ _1891_/Q _1890_/Q VPWR VGND sg13cmos5l_mux4_1
XFILLER_87_82 VPWR VGND sg13cmos5l_decap_8
X_2151_ _2151_/Q Tile_X0Y3_FrameData[12] Tile_X0Y3_FrameStrobe[6] VPWR VGND sg13cmos5l_dlhq_1
XANTENNA__0894__A0 Tile_X0Y0_W2MID[6] VPWR VGND sg13cmos5l_antennanp
X_1102_ _2313_/A AXIL_S_SOC_WDATA5 AXIL_S_SOC_WDATA9 _1101_/X _0725_/X _1817_/Q _1816_/Q
+ VPWR VGND sg13cmos5l_mux4_1
X_2082_ _2082_/Q Tile_X0Y3_FrameData[17] Tile_X0Y3_FrameStrobe[4] VPWR VGND sg13cmos5l_dlhq_1
XFILLER_38_248 VPWR VGND sg13cmos5l_fill_2
XANTENNA__1630__D Tile_X0Y1_FrameData[5] VPWR VGND sg13cmos5l_antennanp
X_1033_ _2212_/A AXIL_S_SOC_WDATA21 AXIL_S_SOC_WDATA29 _0867_/X _0865_/X _1585_/Q
+ _1584_/Q VPWR VGND sg13cmos5l_mux4_1
XANTENNA__0543__B Tile_X0Y0_W6END[1] VPWR VGND sg13cmos5l_antennanp
XFILLER_166_109 VPWR VGND sg13cmos5l_decap_4
X_1935_ _1935_/Q Tile_X0Y2_FrameData[12] Tile_X0Y3_FrameStrobe[7] VPWR VGND sg13cmos5l_dlhq_1
X_1866_ _1866_/Q Tile_X0Y2_FrameData[17] Tile_X0Y3_FrameStrobe[5] VPWR VGND sg13cmos5l_dlhq_1
X_1797_ _1797_/Q Tile_X0Y2_FrameData[22] Tile_X0Y3_FrameStrobe[3] VPWR VGND sg13cmos5l_dlhq_1
X_0817_ _2492_/A _0770_/X AXIL_S_SOC_WVALID Tile_X0Y0_S1END[2] AXIL_S_SOC_AWVALID
+ _1366_/Q _1367_/Q VPWR VGND sg13cmos5l_mux4_1
X_0748_ _2385_/A Tile_X0Y0_W2MID[4] Tile_X0Y0_W2END[4] Tile_X0Y0_W6END[4] _0712_/X
+ _1429_/Q _1428_/Q VPWR VGND sg13cmos5l_mux4_1
XFILLER_115_253 VPWR VGND sg13cmos5l_decap_4
XANTENNA__1805__D Tile_X0Y2_FrameData[14] VPWR VGND sg13cmos5l_antennanp
X_0679_ _2532_/A AXIL_S_SOC_ARADDR1 AXIL_S_SOC_ARADDR5 _0611_/X _0584_/X _2063_/Q
+ _2062_/Q VPWR VGND sg13cmos5l_mux4_1
XANTENNA__1741__GATE Tile_X0Y3_FrameStrobe[1] VPWR VGND sg13cmos5l_antennanp
XFILLER_130_245 VPWR VGND sg13cmos5l_fill_2
XFILLER_130_278 VPWR VGND sg13cmos5l_decap_4
X_2418_ Tile_X0Y0_FrameData_O[4] Tile_X0Y0_FrameData[4] VPWR VGND sg13cmos5l_buf_1
XFILLER_123_14 VPWR VGND sg13cmos5l_fill_1
X_2349_ Tile_X0Y2_FrameData_O[25] Tile_X0Y2_FrameData[25] VPWR VGND sg13cmos5l_buf_1
XANTENNA__0885__A0 AXIL_S_SOC_WSTRB0 VPWR VGND sg13cmos5l_antennanp
XFILLER_123_36 VPWR VGND sg13cmos5l_fill_2
XFILLER_44_207 VPWR VGND sg13cmos5l_fill_2
XANTENNA__1540__D Tile_X0Y1_FrameData[31] VPWR VGND sg13cmos5l_antennanp
XANTENNA__1756__GATE Tile_X0Y3_FrameStrobe[2] VPWR VGND sg13cmos5l_antennanp
XFILLER_203_91 VPWR VGND sg13cmos5l_fill_2
XFILLER_197_245 VPWR VGND sg13cmos5l_decap_4
XFILLER_12_137 VPWR VGND sg13cmos5l_decap_8
XFILLER_157_109 VPWR VGND sg13cmos5l_fill_2
XFILLER_32_22 VPWR VGND sg13cmos5l_fill_2
XFILLER_32_44 VPWR VGND sg13cmos5l_fill_2
XFILLER_32_88 VPWR VGND sg13cmos5l_fill_1
XFILLER_148_99 VPWR VGND sg13cmos5l_decap_8
XFILLER_165_197 VPWR VGND sg13cmos5l_fill_1
XANTENNA__1715__D Tile_X0Y2_FrameData[8] VPWR VGND sg13cmos5l_antennanp
XANTENNA__1117__A1 Tile_X0Y0_S4END[9] VPWR VGND sg13cmos5l_antennanp
XANTENNA__1709__GATE Tile_X0Y3_FrameStrobe[0] VPWR VGND sg13cmos5l_antennanp
XANTENNA__2396__A Tile_X0Y3_FrameStrobe[2] VPWR VGND sg13cmos5l_antennanp
XFILLER_121_278 VPWR VGND sg13cmos5l_decap_4
XFILLER_94_118 VPWR VGND sg13cmos5l_fill_1
XFILLER_196_0 VPWR VGND sg13cmos5l_decap_8
XANTENNA__0876__A0 AXIL_S_SOC_AWADDR0 VPWR VGND sg13cmos5l_antennanp
XFILLER_35_229 VPWR VGND sg13cmos5l_decap_8
XANTENNA__1450__D Tile_X0Y1_FrameData[25] VPWR VGND sg13cmos5l_antennanp
XFILLER_73_51 VPWR VGND sg13cmos5l_decap_4
XFILLER_43_251 VPWR VGND sg13cmos5l_fill_1
XFILLER_73_95 VPWR VGND sg13cmos5l_decap_8
XFILLER_43_262 VPWR VGND sg13cmos5l_decap_4
XANTENNA__0643__A3 Tile_X0Y0_S2END[0] VPWR VGND sg13cmos5l_antennanp
XFILLER_11_170 VPWR VGND sg13cmos5l_fill_1
X_1720_ _1720_/Q Tile_X0Y2_FrameData[3] Tile_X0Y3_FrameStrobe[0] VPWR VGND sg13cmos5l_dlhq_1
XFILLER_7_130 VPWR VGND sg13cmos5l_decap_8
X_1651_ _1651_/Q Tile_X0Y1_FrameData[16] Tile_X0Y3_FrameStrobe[6] VPWR VGND sg13cmos5l_dlhq_1
X_0602_ _0602_/X Tile_X0Y3_N2MID[7] Tile_X0Y3_N2END[7] _2593_/A _0601_/X _1949_/Q
+ _1948_/Q VPWR VGND sg13cmos5l_mux4_1
XFILLER_208_58 VPWR VGND sg13cmos5l_decap_8
XFILLER_208_25 VPWR VGND sg13cmos5l_fill_1
XFILLER_112_201 VPWR VGND sg13cmos5l_fill_1
X_1582_ _1582_/Q Tile_X0Y1_FrameData[21] Tile_X0Y3_FrameStrobe[4] VPWR VGND sg13cmos5l_dlhq_1
XFILLER_208_69 VPWR VGND sg13cmos5l_fill_2
XANTENNA__1625__D Tile_X0Y1_FrameData[10] VPWR VGND sg13cmos5l_antennanp
X_0533_ _0533_/Y _1698_/Q _0533_/B _0533_/C VPWR VGND sg13cmos5l_nor3_1
XFILLER_98_92 VPWR VGND sg13cmos5l_decap_8
X_0464_ _0466_/B Tile_X0Y0_W1END[2] Tile_X0Y0_W6END[10] _0463_/A _0461_/Y _1403_/Q
+ _1402_/Q VPWR VGND sg13cmos5l_mux4_1
X_2203_ Tile_X0Y1_E2BEG[4] _2203_/A VPWR VGND sg13cmos5l_buf_1
X_2134_ _2134_/Q Tile_X0Y3_FrameData[29] Tile_X0Y3_FrameStrobe[6] VPWR VGND sg13cmos5l_dlhq_1
XANTENNA__1360__D Tile_X0Y0_FrameData[27] VPWR VGND sg13cmos5l_antennanp
XANTENNA__2593__X Tile_X0Y3_S2BEGb[7] VPWR VGND sg13cmos5l_antennanp
X_2065_ _2065_/Q Tile_X0Y3_FrameData[2] Tile_X0Y3_FrameStrobe[3] VPWR VGND sg13cmos5l_dlhq_1
X_1016_ AXIL_S_SOC_RDATA31 Tile_X0Y1_W1END[3] Tile_X0Y1_W6END[11] Tile_X0Y1_WW4END[12]
+ _0498_/X _1500_/Q _1501_/Q VPWR VGND sg13cmos5l_mux4_1
XANTENNA__1002__X AXIL_S_SOC_RDATA23 VPWR VGND sg13cmos5l_antennanp
XFILLER_179_278 VPWR VGND sg13cmos5l_decap_4
XANTENNA__2191__D Tile_X0Y3_FrameData[4] VPWR VGND sg13cmos5l_antennanp
XFILLER_147_131 VPWR VGND sg13cmos5l_decap_8
XFILLER_147_153 VPWR VGND sg13cmos5l_decap_8
X_1918_ _1918_/Q Tile_X0Y2_FrameData[29] Tile_X0Y3_FrameStrobe[7] VPWR VGND sg13cmos5l_dlhq_1
X_1849_ _1849_/Q Tile_X0Y2_FrameData[2] Tile_X0Y3_FrameStrobe[4] VPWR VGND sg13cmos5l_dlhq_1
XFILLER_162_167 VPWR VGND sg13cmos5l_decap_4
XANTENNA__1535__D Tile_X0Y1_FrameData[4] VPWR VGND sg13cmos5l_antennanp
XANTENNA__1680__GATE Tile_X0Y3_FrameStrobe[7] VPWR VGND sg13cmos5l_antennanp
XANTENNA__0858__A0 Tile_X0Y2_W1END[3] VPWR VGND sg13cmos5l_antennanp
XFILLER_27_11 VPWR VGND sg13cmos5l_fill_2
XANTENNA__1695__GATE Tile_X0Y3_FrameStrobe[0] VPWR VGND sg13cmos5l_antennanp
XFILLER_27_33 VPWR VGND sg13cmos5l_decap_8
XFILLER_217_124 VPWR VGND sg13cmos5l_fill_2
XANTENNA__1270__D Tile_X0Y0_FrameData[21] VPWR VGND sg13cmos5l_antennanp
XFILLER_217_179 VPWR VGND sg13cmos5l_fill_1
XFILLER_40_210 VPWR VGND sg13cmos5l_fill_1
XANTENNA__1035__A0 AXIL_S_SOC_WDATA18 VPWR VGND sg13cmos5l_antennanp
XANTENNA__1633__GATE Tile_X0Y3_FrameStrobe[5] VPWR VGND sg13cmos5l_antennanp
XFILLER_138_153 VPWR VGND sg13cmos5l_fill_1
XANTENNA__1050__A3 Tile_X0Y0_S4END[9] VPWR VGND sg13cmos5l_antennanp
XFILLER_111_0 VPWR VGND sg13cmos5l_fill_2
XFILLER_4_111 VPWR VGND sg13cmos5l_fill_1
XFILLER_209_0 VPWR VGND sg13cmos5l_fill_2
XFILLER_175_53 VPWR VGND sg13cmos5l_decap_8
XANTENNA__1445__D Tile_X0Y1_FrameData[30] VPWR VGND sg13cmos5l_antennanp
XANTENNA__1648__GATE Tile_X0Y3_FrameStrobe[6] VPWR VGND sg13cmos5l_antennanp
XFILLER_191_74 VPWR VGND sg13cmos5l_decap_8
XANTENNA__0849__A0 AXIL_S_SOC_WSTRB2 VPWR VGND sg13cmos5l_antennanp
XFILLER_75_140 VPWR VGND sg13cmos5l_decap_8
XANTENNA__0864__A3 Tile_X0Y0_S2MID[1] VPWR VGND sg13cmos5l_antennanp
XFILLER_208_168 VPWR VGND sg13cmos5l_decap_8
XFILLER_90_143 VPWR VGND sg13cmos5l_decap_8
XFILLER_223_149 VPWR VGND sg13cmos5l_decap_4
XFILLER_16_262 VPWR VGND sg13cmos5l_decap_8
XFILLER_216_190 VPWR VGND sg13cmos5l_decap_8
XANTENNA__0616__A3 Tile_X0Y0_S4END[13] VPWR VGND sg13cmos5l_antennanp
XFILLER_31_221 VPWR VGND sg13cmos5l_decap_8
XANTENNA__1026__A0 Tile_X0Y3_N4END[9] VPWR VGND sg13cmos5l_antennanp
XFILLER_129_120 VPWR VGND sg13cmos5l_decap_8
XFILLER_176_259 VPWR VGND sg13cmos5l_fill_1
X_1703_ _1703_/Q Tile_X0Y2_FrameData[20] Tile_X0Y3_FrameStrobe[0] VPWR VGND sg13cmos5l_dlhq_1
XFILLER_219_46 VPWR VGND sg13cmos5l_fill_2
XANTENNA__1041__A3 Tile_X0Y0_S4END[9] VPWR VGND sg13cmos5l_antennanp
XFILLER_144_178 VPWR VGND sg13cmos5l_decap_4
X_1634_ _1634_/Q Tile_X0Y1_FrameData[1] Tile_X0Y3_FrameStrobe[5] VPWR VGND sg13cmos5l_dlhq_1
XANTENNA__1355__D Tile_X0Y0_FrameData[0] VPWR VGND sg13cmos5l_antennanp
XANTENNA__2588__X Tile_X0Y3_S2BEGb[2] VPWR VGND sg13cmos5l_antennanp
X_1565_ _1565_/Q Tile_X0Y1_FrameData[6] Tile_X0Y3_FrameStrobe[3] VPWR VGND sg13cmos5l_dlhq_1
XFILLER_98_232 VPWR VGND sg13cmos5l_decap_4
X_0516_ _0516_/Y _1202_/Q Tile_X0Y0_W6END[0] VPWR VGND sg13cmos5l_nand2b_1
XFILLER_98_265 VPWR VGND sg13cmos5l_decap_8
XANTENNA__0549__A Tile_X0Y1_W6END[1] VPWR VGND sg13cmos5l_antennanp
X_1496_ _1496_/Q Tile_X0Y1_FrameData[11] Tile_X0Y3_FrameStrobe[1] VPWR VGND sg13cmos5l_dlhq_1
X_0447_ _0447_/Y Tile_X0Y1_W6END[6] VPWR VGND sg13cmos5l_inv_1
XANTENNA__2186__D Tile_X0Y3_FrameData[9] VPWR VGND sg13cmos5l_antennanp
X_2117_ _2117_/Q Tile_X0Y3_FrameData[14] Tile_X0Y3_FrameStrobe[5] VPWR VGND sg13cmos5l_dlhq_1
X_2048_ _2048_/Q Tile_X0Y3_FrameData[19] Tile_X0Y3_FrameStrobe[3] VPWR VGND sg13cmos5l_dlhq_1
XFILLER_81_165 VPWR VGND sg13cmos5l_decap_8
XFILLER_81_198 VPWR VGND sg13cmos5l_decap_8
XANTENNA__0607__A3 Tile_X0Y0_S4END[12] VPWR VGND sg13cmos5l_antennanp
XFILLER_80_19 VPWR VGND sg13cmos5l_decap_8
XFILLER_22_265 VPWR VGND sg13cmos5l_decap_8
XANTENNA__1017__A0 AXIL_S_SOC_WDATA16 VPWR VGND sg13cmos5l_antennanp
XFILLER_13_35 VPWR VGND sg13cmos5l_decap_8
XANTENNA__1265__D Tile_X0Y0_FrameData[26] VPWR VGND sg13cmos5l_antennanp
XANTENNA__2498__X Tile_X0Y3_E2BEG[0] VPWR VGND sg13cmos5l_antennanp
XFILLER_1_158 VPWR VGND sg13cmos5l_fill_2
XFILLER_161_22 VPWR VGND sg13cmos5l_decap_8
XANTENNA__2096__D Tile_X0Y3_FrameData[3] VPWR VGND sg13cmos5l_antennanp
XFILLER_161_77 VPWR VGND sg13cmos5l_fill_1
XFILLER_54_20 VPWR VGND sg13cmos5l_fill_1
XFILLER_159_0 VPWR VGND sg13cmos5l_fill_2
XFILLER_158_204 VPWR VGND sg13cmos5l_decap_4
XFILLER_110_70 VPWR VGND sg13cmos5l_decap_4
XFILLER_158_237 VPWR VGND sg13cmos5l_fill_2
XANTENNA__1008__A0 Tile_X0Y1_W2MID[1] VPWR VGND sg13cmos5l_antennanp
XANTENNA__1572__GATE Tile_X0Y3_FrameStrobe[4] VPWR VGND sg13cmos5l_antennanp
XFILLER_9_247 VPWR VGND sg13cmos5l_decap_8
XFILLER_173_229 VPWR VGND sg13cmos5l_decap_8
XFILLER_186_96 VPWR VGND sg13cmos5l_decap_4
XANTENNA__1587__GATE Tile_X0Y3_FrameStrobe[4] VPWR VGND sg13cmos5l_antennanp
XFILLER_141_115 VPWR VGND sg13cmos5l_decap_8
XANTENNA__2201__X Tile_X0Y1_E2BEG[2] VPWR VGND sg13cmos5l_antennanp
X_1350_ _1350_/Q Tile_X0Y0_FrameData[5] Tile_X0Y3_FrameStrobe[4] VPWR VGND sg13cmos5l_dlhq_1
XANTENNA__1510__GATE Tile_X0Y3_FrameStrobe[2] VPWR VGND sg13cmos5l_antennanp
XANTENNA__1903__D Tile_X0Y2_FrameData[12] VPWR VGND sg13cmos5l_antennanp
X_1281_ _1281_/Q Tile_X0Y0_FrameData[10] Tile_X0Y3_FrameStrobe[2] VPWR VGND sg13cmos5l_dlhq_1
XFILLER_95_93 VPWR VGND sg13cmos5l_decap_4
XFILLER_48_151 VPWR VGND sg13cmos5l_decap_8
XFILLER_63_110 VPWR VGND sg13cmos5l_decap_4
XFILLER_221_14 VPWR VGND sg13cmos5l_decap_8
XANTENNA__1525__GATE Tile_X0Y3_FrameStrobe[2] VPWR VGND sg13cmos5l_antennanp
XFILLER_63_198 VPWR VGND sg13cmos5l_fill_1
XANTENNA__0470__A1 Tile_X0Y1_W6END[10] VPWR VGND sg13cmos5l_antennanp
X_0996_ _2218_/A Tile_X0Y3_N4END[11] _0914_/A Tile_X0Y0_S4END[7] _0522_/X _1540_/Q
+ _1541_/Q VPWR VGND sg13cmos5l_mux4_1
XFILLER_74_0 VPWR VGND sg13cmos5l_fill_2
XFILLER_8_280 VPWR VGND sg13cmos5l_fill_2
XFILLER_132_126 VPWR VGND sg13cmos5l_fill_2
X_1617_ _1617_/Q Tile_X0Y1_FrameData[18] Tile_X0Y3_FrameStrobe[5] VPWR VGND sg13cmos5l_dlhq_1
X_2597_ Tile_X0Y3_S4BEG[3] _2597_/A VPWR VGND sg13cmos5l_buf_1
X_1548_ _1548_/Q Tile_X0Y1_FrameData[23] Tile_X0Y3_FrameStrobe[3] VPWR VGND sg13cmos5l_dlhq_1
XANTENNA__1813__D Tile_X0Y2_FrameData[6] VPWR VGND sg13cmos5l_antennanp
X_1479_ _1479_/Q Tile_X0Y1_FrameData[28] Tile_X0Y3_FrameStrobe[1] VPWR VGND sg13cmos5l_dlhq_1
XFILLER_86_257 VPWR VGND sg13cmos5l_decap_4
XFILLER_131_14 VPWR VGND sg13cmos5l_decap_4
XFILLER_131_25 VPWR VGND sg13cmos5l_decap_8
XFILLER_94_290 VPWR VGND sg13cmos5l_decap_4
XFILLER_131_58 VPWR VGND sg13cmos5l_decap_8
XFILLER_24_78 VPWR VGND sg13cmos5l_decap_8
XFILLER_210_163 VPWR VGND sg13cmos5l_fill_1
XFILLER_210_152 VPWR VGND sg13cmos5l_decap_8
XFILLER_155_207 VPWR VGND sg13cmos5l_fill_2
XFILLER_6_217 VPWR VGND sg13cmos5l_decap_8
XFILLER_108_134 VPWR VGND sg13cmos5l_fill_2
XFILLER_10_279 VPWR VGND sg13cmos5l_fill_1
XFILLER_148_270 VPWR VGND sg13cmos5l_decap_8
XFILLER_156_44 VPWR VGND sg13cmos5l_fill_1
XFILLER_123_148 VPWR VGND sg13cmos5l_fill_1
XANTENNA__1723__D Tile_X0Y2_FrameData[0] VPWR VGND sg13cmos5l_antennanp
XFILLER_65_30 VPWR VGND sg13cmos5l_decap_8
XFILLER_218_241 VPWR VGND sg13cmos5l_decap_8
XANTENNA__0819__A3 AXIL_S_SOC_AWADDR1 VPWR VGND sg13cmos5l_antennanp
XFILLER_218_285 VPWR VGND sg13cmos5l_fill_2
XFILLER_121_91 VPWR VGND sg13cmos5l_fill_1
XFILLER_198_181 VPWR VGND sg13cmos5l_decap_4
XFILLER_198_170 VPWR VGND sg13cmos5l_decap_8
X_0850_ _2451_/A AXIL_S_SOC_AWVALID AXIL_S_SOC_AWADDR3 _0784_/X _0653_/X _1321_/Q
+ _1320_/Q VPWR VGND sg13cmos5l_mux4_1
X_0781_ _0781_/X Tile_X0Y0_W6END[9] _0542_/X _1414_/Q VPWR VGND sg13cmos5l_mux2_1
X_2520_ Tile_X0Y3_E6BEG[6] _2520_/A VPWR VGND sg13cmos5l_buf_1
XANTENNA__0755__A2 Tile_X0Y0_S2MID[7] VPWR VGND sg13cmos5l_antennanp
X_2451_ Tile_X0Y0_EE4BEG[5] _2451_/A VPWR VGND sg13cmos5l_buf_1
X_1402_ _1402_/Q Tile_X0Y0_FrameData[17] Tile_X0Y3_FrameStrobe[6] VPWR VGND sg13cmos5l_dlhq_1
XFILLER_216_25 VPWR VGND sg13cmos5l_fill_1
X_2382_ Tile_X0Y0_N2BEG[0] _2382_/A VPWR VGND sg13cmos5l_buf_1
XANTENNA__1633__D Tile_X0Y1_FrameData[2] VPWR VGND sg13cmos5l_antennanp
X_1333_ _1333_/Q Tile_X0Y0_FrameData[22] Tile_X0Y3_FrameStrobe[4] VPWR VGND sg13cmos5l_dlhq_1
XANTENNA__1180__A2 Tile_X0Y2_W6END[2] VPWR VGND sg13cmos5l_antennanp
X_1264_ _1264_/Q Tile_X0Y0_FrameData[27] Tile_X0Y3_FrameStrobe[2] VPWR VGND sg13cmos5l_dlhq_1
XANTENNA__1464__GATE Tile_X0Y3_FrameStrobe[0] VPWR VGND sg13cmos5l_antennanp
X_1195_ AXIL_S_SOC_RDATA17 Tile_X0Y2_W1END[1] Tile_X0Y2_W6END[9] Tile_X0Y2_WW4END[14]
+ _0559_/X _1752_/Q _1753_/Q VPWR VGND sg13cmos5l_mux4_1
XFILLER_76_290 VPWR VGND sg13cmos5l_decap_4
XANTENNA__0691__A1 Tile_X0Y0_S4END[14] VPWR VGND sg13cmos5l_antennanp
XANTENNA__1479__GATE Tile_X0Y3_FrameStrobe[1] VPWR VGND sg13cmos5l_antennanp
XFILLER_196_118 VPWR VGND sg13cmos5l_decap_8
XANTENNA__1010__X AXIL_S_SOC_RDATA28 VPWR VGND sg13cmos5l_antennanp
XANTENNA__1402__GATE Tile_X0Y3_FrameStrobe[6] VPWR VGND sg13cmos5l_antennanp
XFILLER_137_229 VPWR VGND sg13cmos5l_decap_8
XANTENNA__1808__D Tile_X0Y2_FrameData[11] VPWR VGND sg13cmos5l_antennanp
X_0979_ _0979_/Y _0447_/Y _0977_/S _0455_/Y VPWR VGND sg13cmos5l_a21oi_1
XANTENNA__0746__A2 Tile_X0Y3_N2MID[3] VPWR VGND sg13cmos5l_antennanp
XFILLER_145_273 VPWR VGND sg13cmos5l_fill_2
XANTENNA__1417__GATE Tile_X0Y3_FrameStrobe[6] VPWR VGND sg13cmos5l_antennanp
XFILLER_10_47 VPWR VGND sg13cmos5l_fill_1
XFILLER_120_118 VPWR VGND sg13cmos5l_decap_8
XFILLER_126_58 VPWR VGND sg13cmos5l_decap_8
XANTENNA__1543__D Tile_X0Y1_FrameData[28] VPWR VGND sg13cmos5l_antennanp
XFILLER_113_192 VPWR VGND sg13cmos5l_decap_8
XFILLER_59_224 VPWR VGND sg13cmos5l_fill_2
XFILLER_222_90 VPWR VGND sg13cmos5l_decap_8
XFILLER_215_244 VPWR VGND sg13cmos5l_decap_8
XANTENNA__0682__A1 AXIL_S_SOC_ARADDR4 VPWR VGND sg13cmos5l_antennanp
XFILLER_82_293 VPWR VGND sg13cmos5l_fill_2
XFILLER_42_113 VPWR VGND sg13cmos5l_decap_8
XFILLER_51_21 VPWR VGND sg13cmos5l_decap_4
XFILLER_136_2 VPWR VGND sg13cmos5l_fill_1
XFILLER_195_162 VPWR VGND sg13cmos5l_fill_2
XANTENNA__1718__D Tile_X0Y2_FrameData[5] VPWR VGND sg13cmos5l_antennanp
XFILLER_167_43 VPWR VGND sg13cmos5l_fill_2
XFILLER_167_87 VPWR VGND sg13cmos5l_decap_8
XANTENNA__0737__A2 Tile_X0Y2_W6END[3] VPWR VGND sg13cmos5l_antennanp
XANTENNA__2399__A Tile_X0Y3_FrameStrobe[5] VPWR VGND sg13cmos5l_antennanp
XFILLER_4_0 VPWR VGND sg13cmos5l_fill_2
XFILLER_151_265 VPWR VGND sg13cmos5l_decap_8
XANTENNA__1453__D Tile_X0Y1_FrameData[22] VPWR VGND sg13cmos5l_antennanp
XFILLER_116_91 VPWR VGND sg13cmos5l_decap_8
XFILLER_76_51 VPWR VGND sg13cmos5l_decap_8
XFILLER_65_216 VPWR VGND sg13cmos5l_decap_8
XANTENNA__2194__GATE Tile_X0Y3_FrameStrobe[7] VPWR VGND sg13cmos5l_antennanp
XFILLER_18_143 VPWR VGND sg13cmos5l_decap_8
XFILLER_202_49 VPWR VGND sg13cmos5l_decap_8
XFILLER_202_27 VPWR VGND sg13cmos5l_decap_4
XFILLER_92_50 VPWR VGND sg13cmos5l_decap_8
XFILLER_73_293 VPWR VGND sg13cmos5l_fill_2
XFILLER_92_94 VPWR VGND sg13cmos5l_fill_2
XFILLER_33_179 VPWR VGND sg13cmos5l_fill_2
XFILLER_221_247 VPWR VGND sg13cmos5l_fill_2
X_1951_ _1951_/Q Tile_X0Y3_FrameData[20] Tile_X0Y3_FrameStrobe[0] VPWR VGND sg13cmos5l_dlhq_1
XFILLER_119_207 VPWR VGND sg13cmos5l_fill_1
X_1882_ _1882_/Q Tile_X0Y2_FrameData[1] Tile_X0Y3_FrameStrobe[5] VPWR VGND sg13cmos5l_dlhq_1
X_0902_ AXIL_S_SOC_RVALID Tile_X0Y0_W2MID[3] Tile_X0Y0_W2END[3] Tile_X0Y0_W6END[3]
+ _0712_/X _1269_/Q _1268_/Q VPWR VGND sg13cmos5l_mux4_1
XANTENNA__1628__D Tile_X0Y1_FrameData[7] VPWR VGND sg13cmos5l_antennanp
XANTENNA__2132__GATE Tile_X0Y3_FrameStrobe[6] VPWR VGND sg13cmos5l_antennanp
X_0833_ _0836_/B _1375_/Q _0463_/Y _0832_/Y VPWR VGND sg13cmos5l_a21oi_1
XANTENNA__0728__A2 Tile_X0Y3_W6END[1] VPWR VGND sg13cmos5l_antennanp
XFILLER_127_273 VPWR VGND sg13cmos5l_decap_8
XFILLER_142_210 VPWR VGND sg13cmos5l_decap_8
X_2503_ Tile_X0Y3_E2BEG[5] _2503_/A VPWR VGND sg13cmos5l_buf_1
X_0764_ _0764_/Y _1418_/Q _0762_/X _0763_/Y VPWR VGND sg13cmos5l_o21ai_1
X_0695_ _2520_/A AXIL_S_SOC_ARADDR1 _0610_/X _0611_/X _0483_/X _2031_/Q _2030_/Q VPWR
+ VGND sg13cmos5l_mux4_1
XANTENNA__0572__B_N Tile_X0Y3_N1END[3] VPWR VGND sg13cmos5l_antennanp
XANTENNA__2147__GATE Tile_X0Y3_FrameStrobe[6] VPWR VGND sg13cmos5l_antennanp
XFILLER_142_265 VPWR VGND sg13cmos5l_decap_8
X_2434_ Tile_X0Y0_FrameData_O[20] Tile_X0Y0_FrameData[20] VPWR VGND sg13cmos5l_buf_1
XANTENNA__1363__D Tile_X0Y0_FrameData[24] VPWR VGND sg13cmos5l_antennanp
XANTENNA__2596__X Tile_X0Y3_S4BEG[2] VPWR VGND sg13cmos5l_antennanp
X_2365_ Tile_X0Y0_N4BEG[7] _2365_/A VPWR VGND sg13cmos5l_buf_1
XFILLER_37_0 VPWR VGND sg13cmos5l_fill_2
X_1316_ _1316_/Q Tile_X0Y0_FrameData[7] Tile_X0Y3_FrameStrobe[3] VPWR VGND sg13cmos5l_dlhq_1
X_2296_ Tile_X0Y2_E6BEG[0] _2296_/A VPWR VGND sg13cmos5l_buf_1
XFILLER_110_195 VPWR VGND sg13cmos5l_fill_2
X_1247_ _1247_/Q Tile_X0Y0_FrameData[12] Tile_X0Y3_FrameStrobe[1] VPWR VGND sg13cmos5l_dlhq_1
XFILLER_112_38 VPWR VGND sg13cmos5l_fill_2
X_1178_ _2306_/A AXIL_S_SOC_WDATA2 _1042_/A _1049_/X _0729_/X _1775_/Q _1774_/Q VPWR
+ VGND sg13cmos5l_mux4_1
XFILLER_71_219 VPWR VGND sg13cmos5l_decap_8
XFILLER_64_260 VPWR VGND sg13cmos5l_fill_2
XANTENNA__0664__A1 AXIL_S_SOC_BREADY VPWR VGND sg13cmos5l_antennanp
XANTENNA__2194__D Tile_X0Y3_FrameData[7] VPWR VGND sg13cmos5l_antennanp
XFILLER_169_118 VPWR VGND sg13cmos5l_fill_1
XFILLER_24_168 VPWR VGND sg13cmos5l_decap_4
XANTENNA__1341__GATE Tile_X0Y3_FrameStrobe[4] VPWR VGND sg13cmos5l_antennanp
XANTENNA__1971__GATE Tile_X0Y3_FrameStrobe[0] VPWR VGND sg13cmos5l_antennanp
XFILLER_177_162 VPWR VGND sg13cmos5l_fill_1
XFILLER_177_151 VPWR VGND sg13cmos5l_decap_8
XANTENNA__1538__D Tile_X0Y1_FrameData[1] VPWR VGND sg13cmos5l_antennanp
XANTENNA__0719__A2 Tile_X0Y3_N2MID[0] VPWR VGND sg13cmos5l_antennanp
XANTENNA__1356__GATE Tile_X0Y3_FrameStrobe[5] VPWR VGND sg13cmos5l_antennanp
XFILLER_133_210 VPWR VGND sg13cmos5l_decap_8
XANTENNA__1986__GATE Tile_X0Y3_FrameStrobe[1] VPWR VGND sg13cmos5l_antennanp
XFILLER_137_79 VPWR VGND sg13cmos5l_decap_8
XANTENNA__1273__D Tile_X0Y0_FrameData[18] VPWR VGND sg13cmos5l_antennanp
XFILLER_153_67 VPWR VGND sg13cmos5l_decap_8
XFILLER_47_216 VPWR VGND sg13cmos5l_decap_8
XANTENNA__1924__GATE Tile_X0Y3_FrameStrobe[7] VPWR VGND sg13cmos5l_antennanp
XFILLER_55_293 VPWR VGND sg13cmos5l_fill_2
XFILLER_203_203 VPWR VGND sg13cmos5l_fill_2
XFILLER_102_71 VPWR VGND sg13cmos5l_decap_4
XFILLER_102_82 VPWR VGND sg13cmos5l_fill_1
XFILLER_15_168 VPWR VGND sg13cmos5l_decap_8
XFILLER_62_20 VPWR VGND sg13cmos5l_fill_1
XANTENNA__1309__GATE Tile_X0Y3_FrameStrobe[3] VPWR VGND sg13cmos5l_antennanp
XFILLER_141_0 VPWR VGND sg13cmos5l_fill_2
XFILLER_15_179 VPWR VGND sg13cmos5l_fill_1
XFILLER_62_64 VPWR VGND sg13cmos5l_decap_8
XFILLER_30_127 VPWR VGND sg13cmos5l_fill_2
XFILLER_178_31 VPWR VGND sg13cmos5l_decap_4
XANTENNA__1939__GATE Tile_X0Y3_FrameStrobe[7] VPWR VGND sg13cmos5l_antennanp
XANTENNA__1080__A1 AXIL_S_SOC_WDATA12 VPWR VGND sg13cmos5l_antennanp
XFILLER_7_15 VPWR VGND sg13cmos5l_fill_2
XANTENNA__1448__D Tile_X0Y1_FrameData[27] VPWR VGND sg13cmos5l_antennanp
XFILLER_109_273 VPWR VGND sg13cmos5l_decap_4
XFILLER_124_210 VPWR VGND sg13cmos5l_decap_8
XFILLER_194_63 VPWR VGND sg13cmos5l_decap_8
XANTENNA__0591__A0 Tile_X0Y3_W1END[0] VPWR VGND sg13cmos5l_antennanp
X_0480_ _0480_/X Tile_X0Y3_N1END[2] Tile_X0Y3_N4END[2] _0569_/B Tile_X0Y0_S4END[14]
+ _1967_/Q _1966_/Q VPWR VGND sg13cmos5l_mux4_1
X_2150_ _2150_/Q Tile_X0Y3_FrameData[13] Tile_X0Y3_FrameStrobe[6] VPWR VGND sg13cmos5l_dlhq_1
XFILLER_213_15 VPWR VGND sg13cmos5l_fill_2
XANTENNA__0894__A1 Tile_X0Y0_W2END[6] VPWR VGND sg13cmos5l_antennanp
XANTENNA__1911__D Tile_X0Y2_FrameData[4] VPWR VGND sg13cmos5l_antennanp
X_1101_ _1101_/X _0936_/X _0470_/X Tile_X0Y3_N4END[6] Tile_X0Y0_S4END[10] _1726_/Q
+ _1727_/Q VPWR VGND sg13cmos5l_mux4_1
X_2081_ _2081_/Q Tile_X0Y3_FrameData[18] Tile_X0Y3_FrameStrobe[4] VPWR VGND sg13cmos5l_dlhq_1
X_1032_ _2211_/A AXIL_S_SOC_WDATA20 AXIL_S_SOC_WDATA28 _0868_/X _0869_/X _1587_/Q
+ _1586_/Q VPWR VGND sg13cmos5l_mux4_1
XFILLER_53_219 VPWR VGND sg13cmos5l_decap_8
XFILLER_46_282 VPWR VGND sg13cmos5l_fill_1
XFILLER_61_263 VPWR VGND sg13cmos5l_decap_8
XFILLER_159_140 VPWR VGND sg13cmos5l_decap_4
X_1934_ _1934_/Q Tile_X0Y2_FrameData[13] Tile_X0Y3_FrameStrobe[7] VPWR VGND sg13cmos5l_dlhq_1
XANTENNA__0949__A2 Tile_X0Y3_N4END[11] VPWR VGND sg13cmos5l_antennanp
XANTENNA__2071__GATE Tile_X0Y3_FrameStrobe[4] VPWR VGND sg13cmos5l_antennanp
XFILLER_159_184 VPWR VGND sg13cmos5l_decap_8
XFILLER_202_280 VPWR VGND sg13cmos5l_decap_4
XANTENNA__1358__D Tile_X0Y0_FrameData[29] VPWR VGND sg13cmos5l_antennanp
X_1865_ _1865_/Q Tile_X0Y2_FrameData[18] Tile_X0Y3_FrameStrobe[5] VPWR VGND sg13cmos5l_dlhq_1
X_1796_ _1796_/Q Tile_X0Y2_FrameData[23] Tile_X0Y3_FrameStrobe[3] VPWR VGND sg13cmos5l_dlhq_1
X_0816_ _2493_/A _0771_/X AXIL_S_SOC_WSTRB0 Tile_X0Y0_S1END[3] AXIL_S_SOC_WSTRB3 _1364_/Q
+ _1365_/Q VPWR VGND sg13cmos5l_mux4_1
XANTENNA__2086__GATE Tile_X0Y3_FrameStrobe[4] VPWR VGND sg13cmos5l_antennanp
X_0747_ _2388_/A Tile_X0Y0_W2MID[1] Tile_X0Y0_W2END[1] Tile_X0Y0_W6END[1] _0751_/X
+ _1423_/Q _1422_/Q VPWR VGND sg13cmos5l_mux4_1
XANTENNA__0582__A0 Tile_X0Y1_W2MID[6] VPWR VGND sg13cmos5l_antennanp
XANTENNA__2189__D Tile_X0Y3_FrameData[2] VPWR VGND sg13cmos5l_antennanp
XFILLER_130_224 VPWR VGND sg13cmos5l_decap_4
X_2417_ Tile_X0Y0_FrameData_O[3] Tile_X0Y0_FrameData[3] VPWR VGND sg13cmos5l_buf_1
X_0678_ _2531_/A AXIL_S_SOC_ARADDR0 AXIL_S_SOC_ARADDR4 _0479_/X _0483_/X _2065_/Q
+ _2064_/Q VPWR VGND sg13cmos5l_mux4_1
XFILLER_88_138 VPWR VGND sg13cmos5l_fill_1
XFILLER_88_127 VPWR VGND sg13cmos5l_fill_1
XFILLER_88_116 VPWR VGND sg13cmos5l_decap_8
X_2348_ Tile_X0Y2_FrameData_O[24] Tile_X0Y2_FrameData[24] VPWR VGND sg13cmos5l_buf_1
XFILLER_29_216 VPWR VGND sg13cmos5l_decap_4
XANTENNA__0885__A1 AXIL_S_SOC_AWADDR7 VPWR VGND sg13cmos5l_antennanp
XANTENNA__1821__D Tile_X0Y2_FrameData[30] VPWR VGND sg13cmos5l_antennanp
XFILLER_123_59 VPWR VGND sg13cmos5l_fill_1
X_2279_ Tile_X0Y2_E1BEG[3] _2279_/A VPWR VGND sg13cmos5l_buf_1
XFILLER_177_9 VPWR VGND sg13cmos5l_decap_8
XANTENNA__2024__GATE Tile_X0Y3_FrameStrobe[2] VPWR VGND sg13cmos5l_antennanp
XFILLER_37_293 VPWR VGND sg13cmos5l_fill_2
XFILLER_37_282 VPWR VGND sg13cmos5l_decap_8
XFILLER_52_252 VPWR VGND sg13cmos5l_decap_8
XANTENNA__1280__GATE Tile_X0Y3_FrameStrobe[2] VPWR VGND sg13cmos5l_antennanp
XFILLER_197_224 VPWR VGND sg13cmos5l_decap_8
XANTENNA__2039__GATE Tile_X0Y3_FrameStrobe[3] VPWR VGND sg13cmos5l_antennanp
XFILLER_32_56 VPWR VGND sg13cmos5l_decap_8
XANTENNA__1268__D Tile_X0Y0_FrameData[23] VPWR VGND sg13cmos5l_antennanp
XANTENNA__1295__GATE Tile_X0Y3_FrameStrobe[3] VPWR VGND sg13cmos5l_antennanp
XFILLER_32_67 VPWR VGND sg13cmos5l_fill_2
XFILLER_113_4 VPWR VGND sg13cmos5l_fill_1
XFILLER_106_210 VPWR VGND sg13cmos5l_decap_4
XANTENNA__2099__D Tile_X0Y3_FrameData[0] VPWR VGND sg13cmos5l_antennanp
XFILLER_164_55 VPWR VGND sg13cmos5l_decap_8
XFILLER_164_66 VPWR VGND sg13cmos5l_fill_1
XFILLER_121_257 VPWR VGND sg13cmos5l_decap_4
XFILLER_57_53 VPWR VGND sg13cmos5l_decap_8
XFILLER_57_31 VPWR VGND sg13cmos5l_fill_2
XANTENNA__1233__GATE Tile_X0Y3_FrameStrobe[1] VPWR VGND sg13cmos5l_antennanp
XANTENNA__1731__D Tile_X0Y2_FrameData[24] VPWR VGND sg13cmos5l_antennanp
XFILLER_189_0 VPWR VGND sg13cmos5l_fill_2
XANTENNA__1863__GATE Tile_X0Y3_FrameStrobe[5] VPWR VGND sg13cmos5l_antennanp
XFILLER_35_208 VPWR VGND sg13cmos5l_decap_8
XFILLER_180_76 VPWR VGND sg13cmos5l_fill_1
XFILLER_28_293 VPWR VGND sg13cmos5l_fill_2
XANTENNA__0628__A1 Tile_X0Y3_W6END[0] VPWR VGND sg13cmos5l_antennanp
XANTENNA__1248__GATE Tile_X0Y3_FrameStrobe[1] VPWR VGND sg13cmos5l_antennanp
XFILLER_73_74 VPWR VGND sg13cmos5l_decap_8
XFILLER_43_241 VPWR VGND sg13cmos5l_decap_4
XFILLER_189_30 VPWR VGND sg13cmos5l_decap_8
XFILLER_188_213 VPWR VGND sg13cmos5l_decap_8
XANTENNA__1878__GATE Tile_X0Y3_FrameStrobe[5] VPWR VGND sg13cmos5l_antennanp
XFILLER_189_96 VPWR VGND sg13cmos5l_fill_2
XFILLER_188_257 VPWR VGND sg13cmos5l_decap_8
XFILLER_85_8 VPWR VGND sg13cmos5l_decap_8
XANTENNA__1801__GATE Tile_X0Y3_FrameStrobe[3] VPWR VGND sg13cmos5l_antennanp
XFILLER_11_182 VPWR VGND sg13cmos5l_fill_1
XFILLER_156_132 VPWR VGND sg13cmos5l_decap_8
XFILLER_156_143 VPWR VGND sg13cmos5l_fill_2
XANTENNA__2204__X Tile_X0Y1_E2BEG[5] VPWR VGND sg13cmos5l_antennanp
X_1650_ _1650_/Q Tile_X0Y1_FrameData[17] Tile_X0Y3_FrameStrobe[6] VPWR VGND sg13cmos5l_dlhq_1
XANTENNA__1906__D Tile_X0Y2_FrameData[9] VPWR VGND sg13cmos5l_antennanp
X_1581_ _1581_/Q Tile_X0Y1_FrameData[22] Tile_X0Y3_FrameStrobe[4] VPWR VGND sg13cmos5l_dlhq_1
X_0601_ _0601_/X Tile_X0Y1_W1END[3] Tile_X0Y1_W2MID[0] Tile_X0Y1_W2END[0] _0862_/X
+ _1633_/Q _1632_/Q VPWR VGND sg13cmos5l_mux4_1
X_0532_ _0533_/C _1699_/Q _0889_/X VPWR VGND sg13cmos5l_nor2_1
XFILLER_98_60 VPWR VGND sg13cmos5l_fill_1
XANTENNA__1816__GATE Tile_X0Y3_FrameStrobe[3] VPWR VGND sg13cmos5l_antennanp
XANTENNA__1108__A2 Tile_X0Y3_N4END[6] VPWR VGND sg13cmos5l_antennanp
X_0463_ _0463_/Y _0463_/A VPWR VGND sg13cmos5l_inv_1
X_2202_ Tile_X0Y1_E2BEG[3] _2202_/A VPWR VGND sg13cmos5l_buf_1
XANTENNA__1641__D Tile_X0Y1_FrameData[26] VPWR VGND sg13cmos5l_antennanp
X_2133_ _2133_/Q Tile_X0Y3_FrameData[30] Tile_X0Y3_FrameStrobe[6] VPWR VGND sg13cmos5l_dlhq_1
X_2064_ _2064_/Q Tile_X0Y3_FrameData[3] Tile_X0Y3_FrameStrobe[3] VPWR VGND sg13cmos5l_dlhq_1
XFILLER_19_293 VPWR VGND sg13cmos5l_fill_2
X_1015_ AXIL_S_SOC_RDATA29 Tile_X0Y1_W1END[1] Tile_X0Y1_W6END[9] Tile_X0Y1_WW4END[14]
+ _0552_/X _1504_/Q _1505_/Q VPWR VGND sg13cmos5l_mux4_1
X_1917_ _1917_/Q Tile_X0Y2_FrameData[30] Tile_X0Y3_FrameStrobe[7] VPWR VGND sg13cmos5l_dlhq_1
XFILLER_187_290 VPWR VGND sg13cmos5l_decap_4
X_1848_ _1848_/Q Tile_X0Y2_FrameData[3] Tile_X0Y3_FrameStrobe[4] VPWR VGND sg13cmos5l_dlhq_1
XFILLER_8_80 VPWR VGND sg13cmos5l_decap_8
XFILLER_118_26 VPWR VGND sg13cmos5l_fill_2
XANTENNA__1816__D Tile_X0Y2_FrameData[3] VPWR VGND sg13cmos5l_antennanp
X_1779_ _1779_/Q Tile_X0Y2_FrameData[8] Tile_X0Y3_FrameStrobe[2] VPWR VGND sg13cmos5l_dlhq_1
XFILLER_103_257 VPWR VGND sg13cmos5l_fill_2
XFILLER_94_18 VPWR VGND sg13cmos5l_fill_2
XFILLER_69_160 VPWR VGND sg13cmos5l_fill_2
XANTENNA__1551__D Tile_X0Y1_FrameData[20] VPWR VGND sg13cmos5l_antennanp
XFILLER_150_13 VPWR VGND sg13cmos5l_fill_1
XFILLER_214_80 VPWR VGND sg13cmos5l_decap_8
XFILLER_150_35 VPWR VGND sg13cmos5l_fill_2
XFILLER_217_158 VPWR VGND sg13cmos5l_fill_2
XFILLER_150_68 VPWR VGND sg13cmos5l_decap_4
XFILLER_43_11 VPWR VGND sg13cmos5l_fill_2
XFILLER_159_55 VPWR VGND sg13cmos5l_decap_8
XFILLER_159_99 VPWR VGND sg13cmos5l_fill_1
XFILLER_178_290 VPWR VGND sg13cmos5l_decap_4
XFILLER_153_113 VPWR VGND sg13cmos5l_decap_4
XFILLER_193_293 VPWR VGND sg13cmos5l_fill_2
XANTENNA__1726__D Tile_X0Y2_FrameData[29] VPWR VGND sg13cmos5l_antennanp
XFILLER_104_0 VPWR VGND sg13cmos5l_fill_2
XFILLER_4_167 VPWR VGND sg13cmos5l_decap_8
XANTENNA__0546__A0 Tile_X0Y0_W1END[1] VPWR VGND sg13cmos5l_antennanp
XFILLER_108_70 VPWR VGND sg13cmos5l_fill_2
XANTENNA__0561__A3 Tile_X0Y0_S4END[13] VPWR VGND sg13cmos5l_antennanp
XFILLER_191_53 VPWR VGND sg13cmos5l_decap_8
XANTENNA__0849__A1 AXIL_S_SOC_AWADDR5 VPWR VGND sg13cmos5l_antennanp
XANTENNA__1461__D Tile_X0Y1_FrameData[14] VPWR VGND sg13cmos5l_antennanp
XFILLER_90_100 VPWR VGND sg13cmos5l_decap_8
XFILLER_75_196 VPWR VGND sg13cmos5l_decap_4
XFILLER_31_200 VPWR VGND sg13cmos5l_decap_8
XANTENNA__1740__GATE Tile_X0Y3_FrameStrobe[1] VPWR VGND sg13cmos5l_antennanp
XFILLER_219_25 VPWR VGND sg13cmos5l_fill_1
X_1702_ _1702_/Q Tile_X0Y2_FrameData[21] Tile_X0Y3_FrameStrobe[0] VPWR VGND sg13cmos5l_dlhq_1
XFILLER_219_58 VPWR VGND sg13cmos5l_decap_8
X_1633_ _1633_/Q Tile_X0Y1_FrameData[2] Tile_X0Y3_FrameStrobe[5] VPWR VGND sg13cmos5l_dlhq_1
XANTENNA__1636__D Tile_X0Y1_FrameData[31] VPWR VGND sg13cmos5l_antennanp
XANTENNA__1755__GATE Tile_X0Y3_FrameStrobe[1] VPWR VGND sg13cmos5l_antennanp
X_1564_ _1564_/Q Tile_X0Y1_FrameData[7] Tile_X0Y3_FrameStrobe[3] VPWR VGND sg13cmos5l_dlhq_1
XFILLER_98_211 VPWR VGND sg13cmos5l_decap_8
X_1495_ _1495_/Q Tile_X0Y1_FrameData[12] Tile_X0Y3_FrameStrobe[1] VPWR VGND sg13cmos5l_dlhq_1
X_0515_ _2361_/A _0514_/X _0512_/X _2152_/Q VPWR VGND sg13cmos5l_mux2_1
X_0446_ _0446_/Y Tile_X0Y1_W6END[7] VPWR VGND sg13cmos5l_inv_1
XANTENNA__1371__D Tile_X0Y0_FrameData[16] VPWR VGND sg13cmos5l_antennanp
XFILLER_104_28 VPWR VGND sg13cmos5l_fill_2
X_2116_ _2116_/Q Tile_X0Y3_FrameData[15] Tile_X0Y3_FrameStrobe[5] VPWR VGND sg13cmos5l_dlhq_1
XFILLER_81_100 VPWR VGND sg13cmos5l_fill_2
X_2047_ _2047_/Q Tile_X0Y3_FrameData[20] Tile_X0Y3_FrameStrobe[3] VPWR VGND sg13cmos5l_dlhq_1
XFILLER_81_144 VPWR VGND sg13cmos5l_decap_8
XANTENNA__1013__X AXIL_S_SOC_RDATA25 VPWR VGND sg13cmos5l_antennanp
XFILLER_120_16 VPWR VGND sg13cmos5l_decap_4
XFILLER_81_177 VPWR VGND sg13cmos5l_decap_8
XFILLER_207_180 VPWR VGND sg13cmos5l_decap_8
XANTENNA__1708__GATE Tile_X0Y3_FrameStrobe[0] VPWR VGND sg13cmos5l_antennanp
XFILLER_22_244 VPWR VGND sg13cmos5l_decap_8
XANTENNA__1546__D Tile_X0Y1_FrameData[25] VPWR VGND sg13cmos5l_antennanp
XANTENNA__0528__A0 Tile_X0Y1_W1END[0] VPWR VGND sg13cmos5l_antennanp
XFILLER_49_108 VPWR VGND sg13cmos5l_fill_2
XANTENNA__0459__B Tile_X0Y0_S1END[2] VPWR VGND sg13cmos5l_antennanp
XFILLER_38_44 VPWR VGND sg13cmos5l_decap_8
XANTENNA__1281__D Tile_X0Y0_FrameData[10] VPWR VGND sg13cmos5l_antennanp
XANTENNA__0700__A0 AXIL_S_SOC_RREADY VPWR VGND sg13cmos5l_antennanp
XFILLER_161_67 VPWR VGND sg13cmos5l_fill_2
XFILLER_72_122 VPWR VGND sg13cmos5l_decap_8
XFILLER_57_196 VPWR VGND sg13cmos5l_fill_2
XFILLER_57_185 VPWR VGND sg13cmos5l_decap_8
XFILLER_205_117 VPWR VGND sg13cmos5l_fill_2
XFILLER_205_106 VPWR VGND sg13cmos5l_decap_8
XFILLER_54_54 VPWR VGND sg13cmos5l_fill_2
XFILLER_158_216 VPWR VGND sg13cmos5l_decap_8
XFILLER_158_227 VPWR VGND sg13cmos5l_decap_4
XANTENNA__1008__A1 Tile_X0Y1_W2END[1] VPWR VGND sg13cmos5l_antennanp
XFILLER_9_226 VPWR VGND sg13cmos5l_decap_4
XFILLER_221_0 VPWR VGND sg13cmos5l_fill_2
XFILLER_186_42 VPWR VGND sg13cmos5l_fill_2
XFILLER_186_31 VPWR VGND sg13cmos5l_fill_1
XANTENNA__0767__A0 Tile_X0Y0_W1END[0] VPWR VGND sg13cmos5l_antennanp
XFILLER_166_293 VPWR VGND sg13cmos5l_fill_2
XFILLER_186_75 VPWR VGND sg13cmos5l_decap_8
XANTENNA__1456__D Tile_X0Y1_FrameData[19] VPWR VGND sg13cmos5l_antennanp
XFILLER_79_84 VPWR VGND sg13cmos5l_decap_4
X_1280_ _1280_/Q Tile_X0Y0_FrameData[11] Tile_X0Y3_FrameStrobe[2] VPWR VGND sg13cmos5l_dlhq_1
XFILLER_95_72 VPWR VGND sg13cmos5l_decap_8
XFILLER_48_130 VPWR VGND sg13cmos5l_decap_8
XFILLER_63_133 VPWR VGND sg13cmos5l_decap_4
XFILLER_204_183 VPWR VGND sg13cmos5l_decap_4
XFILLER_157_260 VPWR VGND sg13cmos5l_decap_4
XFILLER_164_208 VPWR VGND sg13cmos5l_decap_4
X_0995_ _2219_/A AXIL_S_SOC_WDATA20 _0945_/X _0947_/A _0859_/X _1539_/Q _1538_/Q VPWR
+ VGND sg13cmos5l_mux4_1
XANTENNA__1694__GATE Tile_X0Y3_FrameStrobe[0] VPWR VGND sg13cmos5l_antennanp
XFILLER_67_0 VPWR VGND sg13cmos5l_fill_2
XANTENNA__1366__D Tile_X0Y0_FrameData[21] VPWR VGND sg13cmos5l_antennanp
XANTENNA__2599__X Tile_X0Y3_S4BEG[5] VPWR VGND sg13cmos5l_antennanp
XFILLER_117_157 VPWR VGND sg13cmos5l_decap_8
XFILLER_117_168 VPWR VGND sg13cmos5l_fill_2
X_1616_ _1616_/Q Tile_X0Y1_FrameData[19] Tile_X0Y3_FrameStrobe[5] VPWR VGND sg13cmos5l_dlhq_1
X_2596_ Tile_X0Y3_S4BEG[2] _2596_/A VPWR VGND sg13cmos5l_buf_1
XFILLER_5_81 VPWR VGND sg13cmos5l_fill_1
XANTENNA__1008__X AXIL_S_SOC_RDATA21 VPWR VGND sg13cmos5l_antennanp
X_1547_ _1547_/Q Tile_X0Y1_FrameData[24] Tile_X0Y3_FrameStrobe[3] VPWR VGND sg13cmos5l_dlhq_1
XFILLER_5_92 VPWR VGND sg13cmos5l_decap_8
XANTENNA__0930__A0 Tile_X0Y1_W1END[2] VPWR VGND sg13cmos5l_antennanp
XFILLER_115_49 VPWR VGND sg13cmos5l_decap_8
XFILLER_140_193 VPWR VGND sg13cmos5l_decap_8
X_1478_ _1478_/Q Tile_X0Y1_FrameData[29] Tile_X0Y3_FrameStrobe[1] VPWR VGND sg13cmos5l_dlhq_1
X_0429_ _0627_/B _2194_/Q VPWR VGND sg13cmos5l_inv_1
XANTENNA__1632__GATE Tile_X0Y3_FrameStrobe[5] VPWR VGND sg13cmos5l_antennanp
XFILLER_54_177 VPWR VGND sg13cmos5l_decap_8
XANTENNA__1647__GATE Tile_X0Y3_FrameStrobe[6] VPWR VGND sg13cmos5l_antennanp
XANTENNA__0997__A0 Tile_X0Y3_N4END[10] VPWR VGND sg13cmos5l_antennanp
XFILLER_10_225 VPWR VGND sg13cmos5l_fill_2
XFILLER_210_131 VPWR VGND sg13cmos5l_decap_8
XFILLER_155_219 VPWR VGND sg13cmos5l_decap_8
XANTENNA__0749__A0 Tile_X0Y1_W2MID[1] VPWR VGND sg13cmos5l_antennanp
XFILLER_108_113 VPWR VGND sg13cmos5l_fill_1
XFILLER_148_293 VPWR VGND sg13cmos5l_fill_2
XFILLER_156_12 VPWR VGND sg13cmos5l_decap_8
XANTENNA__1276__D Tile_X0Y0_FrameData[15] VPWR VGND sg13cmos5l_antennanp
XFILLER_163_252 VPWR VGND sg13cmos5l_fill_2
XANTENNA__2302__X Tile_X0Y2_E6BEG[6] VPWR VGND sg13cmos5l_antennanp
XFILLER_123_127 VPWR VGND sg13cmos5l_decap_8
XANTENNA__1174__A0 Tile_X0Y2_W2MID[5] VPWR VGND sg13cmos5l_antennanp
XFILLER_49_32 VPWR VGND sg13cmos5l_decap_8
XFILLER_131_182 VPWR VGND sg13cmos5l_decap_8
XFILLER_171_0 VPWR VGND sg13cmos5l_fill_1
XFILLER_65_86 VPWR VGND sg13cmos5l_decap_8
XFILLER_45_166 VPWR VGND sg13cmos5l_decap_8
XFILLER_139_271 VPWR VGND sg13cmos5l_fill_1
XFILLER_139_293 VPWR VGND sg13cmos5l_fill_2
X_0780_ _0780_/Y _0776_/S _0778_/X _0779_/Y VPWR VGND sg13cmos5l_o21ai_1
XFILLER_154_252 VPWR VGND sg13cmos5l_decap_4
XANTENNA__0755__A3 Tile_X0Y0_S2END[7] VPWR VGND sg13cmos5l_antennanp
XANTENNA__2212__X Tile_X0Y1_E2BEGb[5] VPWR VGND sg13cmos5l_antennanp
XFILLER_154_274 VPWR VGND sg13cmos5l_decap_8
X_2450_ Tile_X0Y0_EE4BEG[4] _2450_/A VPWR VGND sg13cmos5l_buf_1
X_1401_ _1401_/Q Tile_X0Y0_FrameData[18] Tile_X0Y3_FrameStrobe[6] VPWR VGND sg13cmos5l_dlhq_1
XFILLER_216_37 VPWR VGND sg13cmos5l_decap_4
XANTENNA__0507__A3 Tile_X0Y0_S4END[15] VPWR VGND sg13cmos5l_antennanp
XANTENNA__1914__D Tile_X0Y2_FrameData[1] VPWR VGND sg13cmos5l_antennanp
X_2381_ Tile_X0Y0_N2BEGb[7] _2381_/A VPWR VGND sg13cmos5l_buf_1
XFILLER_216_48 VPWR VGND sg13cmos5l_fill_2
X_1332_ _1332_/Q Tile_X0Y0_FrameData[23] Tile_X0Y3_FrameStrobe[4] VPWR VGND sg13cmos5l_dlhq_1
X_1263_ _1263_/Q Tile_X0Y0_FrameData[28] Tile_X0Y3_FrameStrobe[2] VPWR VGND sg13cmos5l_dlhq_1
X_1194_ AXIL_S_SOC_RDATA18 Tile_X0Y2_W1END[2] Tile_X0Y2_W6END[10] Tile_X0Y2_WW4END[13]
+ _0476_/X _1750_/Q _1751_/Q VPWR VGND sg13cmos5l_mux4_1
XFILLER_76_280 VPWR VGND sg13cmos5l_fill_1
XFILLER_101_18 VPWR VGND sg13cmos5l_decap_4
XFILLER_91_294 VPWR VGND sg13cmos5l_fill_1
XFILLER_91_283 VPWR VGND sg13cmos5l_fill_1
XFILLER_36_188 VPWR VGND sg13cmos5l_decap_4
XFILLER_189_171 VPWR VGND sg13cmos5l_fill_2
XFILLER_137_208 VPWR VGND sg13cmos5l_decap_8
X_0978_ _0978_/Y _1624_/Q _0977_/X _0454_/Y VPWR VGND sg13cmos5l_a21oi_1
XFILLER_145_252 VPWR VGND sg13cmos5l_decap_8
XFILLER_105_116 VPWR VGND sg13cmos5l_fill_2
XFILLER_126_37 VPWR VGND sg13cmos5l_decap_8
XFILLER_160_222 VPWR VGND sg13cmos5l_fill_1
XFILLER_160_244 VPWR VGND sg13cmos5l_decap_4
XANTENNA__1824__D Tile_X0Y2_FrameData[27] VPWR VGND sg13cmos5l_antennanp
X_2579_ Tile_X0Y3_S2BEG[1] _2579_/A VPWR VGND sg13cmos5l_buf_1
XANTENNA__0903__A0 AXIL_S_SOC_WSTRB2 VPWR VGND sg13cmos5l_antennanp
XANTENNA__1571__GATE Tile_X0Y3_FrameStrobe[3] VPWR VGND sg13cmos5l_antennanp
XFILLER_142_14 VPWR VGND sg13cmos5l_decap_8
XFILLER_206_81 VPWR VGND sg13cmos5l_fill_1
XFILLER_27_144 VPWR VGND sg13cmos5l_fill_1
XFILLER_35_12 VPWR VGND sg13cmos5l_decap_8
XANTENNA__1586__GATE Tile_X0Y3_FrameStrobe[4] VPWR VGND sg13cmos5l_antennanp
XFILLER_82_283 VPWR VGND sg13cmos5l_fill_1
XFILLER_42_136 VPWR VGND sg13cmos5l_decap_4
XFILLER_27_188 VPWR VGND sg13cmos5l_decap_4
XFILLER_35_89 VPWR VGND sg13cmos5l_decap_8
XFILLER_143_4 VPWR VGND sg13cmos5l_fill_1
XFILLER_195_141 VPWR VGND sg13cmos5l_decap_8
XFILLER_167_22 VPWR VGND sg13cmos5l_fill_1
XANTENNA__1524__GATE Tile_X0Y3_FrameStrobe[2] VPWR VGND sg13cmos5l_antennanp
XFILLER_151_244 VPWR VGND sg13cmos5l_decap_8
XANTENNA__1734__D Tile_X0Y2_FrameData[21] VPWR VGND sg13cmos5l_antennanp
XFILLER_111_108 VPWR VGND sg13cmos5l_fill_1
XFILLER_2_254 VPWR VGND sg13cmos5l_decap_8
XANTENNA__1539__GATE Tile_X0Y3_FrameStrobe[2] VPWR VGND sg13cmos5l_antennanp
XFILLER_206_245 VPWR VGND sg13cmos5l_decap_8
XANTENNA__0673__A2 AXIL_S_SOC_ARADDR7 VPWR VGND sg13cmos5l_antennanp
XFILLER_33_136 VPWR VGND sg13cmos5l_decap_4
XANTENNA__2207__X Tile_X0Y1_E2BEGb[0] VPWR VGND sg13cmos5l_antennanp
XFILLER_178_119 VPWR VGND sg13cmos5l_decap_4
X_1950_ _1950_/Q Tile_X0Y3_FrameData[21] Tile_X0Y3_FrameStrobe[0] VPWR VGND sg13cmos5l_dlhq_1
XFILLER_186_130 VPWR VGND sg13cmos5l_fill_1
XANTENNA__1909__D Tile_X0Y2_FrameData[6] VPWR VGND sg13cmos5l_antennanp
X_1881_ _1881_/Q Tile_X0Y2_FrameData[2] Tile_X0Y3_FrameStrobe[5] VPWR VGND sg13cmos5l_dlhq_1
X_0901_ _2469_/A AXIL_S_SOC_AWADDR1 _0760_/X _0762_/X _0712_/X _1284_/Q _1285_/Q VPWR
+ VGND sg13cmos5l_mux4_1
XFILLER_41_191 VPWR VGND sg13cmos5l_decap_8
XFILLER_186_152 VPWR VGND sg13cmos5l_fill_1
X_0832_ _0832_/Y Tile_X0Y0_W6END[6] _1375_/Q _1376_/Q VPWR VGND sg13cmos5l_o21ai_1
XFILLER_186_185 VPWR VGND sg13cmos5l_fill_1
XFILLER_127_230 VPWR VGND sg13cmos5l_decap_8
X_2502_ Tile_X0Y3_E2BEG[4] _2502_/A VPWR VGND sg13cmos5l_buf_1
X_0763_ _0763_/Y _1418_/Q _0520_/Y _1419_/Q VPWR VGND sg13cmos5l_a21oi_1
X_0694_ _2519_/A AXIL_S_SOC_ARADDR0 _0478_/X _0479_/X _0584_/X _2033_/Q _2032_/Q VPWR
+ VGND sg13cmos5l_mux4_1
XANTENNA__1644__D Tile_X0Y1_FrameData[23] VPWR VGND sg13cmos5l_antennanp
X_2433_ Tile_X0Y0_FrameData_O[19] Tile_X0Y0_FrameData[19] VPWR VGND sg13cmos5l_buf_1
X_2364_ Tile_X0Y0_N4BEG[6] _2364_/A VPWR VGND sg13cmos5l_buf_1
X_1315_ _1315_/Q Tile_X0Y0_FrameData[8] Tile_X0Y3_FrameStrobe[3] VPWR VGND sg13cmos5l_dlhq_1
X_2295_ Tile_X0Y2_E2BEGb[7] _2295_/A VPWR VGND sg13cmos5l_buf_1
X_1246_ _1246_/Q Tile_X0Y0_FrameData[13] Tile_X0Y3_FrameStrobe[1] VPWR VGND sg13cmos5l_dlhq_1
XFILLER_2_82 VPWR VGND sg13cmos5l_decap_4
X_1177_ _2307_/A AXIL_S_SOC_WDATA3 _1060_/A _1069_/X _0758_/X _1773_/Q _1772_/Q VPWR
+ VGND sg13cmos5l_mux4_1
XFILLER_64_294 VPWR VGND sg13cmos5l_fill_1
XFILLER_24_103 VPWR VGND sg13cmos5l_fill_1
XFILLER_212_204 VPWR VGND sg13cmos5l_decap_4
XFILLER_24_136 VPWR VGND sg13cmos5l_decap_8
XFILLER_212_226 VPWR VGND sg13cmos5l_decap_4
XFILLER_212_248 VPWR VGND sg13cmos5l_decap_4
XANTENNA_10 Tile_X0Y0_S2MID[1] VPWR VGND sg13cmos5l_antennanp
XANTENNA__1819__D Tile_X0Y2_FrameData[0] VPWR VGND sg13cmos5l_antennanp
XFILLER_220_270 VPWR VGND sg13cmos5l_decap_8
XFILLER_137_25 VPWR VGND sg13cmos5l_decap_8
XFILLER_21_69 VPWR VGND sg13cmos5l_decap_4
XFILLER_192_177 VPWR VGND sg13cmos5l_decap_8
XFILLER_137_58 VPWR VGND sg13cmos5l_decap_8
XFILLER_97_18 VPWR VGND sg13cmos5l_decap_4
XANTENNA__1554__D Tile_X0Y1_FrameData[17] VPWR VGND sg13cmos5l_antennanp
XFILLER_153_13 VPWR VGND sg13cmos5l_fill_1
XFILLER_101_174 VPWR VGND sg13cmos5l_decap_8
XFILLER_15_125 VPWR VGND sg13cmos5l_decap_4
XFILLER_55_272 VPWR VGND sg13cmos5l_decap_4
XFILLER_102_50 VPWR VGND sg13cmos5l_decap_4
XFILLER_178_21 VPWR VGND sg13cmos5l_fill_1
XANTENNA__1729__D Tile_X0Y2_FrameData[26] VPWR VGND sg13cmos5l_antennanp
XANTENNA__1463__GATE Tile_X0Y3_FrameStrobe[0] VPWR VGND sg13cmos5l_antennanp
XFILLER_109_230 VPWR VGND sg13cmos5l_fill_2
XFILLER_183_155 VPWR VGND sg13cmos5l_fill_1
XFILLER_183_177 VPWR VGND sg13cmos5l_fill_1
XANTENNA__1464__D Tile_X0Y1_FrameData[11] VPWR VGND sg13cmos5l_antennanp
XANTENNA__0591__A1 Tile_X0Y3_W2MID[3] VPWR VGND sg13cmos5l_antennanp
XANTENNA__1478__GATE Tile_X0Y3_FrameStrobe[1] VPWR VGND sg13cmos5l_antennanp
X_1100_ _2310_/A AXIL_S_SOC_WDATA2 _0554_/X AXIL_S_SOC_WDATA14 _0732_/X _1822_/Q _1823_/Q
+ VPWR VGND sg13cmos5l_mux4_1
XFILLER_38_206 VPWR VGND sg13cmos5l_decap_8
XANTENNA__0894__A2 Tile_X0Y0_W6END[6] VPWR VGND sg13cmos5l_antennanp
XANTENNA__1401__GATE Tile_X0Y3_FrameStrobe[6] VPWR VGND sg13cmos5l_antennanp
X_2080_ _2080_/Q Tile_X0Y3_FrameData[19] Tile_X0Y3_FrameStrobe[4] VPWR VGND sg13cmos5l_dlhq_1
XFILLER_213_38 VPWR VGND sg13cmos5l_fill_2
X_1031_ _2210_/A AXIL_S_SOC_WDATA19 AXIL_S_SOC_WDATA27 _0868_/X _0869_/X _1589_/Q
+ _1588_/Q VPWR VGND sg13cmos5l_mux4_1
XFILLER_46_272 VPWR VGND sg13cmos5l_fill_2
XANTENNA__0646__A2 Tile_X0Y0_S2MID[1] VPWR VGND sg13cmos5l_antennanp
XANTENNA__1416__GATE Tile_X0Y3_FrameStrobe[6] VPWR VGND sg13cmos5l_antennanp
XFILLER_61_242 VPWR VGND sg13cmos5l_decap_8
XANTENNA__1639__D Tile_X0Y1_FrameData[28] VPWR VGND sg13cmos5l_antennanp
XFILLER_159_130 VPWR VGND sg13cmos5l_decap_4
X_1933_ _1933_/Q Tile_X0Y2_FrameData[14] Tile_X0Y3_FrameStrobe[7] VPWR VGND sg13cmos5l_dlhq_1
XANTENNA__0949__A3 Tile_X0Y0_S4END[7] VPWR VGND sg13cmos5l_antennanp
XFILLER_202_270 VPWR VGND sg13cmos5l_fill_1
X_1864_ _1864_/Q Tile_X0Y2_FrameData[19] Tile_X0Y3_FrameStrobe[5] VPWR VGND sg13cmos5l_dlhq_1
XFILLER_174_144 VPWR VGND sg13cmos5l_fill_2
X_1795_ _1795_/Q Tile_X0Y2_FrameData[24] Tile_X0Y3_FrameStrobe[3] VPWR VGND sg13cmos5l_dlhq_1
X_0815_ _2485_/A AXIL_S_SOC_WSTRB2 AXIL_S_SOC_AWADDR5 _0712_/X _0739_/X _1357_/Q _1356_/Q
+ VPWR VGND sg13cmos5l_mux4_1
X_0746_ _0746_/X _0745_/X _0510_/X Tile_X0Y3_N2MID[3] _0744_/X _1708_/Q _1709_/Q VPWR
+ VGND sg13cmos5l_mux4_1
XANTENNA__1374__D Tile_X0Y0_FrameData[13] VPWR VGND sg13cmos5l_antennanp
XFILLER_107_17 VPWR VGND sg13cmos5l_fill_2
XANTENNA__0582__A1 Tile_X0Y1_W2END[6] VPWR VGND sg13cmos5l_antennanp
XANTENNA__2400__X Tile_X0Y0_FrameStrobe_O[6] VPWR VGND sg13cmos5l_antennanp
X_2416_ Tile_X0Y0_FrameData_O[2] Tile_X0Y0_FrameData[2] VPWR VGND sg13cmos5l_buf_1
X_0677_ _2530_/A AXIL_S_SOC_ARVALID AXIL_S_SOC_ARADDR3 _0507_/X _0511_/X _2067_/Q
+ _2066_/Q VPWR VGND sg13cmos5l_mux4_1
XANTENNA__1016__X AXIL_S_SOC_RDATA31 VPWR VGND sg13cmos5l_antennanp
X_2347_ Tile_X0Y2_FrameData_O[23] Tile_X0Y2_FrameData[23] VPWR VGND sg13cmos5l_buf_1
XFILLER_123_38 VPWR VGND sg13cmos5l_fill_1
X_2278_ Tile_X0Y2_E1BEG[2] _2278_/A VPWR VGND sg13cmos5l_buf_1
X_1229_ _1229_/Q Tile_X0Y0_FrameData[30] Tile_X0Y3_FrameStrobe[1] VPWR VGND sg13cmos5l_dlhq_1
XFILLER_44_209 VPWR VGND sg13cmos5l_fill_1
XFILLER_197_203 VPWR VGND sg13cmos5l_decap_8
XANTENNA__1549__D Tile_X0Y1_FrameData[22] VPWR VGND sg13cmos5l_antennanp
XFILLER_200_229 VPWR VGND sg13cmos5l_fill_1
XFILLER_200_207 VPWR VGND sg13cmos5l_fill_1
XFILLER_20_172 VPWR VGND sg13cmos5l_decap_8
XANTENNA__2193__GATE Tile_X0Y3_FrameStrobe[7] VPWR VGND sg13cmos5l_antennanp
XFILLER_165_166 VPWR VGND sg13cmos5l_decap_4
XANTENNA__1284__D Tile_X0Y0_FrameData[7] VPWR VGND sg13cmos5l_antennanp
XFILLER_106_244 VPWR VGND sg13cmos5l_fill_1
XFILLER_164_34 VPWR VGND sg13cmos5l_decap_4
XANTENNA__0573__A1 Tile_X0Y3_W6END[3] VPWR VGND sg13cmos5l_antennanp
XANTENNA__2310__X Tile_X0Y2_EE4BEG[2] VPWR VGND sg13cmos5l_antennanp
XFILLER_79_128 VPWR VGND sg13cmos5l_decap_8
XFILLER_180_11 VPWR VGND sg13cmos5l_decap_4
XFILLER_87_194 VPWR VGND sg13cmos5l_decap_4
XANTENNA__2131__GATE Tile_X0Y3_FrameStrobe[5] VPWR VGND sg13cmos5l_antennanp
XFILLER_113_60 VPWR VGND sg13cmos5l_decap_8
XANTENNA__2146__GATE Tile_X0Y3_FrameStrobe[6] VPWR VGND sg13cmos5l_antennanp
XFILLER_43_275 VPWR VGND sg13cmos5l_fill_1
XFILLER_189_64 VPWR VGND sg13cmos5l_decap_8
XANTENNA__0562__B_N Tile_X0Y3_N1END[1] VPWR VGND sg13cmos5l_antennanp
XANTENNA__1459__D Tile_X0Y1_FrameData[16] VPWR VGND sg13cmos5l_antennanp
XFILLER_156_111 VPWR VGND sg13cmos5l_decap_8
XFILLER_171_103 VPWR VGND sg13cmos5l_fill_2
X_1580_ _1580_/Q Tile_X0Y1_FrameData[23] Tile_X0Y3_FrameStrobe[4] VPWR VGND sg13cmos5l_dlhq_1
X_0600_ _2593_/A Tile_X0Y2_W1END[3] Tile_X0Y2_W2END[0] Tile_X0Y2_W2MID[0] _0758_/X
+ _1880_/Q _1881_/Q VPWR VGND sg13cmos5l_mux4_1
X_0531_ _0533_/B Tile_X0Y2_W6END[0] _1699_/Q VPWR VGND sg13cmos5l_nor2b_1
XANTENNA__2220__X Tile_X0Y1_E6BEG[5] VPWR VGND sg13cmos5l_antennanp
X_0462_ _0463_/A _0770_/X Tile_X0Y3_N4END[14] Tile_X0Y0_S1END[2] Tile_X0Y0_S4END[2]
+ _1223_/Q _1222_/Q VPWR VGND sg13cmos5l_mux4_1
XANTENNA__1108__A3 Tile_X0Y0_S4END[10] VPWR VGND sg13cmos5l_antennanp
XANTENNA__1340__GATE Tile_X0Y3_FrameStrobe[4] VPWR VGND sg13cmos5l_antennanp
XANTENNA__1922__D Tile_X0Y2_FrameData[25] VPWR VGND sg13cmos5l_antennanp
X_2201_ Tile_X0Y1_E2BEG[2] _2201_/A VPWR VGND sg13cmos5l_buf_1
XFILLER_85_109 VPWR VGND sg13cmos5l_fill_1
XANTENNA__1970__GATE Tile_X0Y3_FrameStrobe[0] VPWR VGND sg13cmos5l_antennanp
XFILLER_120_280 VPWR VGND sg13cmos5l_fill_1
X_2132_ _2132_/Q Tile_X0Y3_FrameData[31] Tile_X0Y3_FrameStrobe[6] VPWR VGND sg13cmos5l_dlhq_1
XFILLER_93_120 VPWR VGND sg13cmos5l_decap_8
XFILLER_93_142 VPWR VGND sg13cmos5l_decap_8
XFILLER_19_250 VPWR VGND sg13cmos5l_decap_4
X_2063_ _2063_/Q Tile_X0Y3_FrameData[4] Tile_X0Y3_FrameStrobe[3] VPWR VGND sg13cmos5l_dlhq_1
XANTENNA__1355__GATE Tile_X0Y3_FrameStrobe[4] VPWR VGND sg13cmos5l_antennanp
X_1014_ AXIL_S_SOC_RDATA24 Tile_X0Y1_W2MID[4] Tile_X0Y1_W2END[4] Tile_X0Y1_W6END[4]
+ _0869_/X _1515_/Q _1514_/Q VPWR VGND sg13cmos5l_mux4_1
XANTENNA__1985__GATE Tile_X0Y3_FrameStrobe[1] VPWR VGND sg13cmos5l_antennanp
XFILLER_179_236 VPWR VGND sg13cmos5l_decap_4
XFILLER_179_214 VPWR VGND sg13cmos5l_decap_4
XFILLER_97_0 VPWR VGND sg13cmos5l_fill_2
XFILLER_34_286 VPWR VGND sg13cmos5l_fill_1
XANTENNA__1369__D Tile_X0Y0_FrameData[18] VPWR VGND sg13cmos5l_antennanp
XFILLER_147_122 VPWR VGND sg13cmos5l_decap_4
X_1916_ _1916_/Q Tile_X0Y2_FrameData[31] Tile_X0Y3_FrameStrobe[7] VPWR VGND sg13cmos5l_dlhq_1
XFILLER_187_280 VPWR VGND sg13cmos5l_fill_1
X_1847_ _1847_/Q Tile_X0Y2_FrameData[4] Tile_X0Y3_FrameStrobe[4] VPWR VGND sg13cmos5l_dlhq_1
XFILLER_118_16 VPWR VGND sg13cmos5l_fill_1
XFILLER_162_114 VPWR VGND sg13cmos5l_fill_1
XANTENNA__1923__GATE Tile_X0Y3_FrameStrobe[7] VPWR VGND sg13cmos5l_antennanp
X_1778_ _1778_/Q Tile_X0Y2_FrameData[9] Tile_X0Y3_FrameStrobe[2] VPWR VGND sg13cmos5l_dlhq_1
X_0729_ _0729_/X _0728_/X _0596_/X Tile_X0Y3_N2MID[6] _0727_/X _1702_/Q _1703_/Q VPWR
+ VGND sg13cmos5l_mux4_1
XFILLER_134_15 VPWR VGND sg13cmos5l_decap_8
XANTENNA__1308__GATE Tile_X0Y3_FrameStrobe[3] VPWR VGND sg13cmos5l_antennanp
XANTENNA__1832__D Tile_X0Y2_FrameData[19] VPWR VGND sg13cmos5l_antennanp
XFILLER_134_48 VPWR VGND sg13cmos5l_fill_2
XANTENNA__0858__A2 Tile_X0Y2_W6END[7] VPWR VGND sg13cmos5l_antennanp
XANTENNA__1938__GATE Tile_X0Y3_FrameStrobe[7] VPWR VGND sg13cmos5l_antennanp
XFILLER_69_183 VPWR VGND sg13cmos5l_decap_8
XFILLER_84_164 VPWR VGND sg13cmos5l_decap_8
XFILLER_27_13 VPWR VGND sg13cmos5l_fill_1
XFILLER_217_137 VPWR VGND sg13cmos5l_decap_8
XFILLER_217_126 VPWR VGND sg13cmos5l_fill_1
XFILLER_17_209 VPWR VGND sg13cmos5l_decap_4
XFILLER_84_197 VPWR VGND sg13cmos5l_decap_8
XFILLER_27_57 VPWR VGND sg13cmos5l_fill_1
XFILLER_25_275 VPWR VGND sg13cmos5l_fill_2
XFILLER_25_264 VPWR VGND sg13cmos5l_decap_8
XFILLER_185_206 VPWR VGND sg13cmos5l_decap_8
XANTENNA__1279__D Tile_X0Y0_FrameData[12] VPWR VGND sg13cmos5l_antennanp
XANTENNA__1035__A2 AXIL_S_SOC_WDATA30 VPWR VGND sg13cmos5l_antennanp
XANTENNA__2305__X Tile_X0Y2_E6BEG[9] VPWR VGND sg13cmos5l_antennanp
XFILLER_193_272 VPWR VGND sg13cmos5l_decap_8
XFILLER_138_199 VPWR VGND sg13cmos5l_fill_2
XFILLER_209_2 VPWR VGND sg13cmos5l_fill_1
XANTENNA__0546__A1 Tile_X0Y0_W6END[9] VPWR VGND sg13cmos5l_antennanp
XFILLER_108_82 VPWR VGND sg13cmos5l_fill_1
XANTENNA__1742__D Tile_X0Y2_FrameData[13] VPWR VGND sg13cmos5l_antennanp
XFILLER_68_75 VPWR VGND sg13cmos5l_fill_2
XFILLER_191_32 VPWR VGND sg13cmos5l_decap_8
XANTENNA__2070__GATE Tile_X0Y3_FrameStrobe[4] VPWR VGND sg13cmos5l_antennanp
XFILLER_208_126 VPWR VGND sg13cmos5l_decap_8
XFILLER_75_175 VPWR VGND sg13cmos5l_decap_8
XFILLER_223_118 VPWR VGND sg13cmos5l_decap_4
XFILLER_223_107 VPWR VGND sg13cmos5l_fill_1
XANTENNA__2085__GATE Tile_X0Y3_FrameStrobe[4] VPWR VGND sg13cmos5l_antennanp
XFILLER_210_39 VPWR VGND sg13cmos5l_fill_2
XFILLER_210_17 VPWR VGND sg13cmos5l_fill_2
XANTENNA__0482__A0 Tile_X0Y1_W2MID[5] VPWR VGND sg13cmos5l_antennanp
XFILLER_16_286 VPWR VGND sg13cmos5l_fill_1
XANTENNA__1026__A2 Tile_X0Y0_S4END[5] VPWR VGND sg13cmos5l_antennanp
XANTENNA__2215__X Tile_X0Y1_E6BEG[0] VPWR VGND sg13cmos5l_antennanp
XFILLER_31_278 VPWR VGND sg13cmos5l_decap_4
XFILLER_219_15 VPWR VGND sg13cmos5l_decap_8
XANTENNA__1917__D Tile_X0Y2_FrameData[30] VPWR VGND sg13cmos5l_antennanp
X_1701_ _1701_/Q Tile_X0Y2_FrameData[22] Tile_X0Y3_FrameStrobe[0] VPWR VGND sg13cmos5l_dlhq_1
XANTENNA__0785__A1 Tile_X0Y3_N4END[14] VPWR VGND sg13cmos5l_antennanp
X_1632_ _1632_/Q Tile_X0Y1_FrameData[3] Tile_X0Y3_FrameStrobe[5] VPWR VGND sg13cmos5l_dlhq_1
XFILLER_184_294 VPWR VGND sg13cmos5l_fill_1
XANTENNA__2023__GATE Tile_X0Y3_FrameStrobe[2] VPWR VGND sg13cmos5l_antennanp
X_1563_ _1563_/Q Tile_X0Y1_FrameData[8] Tile_X0Y3_FrameStrobe[3] VPWR VGND sg13cmos5l_dlhq_1
X_1494_ _1494_/Q Tile_X0Y1_FrameData[13] Tile_X0Y3_FrameStrobe[1] VPWR VGND sg13cmos5l_dlhq_1
X_0514_ _0514_/X Tile_X0Y3_W1END[3] Tile_X0Y3_WW4END[3] Tile_X0Y3_W6END[11] _0513_/X
+ _2154_/Q _2153_/Q VPWR VGND sg13cmos5l_mux4_1
XANTENNA__1652__D Tile_X0Y1_FrameData[15] VPWR VGND sg13cmos5l_antennanp
X_0445_ _0445_/Y _1374_/Q VPWR VGND sg13cmos5l_inv_1
XANTENNA__2038__GATE Tile_X0Y3_FrameStrobe[3] VPWR VGND sg13cmos5l_antennanp
XFILLER_12_0 VPWR VGND sg13cmos5l_decap_4
XANTENNA__1294__GATE Tile_X0Y3_FrameStrobe[3] VPWR VGND sg13cmos5l_antennanp
X_2115_ _2115_/Q Tile_X0Y3_FrameData[16] Tile_X0Y3_FrameStrobe[5] VPWR VGND sg13cmos5l_dlhq_1
X_2046_ _2046_/Q Tile_X0Y3_FrameData[21] Tile_X0Y3_FrameStrobe[3] VPWR VGND sg13cmos5l_dlhq_1
XFILLER_22_223 VPWR VGND sg13cmos5l_decap_8
XFILLER_222_162 VPWR VGND sg13cmos5l_fill_1
XFILLER_13_15 VPWR VGND sg13cmos5l_fill_2
XANTENNA__1017__A2 AXIL_S_SOC_WDATA28 VPWR VGND sg13cmos5l_antennanp
XANTENNA__1232__GATE Tile_X0Y3_FrameStrobe[1] VPWR VGND sg13cmos5l_antennanp
XANTENNA__1827__D Tile_X0Y2_FrameData[24] VPWR VGND sg13cmos5l_antennanp
XANTENNA__1862__GATE Tile_X0Y3_FrameStrobe[5] VPWR VGND sg13cmos5l_antennanp
XFILLER_89_19 VPWR VGND sg13cmos5l_fill_1
XFILLER_175_294 VPWR VGND sg13cmos5l_fill_1
XFILLER_190_253 VPWR VGND sg13cmos5l_fill_2
XFILLER_190_242 VPWR VGND sg13cmos5l_decap_8
XANTENNA__0528__A1 Tile_X0Y1_W6END[8] VPWR VGND sg13cmos5l_antennanp
XANTENNA__1247__GATE Tile_X0Y3_FrameStrobe[1] VPWR VGND sg13cmos5l_antennanp
XFILLER_150_139 VPWR VGND sg13cmos5l_fill_2
XANTENNA__1562__D Tile_X0Y1_FrameData[9] VPWR VGND sg13cmos5l_antennanp
XANTENNA__1877__GATE Tile_X0Y3_FrameStrobe[5] VPWR VGND sg13cmos5l_antennanp
XFILLER_38_23 VPWR VGND sg13cmos5l_decap_8
XFILLER_161_46 VPWR VGND sg13cmos5l_decap_8
XANTENNA__1800__GATE Tile_X0Y3_FrameStrobe[3] VPWR VGND sg13cmos5l_antennanp
XFILLER_161_57 VPWR VGND sg13cmos5l_fill_1
XFILLER_57_164 VPWR VGND sg13cmos5l_decap_8
XFILLER_54_11 VPWR VGND sg13cmos5l_fill_2
XANTENNA__0464__A0 Tile_X0Y0_W1END[2] VPWR VGND sg13cmos5l_antennanp
XANTENNA__1815__GATE Tile_X0Y3_FrameStrobe[3] VPWR VGND sg13cmos5l_antennanp
XFILLER_13_223 VPWR VGND sg13cmos5l_fill_2
XFILLER_54_77 VPWR VGND sg13cmos5l_decap_4
XFILLER_110_50 VPWR VGND sg13cmos5l_fill_2
XFILLER_110_61 VPWR VGND sg13cmos5l_fill_1
XFILLER_213_184 VPWR VGND sg13cmos5l_fill_1
XANTENNA__1008__A2 Tile_X0Y1_W6END[1] VPWR VGND sg13cmos5l_antennanp
XFILLER_110_94 VPWR VGND sg13cmos5l_fill_1
XFILLER_13_278 VPWR VGND sg13cmos5l_fill_2
XFILLER_166_250 VPWR VGND sg13cmos5l_decap_4
XFILLER_70_54 VPWR VGND sg13cmos5l_decap_4
XANTENNA__0767__A1 Tile_X0Y0_W6END[8] VPWR VGND sg13cmos5l_antennanp
XANTENNA__1737__D Tile_X0Y2_FrameData[18] VPWR VGND sg13cmos5l_antennanp
XFILLER_126_125 VPWR VGND sg13cmos5l_fill_1
XFILLER_166_272 VPWR VGND sg13cmos5l_decap_8
XFILLER_214_0 VPWR VGND sg13cmos5l_decap_4
XFILLER_181_220 VPWR VGND sg13cmos5l_fill_2
XANTENNA__0519__A1 Tile_X0Y0_S1END[0] VPWR VGND sg13cmos5l_antennanp
XFILLER_79_63 VPWR VGND sg13cmos5l_decap_8
XFILLER_134_180 VPWR VGND sg13cmos5l_decap_8
XANTENNA__1472__D Tile_X0Y1_FrameData[3] VPWR VGND sg13cmos5l_antennanp
XFILLER_95_40 VPWR VGND sg13cmos5l_fill_1
XFILLER_95_51 VPWR VGND sg13cmos5l_decap_8
XFILLER_48_186 VPWR VGND sg13cmos5l_decap_8
XFILLER_204_162 VPWR VGND sg13cmos5l_decap_8
X_0994_ _2599_/A _0985_/Y _0987_/Y _0993_/Y VPWR VGND sg13cmos5l_a21oi_1
XANTENNA__1647__D Tile_X0Y1_FrameData[20] VPWR VGND sg13cmos5l_antennanp
XFILLER_117_125 VPWR VGND sg13cmos5l_fill_1
XFILLER_157_294 VPWR VGND sg13cmos5l_fill_1
XFILLER_132_128 VPWR VGND sg13cmos5l_fill_1
X_1615_ _1615_/Q Tile_X0Y1_FrameData[20] Tile_X0Y3_FrameStrobe[5] VPWR VGND sg13cmos5l_dlhq_1
X_2595_ Tile_X0Y3_S4BEG[1] _2595_/A VPWR VGND sg13cmos5l_buf_1
X_1546_ _1546_/Q Tile_X0Y1_FrameData[25] Tile_X0Y3_FrameStrobe[3] VPWR VGND sg13cmos5l_dlhq_1
XFILLER_140_150 VPWR VGND sg13cmos5l_fill_1
XANTENNA__0930__A1 Tile_X0Y1_WW4END[2] VPWR VGND sg13cmos5l_antennanp
XANTENNA__1382__D Tile_X0Y0_FrameData[5] VPWR VGND sg13cmos5l_antennanp
X_1477_ _1477_/Q Tile_X0Y1_FrameData[30] Tile_X0Y3_FrameStrobe[1] VPWR VGND sg13cmos5l_dlhq_1
X_0428_ _0428_/Y _2122_/Q VPWR VGND sg13cmos5l_inv_1
XANTENNA__0694__A0 AXIL_S_SOC_ARADDR0 VPWR VGND sg13cmos5l_antennanp
X_2029_ _2029_/Q Tile_X0Y3_FrameData[6] Tile_X0Y3_FrameStrobe[2] VPWR VGND sg13cmos5l_dlhq_1
XFILLER_211_71 VPWR VGND sg13cmos5l_decap_4
XFILLER_24_25 VPWR VGND sg13cmos5l_fill_1
XFILLER_211_93 VPWR VGND sg13cmos5l_fill_2
XFILLER_10_248 VPWR VGND sg13cmos5l_decap_8
XFILLER_148_250 VPWR VGND sg13cmos5l_decap_8
XANTENNA__0749__A1 Tile_X0Y1_W2END[1] VPWR VGND sg13cmos5l_antennanp
XANTENNA__1557__D Tile_X0Y1_FrameData[14] VPWR VGND sg13cmos5l_antennanp
XFILLER_148_283 VPWR VGND sg13cmos5l_fill_1
XFILLER_156_35 VPWR VGND sg13cmos5l_fill_2
XFILLER_116_180 VPWR VGND sg13cmos5l_fill_1
XANTENNA__1174__A1 Tile_X0Y2_W2END[5] VPWR VGND sg13cmos5l_antennanp
XFILLER_49_22 VPWR VGND sg13cmos5l_decap_8
XANTENNA__1292__D Tile_X0Y0_FrameData[31] VPWR VGND sg13cmos5l_antennanp
XFILLER_49_77 VPWR VGND sg13cmos5l_fill_2
XFILLER_92_218 VPWR VGND sg13cmos5l_decap_8
XFILLER_105_94 VPWR VGND sg13cmos5l_fill_1
XFILLER_65_65 VPWR VGND sg13cmos5l_decap_8
XFILLER_45_134 VPWR VGND sg13cmos5l_fill_2
XFILLER_45_112 VPWR VGND sg13cmos5l_decap_4
XANTENNA__1754__GATE Tile_X0Y3_FrameStrobe[1] VPWR VGND sg13cmos5l_antennanp
XANTENNA__0988__A1 Tile_X0Y1_W6END[5] VPWR VGND sg13cmos5l_antennanp
XANTENNA__1769__GATE Tile_X0Y3_FrameStrobe[2] VPWR VGND sg13cmos5l_antennanp
XANTENNA__1467__D Tile_X0Y1_FrameData[8] VPWR VGND sg13cmos5l_antennanp
XFILLER_60_8 VPWR VGND sg13cmos5l_decap_8
XFILLER_5_230 VPWR VGND sg13cmos5l_decap_8
XFILLER_5_241 VPWR VGND sg13cmos5l_fill_2
X_1400_ _1400_/Q Tile_X0Y0_FrameData[19] Tile_X0Y3_FrameStrobe[6] VPWR VGND sg13cmos5l_dlhq_1
XFILLER_5_274 VPWR VGND sg13cmos5l_fill_1
XFILLER_216_16 VPWR VGND sg13cmos5l_fill_2
X_2380_ Tile_X0Y0_N2BEGb[6] _2380_/A VPWR VGND sg13cmos5l_buf_1
X_1331_ _1331_/Q Tile_X0Y0_FrameData[24] Tile_X0Y3_FrameStrobe[4] VPWR VGND sg13cmos5l_dlhq_1
XANTENNA__1707__GATE Tile_X0Y3_FrameStrobe[0] VPWR VGND sg13cmos5l_antennanp
X_1262_ _1262_/Q Tile_X0Y0_FrameData[29] Tile_X0Y3_FrameStrobe[2] VPWR VGND sg13cmos5l_dlhq_1
XANTENNA__1930__D Tile_X0Y2_FrameData[17] VPWR VGND sg13cmos5l_antennanp
XFILLER_83_229 VPWR VGND sg13cmos5l_decap_8
XANTENNA__0676__A0 AXIL_S_SOC_RREADY VPWR VGND sg13cmos5l_antennanp
X_1193_ _2358_/A _1187_/Y _1190_/X _1192_/Y VPWR VGND sg13cmos5l_a21oi_1
XFILLER_36_167 VPWR VGND sg13cmos5l_decap_4
XFILLER_51_104 VPWR VGND sg13cmos5l_fill_1
XANTENNA__1377__D Tile_X0Y0_FrameData[10] VPWR VGND sg13cmos5l_antennanp
X_0977_ _0977_/X _0866_/X _0465_/X _0977_/S VPWR VGND sg13cmos5l_mux2_1
XANTENNA__2403__X Tile_X0Y0_FrameStrobe_O[9] VPWR VGND sg13cmos5l_antennanp
XFILLER_145_220 VPWR VGND sg13cmos5l_decap_8
XANTENNA__0600__A0 Tile_X0Y2_W1END[3] VPWR VGND sg13cmos5l_antennanp
XFILLER_145_275 VPWR VGND sg13cmos5l_fill_1
XFILLER_105_128 VPWR VGND sg13cmos5l_decap_8
XFILLER_126_16 VPWR VGND sg13cmos5l_fill_2
X_2578_ Tile_X0Y3_S2BEG[0] _2578_/A VPWR VGND sg13cmos5l_buf_1
XANTENNA__2001__D Tile_X0Y3_FrameData[2] VPWR VGND sg13cmos5l_antennanp
X_1529_ _1529_/Q Tile_X0Y1_FrameData[10] Tile_X0Y3_FrameStrobe[2] VPWR VGND sg13cmos5l_dlhq_1
XANTENNA__1840__D Tile_X0Y2_FrameData[11] VPWR VGND sg13cmos5l_antennanp
XFILLER_142_48 VPWR VGND sg13cmos5l_decap_8
XFILLER_35_68 VPWR VGND sg13cmos5l_decap_8
XANTENNA__1092__A0 AXIL_S_SOC_WDATA4 VPWR VGND sg13cmos5l_antennanp
XFILLER_128_209 VPWR VGND sg13cmos5l_fill_2
XFILLER_195_164 VPWR VGND sg13cmos5l_fill_1
XANTENNA__1287__D Tile_X0Y0_FrameData[4] VPWR VGND sg13cmos5l_antennanp
XFILLER_167_45 VPWR VGND sg13cmos5l_fill_1
XANTENNA__2313__X Tile_X0Y2_EE4BEG[5] VPWR VGND sg13cmos5l_antennanp
XFILLER_167_56 VPWR VGND sg13cmos5l_decap_4
XFILLER_167_78 VPWR VGND sg13cmos5l_decap_4
XFILLER_136_253 VPWR VGND sg13cmos5l_decap_4
XFILLER_183_33 VPWR VGND sg13cmos5l_fill_1
XFILLER_2_244 VPWR VGND sg13cmos5l_fill_2
XFILLER_2_277 VPWR VGND sg13cmos5l_decap_8
XFILLER_104_194 VPWR VGND sg13cmos5l_decap_8
XFILLER_76_75 VPWR VGND sg13cmos5l_decap_8
XANTENNA__1750__D Tile_X0Y2_FrameData[5] VPWR VGND sg13cmos5l_antennanp
XANTENNA__1693__GATE Tile_X0Y3_FrameStrobe[0] VPWR VGND sg13cmos5l_antennanp
XFILLER_132_81 VPWR VGND sg13cmos5l_fill_2
XFILLER_206_279 VPWR VGND sg13cmos5l_decap_4
XANTENNA__1083__A0 AXIL_S_SOC_WDATA1 VPWR VGND sg13cmos5l_antennanp
X_0900_ _2470_/A AXIL_S_SOC_WVALID _0794_/B _0801_/X _0739_/X _1283_/Q _1282_/Q VPWR
+ VGND sg13cmos5l_mux4_1
XFILLER_221_249 VPWR VGND sg13cmos5l_fill_1
XFILLER_214_290 VPWR VGND sg13cmos5l_decap_4
X_1880_ _1880_/Q Tile_X0Y2_FrameData[3] Tile_X0Y3_FrameStrobe[5] VPWR VGND sg13cmos5l_dlhq_1
XFILLER_41_170 VPWR VGND sg13cmos5l_decap_8
XFILLER_186_164 VPWR VGND sg13cmos5l_decap_8
XANTENNA__1197__D Tile_X0Y0_FrameData[30] VPWR VGND sg13cmos5l_antennanp
X_0831_ _0831_/Y _1376_/Q _0828_/X _0442_/Y VPWR VGND sg13cmos5l_a21oi_1
XANTENNA__1631__GATE Tile_X0Y3_FrameStrobe[5] VPWR VGND sg13cmos5l_antennanp
XANTENNA__2223__X Tile_X0Y1_E6BEG[8] VPWR VGND sg13cmos5l_antennanp
X_0762_ _0762_/X _0709_/X Tile_X0Y0_S1END[0] Tile_X0Y3_N4END[12] Tile_X0Y0_S4END[0]
+ _1242_/Q _1243_/Q VPWR VGND sg13cmos5l_mux4_1
X_2501_ Tile_X0Y3_E2BEG[3] _2501_/A VPWR VGND sg13cmos5l_buf_1
XANTENNA__1925__D Tile_X0Y2_FrameData[22] VPWR VGND sg13cmos5l_antennanp
XFILLER_127_286 VPWR VGND sg13cmos5l_fill_1
X_0693_ _2518_/A AXIL_S_SOC_ARVALID _0506_/X _0507_/X _0580_/A _2035_/Q _2034_/Q VPWR
+ VGND sg13cmos5l_mux4_1
X_2432_ Tile_X0Y0_FrameData_O[18] Tile_X0Y0_FrameData[18] VPWR VGND sg13cmos5l_buf_1
XANTENNA__1646__GATE Tile_X0Y3_FrameStrobe[6] VPWR VGND sg13cmos5l_antennanp
X_2363_ Tile_X0Y0_N4BEG[5] _2363_/A VPWR VGND sg13cmos5l_buf_1
XANTENNA__0897__A0 Tile_X0Y0_W1END[1] VPWR VGND sg13cmos5l_antennanp
X_1314_ _1314_/Q Tile_X0Y0_FrameData[9] Tile_X0Y3_FrameStrobe[3] VPWR VGND sg13cmos5l_dlhq_1
X_2294_ Tile_X0Y2_E2BEGb[6] _2294_/A VPWR VGND sg13cmos5l_buf_1
XANTENNA__1660__D Tile_X0Y1_FrameData[7] VPWR VGND sg13cmos5l_antennanp
X_1245_ _1245_/Q Tile_X0Y0_FrameData[14] Tile_X0Y3_FrameStrobe[1] VPWR VGND sg13cmos5l_dlhq_1
XFILLER_49_281 VPWR VGND sg13cmos5l_fill_1
X_1176_ AXIL_S_SOC_RDATA16 Tile_X0Y2_W1END[0] Tile_X0Y2_W6END[8] Tile_X0Y2_WW4END[15]
+ _0534_/X _1754_/Q _1755_/Q VPWR VGND sg13cmos5l_mux4_1
XFILLER_24_115 VPWR VGND sg13cmos5l_decap_8
XANTENNA_11 _0641_/X VPWR VGND sg13cmos5l_antennanp
XFILLER_177_142 VPWR VGND sg13cmos5l_decap_4
XFILLER_220_293 VPWR VGND sg13cmos5l_fill_2
XFILLER_118_220 VPWR VGND sg13cmos5l_fill_1
XFILLER_118_242 VPWR VGND sg13cmos5l_decap_8
XANTENNA__1835__D Tile_X0Y2_FrameData[16] VPWR VGND sg13cmos5l_antennanp
XANTENNA__1129__A1 Tile_X0Y2_W6END[4] VPWR VGND sg13cmos5l_antennanp
XANTENNA__0888__A0 Tile_X0Y3_W1END[1] VPWR VGND sg13cmos5l_antennanp
XFILLER_101_120 VPWR VGND sg13cmos5l_decap_8
XFILLER_99_192 VPWR VGND sg13cmos5l_decap_8
XANTENNA__1570__D Tile_X0Y1_FrameData[1] VPWR VGND sg13cmos5l_antennanp
XFILLER_46_56 VPWR VGND sg13cmos5l_decap_8
XANTENNA__2308__X Tile_X0Y2_EE4BEG[0] VPWR VGND sg13cmos5l_antennanp
XFILLER_203_216 VPWR VGND sg13cmos5l_fill_2
XFILLER_70_276 VPWR VGND sg13cmos5l_fill_2
XFILLER_62_33 VPWR VGND sg13cmos5l_decap_8
XFILLER_141_2 VPWR VGND sg13cmos5l_fill_1
XFILLER_168_142 VPWR VGND sg13cmos5l_fill_2
XFILLER_30_129 VPWR VGND sg13cmos5l_fill_1
XFILLER_23_170 VPWR VGND sg13cmos5l_fill_2
XANTENNA__0812__A0 Tile_X0Y0_WW4END[13] VPWR VGND sg13cmos5l_antennanp
XFILLER_183_134 VPWR VGND sg13cmos5l_decap_8
XFILLER_183_189 VPWR VGND sg13cmos5l_decap_8
XANTENNA__1745__D Tile_X0Y2_FrameData[10] VPWR VGND sg13cmos5l_antennanp
XFILLER_194_98 VPWR VGND sg13cmos5l_decap_8
XANTENNA__0591__A2 Tile_X0Y3_W2END[3] VPWR VGND sg13cmos5l_antennanp
XFILLER_97_118 VPWR VGND sg13cmos5l_fill_1
XFILLER_87_41 VPWR VGND sg13cmos5l_fill_2
XANTENNA__0879__A0 Tile_X0Y3_N4END[15] VPWR VGND sg13cmos5l_antennanp
XFILLER_213_17 VPWR VGND sg13cmos5l_fill_1
XANTENNA__1480__D Tile_X0Y1_FrameData[27] VPWR VGND sg13cmos5l_antennanp
XFILLER_213_28 VPWR VGND sg13cmos5l_fill_1
X_1030_ _2209_/A AXIL_S_SOC_WDATA18 AXIL_S_SOC_WDATA26 _0867_/X _0865_/X _1591_/Q
+ _1590_/Q VPWR VGND sg13cmos5l_mux4_1
XANTENNA__2218__X Tile_X0Y1_E6BEG[3] VPWR VGND sg13cmos5l_antennanp
XANTENNA__0646__A3 Tile_X0Y0_S2END[1] VPWR VGND sg13cmos5l_antennanp
XFILLER_14_192 VPWR VGND sg13cmos5l_decap_8
X_1932_ _1932_/Q Tile_X0Y2_FrameData[15] Tile_X0Y3_FrameStrobe[7] VPWR VGND sg13cmos5l_dlhq_1
X_1863_ _1863_/Q Tile_X0Y2_FrameData[20] Tile_X0Y3_FrameStrobe[5] VPWR VGND sg13cmos5l_dlhq_1
XFILLER_202_293 VPWR VGND sg13cmos5l_fill_2
XFILLER_174_101 VPWR VGND sg13cmos5l_fill_1
XANTENNA__1570__GATE Tile_X0Y3_FrameStrobe[3] VPWR VGND sg13cmos5l_antennanp
X_0814_ _2595_/A _0811_/Y _0813_/Y _0809_/Y VPWR VGND sg13cmos5l_a21oi_1
X_1794_ _1794_/Q Tile_X0Y2_FrameData[25] Tile_X0Y3_FrameStrobe[3] VPWR VGND sg13cmos5l_dlhq_1
XFILLER_174_178 VPWR VGND sg13cmos5l_fill_1
XFILLER_174_167 VPWR VGND sg13cmos5l_decap_8
XANTENNA__1655__D Tile_X0Y1_FrameData[12] VPWR VGND sg13cmos5l_antennanp
X_0745_ _0745_/X Tile_X0Y3_W2MID[4] Tile_X0Y3_W2END[4] Tile_X0Y3_W6END[4] _0511_/X
+ _2173_/Q _2172_/Q VPWR VGND sg13cmos5l_mux4_1
XANTENNA__1585__GATE Tile_X0Y3_FrameStrobe[4] VPWR VGND sg13cmos5l_antennanp
X_0676_ _2529_/A AXIL_S_SOC_RREADY AXIL_S_SOC_BREADY _0536_/X _0590_/X _2069_/Q _2068_/Q
+ VPWR VGND sg13cmos5l_mux4_1
XFILLER_42_0 VPWR VGND sg13cmos5l_fill_2
XANTENNA__0582__A2 Tile_X0Y1_W6END[9] VPWR VGND sg13cmos5l_antennanp
X_2415_ Tile_X0Y0_FrameData_O[1] Tile_X0Y0_FrameData[1] VPWR VGND sg13cmos5l_buf_1
X_2346_ Tile_X0Y2_FrameData_O[22] Tile_X0Y2_FrameData[22] VPWR VGND sg13cmos5l_buf_1
XFILLER_96_162 VPWR VGND sg13cmos5l_decap_8
XANTENNA__1390__D Tile_X0Y0_FrameData[29] VPWR VGND sg13cmos5l_antennanp
X_2277_ Tile_X0Y2_E1BEG[1] _2277_/A VPWR VGND sg13cmos5l_buf_1
X_1228_ _1228_/Q Tile_X0Y0_FrameData[31] Tile_X0Y3_FrameStrobe[1] VPWR VGND sg13cmos5l_dlhq_1
XFILLER_37_262 VPWR VGND sg13cmos5l_decap_8
XFILLER_203_61 VPWR VGND sg13cmos5l_fill_2
XANTENNA__1523__GATE Tile_X0Y3_FrameStrobe[2] VPWR VGND sg13cmos5l_antennanp
XFILLER_16_48 VPWR VGND sg13cmos5l_fill_1
X_1159_ _2276_/A _0889_/X _0528_/X AXIL_S_SOC_WDATA2 AXIL_S_SOC_WDATA7 _1867_/Q _1866_/Q
+ VPWR VGND sg13cmos5l_mux4_1
XFILLER_52_276 VPWR VGND sg13cmos5l_decap_8
XANTENNA__1538__GATE Tile_X0Y3_FrameStrobe[2] VPWR VGND sg13cmos5l_antennanp
XFILLER_32_36 VPWR VGND sg13cmos5l_fill_2
XANTENNA__1565__D Tile_X0Y1_FrameData[6] VPWR VGND sg13cmos5l_antennanp
XFILLER_180_115 VPWR VGND sg13cmos5l_decap_8
XFILLER_79_107 VPWR VGND sg13cmos5l_decap_4
XFILLER_164_79 VPWR VGND sg13cmos5l_fill_1
XFILLER_87_173 VPWR VGND sg13cmos5l_decap_8
XFILLER_28_240 VPWR VGND sg13cmos5l_decap_8
XANTENNA__1038__A0 AXIL_S_SOC_WDATA16 VPWR VGND sg13cmos5l_antennanp
XFILLER_7_144 VPWR VGND sg13cmos5l_decap_8
XANTENNA__1475__D Tile_X0Y1_FrameData[0] VPWR VGND sg13cmos5l_antennanp
XFILLER_208_39 VPWR VGND sg13cmos5l_fill_2
XANTENNA__2501__X Tile_X0Y3_E2BEG[3] VPWR VGND sg13cmos5l_antennanp
XFILLER_138_91 VPWR VGND sg13cmos5l_fill_2
X_0530_ _0530_/Y _1699_/Q _1698_/Q VPWR VGND sg13cmos5l_nor2b_1
XFILLER_98_51 VPWR VGND sg13cmos5l_decap_8
X_2200_ Tile_X0Y1_E2BEG[1] _2200_/A VPWR VGND sg13cmos5l_buf_1
X_0461_ _0461_/Y _0430_/Y _1199_/Q _1198_/Q _0459_/Y _0460_/Y VPWR VGND sg13cmos5l_a221oi_1
XFILLER_78_151 VPWR VGND sg13cmos5l_decap_4
XFILLER_224_38 VPWR VGND sg13cmos5l_fill_1
XANTENNA__0867__A3 Tile_X0Y0_S2MID[2] VPWR VGND sg13cmos5l_antennanp
X_2131_ _2131_/Q Tile_X0Y3_FrameData[0] Tile_X0Y3_FrameStrobe[5] VPWR VGND sg13cmos5l_dlhq_1
XFILLER_78_173 VPWR VGND sg13cmos5l_fill_2
X_2062_ _2062_/Q Tile_X0Y3_FrameData[5] Tile_X0Y3_FrameStrobe[3] VPWR VGND sg13cmos5l_dlhq_1
X_1013_ AXIL_S_SOC_RDATA25 Tile_X0Y1_W2MID[5] Tile_X0Y1_W2END[5] Tile_X0Y1_W6END[5]
+ _0865_/X _1513_/Q _1512_/Q VPWR VGND sg13cmos5l_mux4_1
XFILLER_219_190 VPWR VGND sg13cmos5l_decap_8
XFILLER_19_273 VPWR VGND sg13cmos5l_decap_8
XFILLER_34_243 VPWR VGND sg13cmos5l_decap_8
XANTENNA__1029__A0 AXIL_S_SOC_WDATA18 VPWR VGND sg13cmos5l_antennanp
XFILLER_147_101 VPWR VGND sg13cmos5l_decap_8
X_1915_ _1915_/Q Tile_X0Y2_FrameData[0] Tile_X0Y3_FrameStrobe[6] VPWR VGND sg13cmos5l_dlhq_1
XFILLER_194_229 VPWR VGND sg13cmos5l_decap_8
XFILLER_147_145 VPWR VGND sg13cmos5l_fill_2
XFILLER_162_104 VPWR VGND sg13cmos5l_fill_2
X_1846_ _1846_/Q Tile_X0Y2_FrameData[5] Tile_X0Y3_FrameStrobe[4] VPWR VGND sg13cmos5l_dlhq_1
XANTENNA__1385__D Tile_X0Y0_FrameData[2] VPWR VGND sg13cmos5l_antennanp
XFILLER_118_28 VPWR VGND sg13cmos5l_fill_1
X_1777_ _1777_/Q Tile_X0Y2_FrameData[10] Tile_X0Y3_FrameStrobe[2] VPWR VGND sg13cmos5l_dlhq_1
XANTENNA__2411__X Tile_X0Y0_FrameStrobe_O[17] VPWR VGND sg13cmos5l_antennanp
X_0728_ _0728_/X Tile_X0Y3_W2MID[1] Tile_X0Y3_W2END[1] Tile_X0Y3_W6END[1] _0598_/X
+ _2167_/Q _2166_/Q VPWR VGND sg13cmos5l_mux4_1
XFILLER_103_204 VPWR VGND sg13cmos5l_decap_8
X_0659_ _2500_/A _0638_/Y _0483_/X AXIL_S_SOC_ARADDR5 _0594_/X _2102_/Q _2103_/Q VPWR
+ VGND sg13cmos5l_mux4_1
X_2329_ Tile_X0Y2_FrameData_O[5] Tile_X0Y2_FrameData[5] VPWR VGND sg13cmos5l_buf_1
XFILLER_217_105 VPWR VGND sg13cmos5l_fill_1
XANTENNA__1462__GATE Tile_X0Y3_FrameStrobe[0] VPWR VGND sg13cmos5l_antennanp
XFILLER_27_47 VPWR VGND sg13cmos5l_fill_2
XFILLER_225_182 VPWR VGND sg13cmos5l_decap_8
XFILLER_40_235 VPWR VGND sg13cmos5l_decap_8
XANTENNA__1477__GATE Tile_X0Y3_FrameStrobe[1] VPWR VGND sg13cmos5l_antennanp
XFILLER_159_35 VPWR VGND sg13cmos5l_fill_1
XFILLER_43_57 VPWR VGND sg13cmos5l_decap_8
XFILLER_138_134 VPWR VGND sg13cmos5l_fill_2
XANTENNA__1400__GATE Tile_X0Y3_FrameStrobe[6] VPWR VGND sg13cmos5l_antennanp
XFILLER_216_4 VPWR VGND sg13cmos5l_fill_1
XFILLER_193_240 VPWR VGND sg13cmos5l_fill_1
XANTENNA__1295__D Tile_X0Y0_FrameData[28] VPWR VGND sg13cmos5l_antennanp
XFILLER_138_178 VPWR VGND sg13cmos5l_decap_8
XFILLER_175_12 VPWR VGND sg13cmos5l_fill_1
XANTENNA__2321__X Tile_X0Y2_EE4BEG[13] VPWR VGND sg13cmos5l_antennanp
XANTENNA__1415__GATE Tile_X0Y3_FrameStrobe[6] VPWR VGND sg13cmos5l_antennanp
XFILLER_102_270 VPWR VGND sg13cmos5l_decap_8
XFILLER_75_121 VPWR VGND sg13cmos5l_fill_2
XFILLER_75_110 VPWR VGND sg13cmos5l_decap_8
XFILLER_191_88 VPWR VGND sg13cmos5l_decap_4
XFILLER_124_60 VPWR VGND sg13cmos5l_decap_4
XFILLER_124_82 VPWR VGND sg13cmos5l_decap_8
XFILLER_84_20 VPWR VGND sg13cmos5l_fill_2
XFILLER_75_154 VPWR VGND sg13cmos5l_decap_8
XANTENNA__0482__A1 Tile_X0Y1_W2END[5] VPWR VGND sg13cmos5l_antennanp
XFILLER_16_276 VPWR VGND sg13cmos5l_decap_4
XFILLER_31_235 VPWR VGND sg13cmos5l_decap_8
X_1700_ _1700_/Q Tile_X0Y2_FrameData[23] Tile_X0Y3_FrameStrobe[0] VPWR VGND sg13cmos5l_dlhq_1
XFILLER_219_38 VPWR VGND sg13cmos5l_fill_2
XANTENNA__0785__A2 Tile_X0Y0_S1END[2] VPWR VGND sg13cmos5l_antennanp
X_1631_ _1631_/Q Tile_X0Y1_FrameData[4] Tile_X0Y3_FrameStrobe[5] VPWR VGND sg13cmos5l_dlhq_1
XANTENNA__2231__X Tile_X0Y1_EE4BEG[4] VPWR VGND sg13cmos5l_antennanp
X_1562_ _1562_/Q Tile_X0Y1_FrameData[9] Tile_X0Y3_FrameStrobe[3] VPWR VGND sg13cmos5l_dlhq_1
XANTENNA__1933__D Tile_X0Y2_FrameData[14] VPWR VGND sg13cmos5l_antennanp
X_1493_ _1493_/Q Tile_X0Y1_FrameData[14] Tile_X0Y3_FrameStrobe[1] VPWR VGND sg13cmos5l_dlhq_1
X_0513_ _0513_/X Tile_X0Y3_N1END[3] Tile_X0Y3_N4END[3] _0574_/B Tile_X0Y0_S4END[15]
+ _1989_/Q _1988_/Q VPWR VGND sg13cmos5l_mux4_1
X_0444_ _0444_/Y Tile_X0Y0_WW4END[3] VPWR VGND sg13cmos5l_inv_1
XFILLER_104_19 VPWR VGND sg13cmos5l_decap_4
X_2114_ _2114_/Q Tile_X0Y3_FrameData[17] Tile_X0Y3_FrameStrobe[5] VPWR VGND sg13cmos5l_dlhq_1
XFILLER_81_102 VPWR VGND sg13cmos5l_fill_1
XANTENNA__2192__GATE Tile_X0Y3_FrameStrobe[7] VPWR VGND sg13cmos5l_antennanp
X_2045_ _2045_/Q Tile_X0Y3_FrameData[22] Tile_X0Y3_FrameStrobe[3] VPWR VGND sg13cmos5l_dlhq_1
XFILLER_214_108 VPWR VGND sg13cmos5l_fill_1
XFILLER_120_29 VPWR VGND sg13cmos5l_fill_2
XANTENNA__2406__X Tile_X0Y0_FrameStrobe_O[12] VPWR VGND sg13cmos5l_antennanp
XFILLER_222_141 VPWR VGND sg13cmos5l_fill_1
XFILLER_222_174 VPWR VGND sg13cmos5l_decap_8
XFILLER_22_279 VPWR VGND sg13cmos5l_decap_4
XFILLER_129_27 VPWR VGND sg13cmos5l_fill_2
XFILLER_13_49 VPWR VGND sg13cmos5l_decap_8
XANTENNA__2130__GATE Tile_X0Y3_FrameStrobe[5] VPWR VGND sg13cmos5l_antennanp
XANTENNA__2004__D Tile_X0Y3_FrameData[31] VPWR VGND sg13cmos5l_antennanp
XFILLER_135_148 VPWR VGND sg13cmos5l_decap_4
X_1829_ _1829_/Q Tile_X0Y2_FrameData[22] Tile_X0Y3_FrameStrobe[4] VPWR VGND sg13cmos5l_dlhq_1
XFILLER_145_15 VPWR VGND sg13cmos5l_fill_2
XFILLER_150_118 VPWR VGND sg13cmos5l_decap_8
XFILLER_89_213 VPWR VGND sg13cmos5l_decap_8
XFILLER_1_106 VPWR VGND sg13cmos5l_fill_1
XFILLER_190_276 VPWR VGND sg13cmos5l_decap_8
XANTENNA__1843__D Tile_X0Y2_FrameData[8] VPWR VGND sg13cmos5l_antennanp
XFILLER_89_235 VPWR VGND sg13cmos5l_fill_2
XFILLER_89_224 VPWR VGND sg13cmos5l_fill_1
XANTENNA__2145__GATE Tile_X0Y3_FrameStrobe[6] VPWR VGND sg13cmos5l_antennanp
XFILLER_161_36 VPWR VGND sg13cmos5l_decap_8
XFILLER_97_290 VPWR VGND sg13cmos5l_decap_4
XFILLER_57_143 VPWR VGND sg13cmos5l_decap_8
XFILLER_38_79 VPWR VGND sg13cmos5l_fill_1
XANTENNA__0464__A1 Tile_X0Y0_W6END[10] VPWR VGND sg13cmos5l_antennanp
XANTENNA__2316__X Tile_X0Y2_EE4BEG[8] VPWR VGND sg13cmos5l_antennanp
XFILLER_13_246 VPWR VGND sg13cmos5l_decap_8
XFILLER_70_11 VPWR VGND sg13cmos5l_fill_2
XANTENNA__0767__A2 Tile_X0Y0_WW4END[0] VPWR VGND sg13cmos5l_antennanp
XFILLER_207_0 VPWR VGND sg13cmos5l_decap_4
XFILLER_181_243 VPWR VGND sg13cmos5l_decap_8
XANTENNA__0519__A2 Tile_X0Y3_N4END[12] VPWR VGND sg13cmos5l_antennanp
XANTENNA__1354__GATE Tile_X0Y3_FrameStrobe[4] VPWR VGND sg13cmos5l_antennanp
XFILLER_79_42 VPWR VGND sg13cmos5l_decap_8
XANTENNA__1753__D Tile_X0Y2_FrameData[2] VPWR VGND sg13cmos5l_antennanp
XANTENNA__1984__GATE Tile_X0Y3_FrameStrobe[1] VPWR VGND sg13cmos5l_antennanp
XFILLER_141_129 VPWR VGND sg13cmos5l_fill_2
XFILLER_135_70 VPWR VGND sg13cmos5l_fill_1
XFILLER_95_216 VPWR VGND sg13cmos5l_decap_8
XANTENNA__1369__GATE Tile_X0Y3_FrameStrobe[5] VPWR VGND sg13cmos5l_antennanp
XFILLER_88_290 VPWR VGND sg13cmos5l_decap_4
XANTENNA__1999__GATE Tile_X0Y3_FrameStrobe[1] VPWR VGND sg13cmos5l_antennanp
XFILLER_48_165 VPWR VGND sg13cmos5l_decap_8
XFILLER_221_39 VPWR VGND sg13cmos5l_fill_1
XANTENNA__1922__GATE Tile_X0Y3_FrameStrobe[7] VPWR VGND sg13cmos5l_antennanp
XANTENNA__2226__X Tile_X0Y1_E6BEG[11] VPWR VGND sg13cmos5l_antennanp
XANTENNA__1307__GATE Tile_X0Y3_FrameStrobe[3] VPWR VGND sg13cmos5l_antennanp
XANTENNA__1928__D Tile_X0Y2_FrameData[19] VPWR VGND sg13cmos5l_antennanp
X_0993_ _0993_/Y _0993_/A _0993_/B VPWR VGND sg13cmos5l_nor2_1
XANTENNA__1937__GATE Tile_X0Y3_FrameStrobe[7] VPWR VGND sg13cmos5l_antennanp
XANTENNA__0758__A2 Tile_X0Y3_N2MID[7] VPWR VGND sg13cmos5l_antennanp
XFILLER_157_284 VPWR VGND sg13cmos5l_fill_2
XANTENNA__2402__A Tile_X0Y3_FrameStrobe[8] VPWR VGND sg13cmos5l_antennanp
X_1614_ _1614_/Q Tile_X0Y1_FrameData[21] Tile_X0Y3_FrameStrobe[5] VPWR VGND sg13cmos5l_dlhq_1
X_2594_ Tile_X0Y3_S4BEG[0] _2594_/A VPWR VGND sg13cmos5l_buf_1
XANTENNA__1663__D Tile_X0Y1_FrameData[4] VPWR VGND sg13cmos5l_antennanp
X_1545_ _1545_/Q Tile_X0Y1_FrameData[26] Tile_X0Y3_FrameStrobe[3] VPWR VGND sg13cmos5l_dlhq_1
XANTENNA__0930__A2 Tile_X0Y1_W6END[10] VPWR VGND sg13cmos5l_antennanp
X_1476_ _1476_/Q Tile_X0Y1_FrameData[31] Tile_X0Y3_FrameStrobe[1] VPWR VGND sg13cmos5l_dlhq_1
XFILLER_94_260 VPWR VGND sg13cmos5l_decap_8
XFILLER_39_154 VPWR VGND sg13cmos5l_fill_1
XFILLER_131_39 VPWR VGND sg13cmos5l_fill_2
X_2028_ _2028_/Q Tile_X0Y3_FrameData[7] Tile_X0Y3_FrameStrobe[2] VPWR VGND sg13cmos5l_dlhq_1
XANTENNA__0997__A2 Tile_X0Y0_S4END[6] VPWR VGND sg13cmos5l_antennanp
XANTENNA__1838__D Tile_X0Y2_FrameData[13] VPWR VGND sg13cmos5l_antennanp
XFILLER_138_8 VPWR VGND sg13cmos5l_fill_1
XFILLER_210_188 VPWR VGND sg13cmos5l_fill_2
XANTENNA__0749__A2 Tile_X0Y1_W6END[1] VPWR VGND sg13cmos5l_antennanp
XANTENNA__1573__D Tile_X0Y1_FrameData[30] VPWR VGND sg13cmos5l_antennanp
XANTENNA__2084__GATE Tile_X0Y3_FrameStrobe[4] VPWR VGND sg13cmos5l_antennanp
XANTENNA__1174__A2 Tile_X0Y2_W6END[5] VPWR VGND sg13cmos5l_antennanp
XFILLER_77_216 VPWR VGND sg13cmos5l_decap_8
XFILLER_49_56 VPWR VGND sg13cmos5l_decap_8
XFILLER_172_24 VPWR VGND sg13cmos5l_decap_8
XANTENNA__2099__GATE Tile_X0Y3_FrameStrobe[4] VPWR VGND sg13cmos5l_antennanp
XFILLER_85_293 VPWR VGND sg13cmos5l_fill_2
XFILLER_65_44 VPWR VGND sg13cmos5l_decap_8
XFILLER_218_277 VPWR VGND sg13cmos5l_fill_2
XFILLER_218_266 VPWR VGND sg13cmos5l_fill_1
XFILLER_218_255 VPWR VGND sg13cmos5l_decap_8
XANTENNA__2022__GATE Tile_X0Y3_FrameStrobe[2] VPWR VGND sg13cmos5l_antennanp
XFILLER_157_0 VPWR VGND sg13cmos5l_fill_1
XANTENNA__1748__D Tile_X0Y2_FrameData[7] VPWR VGND sg13cmos5l_antennanp
XFILLER_201_122 VPWR VGND sg13cmos5l_decap_8
XANTENNA__2037__GATE Tile_X0Y3_FrameStrobe[3] VPWR VGND sg13cmos5l_antennanp
XFILLER_201_188 VPWR VGND sg13cmos5l_fill_1
XANTENNA__1293__GATE Tile_X0Y3_FrameStrobe[3] VPWR VGND sg13cmos5l_antennanp
XANTENNA__1483__D Tile_X0Y1_FrameData[24] VPWR VGND sg13cmos5l_antennanp
XFILLER_114_118 VPWR VGND sg13cmos5l_decap_4
X_1330_ _1330_/Q Tile_X0Y0_FrameData[25] Tile_X0Y3_FrameStrobe[4] VPWR VGND sg13cmos5l_dlhq_1
XFILLER_122_173 VPWR VGND sg13cmos5l_decap_8
X_1261_ _1261_/Q Tile_X0Y0_FrameData[30] Tile_X0Y3_FrameStrobe[2] VPWR VGND sg13cmos5l_dlhq_1
XFILLER_68_249 VPWR VGND sg13cmos5l_decap_4
X_1192_ _1192_/Y _2161_/Q _1192_/B VPWR VGND sg13cmos5l_nor2_1
XFILLER_209_244 VPWR VGND sg13cmos5l_fill_1
XFILLER_209_233 VPWR VGND sg13cmos5l_decap_8
XANTENNA__0676__A1 AXIL_S_SOC_BREADY VPWR VGND sg13cmos5l_antennanp
XANTENNA__1231__GATE Tile_X0Y3_FrameStrobe[1] VPWR VGND sg13cmos5l_antennanp
XFILLER_36_124 VPWR VGND sg13cmos5l_fill_2
XANTENNA__1861__GATE Tile_X0Y3_FrameStrobe[5] VPWR VGND sg13cmos5l_antennanp
XFILLER_91_252 VPWR VGND sg13cmos5l_decap_8
XFILLER_209_288 VPWR VGND sg13cmos5l_decap_8
XANTENNA__1246__GATE Tile_X0Y3_FrameStrobe[1] VPWR VGND sg13cmos5l_antennanp
XANTENNA__1658__D Tile_X0Y1_FrameData[9] VPWR VGND sg13cmos5l_antennanp
XANTENNA__1876__GATE Tile_X0Y3_FrameStrobe[5] VPWR VGND sg13cmos5l_antennanp
X_0976_ _0976_/Y _1625_/Q _0933_/X _0975_/Y VPWR VGND sg13cmos5l_o21ai_1
XFILLER_72_0 VPWR VGND sg13cmos5l_fill_2
XANTENNA__0600__A1 Tile_X0Y2_W2END[0] VPWR VGND sg13cmos5l_antennanp
XANTENNA__1393__D Tile_X0Y0_FrameData[26] VPWR VGND sg13cmos5l_antennanp
XFILLER_160_213 VPWR VGND sg13cmos5l_decap_8
XFILLER_160_257 VPWR VGND sg13cmos5l_fill_2
XFILLER_160_279 VPWR VGND sg13cmos5l_decap_4
X_2577_ Tile_X0Y3_S1BEG[3] _2577_/A VPWR VGND sg13cmos5l_buf_1
XANTENNA__1814__GATE Tile_X0Y3_FrameStrobe[3] VPWR VGND sg13cmos5l_antennanp
X_1528_ _1528_/Q Tile_X0Y1_FrameData[11] Tile_X0Y3_FrameStrobe[2] VPWR VGND sg13cmos5l_dlhq_1
XFILLER_113_184 VPWR VGND sg13cmos5l_decap_4
X_1459_ _1459_/Q Tile_X0Y1_FrameData[16] Tile_X0Y3_FrameStrobe[0] VPWR VGND sg13cmos5l_dlhq_1
XFILLER_67_293 VPWR VGND sg13cmos5l_fill_2
XFILLER_27_102 VPWR VGND sg13cmos5l_fill_2
XFILLER_215_203 VPWR VGND sg13cmos5l_decap_8
XANTENNA__1829__GATE Tile_X0Y3_FrameStrobe[4] VPWR VGND sg13cmos5l_antennanp
XFILLER_222_60 VPWR VGND sg13cmos5l_fill_2
XFILLER_82_274 VPWR VGND sg13cmos5l_fill_2
XFILLER_42_127 VPWR VGND sg13cmos5l_decap_4
XANTENNA__1092__A1 AXIL_S_SOC_WDATA12 VPWR VGND sg13cmos5l_antennanp
XANTENNA__1568__D Tile_X0Y1_FrameData[3] VPWR VGND sg13cmos5l_antennanp
XFILLER_50_171 VPWR VGND sg13cmos5l_decap_4
XFILLER_129_4 VPWR VGND sg13cmos5l_fill_1
XFILLER_167_13 VPWR VGND sg13cmos5l_fill_2
XFILLER_151_279 VPWR VGND sg13cmos5l_decap_4
XFILLER_76_32 VPWR VGND sg13cmos5l_fill_1
XFILLER_76_98 VPWR VGND sg13cmos5l_decap_8
XFILLER_92_20 VPWR VGND sg13cmos5l_fill_2
XFILLER_206_225 VPWR VGND sg13cmos5l_decap_8
XFILLER_18_157 VPWR VGND sg13cmos5l_decap_8
XFILLER_92_75 VPWR VGND sg13cmos5l_fill_2
XFILLER_92_64 VPWR VGND sg13cmos5l_decap_8
XANTENNA__1083__A1 AXIL_S_SOC_WDATA9 VPWR VGND sg13cmos5l_antennanp
XANTENNA__1478__D Tile_X0Y1_FrameData[29] VPWR VGND sg13cmos5l_antennanp
XANTENNA__2504__X Tile_X0Y3_E2BEG[6] VPWR VGND sg13cmos5l_antennanp
X_0830_ _0830_/Y _0828_/S _0784_/X _0829_/Y VPWR VGND sg13cmos5l_o21ai_1
X_0761_ _0761_/X _0709_/X Tile_X0Y0_S1END[0] Tile_X0Y3_N4END[12] Tile_X0Y0_S4END[0]
+ _1250_/Q _1251_/Q VPWR VGND sg13cmos5l_mux4_1
X_2500_ Tile_X0Y3_E2BEG[2] _2500_/A VPWR VGND sg13cmos5l_buf_1
XANTENNA__0594__A0 Tile_X0Y3_N2MID[5] VPWR VGND sg13cmos5l_antennanp
XFILLER_142_224 VPWR VGND sg13cmos5l_fill_1
X_2431_ Tile_X0Y0_FrameData_O[17] Tile_X0Y0_FrameData[17] VPWR VGND sg13cmos5l_buf_1
X_0692_ _2517_/A Tile_X0Y3_N4END[3] Tile_X0Y0_S4END[15] _0604_/X _0536_/X _2037_/Q
+ _2036_/Q VPWR VGND sg13cmos5l_mux4_1
XANTENNA__2102__D Tile_X0Y3_FrameData[29] VPWR VGND sg13cmos5l_antennanp
XFILLER_142_246 VPWR VGND sg13cmos5l_fill_1
XFILLER_142_279 VPWR VGND sg13cmos5l_fill_1
X_2362_ Tile_X0Y0_N4BEG[4] _2362_/A VPWR VGND sg13cmos5l_buf_1
XANTENNA__0897__A1 Tile_X0Y0_W6END[9] VPWR VGND sg13cmos5l_antennanp
XANTENNA__1941__D Tile_X0Y3_FrameData[30] VPWR VGND sg13cmos5l_antennanp
X_1313_ _1313_/Q Tile_X0Y0_FrameData[10] Tile_X0Y3_FrameStrobe[3] VPWR VGND sg13cmos5l_dlhq_1
X_2293_ Tile_X0Y2_E2BEGb[5] _2293_/A VPWR VGND sg13cmos5l_buf_1
XFILLER_110_143 VPWR VGND sg13cmos5l_fill_1
X_1244_ _1244_/Q Tile_X0Y0_FrameData[15] Tile_X0Y3_FrameStrobe[1] VPWR VGND sg13cmos5l_dlhq_1
XFILLER_56_219 VPWR VGND sg13cmos5l_decap_8
XFILLER_49_293 VPWR VGND sg13cmos5l_fill_2
X_1175_ AXIL_S_SOC_RDATA12 Tile_X0Y2_W2MID[4] Tile_X0Y2_W2END[4] Tile_X0Y2_W6END[4]
+ _0742_/X _1763_/Q _1762_/Q VPWR VGND sg13cmos5l_mux4_1
XFILLER_17_190 VPWR VGND sg13cmos5l_fill_2
XANTENNA_12 Tile_X0Y0_S2MID[1] VPWR VGND sg13cmos5l_antennanp
XANTENNA__1388__D Tile_X0Y0_FrameData[31] VPWR VGND sg13cmos5l_antennanp
XFILLER_32_193 VPWR VGND sg13cmos5l_decap_8
XANTENNA__2414__X Tile_X0Y0_FrameData_O[0] VPWR VGND sg13cmos5l_antennanp
XFILLER_21_16 VPWR VGND sg13cmos5l_decap_4
X_0959_ _2199_/A AXIL_S_SOC_WDATA16 AXIL_S_SOC_WDATA24 _0859_/X _0862_/X _1611_/Q
+ _1610_/Q VPWR VGND sg13cmos5l_mux4_1
XANTENNA__0585__A0 Tile_X0Y3_W2MID[6] VPWR VGND sg13cmos5l_antennanp
XANTENNA__1753__GATE Tile_X0Y3_FrameStrobe[1] VPWR VGND sg13cmos5l_antennanp
XANTENNA__2012__D Tile_X0Y3_FrameData[23] VPWR VGND sg13cmos5l_antennanp
XFILLER_217_60 VPWR VGND sg13cmos5l_fill_1
XFILLER_99_171 VPWR VGND sg13cmos5l_decap_8
XFILLER_217_82 VPWR VGND sg13cmos5l_decap_4
XANTENNA__0888__A1 Tile_X0Y3_W6END[5] VPWR VGND sg13cmos5l_antennanp
XANTENNA__1851__D Tile_X0Y2_FrameData[0] VPWR VGND sg13cmos5l_antennanp
XFILLER_141_290 VPWR VGND sg13cmos5l_decap_4
XANTENNA__1768__GATE Tile_X0Y3_FrameStrobe[2] VPWR VGND sg13cmos5l_antennanp
XFILLER_102_63 VPWR VGND sg13cmos5l_decap_4
XFILLER_203_239 VPWR VGND sg13cmos5l_fill_1
XFILLER_178_12 VPWR VGND sg13cmos5l_fill_2
XANTENNA__1298__D Tile_X0Y0_FrameData[25] VPWR VGND sg13cmos5l_antennanp
XFILLER_62_78 VPWR VGND sg13cmos5l_decap_8
XFILLER_211_261 VPWR VGND sg13cmos5l_decap_8
XANTENNA__1706__GATE Tile_X0Y3_FrameStrobe[0] VPWR VGND sg13cmos5l_antennanp
XANTENNA__2324__X Tile_X0Y2_FrameData_O[0] VPWR VGND sg13cmos5l_antennanp
XFILLER_211_294 VPWR VGND sg13cmos5l_fill_1
XFILLER_183_113 VPWR VGND sg13cmos5l_decap_8
XFILLER_109_232 VPWR VGND sg13cmos5l_fill_1
XFILLER_7_29 VPWR VGND sg13cmos5l_decap_4
XFILLER_109_254 VPWR VGND sg13cmos5l_decap_8
XANTENNA__0576__A0 Tile_X0Y3_W1END[3] VPWR VGND sg13cmos5l_antennanp
XFILLER_124_224 VPWR VGND sg13cmos5l_decap_8
XFILLER_2_0 VPWR VGND sg13cmos5l_fill_2
XFILLER_194_77 VPWR VGND sg13cmos5l_decap_8
XANTENNA__0879__A1 Tile_X0Y0_S4END[3] VPWR VGND sg13cmos5l_antennanp
XANTENNA__1761__D Tile_X0Y2_FrameData[26] VPWR VGND sg13cmos5l_antennanp
XFILLER_16_8 VPWR VGND sg13cmos5l_fill_2
XFILLER_61_277 VPWR VGND sg13cmos5l_fill_2
X_1931_ _1931_/Q Tile_X0Y2_FrameData[16] Tile_X0Y3_FrameStrobe[7] VPWR VGND sg13cmos5l_dlhq_1
XFILLER_202_250 VPWR VGND sg13cmos5l_fill_1
XANTENNA__2234__X Tile_X0Y1_EE4BEG[7] VPWR VGND sg13cmos5l_antennanp
X_1862_ _1862_/Q Tile_X0Y2_FrameData[21] Tile_X0Y3_FrameStrobe[5] VPWR VGND sg13cmos5l_dlhq_1
XFILLER_202_261 VPWR VGND sg13cmos5l_decap_8
XFILLER_159_198 VPWR VGND sg13cmos5l_decap_8
X_0813_ _0813_/Y _1380_/Q _0812_/X _1379_/Q VPWR VGND sg13cmos5l_a21oi_1
XANTENNA__1936__D Tile_X0Y2_FrameData[11] VPWR VGND sg13cmos5l_antennanp
X_1793_ _1793_/Q Tile_X0Y2_FrameData[26] Tile_X0Y3_FrameStrobe[3] VPWR VGND sg13cmos5l_dlhq_1
X_0744_ _0744_/X Tile_X0Y0_W2MID[4] Tile_X0Y0_W2END[4] Tile_X0Y0_W6END[11] _0712_/X
+ _1393_/Q _1392_/Q VPWR VGND sg13cmos5l_mux4_1
XFILLER_115_257 VPWR VGND sg13cmos5l_fill_1
X_0675_ _2528_/A _0638_/Y _0561_/X AXIL_S_SOC_ARADDR9 _0594_/X _2070_/Q _2071_/Q VPWR
+ VGND sg13cmos5l_mux4_1
XANTENNA__2410__A Tile_X0Y3_FrameStrobe[16] VPWR VGND sg13cmos5l_antennanp
XFILLER_115_279 VPWR VGND sg13cmos5l_fill_1
X_2414_ Tile_X0Y0_FrameData_O[0] Tile_X0Y0_FrameData[0] VPWR VGND sg13cmos5l_buf_1
XFILLER_123_290 VPWR VGND sg13cmos5l_decap_4
XFILLER_35_0 VPWR VGND sg13cmos5l_fill_2
XANTENNA__1671__D Tile_X0Y1_FrameData[28] VPWR VGND sg13cmos5l_antennanp
X_2345_ Tile_X0Y2_FrameData_O[21] Tile_X0Y2_FrameData[21] VPWR VGND sg13cmos5l_buf_1
XFILLER_96_141 VPWR VGND sg13cmos5l_decap_8
X_2276_ Tile_X0Y2_E1BEG[0] _2276_/A VPWR VGND sg13cmos5l_buf_1
XANTENNA__2409__X Tile_X0Y0_FrameStrobe_O[15] VPWR VGND sg13cmos5l_antennanp
X_1227_ _1227_/Q Tile_X0Y0_FrameData[0] Tile_X0Y3_FrameStrobe[0] VPWR VGND sg13cmos5l_dlhq_1
X_1158_ _2277_/A _0888_/X _0553_/X AXIL_S_SOC_WDATA3 AXIL_S_SOC_WDATA6 _1865_/Q _1864_/Q
+ VPWR VGND sg13cmos5l_mux4_1
XFILLER_52_244 VPWR VGND sg13cmos5l_decap_4
XFILLER_203_84 VPWR VGND sg13cmos5l_decap_8
X_1089_ _2295_/A AXIL_S_SOC_WDATA7 AXIL_S_SOC_WDATA15 _0719_/X _0758_/X _1829_/Q _1828_/Q
+ VPWR VGND sg13cmos5l_mux4_1
XFILLER_197_238 VPWR VGND sg13cmos5l_decap_8
XANTENNA__2007__D Tile_X0Y3_FrameData[28] VPWR VGND sg13cmos5l_antennanp
XFILLER_20_130 VPWR VGND sg13cmos5l_decap_4
XANTENNA__1846__D Tile_X0Y2_FrameData[5] VPWR VGND sg13cmos5l_antennanp
XFILLER_165_157 VPWR VGND sg13cmos5l_decap_4
XANTENNA__1692__GATE Tile_X0Y3_FrameStrobe[0] VPWR VGND sg13cmos5l_antennanp
XFILLER_114_290 VPWR VGND sg13cmos5l_decap_4
XANTENNA__1581__D Tile_X0Y1_FrameData[22] VPWR VGND sg13cmos5l_antennanp
XANTENNA__0730__A0 Tile_X0Y0_W1END[1] VPWR VGND sg13cmos5l_antennanp
XFILLER_57_67 VPWR VGND sg13cmos5l_decap_4
XANTENNA__2319__X Tile_X0Y2_EE4BEG[11] VPWR VGND sg13cmos5l_antennanp
XFILLER_113_40 VPWR VGND sg13cmos5l_decap_4
XANTENNA__1630__GATE Tile_X0Y3_FrameStrobe[5] VPWR VGND sg13cmos5l_antennanp
XFILLER_113_51 VPWR VGND sg13cmos5l_fill_1
XFILLER_73_55 VPWR VGND sg13cmos5l_fill_2
XFILLER_28_285 VPWR VGND sg13cmos5l_fill_2
XFILLER_73_88 VPWR VGND sg13cmos5l_decap_8
XFILLER_43_266 VPWR VGND sg13cmos5l_fill_2
XFILLER_43_255 VPWR VGND sg13cmos5l_decap_8
XFILLER_188_227 VPWR VGND sg13cmos5l_decap_4
XANTENNA__1645__GATE Tile_X0Y3_FrameStrobe[6] VPWR VGND sg13cmos5l_antennanp
XFILLER_196_271 VPWR VGND sg13cmos5l_decap_8
XFILLER_7_123 VPWR VGND sg13cmos5l_decap_8
XANTENNA__1756__D Tile_X0Y2_FrameData[31] VPWR VGND sg13cmos5l_antennanp
XFILLER_22_70 VPWR VGND sg13cmos5l_fill_1
XFILLER_208_29 VPWR VGND sg13cmos5l_decap_8
XFILLER_208_18 VPWR VGND sg13cmos5l_decap_4
X_0460_ _0460_/Y _1199_/Q _1198_/Q _0770_/X VPWR VGND sg13cmos5l_nor3_1
XFILLER_98_85 VPWR VGND sg13cmos5l_decap_8
XANTENNA__1491__D Tile_X0Y1_FrameData[16] VPWR VGND sg13cmos5l_antennanp
XFILLER_154_91 VPWR VGND sg13cmos5l_decap_8
XANTENNA__0721__A0 Tile_X0Y0_W1END[3] VPWR VGND sg13cmos5l_antennanp
X_2130_ _2130_/Q Tile_X0Y3_FrameData[1] Tile_X0Y3_FrameStrobe[5] VPWR VGND sg13cmos5l_dlhq_1
XFILLER_78_196 VPWR VGND sg13cmos5l_decap_8
XANTENNA__2229__X Tile_X0Y1_EE4BEG[2] VPWR VGND sg13cmos5l_antennanp
XFILLER_120_293 VPWR VGND sg13cmos5l_fill_2
X_2061_ _2061_/Q Tile_X0Y3_FrameData[6] Tile_X0Y3_FrameStrobe[3] VPWR VGND sg13cmos5l_dlhq_1
X_1012_ AXIL_S_SOC_RDATA26 Tile_X0Y1_W2MID[6] Tile_X0Y1_W2END[6] Tile_X0Y1_W6END[6]
+ _0866_/X _1511_/Q _1510_/Q VPWR VGND sg13cmos5l_mux4_1
XANTENNA__2405__A Tile_X0Y3_FrameStrobe[11] VPWR VGND sg13cmos5l_antennanp
X_1914_ _1914_/Q Tile_X0Y2_FrameData[1] Tile_X0Y3_FrameStrobe[6] VPWR VGND sg13cmos5l_dlhq_1
XANTENNA__1666__D Tile_X0Y1_FrameData[1] VPWR VGND sg13cmos5l_antennanp
X_1845_ _1845_/Q Tile_X0Y2_FrameData[6] Tile_X0Y3_FrameStrobe[4] VPWR VGND sg13cmos5l_dlhq_1
X_1776_ _1776_/Q Tile_X0Y2_FrameData[11] Tile_X0Y3_FrameStrobe[2] VPWR VGND sg13cmos5l_dlhq_1
X_0727_ _0727_/X Tile_X0Y0_W1END[2] Tile_X0Y0_W2END[1] Tile_X0Y0_W2MID[1] _0751_/X
+ _1386_/Q _1387_/Q VPWR VGND sg13cmos5l_mux4_1
XFILLER_170_160 VPWR VGND sg13cmos5l_decap_8
X_0658_ _2499_/A _0655_/X _0584_/X AXIL_S_SOC_ARADDR4 _0598_/X _2104_/Q _2105_/Q VPWR
+ VGND sg13cmos5l_mux4_1
XFILLER_134_28 VPWR VGND sg13cmos5l_fill_2
X_0589_ _2590_/A Tile_X0Y2_W1END[0] Tile_X0Y2_W2END[3] Tile_X0Y2_W2MID[3] _0742_/X
+ _1886_/Q _1887_/Q VPWR VGND sg13cmos5l_mux4_1
X_2328_ Tile_X0Y2_FrameData_O[4] Tile_X0Y2_FrameData[4] VPWR VGND sg13cmos5l_buf_1
XFILLER_111_293 VPWR VGND sg13cmos5l_fill_2
XFILLER_84_133 VPWR VGND sg13cmos5l_fill_2
XFILLER_214_72 VPWR VGND sg13cmos5l_fill_2
X_2259_ Tile_X0Y1_FrameData_O[16] Tile_X0Y1_FrameData[16] VPWR VGND sg13cmos5l_buf_1
XFILLER_214_94 VPWR VGND sg13cmos5l_decap_8
XFILLER_168_8 VPWR VGND sg13cmos5l_fill_1
XFILLER_225_161 VPWR VGND sg13cmos5l_decap_8
XFILLER_225_172 VPWR VGND sg13cmos5l_fill_1
XFILLER_159_14 VPWR VGND sg13cmos5l_fill_1
XFILLER_40_269 VPWR VGND sg13cmos5l_decap_8
XFILLER_159_69 VPWR VGND sg13cmos5l_decap_4
XANTENNA__1576__D Tile_X0Y1_FrameData[27] VPWR VGND sg13cmos5l_antennanp
XANTENNA__2602__X Tile_X0Y3_S4BEG[8] VPWR VGND sg13cmos5l_antennanp
XFILLER_153_127 VPWR VGND sg13cmos5l_decap_4
XFILLER_175_35 VPWR VGND sg13cmos5l_fill_2
XFILLER_175_46 VPWR VGND sg13cmos5l_decap_8
XFILLER_108_40 VPWR VGND sg13cmos5l_fill_2
XFILLER_108_62 VPWR VGND sg13cmos5l_fill_2
XFILLER_4_19 VPWR VGND sg13cmos5l_decap_4
XANTENNA__0489__B Tile_X0Y0_S1END[3] VPWR VGND sg13cmos5l_antennanp
XFILLER_68_22 VPWR VGND sg13cmos5l_decap_8
XFILLER_68_77 VPWR VGND sg13cmos5l_fill_1
XANTENNA__0703__A0 Tile_X0Y3_W2MID[6] VPWR VGND sg13cmos5l_antennanp
XFILLER_191_67 VPWR VGND sg13cmos5l_decap_8
XFILLER_102_293 VPWR VGND sg13cmos5l_fill_2
XFILLER_187_0 VPWR VGND sg13cmos5l_fill_2
XFILLER_90_136 VPWR VGND sg13cmos5l_decap_8
XFILLER_216_150 VPWR VGND sg13cmos5l_decap_8
XFILLER_16_255 VPWR VGND sg13cmos5l_decap_8
XFILLER_216_183 VPWR VGND sg13cmos5l_decap_4
XFILLER_210_19 VPWR VGND sg13cmos5l_fill_1
XANTENNA__0482__A2 Tile_X0Y1_W6END[10] VPWR VGND sg13cmos5l_antennanp
XANTENNA__1584__GATE Tile_X0Y3_FrameStrobe[4] VPWR VGND sg13cmos5l_antennanp
XFILLER_31_214 VPWR VGND sg13cmos5l_decap_8
XFILLER_129_113 VPWR VGND sg13cmos5l_decap_8
XFILLER_169_293 VPWR VGND sg13cmos5l_fill_2
XANTENNA__1486__D Tile_X0Y1_FrameData[21] VPWR VGND sg13cmos5l_antennanp
XANTENNA__1599__GATE Tile_X0Y3_FrameStrobe[4] VPWR VGND sg13cmos5l_antennanp
XANTENNA__0785__A3 Tile_X0Y0_S4END[2] VPWR VGND sg13cmos5l_antennanp
XANTENNA__2512__X Tile_X0Y3_E2BEGb[6] VPWR VGND sg13cmos5l_antennanp
X_1630_ _1630_/Q Tile_X0Y1_FrameData[5] Tile_X0Y3_FrameStrobe[5] VPWR VGND sg13cmos5l_dlhq_1
XANTENNA__1195__A0 Tile_X0Y2_W1END[1] VPWR VGND sg13cmos5l_antennanp
XANTENNA__1522__GATE Tile_X0Y3_FrameStrobe[2] VPWR VGND sg13cmos5l_antennanp
X_1561_ _1561_/Q Tile_X0Y1_FrameData[10] Tile_X0Y3_FrameStrobe[3] VPWR VGND sg13cmos5l_dlhq_1
X_1492_ _1492_/Q Tile_X0Y1_FrameData[15] Tile_X0Y3_FrameStrobe[1] VPWR VGND sg13cmos5l_dlhq_1
X_0512_ _0512_/X _0506_/X _0507_/X _0508_/X _0511_/X _2154_/Q _2153_/Q VPWR VGND sg13cmos5l_mux4_1
XFILLER_98_236 VPWR VGND sg13cmos5l_fill_2
XFILLER_98_225 VPWR VGND sg13cmos5l_decap_8
X_0443_ _0443_/Y _1408_/Q VPWR VGND sg13cmos5l_inv_1
XANTENNA__2110__D Tile_X0Y3_FrameData[21] VPWR VGND sg13cmos5l_antennanp
XANTENNA__1537__GATE Tile_X0Y3_FrameStrobe[2] VPWR VGND sg13cmos5l_antennanp
X_2113_ _2113_/Q Tile_X0Y3_FrameData[18] Tile_X0Y3_FrameStrobe[5] VPWR VGND sg13cmos5l_dlhq_1
X_2044_ _2044_/Q Tile_X0Y3_FrameData[23] Tile_X0Y3_FrameStrobe[3] VPWR VGND sg13cmos5l_dlhq_1
XFILLER_66_188 VPWR VGND sg13cmos5l_decap_4
XFILLER_81_158 VPWR VGND sg13cmos5l_decap_8
XFILLER_167_208 VPWR VGND sg13cmos5l_decap_4
XFILLER_22_258 VPWR VGND sg13cmos5l_decap_8
XANTENNA__1396__D Tile_X0Y0_FrameData[23] VPWR VGND sg13cmos5l_antennanp
XANTENNA__2422__X Tile_X0Y0_FrameData_O[8] VPWR VGND sg13cmos5l_antennanp
X_1828_ _1828_/Q Tile_X0Y2_FrameData[23] Tile_X0Y3_FrameStrobe[4] VPWR VGND sg13cmos5l_dlhq_1
XFILLER_175_274 VPWR VGND sg13cmos5l_fill_2
X_1759_ _1759_/Q Tile_X0Y2_FrameData[28] Tile_X0Y3_FrameStrobe[2] VPWR VGND sg13cmos5l_dlhq_1
XFILLER_209_94 VPWR VGND sg13cmos5l_fill_2
XFILLER_143_171 VPWR VGND sg13cmos5l_decap_8
XFILLER_89_269 VPWR VGND sg13cmos5l_fill_2
XANTENNA__2020__D Tile_X0Y3_FrameData[15] VPWR VGND sg13cmos5l_antennanp
XFILLER_225_93 VPWR VGND sg13cmos5l_decap_8
XFILLER_225_71 VPWR VGND sg13cmos5l_fill_2
XFILLER_161_15 VPWR VGND sg13cmos5l_decap_8
XFILLER_38_58 VPWR VGND sg13cmos5l_decap_8
XFILLER_72_136 VPWR VGND sg13cmos5l_fill_1
XFILLER_213_142 VPWR VGND sg13cmos5l_decap_8
XFILLER_158_208 VPWR VGND sg13cmos5l_fill_1
XANTENNA__2332__X Tile_X0Y2_FrameData_O[8] VPWR VGND sg13cmos5l_antennanp
XFILLER_186_89 VPWR VGND sg13cmos5l_decap_8
XANTENNA__0519__A3 Tile_X0Y0_S4END[0] VPWR VGND sg13cmos5l_antennanp
XANTENNA__1177__A0 AXIL_S_SOC_WDATA3 VPWR VGND sg13cmos5l_antennanp
XFILLER_102_0 VPWR VGND sg13cmos5l_fill_2
XFILLER_141_108 VPWR VGND sg13cmos5l_decap_8
XFILLER_79_21 VPWR VGND sg13cmos5l_decap_8
XANTENNA__0924__A0 Tile_X0Y1_W1END[1] VPWR VGND sg13cmos5l_antennanp
XFILLER_95_31 VPWR VGND sg13cmos5l_decap_8
XFILLER_88_280 VPWR VGND sg13cmos5l_decap_8
XFILLER_48_144 VPWR VGND sg13cmos5l_decap_8
XFILLER_95_86 VPWR VGND sg13cmos5l_decap_8
XFILLER_63_114 VPWR VGND sg13cmos5l_fill_2
XFILLER_28_91 VPWR VGND sg13cmos5l_fill_2
XANTENNA__2507__X Tile_X0Y3_E2BEGb[1] VPWR VGND sg13cmos5l_antennanp
XFILLER_151_81 VPWR VGND sg13cmos5l_decap_8
XFILLER_151_92 VPWR VGND sg13cmos5l_fill_2
X_0992_ _0993_/B _1627_/Q _0991_/Y _0450_/Y VPWR VGND sg13cmos5l_o21ai_1
XFILLER_44_90 VPWR VGND sg13cmos5l_decap_8
XANTENNA__2105__D Tile_X0Y3_FrameData[26] VPWR VGND sg13cmos5l_antennanp
XANTENNA__2242__X Tile_X0Y1_EE4BEG[15] VPWR VGND sg13cmos5l_antennanp
XFILLER_8_273 VPWR VGND sg13cmos5l_decap_8
XFILLER_172_233 VPWR VGND sg13cmos5l_fill_2
XFILLER_172_222 VPWR VGND sg13cmos5l_decap_8
XANTENNA__1461__GATE Tile_X0Y3_FrameStrobe[0] VPWR VGND sg13cmos5l_antennanp
XANTENNA__1944__D Tile_X0Y3_FrameData[27] VPWR VGND sg13cmos5l_antennanp
X_1613_ _1613_/Q Tile_X0Y1_FrameData[22] Tile_X0Y3_FrameStrobe[5] VPWR VGND sg13cmos5l_dlhq_1
X_2593_ Tile_X0Y3_S2BEGb[7] _2593_/A VPWR VGND sg13cmos5l_buf_1
XFILLER_132_119 VPWR VGND sg13cmos5l_decap_8
X_1544_ _1544_/Q Tile_X0Y1_FrameData[27] Tile_X0Y3_FrameStrobe[3] VPWR VGND sg13cmos5l_dlhq_1
XFILLER_140_141 VPWR VGND sg13cmos5l_decap_8
XANTENNA__1476__GATE Tile_X0Y3_FrameStrobe[1] VPWR VGND sg13cmos5l_antennanp
X_1475_ _1475_/Q Tile_X0Y1_FrameData[0] Tile_X0Y3_FrameStrobe[0] VPWR VGND sg13cmos5l_dlhq_1
XFILLER_131_18 VPWR VGND sg13cmos5l_fill_1
XFILLER_94_294 VPWR VGND sg13cmos5l_fill_1
XANTENNA__2417__X Tile_X0Y0_FrameData_O[3] VPWR VGND sg13cmos5l_antennanp
X_2027_ _2027_/Q Tile_X0Y3_FrameData[8] Tile_X0Y3_FrameStrobe[2] VPWR VGND sg13cmos5l_dlhq_1
XFILLER_211_95 VPWR VGND sg13cmos5l_fill_1
XFILLER_210_101 VPWR VGND sg13cmos5l_decap_8
XANTENNA__1414__GATE Tile_X0Y3_FrameStrobe[6] VPWR VGND sg13cmos5l_antennanp
XFILLER_210_145 VPWR VGND sg13cmos5l_decap_8
XANTENNA__2015__D Tile_X0Y3_FrameData[20] VPWR VGND sg13cmos5l_antennanp
XFILLER_40_15 VPWR VGND sg13cmos5l_fill_2
XANTENNA__1429__GATE Tile_X0Y3_FrameStrobe[7] VPWR VGND sg13cmos5l_antennanp
XFILLER_108_127 VPWR VGND sg13cmos5l_fill_1
XANTENNA__1854__D Tile_X0Y2_FrameData[29] VPWR VGND sg13cmos5l_antennanp
XFILLER_156_37 VPWR VGND sg13cmos5l_fill_1
XFILLER_156_48 VPWR VGND sg13cmos5l_fill_2
XFILLER_49_46 VPWR VGND sg13cmos5l_decap_8
XFILLER_49_79 VPWR VGND sg13cmos5l_fill_1
XFILLER_65_23 VPWR VGND sg13cmos5l_decap_8
XANTENNA__0685__A2 AXIL_S_SOC_ARADDR7 VPWR VGND sg13cmos5l_antennanp
XFILLER_45_136 VPWR VGND sg13cmos5l_fill_1
XANTENNA__2327__X Tile_X0Y2_FrameData_O[3] VPWR VGND sg13cmos5l_antennanp
XFILLER_121_84 VPWR VGND sg13cmos5l_decap_8
XFILLER_198_163 VPWR VGND sg13cmos5l_decap_8
XFILLER_81_77 VPWR VGND sg13cmos5l_fill_2
XFILLER_81_55 VPWR VGND sg13cmos5l_fill_1
XFILLER_201_112 VPWR VGND sg13cmos5l_fill_2
XFILLER_198_185 VPWR VGND sg13cmos5l_fill_1
XFILLER_197_88 VPWR VGND sg13cmos5l_fill_1
XFILLER_14_82 VPWR VGND sg13cmos5l_fill_2
XFILLER_154_211 VPWR VGND sg13cmos5l_fill_2
XANTENNA__1764__D Tile_X0Y2_FrameData[23] VPWR VGND sg13cmos5l_antennanp
XANTENNA__2191__GATE Tile_X0Y3_FrameStrobe[7] VPWR VGND sg13cmos5l_antennanp
XFILLER_107_171 VPWR VGND sg13cmos5l_decap_8
X_1260_ _1260_/Q Tile_X0Y0_FrameData[31] Tile_X0Y3_FrameStrobe[2] VPWR VGND sg13cmos5l_dlhq_1
X_1191_ _1192_/B Tile_X0Y3_W1END[0] Tile_X0Y3_W6END[8] Tile_X0Y3_WW4END[0] _0607_/X
+ _2162_/Q _2163_/Q VPWR VGND sg13cmos5l_mux4_1
XFILLER_76_250 VPWR VGND sg13cmos5l_decap_8
XFILLER_39_90 VPWR VGND sg13cmos5l_fill_2
XFILLER_76_294 VPWR VGND sg13cmos5l_fill_1
XANTENNA__2237__X Tile_X0Y1_EE4BEG[10] VPWR VGND sg13cmos5l_antennanp
XFILLER_224_248 VPWR VGND sg13cmos5l_fill_1
XANTENNA__1939__D Tile_X0Y2_FrameData[8] VPWR VGND sg13cmos5l_antennanp
XFILLER_189_152 VPWR VGND sg13cmos5l_fill_2
XANTENNA__2144__GATE Tile_X0Y3_FrameStrobe[6] VPWR VGND sg13cmos5l_antennanp
X_0975_ _0975_/Y _1625_/Q _0932_/Y _1624_/Q VPWR VGND sg13cmos5l_a21oi_1
XANTENNA__2413__A Tile_X0Y3_FrameStrobe[19] VPWR VGND sg13cmos5l_antennanp
XFILLER_65_0 VPWR VGND sg13cmos5l_fill_2
XANTENNA__0600__A2 Tile_X0Y2_W2MID[0] VPWR VGND sg13cmos5l_antennanp
XANTENNA__1674__D Tile_X0Y1_FrameData[25] VPWR VGND sg13cmos5l_antennanp
XANTENNA__2159__GATE Tile_X0Y3_FrameStrobe[6] VPWR VGND sg13cmos5l_antennanp
XFILLER_145_266 VPWR VGND sg13cmos5l_decap_8
XFILLER_160_269 VPWR VGND sg13cmos5l_decap_8
X_2576_ Tile_X0Y3_S1BEG[2] _2576_/A VPWR VGND sg13cmos5l_buf_1
XFILLER_113_152 VPWR VGND sg13cmos5l_decap_8
X_1527_ _1527_/Q Tile_X0Y1_FrameData[12] Tile_X0Y3_FrameStrobe[2] VPWR VGND sg13cmos5l_dlhq_1
XFILLER_59_217 VPWR VGND sg13cmos5l_decap_8
X_1458_ _1458_/Q Tile_X0Y1_FrameData[17] Tile_X0Y3_FrameStrobe[0] VPWR VGND sg13cmos5l_dlhq_1
XFILLER_74_209 VPWR VGND sg13cmos5l_decap_4
XANTENNA__0667__A2 AXIL_S_SOC_ARADDR5 VPWR VGND sg13cmos5l_antennanp
X_1389_ _1389_/Q Tile_X0Y0_FrameData[30] Tile_X0Y3_FrameStrobe[6] VPWR VGND sg13cmos5l_dlhq_1
XFILLER_222_72 VPWR VGND sg13cmos5l_decap_8
XFILLER_27_169 VPWR VGND sg13cmos5l_fill_1
XANTENNA__1353__GATE Tile_X0Y3_FrameStrobe[4] VPWR VGND sg13cmos5l_antennanp
XANTENNA__1849__D Tile_X0Y2_FrameData[2] VPWR VGND sg13cmos5l_antennanp
XFILLER_35_191 VPWR VGND sg13cmos5l_decap_8
XANTENNA__0890__X AXIL_S_SOC_AWREADY VPWR VGND sg13cmos5l_antennanp
XANTENNA__1983__GATE Tile_X0Y3_FrameStrobe[1] VPWR VGND sg13cmos5l_antennanp
XFILLER_51_25 VPWR VGND sg13cmos5l_fill_2
XFILLER_51_14 VPWR VGND sg13cmos5l_decap_4
XFILLER_195_155 VPWR VGND sg13cmos5l_decap_8
XANTENNA__1368__GATE Tile_X0Y3_FrameStrobe[5] VPWR VGND sg13cmos5l_antennanp
XFILLER_167_36 VPWR VGND sg13cmos5l_decap_8
XANTENNA__1998__GATE Tile_X0Y3_FrameStrobe[1] VPWR VGND sg13cmos5l_antennanp
XANTENNA__1584__D Tile_X0Y1_FrameData[19] VPWR VGND sg13cmos5l_antennanp
XANTENNA__2610__X Tile_X0Y3_UserCLKo VPWR VGND sg13cmos5l_antennanp
XFILLER_151_214 VPWR VGND sg13cmos5l_fill_2
XANTENNA__1921__GATE Tile_X0Y3_FrameStrobe[7] VPWR VGND sg13cmos5l_antennanp
XFILLER_151_258 VPWR VGND sg13cmos5l_decap_8
XFILLER_116_84 VPWR VGND sg13cmos5l_decap_8
XANTENNA__1306__GATE Tile_X0Y3_FrameStrobe[3] VPWR VGND sg13cmos5l_antennanp
XFILLER_65_209 VPWR VGND sg13cmos5l_decap_8
XANTENNA__1936__GATE Tile_X0Y3_FrameStrobe[7] VPWR VGND sg13cmos5l_antennanp
XFILLER_58_294 VPWR VGND sg13cmos5l_fill_1
XFILLER_58_272 VPWR VGND sg13cmos5l_decap_8
XANTENNA__0658__A2 AXIL_S_SOC_ARADDR4 VPWR VGND sg13cmos5l_antennanp
XFILLER_132_61 VPWR VGND sg13cmos5l_fill_2
XFILLER_132_83 VPWR VGND sg13cmos5l_fill_1
XFILLER_92_43 VPWR VGND sg13cmos5l_decap_8
XANTENNA__1759__D Tile_X0Y2_FrameData[28] VPWR VGND sg13cmos5l_antennanp
XFILLER_26_180 VPWR VGND sg13cmos5l_decap_8
XFILLER_186_100 VPWR VGND sg13cmos5l_fill_2
X_0760_ _0760_/X _0709_/X Tile_X0Y0_S1END[0] Tile_X0Y3_N4END[12] Tile_X0Y0_S4END[0]
+ _1234_/Q _1235_/Q VPWR VGND sg13cmos5l_mux4_1
XANTENNA__1494__D Tile_X0Y1_FrameData[13] VPWR VGND sg13cmos5l_antennanp
XFILLER_127_244 VPWR VGND sg13cmos5l_decap_4
XFILLER_127_266 VPWR VGND sg13cmos5l_decap_8
XANTENNA__0594__A1 Tile_X0Y3_N2END[5] VPWR VGND sg13cmos5l_antennanp
XANTENNA__2520__X Tile_X0Y3_E6BEG[6] VPWR VGND sg13cmos5l_antennanp
XFILLER_157_91 VPWR VGND sg13cmos5l_decap_8
X_2430_ Tile_X0Y0_FrameData_O[16] Tile_X0Y0_FrameData[16] VPWR VGND sg13cmos5l_buf_1
X_0691_ _2516_/A Tile_X0Y3_N4END[2] Tile_X0Y0_S4END[14] _0611_/X _0561_/X _2039_/Q
+ _2038_/Q VPWR VGND sg13cmos5l_mux4_1
XFILLER_142_258 VPWR VGND sg13cmos5l_decap_8
X_2361_ Tile_X0Y0_N4BEG[3] _2361_/A VPWR VGND sg13cmos5l_buf_1
XANTENNA__0897__A2 Tile_X0Y0_WW4END[14] VPWR VGND sg13cmos5l_antennanp
XFILLER_110_122 VPWR VGND sg13cmos5l_fill_1
XFILLER_150_280 VPWR VGND sg13cmos5l_fill_2
X_1312_ _1312_/Q Tile_X0Y0_FrameData[11] Tile_X0Y3_FrameStrobe[3] VPWR VGND sg13cmos5l_dlhq_1
X_2292_ Tile_X0Y2_E2BEGb[4] _2292_/A VPWR VGND sg13cmos5l_buf_1
X_1243_ _1243_/Q Tile_X0Y0_FrameData[16] Tile_X0Y3_FrameStrobe[1] VPWR VGND sg13cmos5l_dlhq_1
XFILLER_49_250 VPWR VGND sg13cmos5l_fill_2
XFILLER_2_30 VPWR VGND sg13cmos5l_fill_1
XFILLER_110_188 VPWR VGND sg13cmos5l_decap_8
XFILLER_2_63 VPWR VGND sg13cmos5l_fill_2
X_1174_ AXIL_S_SOC_RDATA13 Tile_X0Y2_W2MID[5] Tile_X0Y2_W2END[5] Tile_X0Y2_W6END[5]
+ _0732_/X _1761_/Q _1760_/Q VPWR VGND sg13cmos5l_mux4_1
XFILLER_64_242 VPWR VGND sg13cmos5l_fill_1
XFILLER_64_231 VPWR VGND sg13cmos5l_decap_8
XFILLER_2_96 VPWR VGND sg13cmos5l_decap_4
XANTENNA__2408__A Tile_X0Y3_FrameStrobe[14] VPWR VGND sg13cmos5l_antennanp
XANTENNA__1669__D Tile_X0Y1_FrameData[30] VPWR VGND sg13cmos5l_antennanp
XANTENNA__2083__GATE Tile_X0Y3_FrameStrobe[4] VPWR VGND sg13cmos5l_antennanp
XFILLER_32_172 VPWR VGND sg13cmos5l_decap_8
XANTENNA__2098__GATE Tile_X0Y3_FrameStrobe[4] VPWR VGND sg13cmos5l_antennanp
X_0958_ _2200_/A AXIL_S_SOC_WDATA17 AXIL_S_SOC_WDATA25 _0864_/X _0866_/X _1609_/Q
+ _1608_/Q VPWR VGND sg13cmos5l_mux4_1
XANTENNA__0585__A1 Tile_X0Y3_W2END[6] VPWR VGND sg13cmos5l_antennanp
XANTENNA__2430__X Tile_X0Y0_FrameData_O[16] VPWR VGND sg13cmos5l_antennanp
XFILLER_118_277 VPWR VGND sg13cmos5l_decap_4
X_0889_ _0889_/X Tile_X0Y3_W1END[0] Tile_X0Y3_W6END[4] _0536_/X _0540_/Y _2187_/Q
+ _2186_/Q VPWR VGND sg13cmos5l_mux4_1
XANTENNA__2021__GATE Tile_X0Y3_FrameStrobe[2] VPWR VGND sg13cmos5l_antennanp
XFILLER_133_269 VPWR VGND sg13cmos5l_fill_1
X_2559_ Tile_X0Y3_FrameData_O[17] Tile_X0Y3_FrameData[17] VPWR VGND sg13cmos5l_buf_1
XFILLER_101_100 VPWR VGND sg13cmos5l_fill_2
XFILLER_47_209 VPWR VGND sg13cmos5l_decap_8
XANTENNA__2036__GATE Tile_X0Y3_FrameStrobe[3] VPWR VGND sg13cmos5l_antennanp
XFILLER_101_188 VPWR VGND sg13cmos5l_fill_1
XFILLER_46_36 VPWR VGND sg13cmos5l_decap_8
XANTENNA__1292__GATE Tile_X0Y3_FrameStrobe[3] VPWR VGND sg13cmos5l_antennanp
XFILLER_70_212 VPWR VGND sg13cmos5l_fill_2
XANTENNA__1579__D Tile_X0Y1_FrameData[24] VPWR VGND sg13cmos5l_antennanp
XFILLER_102_75 VPWR VGND sg13cmos5l_fill_1
XFILLER_70_278 VPWR VGND sg13cmos5l_fill_1
XFILLER_62_24 VPWR VGND sg13cmos5l_fill_2
XANTENNA__2605__X Tile_X0Y3_S4BEG[11] VPWR VGND sg13cmos5l_antennanp
XFILLER_168_144 VPWR VGND sg13cmos5l_fill_1
XFILLER_211_240 VPWR VGND sg13cmos5l_decap_8
XFILLER_168_166 VPWR VGND sg13cmos5l_fill_2
XFILLER_211_284 VPWR VGND sg13cmos5l_fill_1
XFILLER_178_57 VPWR VGND sg13cmos5l_decap_8
XFILLER_109_211 VPWR VGND sg13cmos5l_decap_8
XANTENNA__1230__GATE Tile_X0Y3_FrameStrobe[1] VPWR VGND sg13cmos5l_antennanp
XANTENNA__2340__X Tile_X0Y2_FrameData_O[16] VPWR VGND sg13cmos5l_antennanp
XFILLER_194_56 VPWR VGND sg13cmos5l_decap_8
XANTENNA__1860__GATE Tile_X0Y3_FrameStrobe[5] VPWR VGND sg13cmos5l_antennanp
XFILLER_127_72 VPWR VGND sg13cmos5l_decap_8
XFILLER_127_83 VPWR VGND sg13cmos5l_fill_2
XFILLER_87_43 VPWR VGND sg13cmos5l_fill_1
XFILLER_87_32 VPWR VGND sg13cmos5l_fill_2
XANTENNA__1245__GATE Tile_X0Y3_FrameStrobe[1] VPWR VGND sg13cmos5l_antennanp
XANTENNA__1875__GATE Tile_X0Y3_FrameStrobe[5] VPWR VGND sg13cmos5l_antennanp
XFILLER_46_220 VPWR VGND sg13cmos5l_fill_1
XANTENNA__1132__A Tile_X0Y2_W1END[0] VPWR VGND sg13cmos5l_antennanp
XANTENNA__1489__D Tile_X0Y1_FrameData[18] VPWR VGND sg13cmos5l_antennanp
XFILLER_61_256 VPWR VGND sg13cmos5l_decap_8
XANTENNA__2515__X Tile_X0Y3_E6BEG[1] VPWR VGND sg13cmos5l_antennanp
XFILLER_159_111 VPWR VGND sg13cmos5l_decap_8
XFILLER_159_144 VPWR VGND sg13cmos5l_fill_1
X_1930_ _1930_/Q Tile_X0Y2_FrameData[17] Tile_X0Y3_FrameStrobe[7] VPWR VGND sg13cmos5l_dlhq_1
XANTENNA__1813__GATE Tile_X0Y3_FrameStrobe[3] VPWR VGND sg13cmos5l_antennanp
XFILLER_159_155 VPWR VGND sg13cmos5l_decap_4
XFILLER_159_177 VPWR VGND sg13cmos5l_decap_8
X_1861_ _1861_/Q Tile_X0Y2_FrameData[22] Tile_X0Y3_FrameStrobe[5] VPWR VGND sg13cmos5l_dlhq_1
X_0812_ _0812_/X Tile_X0Y0_WW4END[13] _0772_/X _1378_/Q VPWR VGND sg13cmos5l_mux2_1
X_1792_ _1792_/Q Tile_X0Y2_FrameData[27] Tile_X0Y3_FrameStrobe[3] VPWR VGND sg13cmos5l_dlhq_1
XANTENNA__1828__GATE Tile_X0Y3_FrameStrobe[4] VPWR VGND sg13cmos5l_antennanp
XANTENNA__2113__D Tile_X0Y3_FrameData[18] VPWR VGND sg13cmos5l_antennanp
XFILLER_115_214 VPWR VGND sg13cmos5l_fill_1
X_0743_ _2386_/A Tile_X0Y0_W2MID[3] Tile_X0Y0_W2END[3] Tile_X0Y0_W6END[3] _0739_/X
+ _1427_/Q _1426_/Q VPWR VGND sg13cmos5l_mux4_1
XANTENNA__2250__X Tile_X0Y1_FrameData_O[7] VPWR VGND sg13cmos5l_antennanp
X_0674_ _2527_/A _0655_/X _0480_/X AXIL_S_SOC_ARADDR8 _0598_/X _2072_/Q _2073_/Q VPWR
+ VGND sg13cmos5l_mux4_1
XANTENNA__1952__D Tile_X0Y3_FrameData[19] VPWR VGND sg13cmos5l_antennanp
XFILLER_130_217 VPWR VGND sg13cmos5l_decap_8
X_2413_ Tile_X0Y0_FrameStrobe_O[19] Tile_X0Y3_FrameStrobe[19] VPWR VGND sg13cmos5l_buf_1
XFILLER_88_109 VPWR VGND sg13cmos5l_decap_8
X_2344_ Tile_X0Y2_FrameData_O[20] Tile_X0Y2_FrameData[20] VPWR VGND sg13cmos5l_buf_1
XFILLER_29_209 VPWR VGND sg13cmos5l_decap_8
XFILLER_28_0 VPWR VGND sg13cmos5l_fill_2
X_2275_ Tile_X0Y1_UserCLKo Tile_X0Y1_UserCLK VPWR VGND sg13cmos5l_buf_1
X_1226_ _1226_/Q Tile_X0Y0_FrameData[1] Tile_X0Y3_FrameStrobe[0] VPWR VGND sg13cmos5l_dlhq_1
X_1157_ _2605_/A _1157_/A VPWR VGND sg13cmos5l_inv_1
XANTENNA__1399__D Tile_X0Y0_FrameData[20] VPWR VGND sg13cmos5l_antennanp
X_1088_ _2309_/A AXIL_S_SOC_WDATA1 _0471_/X AXIL_S_SOC_WDATA13 _0729_/X _1824_/Q _1825_/Q
+ VPWR VGND sg13cmos5l_mux4_1
XFILLER_197_217 VPWR VGND sg13cmos5l_decap_8
XANTENNA__2425__X Tile_X0Y0_FrameData_O[11] VPWR VGND sg13cmos5l_antennanp
XFILLER_32_49 VPWR VGND sg13cmos5l_decap_8
XANTENNA__2023__D Tile_X0Y3_FrameData[12] VPWR VGND sg13cmos5l_antennanp
XFILLER_106_203 VPWR VGND sg13cmos5l_decap_8
XFILLER_106_214 VPWR VGND sg13cmos5l_fill_2
XFILLER_113_8 VPWR VGND sg13cmos5l_fill_2
XANTENNA__1862__D Tile_X0Y2_FrameData[21] VPWR VGND sg13cmos5l_antennanp
XFILLER_106_258 VPWR VGND sg13cmos5l_fill_1
XFILLER_164_48 VPWR VGND sg13cmos5l_decap_8
XFILLER_57_13 VPWR VGND sg13cmos5l_decap_4
XANTENNA__0730__A1 Tile_X0Y0_W2END[2] VPWR VGND sg13cmos5l_antennanp
XFILLER_113_30 VPWR VGND sg13cmos5l_fill_1
XFILLER_113_74 VPWR VGND sg13cmos5l_decap_4
XFILLER_43_212 VPWR VGND sg13cmos5l_decap_8
XFILLER_73_67 VPWR VGND sg13cmos5l_decap_8
XFILLER_43_245 VPWR VGND sg13cmos5l_fill_2
XFILLER_189_23 VPWR VGND sg13cmos5l_decap_8
XANTENNA__1038__A2 AXIL_S_SOC_WDATA28 VPWR VGND sg13cmos5l_antennanp
XANTENNA__2335__X Tile_X0Y2_FrameData_O[11] VPWR VGND sg13cmos5l_antennanp
XFILLER_132_0 VPWR VGND sg13cmos5l_fill_2
XFILLER_156_125 VPWR VGND sg13cmos5l_decap_8
XFILLER_196_294 VPWR VGND sg13cmos5l_fill_1
XFILLER_11_175 VPWR VGND sg13cmos5l_decap_8
XFILLER_164_180 VPWR VGND sg13cmos5l_decap_8
XFILLER_98_31 VPWR VGND sg13cmos5l_decap_8
XANTENNA__1772__D Tile_X0Y2_FrameData[15] VPWR VGND sg13cmos5l_antennanp
XANTENNA__1199__GATE Tile_X0Y3_FrameStrobe[0] VPWR VGND sg13cmos5l_antennanp
X_2060_ _2060_/Q Tile_X0Y3_FrameData[7] Tile_X0Y3_FrameStrobe[3] VPWR VGND sg13cmos5l_dlhq_1
XFILLER_19_231 VPWR VGND sg13cmos5l_fill_2
X_1011_ AXIL_S_SOC_RDATA27 Tile_X0Y1_W2MID[7] Tile_X0Y1_W2END[7] Tile_X0Y1_W6END[7]
+ _0862_/X _1509_/Q _1508_/Q VPWR VGND sg13cmos5l_mux4_1
XFILLER_93_189 VPWR VGND sg13cmos5l_decap_8
XANTENNA__0485__A0 Tile_X0Y3_N1END[2] VPWR VGND sg13cmos5l_antennanp
XFILLER_170_91 VPWR VGND sg13cmos5l_decap_8
XANTENNA__1029__A2 AXIL_S_SOC_WDATA30 VPWR VGND sg13cmos5l_antennanp
XANTENNA__1752__GATE Tile_X0Y3_FrameStrobe[1] VPWR VGND sg13cmos5l_antennanp
XANTENNA__2108__D Tile_X0Y3_FrameData[23] VPWR VGND sg13cmos5l_antennanp
XANTENNA__2245__X Tile_X0Y1_FrameData_O[2] VPWR VGND sg13cmos5l_antennanp
X_1913_ _1913_/Q Tile_X0Y2_FrameData[2] Tile_X0Y3_FrameStrobe[6] VPWR VGND sg13cmos5l_dlhq_1
XANTENNA__1947__D Tile_X0Y3_FrameData[24] VPWR VGND sg13cmos5l_antennanp
XFILLER_187_294 VPWR VGND sg13cmos5l_fill_1
XANTENNA__1767__GATE Tile_X0Y3_FrameStrobe[2] VPWR VGND sg13cmos5l_antennanp
XFILLER_147_147 VPWR VGND sg13cmos5l_fill_1
X_1844_ _1844_/Q Tile_X0Y2_FrameData[7] Tile_X0Y3_FrameStrobe[4] VPWR VGND sg13cmos5l_dlhq_1
XFILLER_8_73 VPWR VGND sg13cmos5l_decap_8
XFILLER_162_106 VPWR VGND sg13cmos5l_fill_1
X_1775_ _1775_/Q Tile_X0Y2_FrameData[12] Tile_X0Y3_FrameStrobe[2] VPWR VGND sg13cmos5l_dlhq_1
XFILLER_8_95 VPWR VGND sg13cmos5l_decap_4
XANTENNA__2421__A Tile_X0Y0_FrameData[7] VPWR VGND sg13cmos5l_antennanp
X_0726_ _2384_/A Tile_X0Y0_W2MID[5] Tile_X0Y0_W2END[5] Tile_X0Y0_W6END[5] _0653_/X
+ _1431_/Q _1430_/Q VPWR VGND sg13cmos5l_mux4_1
XANTENNA__1682__D Tile_X0Y1_FrameData[17] VPWR VGND sg13cmos5l_antennanp
X_0657_ _2498_/A _0649_/X _0580_/A AXIL_S_SOC_ARADDR3 _0602_/X _2106_/Q _2107_/Q VPWR
+ VGND sg13cmos5l_mux4_1
X_0588_ _0588_/X Tile_X0Y1_W1END[0] Tile_X0Y1_W2END[3] Tile_X0Y1_W2MID[3] _0869_/X
+ _1638_/Q _1639_/Q VPWR VGND sg13cmos5l_mux4_1
XFILLER_69_153 VPWR VGND sg13cmos5l_decap_8
X_2327_ Tile_X0Y2_FrameData_O[3] Tile_X0Y2_FrameData[3] VPWR VGND sg13cmos5l_buf_1
XANTENNA__1705__GATE Tile_X0Y3_FrameStrobe[0] VPWR VGND sg13cmos5l_antennanp
X_2258_ Tile_X0Y1_FrameData_O[15] Tile_X0Y1_FrameData[15] VPWR VGND sg13cmos5l_buf_1
X_1209_ _1209_/Q Tile_X0Y0_FrameData[18] Tile_X0Y3_FrameStrobe[0] VPWR VGND sg13cmos5l_dlhq_1
XFILLER_84_178 VPWR VGND sg13cmos5l_fill_2
XFILLER_84_156 VPWR VGND sg13cmos5l_fill_2
XFILLER_27_49 VPWR VGND sg13cmos5l_fill_1
X_2189_ _2189_/Q Tile_X0Y3_FrameData[2] Tile_X0Y3_FrameStrobe[7] VPWR VGND sg13cmos5l_dlhq_1
XFILLER_25_212 VPWR VGND sg13cmos5l_decap_8
XFILLER_225_195 VPWR VGND sg13cmos5l_decap_8
XANTENNA__2018__D Tile_X0Y3_FrameData[17] VPWR VGND sg13cmos5l_antennanp
XANTENNA__1857__D Tile_X0Y2_FrameData[26] VPWR VGND sg13cmos5l_antennanp
XFILLER_178_294 VPWR VGND sg13cmos5l_fill_1
XFILLER_178_283 VPWR VGND sg13cmos5l_fill_1
XFILLER_178_272 VPWR VGND sg13cmos5l_decap_8
XFILLER_153_106 VPWR VGND sg13cmos5l_decap_8
XANTENNA__2331__A Tile_X0Y2_FrameData[7] VPWR VGND sg13cmos5l_antennanp
XFILLER_146_191 VPWR VGND sg13cmos5l_decap_8
XFILLER_4_127 VPWR VGND sg13cmos5l_fill_2
XANTENNA__1592__D Tile_X0Y1_FrameData[11] VPWR VGND sg13cmos5l_antennanp
XFILLER_108_96 VPWR VGND sg13cmos5l_fill_1
XFILLER_161_172 VPWR VGND sg13cmos5l_fill_2
XFILLER_191_46 VPWR VGND sg13cmos5l_decap_8
XANTENNA__0703__A1 Tile_X0Y3_W2END[6] VPWR VGND sg13cmos5l_antennanp
XFILLER_84_22 VPWR VGND sg13cmos5l_fill_1
XFILLER_75_189 VPWR VGND sg13cmos5l_decap_8
XFILLER_140_61 VPWR VGND sg13cmos5l_decap_8
XFILLER_140_94 VPWR VGND sg13cmos5l_decap_8
XANTENNA__1767__D Tile_X0Y2_FrameData[20] VPWR VGND sg13cmos5l_antennanp
XFILLER_169_283 VPWR VGND sg13cmos5l_fill_1
XFILLER_83_9 VPWR VGND sg13cmos5l_fill_1
XFILLER_219_29 VPWR VGND sg13cmos5l_decap_4
XFILLER_149_92 VPWR VGND sg13cmos5l_decap_8
XFILLER_184_286 VPWR VGND sg13cmos5l_fill_1
X_1560_ _1560_/Q Tile_X0Y1_FrameData[11] Tile_X0Y3_FrameStrobe[3] VPWR VGND sg13cmos5l_dlhq_1
XANTENNA__1195__A1 Tile_X0Y2_W6END[9] VPWR VGND sg13cmos5l_antennanp
X_0511_ _0511_/X Tile_X0Y3_N2MID[3] Tile_X0Y3_N2END[3] _2589_/A _0510_/X _1957_/Q
+ _1956_/Q VPWR VGND sg13cmos5l_mux4_1
XFILLER_98_204 VPWR VGND sg13cmos5l_decap_8
X_1491_ _1491_/Q Tile_X0Y1_FrameData[16] Tile_X0Y3_FrameStrobe[1] VPWR VGND sg13cmos5l_dlhq_1
XFILLER_152_194 VPWR VGND sg13cmos5l_decap_8
X_0442_ _0442_/Y _1377_/Q VPWR VGND sg13cmos5l_inv_1
XFILLER_3_193 VPWR VGND sg13cmos5l_fill_2
XFILLER_100_209 VPWR VGND sg13cmos5l_fill_1
X_2112_ _2112_/Q Tile_X0Y3_FrameData[19] Tile_X0Y3_FrameStrobe[5] VPWR VGND sg13cmos5l_dlhq_1
X_2043_ _2043_/Q Tile_X0Y3_FrameData[24] Tile_X0Y3_FrameStrobe[3] VPWR VGND sg13cmos5l_dlhq_1
XANTENNA__1691__GATE Tile_X0Y3_FrameStrobe[7] VPWR VGND sg13cmos5l_antennanp
XANTENNA__2416__A Tile_X0Y0_FrameData[2] VPWR VGND sg13cmos5l_antennanp
XFILLER_95_0 VPWR VGND sg13cmos5l_fill_2
XFILLER_22_237 VPWR VGND sg13cmos5l_decap_8
XANTENNA__1677__D Tile_X0Y1_FrameData[22] VPWR VGND sg13cmos5l_antennanp
XFILLER_129_18 VPWR VGND sg13cmos5l_decap_4
XFILLER_30_281 VPWR VGND sg13cmos5l_fill_2
XFILLER_30_270 VPWR VGND sg13cmos5l_decap_8
XFILLER_200_97 VPWR VGND sg13cmos5l_fill_2
X_1827_ _1827_/Q Tile_X0Y2_FrameData[24] Tile_X0Y3_FrameStrobe[4] VPWR VGND sg13cmos5l_dlhq_1
XFILLER_145_17 VPWR VGND sg13cmos5l_fill_1
X_1758_ _1758_/Q Tile_X0Y2_FrameData[29] Tile_X0Y3_FrameStrobe[2] VPWR VGND sg13cmos5l_dlhq_1
X_1689_ _1689_/Q Tile_X0Y1_FrameData[10] Tile_X0Y3_FrameStrobe[7] VPWR VGND sg13cmos5l_dlhq_1
X_0709_ _0709_/X Tile_X0Y1_W1END[0] _0522_/X Tile_X0Y1_W6END[4] _0527_/X _1690_/Q
+ _1691_/Q VPWR VGND sg13cmos5l_mux4_1
XFILLER_225_50 VPWR VGND sg13cmos5l_fill_2
XANTENNA__1644__GATE Tile_X0Y3_FrameStrobe[6] VPWR VGND sg13cmos5l_antennanp
XFILLER_225_83 VPWR VGND sg13cmos5l_decap_4
XFILLER_38_37 VPWR VGND sg13cmos5l_decap_8
XFILLER_57_178 VPWR VGND sg13cmos5l_decap_8
XANTENNA__0893__X AXIL_S_SOC_BVALID VPWR VGND sg13cmos5l_antennanp
XFILLER_72_104 VPWR VGND sg13cmos5l_fill_1
XANTENNA__1659__GATE Tile_X0Y3_FrameStrobe[6] VPWR VGND sg13cmos5l_antennanp
XANTENNA__2326__A Tile_X0Y2_FrameData[2] VPWR VGND sg13cmos5l_antennanp
XFILLER_54_69 VPWR VGND sg13cmos5l_fill_2
XANTENNA__1587__D Tile_X0Y1_FrameData[16] VPWR VGND sg13cmos5l_antennanp
XFILLER_9_208 VPWR VGND sg13cmos5l_fill_1
XFILLER_166_220 VPWR VGND sg13cmos5l_decap_8
XFILLER_166_231 VPWR VGND sg13cmos5l_fill_1
XFILLER_186_35 VPWR VGND sg13cmos5l_decap_8
XANTENNA__0621__A0 Tile_X0Y3_W1END[2] VPWR VGND sg13cmos5l_antennanp
XFILLER_186_68 VPWR VGND sg13cmos5l_decap_8
XANTENNA__0924__A1 Tile_X0Y1_W6END[9] VPWR VGND sg13cmos5l_antennanp
XFILLER_79_88 VPWR VGND sg13cmos5l_fill_2
XFILLER_79_77 VPWR VGND sg13cmos5l_decap_8
XFILLER_135_50 VPWR VGND sg13cmos5l_fill_1
XFILLER_0_163 VPWR VGND sg13cmos5l_decap_4
XANTENNA__0688__A0 AXIL_S_SOC_RREADY VPWR VGND sg13cmos5l_antennanp
XFILLER_0_174 VPWR VGND sg13cmos5l_fill_2
XFILLER_0_185 VPWR VGND sg13cmos5l_fill_1
XFILLER_0_196 VPWR VGND sg13cmos5l_fill_2
XFILLER_95_65 VPWR VGND sg13cmos5l_decap_8
XFILLER_63_137 VPWR VGND sg13cmos5l_fill_2
XFILLER_28_70 VPWR VGND sg13cmos5l_decap_8
XANTENNA__0860__A0 Tile_X0Y2_W1END[2] VPWR VGND sg13cmos5l_antennanp
XFILLER_204_176 VPWR VGND sg13cmos5l_decap_8
XANTENNA__1497__D Tile_X0Y1_FrameData[10] VPWR VGND sg13cmos5l_antennanp
X_0991_ _0991_/Y Tile_X0Y1_W1END[1] _1628_/Q _0990_/Y VPWR VGND sg13cmos5l_o21ai_1
XFILLER_204_187 VPWR VGND sg13cmos5l_fill_2
XANTENNA__2523__X Tile_X0Y3_E6BEG[9] VPWR VGND sg13cmos5l_antennanp
XFILLER_157_264 VPWR VGND sg13cmos5l_fill_2
XFILLER_157_286 VPWR VGND sg13cmos5l_fill_1
X_1612_ _1612_/Q Tile_X0Y1_FrameData[23] Tile_X0Y3_FrameStrobe[5] VPWR VGND sg13cmos5l_dlhq_1
X_2592_ Tile_X0Y3_S2BEGb[6] _2592_/A VPWR VGND sg13cmos5l_buf_1
X_1543_ _1543_/Q Tile_X0Y1_FrameData[28] Tile_X0Y3_FrameStrobe[3] VPWR VGND sg13cmos5l_dlhq_1
XANTENNA__2121__D Tile_X0Y3_FrameData[10] VPWR VGND sg13cmos5l_antennanp
X_1474_ _1474_/Q Tile_X0Y1_FrameData[1] Tile_X0Y3_FrameStrobe[0] VPWR VGND sg13cmos5l_dlhq_1
XFILLER_5_85 VPWR VGND sg13cmos5l_decap_8
XFILLER_5_74 VPWR VGND sg13cmos5l_decap_8
XANTENNA__0679__A0 AXIL_S_SOC_ARADDR1 VPWR VGND sg13cmos5l_antennanp
XANTENNA__1960__D Tile_X0Y3_FrameData[11] VPWR VGND sg13cmos5l_antennanp
XFILLER_10_0 VPWR VGND sg13cmos5l_fill_2
XFILLER_94_251 VPWR VGND sg13cmos5l_fill_1
XFILLER_94_284 VPWR VGND sg13cmos5l_fill_2
X_2026_ _2026_/Q Tile_X0Y3_FrameData[9] Tile_X0Y3_FrameStrobe[2] VPWR VGND sg13cmos5l_dlhq_1
XFILLER_54_148 VPWR VGND sg13cmos5l_fill_1
XFILLER_211_52 VPWR VGND sg13cmos5l_decap_4
XFILLER_211_30 VPWR VGND sg13cmos5l_decap_4
XANTENNA__0851__A0 AXIL_S_SOC_WSTRB3 VPWR VGND sg13cmos5l_antennanp
XFILLER_62_192 VPWR VGND sg13cmos5l_decap_8
XANTENNA__1200__D Tile_X0Y0_FrameData[27] VPWR VGND sg13cmos5l_antennanp
XANTENNA__2433__X Tile_X0Y0_FrameData_O[19] VPWR VGND sg13cmos5l_antennanp
XFILLER_10_218 VPWR VGND sg13cmos5l_decap_8
XANTENNA__0603__A0 Tile_X0Y3_W1END[3] VPWR VGND sg13cmos5l_antennanp
XFILLER_148_264 VPWR VGND sg13cmos5l_fill_1
XFILLER_116_172 VPWR VGND sg13cmos5l_fill_2
XANTENNA__1583__GATE Tile_X0Y3_FrameStrobe[4] VPWR VGND sg13cmos5l_antennanp
XANTENNA__2031__D Tile_X0Y3_FrameData[4] VPWR VGND sg13cmos5l_antennanp
XFILLER_131_175 VPWR VGND sg13cmos5l_decap_8
XFILLER_172_15 VPWR VGND sg13cmos5l_fill_2
XANTENNA__1870__D Tile_X0Y2_FrameData[13] VPWR VGND sg13cmos5l_antennanp
XFILLER_105_64 VPWR VGND sg13cmos5l_decap_4
XANTENNA__1598__GATE Tile_X0Y3_FrameStrobe[4] VPWR VGND sg13cmos5l_antennanp
XANTENNA__2608__X Tile_X0Y3_S4BEG[14] VPWR VGND sg13cmos5l_antennanp
XFILLER_65_79 VPWR VGND sg13cmos5l_decap_8
XANTENNA__1095__A0 AXIL_S_SOC_WDATA0 VPWR VGND sg13cmos5l_antennanp
XANTENNA__1521__GATE Tile_X0Y3_FrameStrobe[2] VPWR VGND sg13cmos5l_antennanp
XANTENNA__0842__A0 AXIL_S_SOC_WVALID VPWR VGND sg13cmos5l_antennanp
XANTENNA__2343__X Tile_X0Y2_FrameData_O[19] VPWR VGND sg13cmos5l_antennanp
XANTENNA__1536__GATE Tile_X0Y3_FrameStrobe[2] VPWR VGND sg13cmos5l_antennanp
XFILLER_212_0 VPWR VGND sg13cmos5l_fill_1
XFILLER_154_256 VPWR VGND sg13cmos5l_fill_2
XFILLER_122_120 VPWR VGND sg13cmos5l_fill_1
XFILLER_146_71 VPWR VGND sg13cmos5l_decap_8
XFILLER_39_8 VPWR VGND sg13cmos5l_fill_2
XANTENNA__1780__D Tile_X0Y2_FrameData[7] VPWR VGND sg13cmos5l_antennanp
X_1190_ _1190_/X _2161_/Q _1190_/B VPWR VGND sg13cmos5l_and2_1
XANTENNA__2518__X Tile_X0Y3_E6BEG[4] VPWR VGND sg13cmos5l_antennanp
XFILLER_224_238 VPWR VGND sg13cmos5l_fill_2
XANTENNA__1086__A0 AXIL_S_SOC_WDATA0 VPWR VGND sg13cmos5l_antennanp
XFILLER_91_276 VPWR VGND sg13cmos5l_decap_8
XANTENNA__2116__D Tile_X0Y3_FrameData[15] VPWR VGND sg13cmos5l_antennanp
XANTENNA__2253__X Tile_X0Y1_FrameData_O[10] VPWR VGND sg13cmos5l_antennanp
X_0974_ _2601_/A _0967_/Y _0969_/Y _0971_/Y _0973_/Y VPWR VGND sg13cmos5l_a22oi_1
XANTENNA__1955__D Tile_X0Y3_FrameData[16] VPWR VGND sg13cmos5l_antennanp
XFILLER_145_234 VPWR VGND sg13cmos5l_fill_1
X_2575_ Tile_X0Y3_S1BEG[1] _2575_/A VPWR VGND sg13cmos5l_buf_1
XFILLER_58_0 VPWR VGND sg13cmos5l_fill_1
XANTENNA__1010__A0 Tile_X0Y1_W1END[0] VPWR VGND sg13cmos5l_antennanp
XFILLER_160_248 VPWR VGND sg13cmos5l_fill_1
X_1526_ _1526_/Q Tile_X0Y1_FrameData[13] Tile_X0Y3_FrameStrobe[2] VPWR VGND sg13cmos5l_dlhq_1
XFILLER_206_52 VPWR VGND sg13cmos5l_fill_1
XFILLER_206_30 VPWR VGND sg13cmos5l_fill_1
XANTENNA__1045__A Tile_X0Y2_W1END[1] VPWR VGND sg13cmos5l_antennanp
XANTENNA__1690__D Tile_X0Y1_FrameData[9] VPWR VGND sg13cmos5l_antennanp
X_1457_ _1457_/Q Tile_X0Y1_FrameData[18] Tile_X0Y3_FrameStrobe[0] VPWR VGND sg13cmos5l_dlhq_1
X_1388_ _1388_/Q Tile_X0Y0_FrameData[31] Tile_X0Y3_FrameStrobe[6] VPWR VGND sg13cmos5l_dlhq_1
XANTENNA__2428__X Tile_X0Y0_FrameData_O[14] VPWR VGND sg13cmos5l_antennanp
XFILLER_222_40 VPWR VGND sg13cmos5l_decap_8
XANTENNA__1077__A0 AXIL_S_SOC_WDATA1 VPWR VGND sg13cmos5l_antennanp
XFILLER_82_276 VPWR VGND sg13cmos5l_fill_1
XFILLER_35_38 VPWR VGND sg13cmos5l_fill_1
X_2009_ _2009_/Q Tile_X0Y3_FrameData[26] Tile_X0Y3_FrameStrobe[2] VPWR VGND sg13cmos5l_dlhq_1
XFILLER_35_170 VPWR VGND sg13cmos5l_decap_8
XANTENNA__0824__A0 Tile_X0Y0_W6END[7] VPWR VGND sg13cmos5l_antennanp
XFILLER_143_8 VPWR VGND sg13cmos5l_fill_2
XFILLER_223_293 VPWR VGND sg13cmos5l_fill_2
XFILLER_195_101 VPWR VGND sg13cmos5l_fill_2
XANTENNA__2026__D Tile_X0Y3_FrameData[9] VPWR VGND sg13cmos5l_antennanp
XFILLER_51_48 VPWR VGND sg13cmos5l_fill_2
XANTENNA__1865__D Tile_X0Y2_FrameData[18] VPWR VGND sg13cmos5l_antennanp
XFILLER_136_212 VPWR VGND sg13cmos5l_fill_2
XANTENNA__1001__A0 AXIL_S_SOC_WDATA16 VPWR VGND sg13cmos5l_antennanp
XFILLER_151_237 VPWR VGND sg13cmos5l_decap_8
XFILLER_2_225 VPWR VGND sg13cmos5l_fill_2
XFILLER_76_45 VPWR VGND sg13cmos5l_fill_1
XFILLER_58_251 VPWR VGND sg13cmos5l_decap_8
XANTENNA__2338__X Tile_X0Y2_FrameData_O[14] VPWR VGND sg13cmos5l_antennanp
XANTENNA__1460__GATE Tile_X0Y3_FrameStrobe[0] VPWR VGND sg13cmos5l_antennanp
XFILLER_162_0 VPWR VGND sg13cmos5l_fill_2
XFILLER_92_22 VPWR VGND sg13cmos5l_fill_1
XFILLER_73_276 VPWR VGND sg13cmos5l_decap_4
XFILLER_206_238 VPWR VGND sg13cmos5l_decap_8
XFILLER_214_260 VPWR VGND sg13cmos5l_fill_2
XANTENNA__0815__A0 AXIL_S_SOC_WSTRB2 VPWR VGND sg13cmos5l_antennanp
XFILLER_25_71 VPWR VGND sg13cmos5l_decap_8
XFILLER_214_282 VPWR VGND sg13cmos5l_decap_4
XFILLER_41_184 VPWR VGND sg13cmos5l_decap_8
XANTENNA__1475__GATE Tile_X0Y3_FrameStrobe[0] VPWR VGND sg13cmos5l_antennanp
XFILLER_186_178 VPWR VGND sg13cmos5l_decap_8
XANTENNA__1775__D Tile_X0Y2_FrameData[12] VPWR VGND sg13cmos5l_antennanp
XFILLER_127_223 VPWR VGND sg13cmos5l_decap_8
X_0690_ _2515_/A Tile_X0Y3_N4END[1] Tile_X0Y0_S4END[13] _0479_/X _0480_/X _2041_/Q
+ _2040_/Q VPWR VGND sg13cmos5l_mux4_1
XFILLER_41_81 VPWR VGND sg13cmos5l_decap_4
XFILLER_157_70 VPWR VGND sg13cmos5l_decap_8
X_2360_ Tile_X0Y0_N4BEG[2] _2360_/A VPWR VGND sg13cmos5l_buf_1
XANTENNA__1413__GATE Tile_X0Y3_FrameStrobe[6] VPWR VGND sg13cmos5l_antennanp
X_1311_ _1311_/Q Tile_X0Y0_FrameData[12] Tile_X0Y3_FrameStrobe[3] VPWR VGND sg13cmos5l_dlhq_1
X_2291_ Tile_X0Y2_E2BEGb[3] _2291_/A VPWR VGND sg13cmos5l_buf_1
X_1242_ _1242_/Q Tile_X0Y0_FrameData[17] Tile_X0Y3_FrameStrobe[1] VPWR VGND sg13cmos5l_dlhq_1
XANTENNA__2248__X Tile_X0Y1_FrameData_O[5] VPWR VGND sg13cmos5l_antennanp
XFILLER_64_210 VPWR VGND sg13cmos5l_decap_8
XFILLER_49_262 VPWR VGND sg13cmos5l_fill_1
XFILLER_2_75 VPWR VGND sg13cmos5l_decap_4
X_1173_ AXIL_S_SOC_RDATA14 Tile_X0Y2_W2MID[6] Tile_X0Y2_W2END[6] Tile_X0Y2_W6END[6]
+ _0729_/X _1759_/Q _1758_/Q VPWR VGND sg13cmos5l_mux4_1
XANTENNA__1428__GATE Tile_X0Y3_FrameStrobe[7] VPWR VGND sg13cmos5l_antennanp
XFILLER_64_287 VPWR VGND sg13cmos5l_decap_8
XFILLER_24_129 VPWR VGND sg13cmos5l_decap_8
XFILLER_212_208 VPWR VGND sg13cmos5l_fill_1
XFILLER_205_293 VPWR VGND sg13cmos5l_fill_2
XFILLER_220_230 VPWR VGND sg13cmos5l_decap_4
XANTENNA__2424__A Tile_X0Y0_FrameData[10] VPWR VGND sg13cmos5l_antennanp
XANTENNA__1685__D Tile_X0Y1_FrameData[14] VPWR VGND sg13cmos5l_antennanp
X_0957_ _2201_/A AXIL_S_SOC_WDATA18 AXIL_S_SOC_WDATA26 _0867_/X _0865_/X _1607_/Q
+ _1606_/Q VPWR VGND sg13cmos5l_mux4_1
XFILLER_21_29 VPWR VGND sg13cmos5l_fill_2
XANTENNA__0585__A2 Tile_X0Y3_W6END[9] VPWR VGND sg13cmos5l_antennanp
X_0888_ _0888_/X Tile_X0Y3_W1END[1] Tile_X0Y3_W6END[5] _0561_/X _0565_/Y _2185_/Q
+ _2184_/Q VPWR VGND sg13cmos5l_mux4_1
X_2558_ Tile_X0Y3_FrameData_O[16] Tile_X0Y3_FrameData[16] VPWR VGND sg13cmos5l_buf_1
XFILLER_99_140 VPWR VGND sg13cmos5l_decap_8
XFILLER_153_17 VPWR VGND sg13cmos5l_fill_1
XFILLER_153_39 VPWR VGND sg13cmos5l_fill_2
X_1509_ _1509_/Q Tile_X0Y1_FrameData[30] Tile_X0Y3_FrameStrobe[2] VPWR VGND sg13cmos5l_dlhq_1
X_2489_ Tile_X0Y0_E2BEG[7] _2489_/A VPWR VGND sg13cmos5l_buf_1
XFILLER_101_167 VPWR VGND sg13cmos5l_decap_8
XFILLER_55_276 VPWR VGND sg13cmos5l_fill_1
XANTENNA__2190__GATE Tile_X0Y3_FrameStrobe[7] VPWR VGND sg13cmos5l_antennanp
XFILLER_102_54 VPWR VGND sg13cmos5l_fill_1
XFILLER_15_118 VPWR VGND sg13cmos5l_decap_8
XFILLER_15_129 VPWR VGND sg13cmos5l_fill_1
XANTENNA__2334__A Tile_X0Y2_FrameData[10] VPWR VGND sg13cmos5l_antennanp
XANTENNA__1595__D Tile_X0Y1_FrameData[8] VPWR VGND sg13cmos5l_antennanp
XFILLER_168_189 VPWR VGND sg13cmos5l_fill_2
XFILLER_183_148 VPWR VGND sg13cmos5l_decap_8
XANTENNA__0576__A2 Tile_X0Y3_W6END[11] VPWR VGND sg13cmos5l_antennanp
XFILLER_127_62 VPWR VGND sg13cmos5l_decap_4
XANTENNA__2143__GATE Tile_X0Y3_FrameStrobe[6] VPWR VGND sg13cmos5l_antennanp
XANTENNA__0500__A2 Tile_X0Y3_N4END[7] VPWR VGND sg13cmos5l_antennanp
XANTENNA__2158__GATE Tile_X0Y3_FrameStrobe[6] VPWR VGND sg13cmos5l_antennanp
XFILLER_61_235 VPWR VGND sg13cmos5l_decap_8
XFILLER_14_173 VPWR VGND sg13cmos5l_fill_1
XFILLER_61_279 VPWR VGND sg13cmos5l_fill_1
XFILLER_202_241 VPWR VGND sg13cmos5l_decap_4
XANTENNA__2244__A Tile_X0Y1_FrameData[1] VPWR VGND sg13cmos5l_antennanp
X_1860_ _1860_/Q Tile_X0Y2_FrameData[23] Tile_X0Y3_FrameStrobe[5] VPWR VGND sg13cmos5l_dlhq_1
X_1791_ _1791_/Q Tile_X0Y2_FrameData[28] Tile_X0Y3_FrameStrobe[3] VPWR VGND sg13cmos5l_dlhq_1
X_0811_ _0811_/Y _1380_/Q _0811_/B VPWR VGND sg13cmos5l_nand2b_1
XANTENNA__2531__X Tile_X0Y3_EE4BEG[5] VPWR VGND sg13cmos5l_antennanp
X_0742_ _0742_/X _0741_/X _0588_/X Tile_X0Y3_N2MID[4] _0740_/X _1706_/Q _1707_/Q VPWR
+ VGND sg13cmos5l_mux4_1
X_0673_ _2526_/A _0649_/X _0508_/X AXIL_S_SOC_ARADDR7 _0602_/X _2074_/Q _2075_/Q VPWR
+ VGND sg13cmos5l_mux4_1
XFILLER_182_170 VPWR VGND sg13cmos5l_fill_2
XANTENNA__1352__GATE Tile_X0Y3_FrameStrobe[4] VPWR VGND sg13cmos5l_antennanp
X_2412_ Tile_X0Y0_FrameStrobe_O[18] Tile_X0Y3_FrameStrobe[18] VPWR VGND sg13cmos5l_buf_1
XANTENNA__1982__GATE Tile_X0Y3_FrameStrobe[1] VPWR VGND sg13cmos5l_antennanp
X_2343_ Tile_X0Y2_FrameData_O[19] Tile_X0Y2_FrameData[19] VPWR VGND sg13cmos5l_buf_1
XFILLER_35_2 VPWR VGND sg13cmos5l_fill_1
X_2274_ Tile_X0Y1_FrameData_O[31] Tile_X0Y1_FrameData[31] VPWR VGND sg13cmos5l_buf_1
XANTENNA__1367__GATE Tile_X0Y3_FrameStrobe[5] VPWR VGND sg13cmos5l_antennanp
XANTENNA__2419__A Tile_X0Y0_FrameData[5] VPWR VGND sg13cmos5l_antennanp
X_1225_ _1225_/Q Tile_X0Y0_FrameData[2] Tile_X0Y3_FrameStrobe[0] VPWR VGND sg13cmos5l_dlhq_1
XANTENNA__1997__GATE Tile_X0Y3_FrameStrobe[1] VPWR VGND sg13cmos5l_antennanp
X_1156_ _1157_/A _1868_/Q _1149_/X _1155_/Y VPWR VGND sg13cmos5l_o21ai_1
X_1087_ _2287_/A AXIL_S_SOC_WDATA7 AXIL_S_SOC_WDATA15 _0719_/X _0758_/X _1845_/Q _1844_/Q
+ VPWR VGND sg13cmos5l_mux4_1
XANTENNA__1920__GATE Tile_X0Y3_FrameStrobe[7] VPWR VGND sg13cmos5l_antennanp
XANTENNA__1305__GATE Tile_X0Y3_FrameStrobe[3] VPWR VGND sg13cmos5l_antennanp
XANTENNA__1935__GATE Tile_X0Y3_FrameStrobe[7] VPWR VGND sg13cmos5l_antennanp
XANTENNA__2441__X Tile_X0Y0_FrameData_O[27] VPWR VGND sg13cmos5l_antennanp
X_1989_ _1989_/Q Tile_X0Y3_FrameData[14] Tile_X0Y3_FrameStrobe[1] VPWR VGND sg13cmos5l_dlhq_1
XFILLER_20_198 VPWR VGND sg13cmos5l_decap_4
XFILLER_180_129 VPWR VGND sg13cmos5l_decap_8
XFILLER_106_237 VPWR VGND sg13cmos5l_decap_8
XFILLER_173_192 VPWR VGND sg13cmos5l_decap_8
XFILLER_164_27 VPWR VGND sg13cmos5l_decap_8
XANTENNA__0896__X AXIL_S_SOC_RRESP0 VPWR VGND sg13cmos5l_antennanp
XANTENNA__0730__A2 Tile_X0Y0_W2MID[2] VPWR VGND sg13cmos5l_antennanp
XFILLER_87_187 VPWR VGND sg13cmos5l_decap_8
XFILLER_57_36 VPWR VGND sg13cmos5l_decap_4
XFILLER_180_15 VPWR VGND sg13cmos5l_fill_2
XANTENNA__2329__A Tile_X0Y2_FrameData[5] VPWR VGND sg13cmos5l_antennanp
XFILLER_28_254 VPWR VGND sg13cmos5l_decap_4
XFILLER_113_97 VPWR VGND sg13cmos5l_decap_8
XFILLER_73_24 VPWR VGND sg13cmos5l_decap_4
XFILLER_28_276 VPWR VGND sg13cmos5l_fill_2
XFILLER_189_57 VPWR VGND sg13cmos5l_decap_8
XFILLER_11_110 VPWR VGND sg13cmos5l_fill_1
XANTENNA__2351__X Tile_X0Y2_FrameData_O[27] VPWR VGND sg13cmos5l_antennanp
XFILLER_125_0 VPWR VGND sg13cmos5l_fill_1
XFILLER_156_148 VPWR VGND sg13cmos5l_decap_8
XFILLER_7_158 VPWR VGND sg13cmos5l_decap_4
XANTENNA__2082__GATE Tile_X0Y3_FrameStrobe[4] VPWR VGND sg13cmos5l_antennanp
XFILLER_78_110 VPWR VGND sg13cmos5l_decap_8
XFILLER_154_60 VPWR VGND sg13cmos5l_fill_1
XANTENNA__0721__A2 Tile_X0Y0_W6END[7] VPWR VGND sg13cmos5l_antennanp
XFILLER_93_113 VPWR VGND sg13cmos5l_decap_8
XANTENNA__2097__GATE Tile_X0Y3_FrameStrobe[4] VPWR VGND sg13cmos5l_antennanp
X_1010_ AXIL_S_SOC_RDATA28 Tile_X0Y1_W1END[0] Tile_X0Y1_W6END[8] Tile_X0Y1_WW4END[15]
+ _0527_/X _1506_/Q _1507_/Q VPWR VGND sg13cmos5l_mux4_1
XFILLER_19_254 VPWR VGND sg13cmos5l_fill_1
XANTENNA__0485__A1 Tile_X0Y3_N4END[2] VPWR VGND sg13cmos5l_antennanp
XFILLER_170_70 VPWR VGND sg13cmos5l_decap_8
XANTENNA__2526__X Tile_X0Y3_EE4BEG[0] VPWR VGND sg13cmos5l_antennanp
XFILLER_34_257 VPWR VGND sg13cmos5l_decap_4
XFILLER_179_229 VPWR VGND sg13cmos5l_decap_8
XFILLER_179_218 VPWR VGND sg13cmos5l_fill_1
XFILLER_179_207 VPWR VGND sg13cmos5l_decap_8
XANTENNA__2020__GATE Tile_X0Y3_FrameStrobe[2] VPWR VGND sg13cmos5l_antennanp
X_1912_ _1912_/Q Tile_X0Y2_FrameData[3] Tile_X0Y3_FrameStrobe[6] VPWR VGND sg13cmos5l_dlhq_1
XFILLER_147_115 VPWR VGND sg13cmos5l_decap_8
XFILLER_147_126 VPWR VGND sg13cmos5l_fill_1
XANTENNA__2035__GATE Tile_X0Y3_FrameStrobe[2] VPWR VGND sg13cmos5l_antennanp
XANTENNA__2124__D Tile_X0Y3_FrameData[7] VPWR VGND sg13cmos5l_antennanp
XANTENNA__2261__X Tile_X0Y1_FrameData_O[18] VPWR VGND sg13cmos5l_antennanp
X_1843_ _1843_/Q Tile_X0Y2_FrameData[8] Tile_X0Y3_FrameStrobe[4] VPWR VGND sg13cmos5l_dlhq_1
XFILLER_162_118 VPWR VGND sg13cmos5l_fill_1
X_1774_ _1774_/Q Tile_X0Y2_FrameData[13] Tile_X0Y3_FrameStrobe[2] VPWR VGND sg13cmos5l_dlhq_1
XANTENNA__1963__D Tile_X0Y3_FrameData[8] VPWR VGND sg13cmos5l_antennanp
XFILLER_162_129 VPWR VGND sg13cmos5l_fill_2
X_0725_ _0725_/X _0724_/X _0482_/X Tile_X0Y3_N2MID[2] _0723_/X _1710_/Q _1711_/Q VPWR
+ VGND sg13cmos5l_mux4_1
XANTENNA__1291__GATE Tile_X0Y3_FrameStrobe[2] VPWR VGND sg13cmos5l_antennanp
X_0656_ _2497_/A Tile_X0Y3_N1END[3] _0574_/B _0655_/X AXIL_S_SOC_ARVALID _2109_/Q
+ _2108_/Q VPWR VGND sg13cmos5l_mux4_1
XFILLER_6_191 VPWR VGND sg13cmos5l_decap_8
XANTENNA__0960__A2 AXIL_S_SOC_WDATA17 VPWR VGND sg13cmos5l_antennanp
XFILLER_40_0 VPWR VGND sg13cmos5l_fill_2
XFILLER_170_195 VPWR VGND sg13cmos5l_decap_8
X_0587_ _2581_/A Tile_X0Y3_W2MID[4] Tile_X0Y3_W2END[4] Tile_X0Y3_W6END[11] _0511_/X
+ _2137_/Q _2136_/Q VPWR VGND sg13cmos5l_mux4_1
X_2326_ Tile_X0Y2_FrameData_O[2] Tile_X0Y2_FrameData[2] VPWR VGND sg13cmos5l_buf_1
XANTENNA__0712__A2 Tile_X0Y0_S2MID[3] VPWR VGND sg13cmos5l_antennanp
X_2257_ Tile_X0Y1_FrameData_O[14] Tile_X0Y1_FrameData[14] VPWR VGND sg13cmos5l_buf_1
X_1208_ _1208_/Q Tile_X0Y0_FrameData[19] Tile_X0Y3_FrameStrobe[0] VPWR VGND sg13cmos5l_dlhq_1
X_2188_ _2188_/Q Tile_X0Y3_FrameData[31] Tile_X0Y3_FrameStrobe[0] VPWR VGND sg13cmos5l_dlhq_1
XFILLER_225_152 VPWR VGND sg13cmos5l_decap_4
XANTENNA__1203__D Tile_X0Y0_FrameData[24] VPWR VGND sg13cmos5l_antennanp
XANTENNA__2436__X Tile_X0Y0_FrameData_O[22] VPWR VGND sg13cmos5l_antennanp
X_1139_ _1139_/Y Tile_X0Y2_W6END[5] _1876_/Q _1875_/Q VPWR VGND sg13cmos5l_o21ai_1
XFILLER_25_257 VPWR VGND sg13cmos5l_decap_8
XFILLER_159_27 VPWR VGND sg13cmos5l_fill_1
XFILLER_40_249 VPWR VGND sg13cmos5l_fill_2
XFILLER_33_290 VPWR VGND sg13cmos5l_decap_4
XFILLER_178_240 VPWR VGND sg13cmos5l_fill_1
XANTENNA__1244__GATE Tile_X0Y3_FrameStrobe[1] VPWR VGND sg13cmos5l_antennanp
XANTENNA__1874__GATE Tile_X0Y3_FrameStrobe[5] VPWR VGND sg13cmos5l_antennanp
XANTENNA__2034__D Tile_X0Y3_FrameData[1] VPWR VGND sg13cmos5l_antennanp
XFILLER_193_265 VPWR VGND sg13cmos5l_decap_8
XANTENNA__1259__GATE Tile_X0Y3_FrameStrobe[1] VPWR VGND sg13cmos5l_antennanp
XANTENNA__1873__D Tile_X0Y2_FrameData[10] VPWR VGND sg13cmos5l_antennanp
XFILLER_146_170 VPWR VGND sg13cmos5l_decap_4
XANTENNA__1889__GATE Tile_X0Y3_FrameStrobe[6] VPWR VGND sg13cmos5l_antennanp
XFILLER_108_42 VPWR VGND sg13cmos5l_fill_1
XFILLER_108_75 VPWR VGND sg13cmos5l_decap_8
XFILLER_108_86 VPWR VGND sg13cmos5l_decap_4
XFILLER_161_195 VPWR VGND sg13cmos5l_decap_8
XFILLER_68_68 VPWR VGND sg13cmos5l_decap_8
XFILLER_191_25 VPWR VGND sg13cmos5l_decap_4
XFILLER_191_14 VPWR VGND sg13cmos5l_fill_2
XANTENNA__1812__GATE Tile_X0Y3_FrameStrobe[3] VPWR VGND sg13cmos5l_antennanp
XANTENNA__0703__A2 Tile_X0Y3_W6END[6] VPWR VGND sg13cmos5l_antennanp
XFILLER_208_119 VPWR VGND sg13cmos5l_decap_8
XFILLER_75_168 VPWR VGND sg13cmos5l_decap_8
XFILLER_16_213 VPWR VGND sg13cmos5l_fill_1
XFILLER_90_127 VPWR VGND sg13cmos5l_decap_4
XFILLER_84_78 VPWR VGND sg13cmos5l_decap_4
XANTENNA__1827__GATE Tile_X0Y3_FrameStrobe[4] VPWR VGND sg13cmos5l_antennanp
XANTENNA__2346__X Tile_X0Y2_FrameData_O[22] VPWR VGND sg13cmos5l_antennanp
XFILLER_16_235 VPWR VGND sg13cmos5l_fill_2
XFILLER_169_273 VPWR VGND sg13cmos5l_fill_2
XANTENNA__1783__D Tile_X0Y2_FrameData[4] VPWR VGND sg13cmos5l_antennanp
XFILLER_144_129 VPWR VGND sg13cmos5l_decap_4
XANTENNA__1195__A2 Tile_X0Y2_WW4END[14] VPWR VGND sg13cmos5l_antennanp
X_0510_ _0510_/X Tile_X0Y1_W2MID[4] Tile_X0Y1_W2END[4] Tile_X0Y1_W6END[11] _0868_/X
+ _1641_/Q _1640_/Q VPWR VGND sg13cmos5l_mux4_1
X_1490_ _1490_/Q Tile_X0Y1_FrameData[17] Tile_X0Y3_FrameStrobe[1] VPWR VGND sg13cmos5l_dlhq_1
X_0441_ _0441_/Y Tile_X0Y0_WW4END[14] VPWR VGND sg13cmos5l_inv_1
XFILLER_12_4 VPWR VGND sg13cmos5l_fill_1
X_2111_ _2111_/Q Tile_X0Y3_FrameData[20] Tile_X0Y3_FrameStrobe[5] VPWR VGND sg13cmos5l_dlhq_1
X_2042_ _2042_/Q Tile_X0Y3_FrameData[25] Tile_X0Y3_FrameStrobe[3] VPWR VGND sg13cmos5l_dlhq_1
XFILLER_181_91 VPWR VGND sg13cmos5l_decap_4
XANTENNA__2119__D Tile_X0Y3_FrameData[12] VPWR VGND sg13cmos5l_antennanp
XFILLER_66_179 VPWR VGND sg13cmos5l_decap_4
XFILLER_207_141 VPWR VGND sg13cmos5l_decap_4
XANTENNA__2256__X Tile_X0Y1_FrameData_O[13] VPWR VGND sg13cmos5l_antennanp
XANTENNA__1958__D Tile_X0Y3_FrameData[13] VPWR VGND sg13cmos5l_antennanp
XFILLER_222_155 VPWR VGND sg13cmos5l_decap_8
XFILLER_88_0 VPWR VGND sg13cmos5l_fill_2
XANTENNA__2432__A Tile_X0Y0_FrameData[18] VPWR VGND sg13cmos5l_antennanp
X_1826_ _1826_/Q Tile_X0Y2_FrameData[25] Tile_X0Y3_FrameStrobe[4] VPWR VGND sg13cmos5l_dlhq_1
XFILLER_175_254 VPWR VGND sg13cmos5l_fill_2
XANTENNA__1693__D Tile_X0Y2_FrameData[30] VPWR VGND sg13cmos5l_antennanp
XFILLER_190_235 VPWR VGND sg13cmos5l_decap_8
X_1757_ _1757_/Q Tile_X0Y2_FrameData[30] Tile_X0Y3_FrameStrobe[2] VPWR VGND sg13cmos5l_dlhq_1
XFILLER_209_96 VPWR VGND sg13cmos5l_fill_1
XFILLER_209_74 VPWR VGND sg13cmos5l_fill_2
XANTENNA__0933__A2 Tile_X0Y3_N4END[10] VPWR VGND sg13cmos5l_antennanp
X_1688_ _1688_/Q Tile_X0Y1_FrameData[11] Tile_X0Y3_FrameStrobe[7] VPWR VGND sg13cmos5l_dlhq_1
X_0708_ AXIL_S_SOC_RDATA7 Tile_X0Y3_W1END[3] Tile_X0Y3_WW4END[12] Tile_X0Y3_W6END[11]
+ _0575_/Y _1997_/Q _1996_/Q VPWR VGND sg13cmos5l_mux4_1
X_0639_ _2494_/A Tile_X0Y3_N1END[0] _0539_/B _0638_/Y AXIL_S_SOC_ARADDR2 _2115_/Q
+ _2114_/Q VPWR VGND sg13cmos5l_mux4_1
X_2309_ Tile_X0Y2_EE4BEG[1] _2309_/A VPWR VGND sg13cmos5l_buf_1
XFILLER_97_282 VPWR VGND sg13cmos5l_decap_4
XFILLER_57_157 VPWR VGND sg13cmos5l_decap_8
XANTENNA__2029__D Tile_X0Y3_FrameData[6] VPWR VGND sg13cmos5l_antennanp
XFILLER_213_111 VPWR VGND sg13cmos5l_fill_2
XANTENNA__1110__A2 Tile_X0Y3_N4END[6] VPWR VGND sg13cmos5l_antennanp
XFILLER_13_216 VPWR VGND sg13cmos5l_decap_8
XANTENNA__1868__D Tile_X0Y2_FrameData[15] VPWR VGND sg13cmos5l_antennanp
XFILLER_110_65 VPWR VGND sg13cmos5l_fill_2
XFILLER_166_243 VPWR VGND sg13cmos5l_decap_8
XFILLER_70_58 VPWR VGND sg13cmos5l_fill_1
XFILLER_186_25 VPWR VGND sg13cmos5l_fill_1
XANTENNA__0621__A1 Tile_X0Y3_W6END[6] VPWR VGND sg13cmos5l_antennanp
XANTENNA__2342__A Tile_X0Y2_FrameData[18] VPWR VGND sg13cmos5l_antennanp
XFILLER_166_254 VPWR VGND sg13cmos5l_fill_1
XFILLER_21_293 VPWR VGND sg13cmos5l_fill_2
XANTENNA__1198__GATE Tile_X0Y3_FrameStrobe[0] VPWR VGND sg13cmos5l_antennanp
XFILLER_119_181 VPWR VGND sg13cmos5l_decap_8
XFILLER_119_52 VPWR VGND sg13cmos5l_fill_2
XFILLER_214_4 VPWR VGND sg13cmos5l_fill_1
XFILLER_181_279 VPWR VGND sg13cmos5l_decap_4
XANTENNA__0924__A2 Tile_X0Y1_WW4END[1] VPWR VGND sg13cmos5l_antennanp
XFILLER_79_56 VPWR VGND sg13cmos5l_decap_8
XANTENNA__1751__GATE Tile_X0Y3_FrameStrobe[1] VPWR VGND sg13cmos5l_antennanp
XFILLER_0_153 VPWR VGND sg13cmos5l_decap_4
XFILLER_95_22 VPWR VGND sg13cmos5l_fill_1
XANTENNA__0688__A1 AXIL_S_SOC_BREADY VPWR VGND sg13cmos5l_antennanp
XFILLER_135_95 VPWR VGND sg13cmos5l_decap_4
XFILLER_95_44 VPWR VGND sg13cmos5l_decap_8
XANTENNA__1766__GATE Tile_X0Y3_FrameStrobe[2] VPWR VGND sg13cmos5l_antennanp
XFILLER_48_179 VPWR VGND sg13cmos5l_decap_8
XANTENNA__1101__A2 Tile_X0Y3_N4END[6] VPWR VGND sg13cmos5l_antennanp
XFILLER_204_122 VPWR VGND sg13cmos5l_fill_2
XFILLER_204_111 VPWR VGND sg13cmos5l_decap_8
XANTENNA__1778__D Tile_X0Y2_FrameData[9] VPWR VGND sg13cmos5l_antennanp
X_0990_ _0990_/Y Tile_X0Y1_WW4END[13] _1628_/Q VPWR VGND sg13cmos5l_nand2b_1
XFILLER_157_243 VPWR VGND sg13cmos5l_fill_1
XANTENNA__2252__A Tile_X0Y1_FrameData[9] VPWR VGND sg13cmos5l_antennanp
XFILLER_12_293 VPWR VGND sg13cmos5l_fill_2
XFILLER_157_254 VPWR VGND sg13cmos5l_fill_2
XFILLER_157_276 VPWR VGND sg13cmos5l_fill_1
XFILLER_8_231 VPWR VGND sg13cmos5l_decap_8
XANTENNA__1704__GATE Tile_X0Y3_FrameStrobe[0] VPWR VGND sg13cmos5l_antennanp
XFILLER_117_118 VPWR VGND sg13cmos5l_decap_8
X_1611_ _1611_/Q Tile_X0Y1_FrameData[24] Tile_X0Y3_FrameStrobe[5] VPWR VGND sg13cmos5l_dlhq_1
X_2591_ Tile_X0Y3_S2BEGb[5] _2591_/A VPWR VGND sg13cmos5l_buf_1
XFILLER_5_31 VPWR VGND sg13cmos5l_fill_2
X_1542_ _1542_/Q Tile_X0Y1_FrameData[29] Tile_X0Y3_FrameStrobe[3] VPWR VGND sg13cmos5l_dlhq_1
XANTENNA__0915__A2 Tile_X0Y3_N4END[8] VPWR VGND sg13cmos5l_antennanp
XANTENNA__1719__GATE Tile_X0Y3_FrameStrobe[0] VPWR VGND sg13cmos5l_antennanp
XFILLER_125_184 VPWR VGND sg13cmos5l_decap_8
X_1473_ _1473_/Q Tile_X0Y1_FrameData[2] Tile_X0Y3_FrameStrobe[0] VPWR VGND sg13cmos5l_dlhq_1
XFILLER_86_219 VPWR VGND sg13cmos5l_fill_2
XANTENNA__0679__A1 AXIL_S_SOC_ARADDR5 VPWR VGND sg13cmos5l_antennanp
XFILLER_140_187 VPWR VGND sg13cmos5l_fill_1
XFILLER_79_293 VPWR VGND sg13cmos5l_fill_2
XANTENNA__2427__A Tile_X0Y0_FrameData[13] VPWR VGND sg13cmos5l_antennanp
X_2025_ _2025_/Q Tile_X0Y3_FrameData[10] Tile_X0Y3_FrameStrobe[2] VPWR VGND sg13cmos5l_dlhq_1
XANTENNA__1688__D Tile_X0Y1_FrameData[11] VPWR VGND sg13cmos5l_antennanp
XFILLER_62_171 VPWR VGND sg13cmos5l_decap_4
XFILLER_211_75 VPWR VGND sg13cmos5l_fill_1
XANTENNA__0603__A1 Tile_X0Y3_W2MID[0] VPWR VGND sg13cmos5l_antennanp
XFILLER_148_243 VPWR VGND sg13cmos5l_decap_8
XANTENNA__1159__A2 AXIL_S_SOC_WDATA2 VPWR VGND sg13cmos5l_antennanp
XFILLER_156_28 VPWR VGND sg13cmos5l_fill_1
X_1809_ _1809_/Q Tile_X0Y2_FrameData[10] Tile_X0Y3_FrameStrobe[3] VPWR VGND sg13cmos5l_dlhq_1
XFILLER_49_15 VPWR VGND sg13cmos5l_decap_8
XFILLER_131_143 VPWR VGND sg13cmos5l_fill_1
XFILLER_131_165 VPWR VGND sg13cmos5l_decap_4
XFILLER_65_14 VPWR VGND sg13cmos5l_fill_2
XFILLER_85_274 VPWR VGND sg13cmos5l_fill_2
XFILLER_65_58 VPWR VGND sg13cmos5l_decap_8
XFILLER_45_116 VPWR VGND sg13cmos5l_fill_1
XANTENNA__2337__A Tile_X0Y2_FrameData[13] VPWR VGND sg13cmos5l_antennanp
XFILLER_121_20 VPWR VGND sg13cmos5l_fill_1
XANTENNA__1598__D Tile_X0Y1_FrameData[5] VPWR VGND sg13cmos5l_antennanp
XANTENNA__0842__A1 AXIL_S_SOC_AWADDR2 VPWR VGND sg13cmos5l_antennanp
XFILLER_201_136 VPWR VGND sg13cmos5l_decap_4
XFILLER_197_57 VPWR VGND sg13cmos5l_decap_8
XFILLER_14_84 VPWR VGND sg13cmos5l_fill_1
XFILLER_154_213 VPWR VGND sg13cmos5l_fill_1
XFILLER_154_268 VPWR VGND sg13cmos5l_fill_2
XFILLER_5_223 VPWR VGND sg13cmos5l_decap_8
XFILLER_205_0 VPWR VGND sg13cmos5l_fill_2
XFILLER_5_278 VPWR VGND sg13cmos5l_decap_4
XFILLER_5_267 VPWR VGND sg13cmos5l_decap_4
XANTENNA__1690__GATE Tile_X0Y3_FrameStrobe[7] VPWR VGND sg13cmos5l_antennanp
XFILLER_76_285 VPWR VGND sg13cmos5l_fill_2
XANTENNA__2247__A Tile_X0Y1_FrameData[4] VPWR VGND sg13cmos5l_antennanp
XFILLER_91_233 VPWR VGND sg13cmos5l_fill_2
XFILLER_224_217 VPWR VGND sg13cmos5l_fill_2
XANTENNA__1086__A1 AXIL_S_SOC_WDATA8 VPWR VGND sg13cmos5l_antennanp
XANTENNA__1301__D Tile_X0Y0_FrameData[22] VPWR VGND sg13cmos5l_antennanp
XANTENNA__2534__X Tile_X0Y3_EE4BEG[8] VPWR VGND sg13cmos5l_antennanp
XFILLER_44_193 VPWR VGND sg13cmos5l_decap_8
XANTENNA__1643__GATE Tile_X0Y3_FrameStrobe[6] VPWR VGND sg13cmos5l_antennanp
X_0973_ _0973_/Y _1621_/Q _0972_/X _0453_/Y VPWR VGND sg13cmos5l_a21oi_1
XANTENNA__0597__A0 Tile_X0Y2_W1END[2] VPWR VGND sg13cmos5l_antennanp
XFILLER_145_213 VPWR VGND sg13cmos5l_decap_8
XANTENNA__2132__D Tile_X0Y3_FrameData[31] VPWR VGND sg13cmos5l_antennanp
XANTENNA__1658__GATE Tile_X0Y3_FrameStrobe[6] VPWR VGND sg13cmos5l_antennanp
X_2574_ Tile_X0Y3_S1BEG[0] _2574_/A VPWR VGND sg13cmos5l_buf_1
XANTENNA__1010__A1 Tile_X0Y1_W6END[8] VPWR VGND sg13cmos5l_antennanp
XANTENNA__1971__D Tile_X0Y3_FrameData[0] VPWR VGND sg13cmos5l_antennanp
XFILLER_153_290 VPWR VGND sg13cmos5l_decap_4
X_1525_ _1525_/Q Tile_X0Y1_FrameData[14] Tile_X0Y3_FrameStrobe[2] VPWR VGND sg13cmos5l_dlhq_1
X_1456_ _1456_/Q Tile_X0Y1_FrameData[19] Tile_X0Y3_FrameStrobe[0] VPWR VGND sg13cmos5l_dlhq_1
X_1387_ _1387_/Q Tile_X0Y0_FrameData[0] Tile_X0Y3_FrameStrobe[5] VPWR VGND sg13cmos5l_dlhq_1
XANTENNA__0521__A0 Tile_X0Y0_W1END[0] VPWR VGND sg13cmos5l_antennanp
XFILLER_215_217 VPWR VGND sg13cmos5l_fill_1
XFILLER_215_239 VPWR VGND sg13cmos5l_fill_1
XANTENNA__1077__A1 AXIL_S_SOC_WDATA9 VPWR VGND sg13cmos5l_antennanp
X_2008_ _2008_/Q Tile_X0Y3_FrameData[27] Tile_X0Y3_FrameStrobe[2] VPWR VGND sg13cmos5l_dlhq_1
XANTENNA__1211__D Tile_X0Y0_FrameData[16] VPWR VGND sg13cmos5l_antennanp
XANTENNA__2444__X Tile_X0Y0_FrameData_O[30] VPWR VGND sg13cmos5l_antennanp
XFILLER_223_272 VPWR VGND sg13cmos5l_fill_2
XFILLER_50_196 VPWR VGND sg13cmos5l_fill_2
XANTENNA__0588__A0 Tile_X0Y1_W1END[0] VPWR VGND sg13cmos5l_antennanp
XFILLER_167_49 VPWR VGND sg13cmos5l_decap_8
XFILLER_136_257 VPWR VGND sg13cmos5l_fill_1
XANTENNA__2042__D Tile_X0Y3_FrameData[25] VPWR VGND sg13cmos5l_antennanp
XFILLER_136_279 VPWR VGND sg13cmos5l_fill_2
XANTENNA__1881__D Tile_X0Y2_FrameData[2] VPWR VGND sg13cmos5l_antennanp
XFILLER_144_290 VPWR VGND sg13cmos5l_decap_4
XFILLER_104_187 VPWR VGND sg13cmos5l_decap_8
XFILLER_76_68 VPWR VGND sg13cmos5l_decap_8
XFILLER_132_63 VPWR VGND sg13cmos5l_fill_1
XFILLER_73_211 VPWR VGND sg13cmos5l_fill_1
XFILLER_132_74 VPWR VGND sg13cmos5l_decap_8
XANTENNA__0815__A1 AXIL_S_SOC_AWADDR5 VPWR VGND sg13cmos5l_antennanp
XANTENNA__2354__X Tile_X0Y2_FrameData_O[30] VPWR VGND sg13cmos5l_antennanp
XFILLER_155_0 VPWR VGND sg13cmos5l_fill_2
XFILLER_25_61 VPWR VGND sg13cmos5l_decap_8
XFILLER_214_294 VPWR VGND sg13cmos5l_fill_1
XFILLER_41_163 VPWR VGND sg13cmos5l_decap_8
XFILLER_186_157 VPWR VGND sg13cmos5l_decap_8
XANTENNA__0579__A0 Tile_X0Y3_N2MID[0] VPWR VGND sg13cmos5l_antennanp
XFILLER_142_205 VPWR VGND sg13cmos5l_fill_2
XANTENNA__1791__D Tile_X0Y2_FrameData[28] VPWR VGND sg13cmos5l_antennanp
X_1310_ _1310_/Q Tile_X0Y0_FrameData[13] Tile_X0Y3_FrameStrobe[3] VPWR VGND sg13cmos5l_dlhq_1
X_2290_ Tile_X0Y2_E2BEGb[2] _2290_/A VPWR VGND sg13cmos5l_buf_1
XANTENNA__2529__X Tile_X0Y3_EE4BEG[3] VPWR VGND sg13cmos5l_antennanp
XFILLER_110_157 VPWR VGND sg13cmos5l_decap_8
X_1241_ _1241_/Q Tile_X0Y0_FrameData[18] Tile_X0Y3_FrameStrobe[1] VPWR VGND sg13cmos5l_dlhq_1
X_1172_ AXIL_S_SOC_RDATA15 Tile_X0Y2_W2MID[7] Tile_X0Y2_W2END[7] Tile_X0Y2_W6END[7]
+ _0758_/X _1757_/Q _1756_/Q VPWR VGND sg13cmos5l_mux4_1
XFILLER_2_65 VPWR VGND sg13cmos5l_fill_1
XFILLER_24_108 VPWR VGND sg13cmos5l_decap_8
XANTENNA__2127__D Tile_X0Y3_FrameData[4] VPWR VGND sg13cmos5l_antennanp
XANTENNA__2264__X Tile_X0Y1_FrameData_O[21] VPWR VGND sg13cmos5l_antennanp
XFILLER_205_261 VPWR VGND sg13cmos5l_decap_8
XANTENNA__1582__GATE Tile_X0Y3_FrameStrobe[4] VPWR VGND sg13cmos5l_antennanp
XANTENNA__1966__D Tile_X0Y3_FrameData[5] VPWR VGND sg13cmos5l_antennanp
XFILLER_177_146 VPWR VGND sg13cmos5l_fill_1
XFILLER_118_213 VPWR VGND sg13cmos5l_decap_8
X_0956_ _2202_/A AXIL_S_SOC_WDATA19 AXIL_S_SOC_WDATA27 _0868_/X _0869_/X _1605_/Q
+ _1604_/Q VPWR VGND sg13cmos5l_mux4_1
XFILLER_70_0 VPWR VGND sg13cmos5l_fill_2
XANTENNA__1597__GATE Tile_X0Y3_FrameStrobe[4] VPWR VGND sg13cmos5l_antennanp
XANTENNA__2440__A Tile_X0Y0_FrameData[26] VPWR VGND sg13cmos5l_antennanp
X_0887_ _2457_/A AXIL_S_SOC_AWADDR1 _0762_/X AXIL_S_SOC_AWADDR5 _0739_/X _1308_/Q
+ _1309_/Q VPWR VGND sg13cmos5l_mux4_1
XFILLER_126_290 VPWR VGND sg13cmos5l_decap_4
XANTENNA__1520__GATE Tile_X0Y3_FrameStrobe[2] VPWR VGND sg13cmos5l_antennanp
X_2557_ Tile_X0Y3_FrameData_O[15] Tile_X0Y3_FrameData[15] VPWR VGND sg13cmos5l_buf_1
XFILLER_101_102 VPWR VGND sg13cmos5l_fill_1
X_1508_ _1508_/Q Tile_X0Y1_FrameData[31] Tile_X0Y3_FrameStrobe[2] VPWR VGND sg13cmos5l_dlhq_1
X_2488_ Tile_X0Y0_E2BEG[6] _2488_/A VPWR VGND sg13cmos5l_buf_1
XFILLER_99_185 VPWR VGND sg13cmos5l_decap_8
XANTENNA__1206__D Tile_X0Y0_FrameData[21] VPWR VGND sg13cmos5l_antennanp
XANTENNA__2439__X Tile_X0Y0_FrameData_O[25] VPWR VGND sg13cmos5l_antennanp
X_1439_ _1439_/Q Tile_X0Y0_FrameData[12] Tile_X0Y3_FrameStrobe[7] VPWR VGND sg13cmos5l_dlhq_1
XFILLER_55_200 VPWR VGND sg13cmos5l_fill_1
XANTENNA__1535__GATE Tile_X0Y3_FrameStrobe[2] VPWR VGND sg13cmos5l_antennanp
XFILLER_55_211 VPWR VGND sg13cmos5l_decap_8
XFILLER_46_49 VPWR VGND sg13cmos5l_decap_8
XFILLER_55_266 VPWR VGND sg13cmos5l_fill_2
XFILLER_203_209 VPWR VGND sg13cmos5l_decap_8
XANTENNA__2037__D Tile_X0Y3_FrameData[30] VPWR VGND sg13cmos5l_antennanp
XFILLER_62_26 VPWR VGND sg13cmos5l_fill_1
XFILLER_23_163 VPWR VGND sg13cmos5l_decap_8
XANTENNA__1876__D Tile_X0Y2_FrameData[7] VPWR VGND sg13cmos5l_antennanp
XFILLER_211_275 VPWR VGND sg13cmos5l_fill_2
XFILLER_183_127 VPWR VGND sg13cmos5l_decap_8
XANTENNA__2350__A Tile_X0Y2_FrameData[26] VPWR VGND sg13cmos5l_antennanp
XFILLER_109_268 VPWR VGND sg13cmos5l_fill_1
XANTENNA__0981__A0 Tile_X0Y1_W1END[2] VPWR VGND sg13cmos5l_antennanp
XFILLER_11_63 VPWR VGND sg13cmos5l_fill_1
XFILLER_11_85 VPWR VGND sg13cmos5l_decap_4
XFILLER_124_238 VPWR VGND sg13cmos5l_decap_8
XFILLER_127_52 VPWR VGND sg13cmos5l_decap_4
XANTENNA__0733__A0 Tile_X0Y0_W2MID[2] VPWR VGND sg13cmos5l_antennanp
XANTENNA__2349__X Tile_X0Y2_FrameData_O[25] VPWR VGND sg13cmos5l_antennanp
XFILLER_87_89 VPWR VGND sg13cmos5l_fill_1
XFILLER_143_62 VPWR VGND sg13cmos5l_decap_4
XFILLER_46_211 VPWR VGND sg13cmos5l_decap_8
XFILLER_46_266 VPWR VGND sg13cmos5l_fill_2
XANTENNA__0500__A3 Tile_X0Y0_S4END[11] VPWR VGND sg13cmos5l_antennanp
XFILLER_14_141 VPWR VGND sg13cmos5l_decap_8
XFILLER_199_293 VPWR VGND sg13cmos5l_fill_2
XANTENNA__1786__D Tile_X0Y2_FrameData[1] VPWR VGND sg13cmos5l_antennanp
XFILLER_14_185 VPWR VGND sg13cmos5l_decap_8
X_1790_ _1790_/Q Tile_X0Y2_FrameData[29] Tile_X0Y3_FrameStrobe[3] VPWR VGND sg13cmos5l_dlhq_1
X_0810_ _0811_/B Tile_X0Y0_W1END[1] _0778_/X _1378_/Q VPWR VGND sg13cmos5l_mux2_1
XFILLER_52_92 VPWR VGND sg13cmos5l_decap_8
XFILLER_168_81 VPWR VGND sg13cmos5l_decap_4
X_0741_ _0741_/X Tile_X0Y3_W2MID[3] Tile_X0Y3_W2END[3] Tile_X0Y3_W6END[3] _0590_/X
+ _2171_/Q _2170_/Q VPWR VGND sg13cmos5l_mux4_1
XANTENNA__2260__A Tile_X0Y1_FrameData[17] VPWR VGND sg13cmos5l_antennanp
X_0672_ _2513_/A AXIL_S_SOC_ARADDR2 AXIL_S_SOC_BREADY _0580_/A _0602_/X _2077_/Q _2076_/Q
+ VPWR VGND sg13cmos5l_mux4_1
X_2411_ Tile_X0Y0_FrameStrobe_O[17] Tile_X0Y3_FrameStrobe[17] VPWR VGND sg13cmos5l_buf_1
XANTENNA__0724__A0 Tile_X0Y3_W2MID[5] VPWR VGND sg13cmos5l_antennanp
X_2342_ Tile_X0Y2_FrameData_O[18] Tile_X0Y2_FrameData[18] VPWR VGND sg13cmos5l_buf_1
XANTENNA__2259__X Tile_X0Y1_FrameData_O[16] VPWR VGND sg13cmos5l_antennanp
XFILLER_123_282 VPWR VGND sg13cmos5l_fill_1
X_2273_ Tile_X0Y1_FrameData_O[30] Tile_X0Y1_FrameData[30] VPWR VGND sg13cmos5l_buf_1
XFILLER_96_155 VPWR VGND sg13cmos5l_decap_8
X_1224_ _1224_/Q Tile_X0Y0_FrameData[3] Tile_X0Y3_FrameStrobe[0] VPWR VGND sg13cmos5l_dlhq_1
X_1155_ _1155_/Y _1868_/Q _1155_/B _1155_/C VPWR VGND sg13cmos5l_nand3_1
XFILLER_37_255 VPWR VGND sg13cmos5l_decap_8
X_1086_ _2288_/A AXIL_S_SOC_WDATA0 AXIL_S_SOC_WDATA8 _0719_/X _0758_/X _1843_/Q _1842_/Q
+ VPWR VGND sg13cmos5l_mux4_1
XANTENNA__2435__A Tile_X0Y0_FrameData[21] VPWR VGND sg13cmos5l_antennanp
XFILLER_52_269 VPWR VGND sg13cmos5l_decap_8
XANTENNA__1696__D Tile_X0Y2_FrameData[27] VPWR VGND sg13cmos5l_antennanp
XFILLER_32_18 VPWR VGND sg13cmos5l_decap_4
XFILLER_165_116 VPWR VGND sg13cmos5l_fill_2
X_1988_ _1988_/Q Tile_X0Y3_FrameData[15] Tile_X0Y3_FrameStrobe[1] VPWR VGND sg13cmos5l_dlhq_1
X_0939_ _0939_/Y _1629_/Q _0939_/B VPWR VGND sg13cmos5l_nor2_1
XFILLER_173_171 VPWR VGND sg13cmos5l_decap_8
X_2609_ Tile_X0Y3_S4BEG[15] _2609_/A VPWR VGND sg13cmos5l_buf_1
XANTENNA__1474__GATE Tile_X0Y3_FrameStrobe[0] VPWR VGND sg13cmos5l_antennanp
XFILLER_57_48 VPWR VGND sg13cmos5l_fill_2
XFILLER_113_10 VPWR VGND sg13cmos5l_fill_1
XFILLER_28_233 VPWR VGND sg13cmos5l_decap_8
XANTENNA__1489__GATE Tile_X0Y3_FrameStrobe[1] VPWR VGND sg13cmos5l_antennanp
XANTENNA__2345__A Tile_X0Y2_FrameData[21] VPWR VGND sg13cmos5l_antennanp
XFILLER_11_122 VPWR VGND sg13cmos5l_decap_4
XANTENNA__1412__GATE Tile_X0Y3_FrameStrobe[6] VPWR VGND sg13cmos5l_antennanp
XFILLER_11_166 VPWR VGND sg13cmos5l_decap_4
XFILLER_7_137 VPWR VGND sg13cmos5l_decap_8
XFILLER_118_0 VPWR VGND sg13cmos5l_fill_1
XANTENNA__0954__A0 AXIL_S_SOC_WDATA21 VPWR VGND sg13cmos5l_antennanp
XANTENNA__1427__GATE Tile_X0Y3_FrameStrobe[7] VPWR VGND sg13cmos5l_antennanp
XFILLER_164_160 VPWR VGND sg13cmos5l_fill_2
XANTENNA__0706__A0 Tile_X0Y3_W1END[1] VPWR VGND sg13cmos5l_antennanp
XFILLER_0_0 VPWR VGND sg13cmos5l_fill_2
XFILLER_98_99 VPWR VGND sg13cmos5l_decap_8
XFILLER_105_293 VPWR VGND sg13cmos5l_fill_2
XFILLER_154_50 VPWR VGND sg13cmos5l_fill_2
XFILLER_78_144 VPWR VGND sg13cmos5l_decap_8
XFILLER_120_252 VPWR VGND sg13cmos5l_decap_4
XFILLER_78_155 VPWR VGND sg13cmos5l_fill_1
XFILLER_219_183 VPWR VGND sg13cmos5l_decap_8
XFILLER_34_214 VPWR VGND sg13cmos5l_decap_4
XFILLER_19_266 VPWR VGND sg13cmos5l_decap_8
XFILLER_34_236 VPWR VGND sg13cmos5l_decap_8
XANTENNA__2255__A Tile_X0Y1_FrameData[12] VPWR VGND sg13cmos5l_antennanp
X_1911_ _1911_/Q Tile_X0Y2_FrameData[4] Tile_X0Y3_FrameStrobe[6] VPWR VGND sg13cmos5l_dlhq_1
XFILLER_42_280 VPWR VGND sg13cmos5l_fill_1
XANTENNA__2542__X Tile_X0Y3_FrameData_O[0] VPWR VGND sg13cmos5l_antennanp
X_1842_ _1842_/Q Tile_X0Y2_FrameData[9] Tile_X0Y3_FrameStrobe[4] VPWR VGND sg13cmos5l_dlhq_1
XFILLER_187_285 VPWR VGND sg13cmos5l_fill_2
XFILLER_179_80 VPWR VGND sg13cmos5l_decap_8
XFILLER_147_138 VPWR VGND sg13cmos5l_decap_8
X_1773_ _1773_/Q Tile_X0Y2_FrameData[14] Tile_X0Y3_FrameStrobe[2] VPWR VGND sg13cmos5l_dlhq_1
X_0724_ _0724_/X Tile_X0Y3_W2MID[5] Tile_X0Y3_W2END[5] Tile_X0Y3_W6END[5] _0483_/X
+ _2175_/Q _2174_/Q VPWR VGND sg13cmos5l_mux4_1
X_0655_ _0655_/X _0654_/X _0648_/X _0647_/X _0636_/X _2192_/Q _2191_/Q VPWR VGND sg13cmos5l_mux4_1
XANTENNA__0960__A3 AXIL_S_SOC_WDATA20 VPWR VGND sg13cmos5l_antennanp
XANTENNA__2140__D Tile_X0Y3_FrameData[23] VPWR VGND sg13cmos5l_antennanp
X_0586_ _2580_/A Tile_X0Y3_W2MID[5] Tile_X0Y3_W2END[5] Tile_X0Y3_W6END[10] _0483_/X
+ _2139_/Q _2138_/Q VPWR VGND sg13cmos5l_mux4_1
XFILLER_33_0 VPWR VGND sg13cmos5l_fill_2
XFILLER_111_252 VPWR VGND sg13cmos5l_decap_4
X_2325_ Tile_X0Y2_FrameData_O[1] Tile_X0Y2_FrameData[1] VPWR VGND sg13cmos5l_buf_1
XANTENNA__0712__A3 Tile_X0Y0_S2END[3] VPWR VGND sg13cmos5l_antennanp
X_2256_ Tile_X0Y1_FrameData_O[13] Tile_X0Y1_FrameData[13] VPWR VGND sg13cmos5l_buf_1
XANTENNA__1122__A0 AXIL_S_SOC_WDATA4 VPWR VGND sg13cmos5l_antennanp
X_1207_ _1207_/Q Tile_X0Y0_FrameData[20] Tile_X0Y3_FrameStrobe[0] VPWR VGND sg13cmos5l_dlhq_1
XFILLER_84_158 VPWR VGND sg13cmos5l_fill_1
X_2187_ _2187_/Q Tile_X0Y3_FrameData[8] Tile_X0Y3_FrameStrobe[7] VPWR VGND sg13cmos5l_dlhq_1
X_1138_ _2604_/A _1136_/X _1137_/X _1871_/Q VPWR VGND sg13cmos5l_mux2_1
X_1069_ _1069_/X _0889_/X _0528_/X Tile_X0Y3_N4END[4] Tile_X0Y0_S4END[8] _1738_/Q
+ _1739_/Q VPWR VGND sg13cmos5l_mux4_1
XFILLER_40_228 VPWR VGND sg13cmos5l_decap_8
XANTENNA__2452__X Tile_X0Y0_EE4BEG[6] VPWR VGND sg13cmos5l_antennanp
XANTENNA__2142__GATE Tile_X0Y3_FrameStrobe[6] VPWR VGND sg13cmos5l_antennanp
XFILLER_138_127 VPWR VGND sg13cmos5l_decap_8
XFILLER_216_8 VPWR VGND sg13cmos5l_fill_2
XANTENNA__0936__A0 Tile_X0Y3_W1END[2] VPWR VGND sg13cmos5l_antennanp
XANTENNA__2157__GATE Tile_X0Y3_FrameStrobe[6] VPWR VGND sg13cmos5l_antennanp
XANTENNA__2050__D Tile_X0Y3_FrameData[17] VPWR VGND sg13cmos5l_antennanp
XFILLER_124_53 VPWR VGND sg13cmos5l_decap_8
XFILLER_124_64 VPWR VGND sg13cmos5l_fill_1
XANTENNA__1113__A0 AXIL_S_SOC_WDATA0 VPWR VGND sg13cmos5l_antennanp
XFILLER_75_147 VPWR VGND sg13cmos5l_decap_8
XFILLER_216_120 VPWR VGND sg13cmos5l_decap_4
XFILLER_16_269 VPWR VGND sg13cmos5l_decap_8
XFILLER_216_197 VPWR VGND sg13cmos5l_decap_8
XANTENNA__1351__GATE Tile_X0Y3_FrameStrobe[4] VPWR VGND sg13cmos5l_antennanp
XFILLER_31_228 VPWR VGND sg13cmos5l_decap_8
XANTENNA__1981__GATE Tile_X0Y3_FrameStrobe[1] VPWR VGND sg13cmos5l_antennanp
XANTENNA__2362__X Tile_X0Y0_N4BEG[4] VPWR VGND sg13cmos5l_antennanp
XFILLER_33_50 VPWR VGND sg13cmos5l_fill_1
XFILLER_129_127 VPWR VGND sg13cmos5l_fill_1
XFILLER_184_277 VPWR VGND sg13cmos5l_fill_1
XANTENNA__1366__GATE Tile_X0Y3_FrameStrobe[5] VPWR VGND sg13cmos5l_antennanp
XANTENNA__1996__GATE Tile_X0Y3_FrameStrobe[1] VPWR VGND sg13cmos5l_antennanp
XFILLER_165_71 VPWR VGND sg13cmos5l_fill_2
X_0440_ _0828_/S _1375_/Q VPWR VGND sg13cmos5l_inv_1
XFILLER_3_195 VPWR VGND sg13cmos5l_fill_1
XFILLER_3_173 VPWR VGND sg13cmos5l_fill_2
X_2110_ _2110_/Q Tile_X0Y3_FrameData[21] Tile_X0Y3_FrameStrobe[5] VPWR VGND sg13cmos5l_dlhq_1
XANTENNA__1304__GATE Tile_X0Y3_FrameStrobe[3] VPWR VGND sg13cmos5l_antennanp
XANTENNA__2537__X Tile_X0Y3_EE4BEG[11] VPWR VGND sg13cmos5l_antennanp
X_2041_ _2041_/Q Tile_X0Y3_FrameData[26] Tile_X0Y3_FrameStrobe[3] VPWR VGND sg13cmos5l_dlhq_1
XFILLER_181_70 VPWR VGND sg13cmos5l_decap_8
XANTENNA__1104__A0 AXIL_S_SOC_WDATA4 VPWR VGND sg13cmos5l_antennanp
XANTENNA__1304__D Tile_X0Y0_FrameData[19] VPWR VGND sg13cmos5l_antennanp
XANTENNA__1934__GATE Tile_X0Y3_FrameStrobe[7] VPWR VGND sg13cmos5l_antennanp
XFILLER_207_120 VPWR VGND sg13cmos5l_decap_8
XANTENNA__1319__GATE Tile_X0Y3_FrameStrobe[3] VPWR VGND sg13cmos5l_antennanp
XFILLER_222_167 VPWR VGND sg13cmos5l_decap_8
XANTENNA__1949__GATE Tile_X0Y3_FrameStrobe[0] VPWR VGND sg13cmos5l_antennanp
XANTENNA__2135__D Tile_X0Y3_FrameData[28] VPWR VGND sg13cmos5l_antennanp
XANTENNA__2272__X Tile_X0Y1_FrameData_O[29] VPWR VGND sg13cmos5l_antennanp
XANTENNA__1974__D Tile_X0Y3_FrameData[29] VPWR VGND sg13cmos5l_antennanp
X_1825_ _1825_/Q Tile_X0Y2_FrameData[26] Tile_X0Y3_FrameStrobe[4] VPWR VGND sg13cmos5l_dlhq_1
XFILLER_209_20 VPWR VGND sg13cmos5l_fill_1
X_1756_ _1756_/Q Tile_X0Y2_FrameData[31] Tile_X0Y3_FrameStrobe[2] VPWR VGND sg13cmos5l_dlhq_1
X_0707_ AXIL_S_SOC_RDATA6 Tile_X0Y3_W1END[2] Tile_X0Y3_WW4END[13] Tile_X0Y3_W6END[10]
+ _0570_/Y _1999_/Q _1998_/Q VPWR VGND sg13cmos5l_mux4_1
XFILLER_143_152 VPWR VGND sg13cmos5l_fill_2
X_1687_ _1687_/Q Tile_X0Y1_FrameData[12] Tile_X0Y3_FrameStrobe[7] VPWR VGND sg13cmos5l_dlhq_1
XANTENNA__0933__A3 Tile_X0Y0_S4END[6] VPWR VGND sg13cmos5l_antennanp
XFILLER_143_185 VPWR VGND sg13cmos5l_fill_1
X_0638_ _0638_/Y _2193_/Q _0633_/Y _0635_/Y _0637_/Y VPWR VGND sg13cmos5l_a22oi_1
XFILLER_225_41 VPWR VGND sg13cmos5l_decap_4
XANTENNA__1064__A Tile_X0Y2_W1END[0] VPWR VGND sg13cmos5l_antennanp
X_0569_ _0569_/Y _1943_/Q _0569_/B _1942_/Q VPWR VGND sg13cmos5l_nand3b_1
X_2308_ Tile_X0Y2_EE4BEG[0] _2308_/A VPWR VGND sg13cmos5l_buf_1
XFILLER_97_294 VPWR VGND sg13cmos5l_fill_1
XFILLER_57_136 VPWR VGND sg13cmos5l_decap_8
XANTENNA__1214__D Tile_X0Y0_FrameData[13] VPWR VGND sg13cmos5l_antennanp
XANTENNA__2447__X Tile_X0Y0_EE4BEG[1] VPWR VGND sg13cmos5l_antennanp
X_2239_ Tile_X0Y1_EE4BEG[12] _2239_/A VPWR VGND sg13cmos5l_buf_1
XFILLER_54_16 VPWR VGND sg13cmos5l_decap_4
XANTENNA__1110__A3 Tile_X0Y0_S4END[10] VPWR VGND sg13cmos5l_antennanp
XANTENNA__2045__D Tile_X0Y3_FrameData[22] VPWR VGND sg13cmos5l_antennanp
XANTENNA__2081__GATE Tile_X0Y3_FrameStrobe[4] VPWR VGND sg13cmos5l_antennanp
XFILLER_166_200 VPWR VGND sg13cmos5l_decap_8
XFILLER_186_15 VPWR VGND sg13cmos5l_decap_8
XANTENNA__0621__A2 Tile_X0Y3_WW4END[14] VPWR VGND sg13cmos5l_antennanp
XANTENNA__1884__D Tile_X0Y2_FrameData[31] VPWR VGND sg13cmos5l_antennanp
XANTENNA__2096__GATE Tile_X0Y3_FrameStrobe[4] VPWR VGND sg13cmos5l_antennanp
XFILLER_79_35 VPWR VGND sg13cmos5l_decap_8
XFILLER_207_4 VPWR VGND sg13cmos5l_fill_1
XFILLER_0_121 VPWR VGND sg13cmos5l_decap_8
XFILLER_0_132 VPWR VGND sg13cmos5l_fill_1
XFILLER_95_209 VPWR VGND sg13cmos5l_decap_8
XFILLER_88_294 VPWR VGND sg13cmos5l_fill_1
XFILLER_48_158 VPWR VGND sg13cmos5l_decap_8
XANTENNA__2034__GATE Tile_X0Y3_FrameStrobe[2] VPWR VGND sg13cmos5l_antennanp
XANTENNA__2357__X Tile_X0Y0_UserCLKo VPWR VGND sg13cmos5l_antennanp
XANTENNA__1101__A3 Tile_X0Y0_S4END[10] VPWR VGND sg13cmos5l_antennanp
XANTENNA__1290__GATE Tile_X0Y3_FrameStrobe[2] VPWR VGND sg13cmos5l_antennanp
XANTENNA__0860__A2 Tile_X0Y2_W6END[6] VPWR VGND sg13cmos5l_antennanp
XANTENNA__2049__GATE Tile_X0Y3_FrameStrobe[3] VPWR VGND sg13cmos5l_antennanp
XFILLER_81_8 VPWR VGND sg13cmos5l_fill_2
XANTENNA__1794__D Tile_X0Y2_FrameData[25] VPWR VGND sg13cmos5l_antennanp
X_1610_ _1610_/Q Tile_X0Y1_FrameData[25] Tile_X0Y3_FrameStrobe[5] VPWR VGND sg13cmos5l_dlhq_1
XFILLER_60_70 VPWR VGND sg13cmos5l_fill_2
X_2590_ Tile_X0Y3_S2BEGb[4] _2590_/A VPWR VGND sg13cmos5l_buf_1
XFILLER_176_81 VPWR VGND sg13cmos5l_decap_8
X_1541_ _1541_/Q Tile_X0Y1_FrameData[30] Tile_X0Y3_FrameStrobe[3] VPWR VGND sg13cmos5l_dlhq_1
XANTENNA__0915__A3 Tile_X0Y0_S4END[4] VPWR VGND sg13cmos5l_antennanp
X_1472_ _1472_/Q Tile_X0Y1_FrameData[3] Tile_X0Y3_FrameStrobe[0] VPWR VGND sg13cmos5l_dlhq_1
XANTENNA__1243__GATE Tile_X0Y3_FrameStrobe[1] VPWR VGND sg13cmos5l_antennanp
XFILLER_79_272 VPWR VGND sg13cmos5l_decap_4
XFILLER_192_80 VPWR VGND sg13cmos5l_fill_1
XANTENNA__1873__GATE Tile_X0Y3_FrameStrobe[5] VPWR VGND sg13cmos5l_antennanp
XFILLER_94_242 VPWR VGND sg13cmos5l_decap_8
XFILLER_39_147 VPWR VGND sg13cmos5l_decap_8
XANTENNA__2267__X Tile_X0Y1_FrameData_O[24] VPWR VGND sg13cmos5l_antennanp
XFILLER_94_286 VPWR VGND sg13cmos5l_fill_1
XANTENNA__1969__D Tile_X0Y3_FrameData[2] VPWR VGND sg13cmos5l_antennanp
X_2024_ _2024_/Q Tile_X0Y3_FrameData[11] Tile_X0Y3_FrameStrobe[2] VPWR VGND sg13cmos5l_dlhq_1
XANTENNA__1258__GATE Tile_X0Y3_FrameStrobe[1] VPWR VGND sg13cmos5l_antennanp
XANTENNA__1888__GATE Tile_X0Y3_FrameStrobe[6] VPWR VGND sg13cmos5l_antennanp
XFILLER_62_161 VPWR VGND sg13cmos5l_decap_4
XANTENNA__0851__A2 AXIL_S_SOC_AWADDR2 VPWR VGND sg13cmos5l_antennanp
XANTENNA__2443__A Tile_X0Y0_FrameData[29] VPWR VGND sg13cmos5l_antennanp
XFILLER_210_159 VPWR VGND sg13cmos5l_decap_4
XANTENNA__0603__A2 Tile_X0Y3_W2END[0] VPWR VGND sg13cmos5l_antennanp
XANTENNA__1811__GATE Tile_X0Y3_FrameStrobe[3] VPWR VGND sg13cmos5l_antennanp
XFILLER_148_277 VPWR VGND sg13cmos5l_fill_2
X_1808_ _1808_/Q Tile_X0Y2_FrameData[11] Tile_X0Y3_FrameStrobe[3] VPWR VGND sg13cmos5l_dlhq_1
XANTENNA__1159__A3 AXIL_S_SOC_WDATA7 VPWR VGND sg13cmos5l_antennanp
XFILLER_163_247 VPWR VGND sg13cmos5l_fill_1
XANTENNA__1209__D Tile_X0Y0_FrameData[18] VPWR VGND sg13cmos5l_antennanp
XANTENNA__1826__GATE Tile_X0Y3_FrameStrobe[4] VPWR VGND sg13cmos5l_antennanp
X_1739_ _1739_/Q Tile_X0Y2_FrameData[16] Tile_X0Y3_FrameStrobe[1] VPWR VGND sg13cmos5l_dlhq_1
XFILLER_171_280 VPWR VGND sg13cmos5l_decap_4
XFILLER_172_17 VPWR VGND sg13cmos5l_fill_1
XFILLER_85_253 VPWR VGND sg13cmos5l_fill_1
XFILLER_85_286 VPWR VGND sg13cmos5l_fill_1
XFILLER_65_37 VPWR VGND sg13cmos5l_decap_8
XFILLER_218_248 VPWR VGND sg13cmos5l_decap_4
XANTENNA__1879__D Tile_X0Y2_FrameData[4] VPWR VGND sg13cmos5l_antennanp
XANTENNA__1095__A2 AXIL_S_SOC_WDATA12 VPWR VGND sg13cmos5l_antennanp
XFILLER_198_177 VPWR VGND sg13cmos5l_fill_1
XANTENNA__2353__A Tile_X0Y2_FrameData[29] VPWR VGND sg13cmos5l_antennanp
XFILLER_100_0 VPWR VGND sg13cmos5l_fill_2
XFILLER_122_111 VPWR VGND sg13cmos5l_decap_8
XFILLER_30_95 VPWR VGND sg13cmos5l_decap_8
XFILLER_122_166 VPWR VGND sg13cmos5l_decap_8
XFILLER_122_199 VPWR VGND sg13cmos5l_decap_8
XFILLER_209_226 VPWR VGND sg13cmos5l_decap_8
XANTENNA__1789__D Tile_X0Y2_FrameData[30] VPWR VGND sg13cmos5l_antennanp
XFILLER_91_212 VPWR VGND sg13cmos5l_decap_8
XFILLER_44_172 VPWR VGND sg13cmos5l_decap_8
XFILLER_189_133 VPWR VGND sg13cmos5l_fill_2
XFILLER_189_122 VPWR VGND sg13cmos5l_decap_8
XFILLER_189_177 VPWR VGND sg13cmos5l_fill_2
XANTENNA__2263__A Tile_X0Y1_FrameData[20] VPWR VGND sg13cmos5l_antennanp
X_0972_ _0972_/X _0862_/X _0493_/X _0972_/S VPWR VGND sg13cmos5l_mux2_1
XANTENNA__0597__A1 Tile_X0Y2_W2END[1] VPWR VGND sg13cmos5l_antennanp
XANTENNA__2550__X Tile_X0Y3_FrameData_O[8] VPWR VGND sg13cmos5l_antennanp
X_2573_ Tile_X0Y3_FrameData_O[31] Tile_X0Y3_FrameData[31] VPWR VGND sg13cmos5l_buf_1
XANTENNA__1010__A2 Tile_X0Y1_WW4END[15] VPWR VGND sg13cmos5l_antennanp
X_1524_ _1524_/Q Tile_X0Y1_FrameData[15] Tile_X0Y3_FrameStrobe[2] VPWR VGND sg13cmos5l_dlhq_1
XFILLER_4_290 VPWR VGND sg13cmos5l_decap_4
XFILLER_113_166 VPWR VGND sg13cmos5l_fill_1
XFILLER_113_199 VPWR VGND sg13cmos5l_decap_8
X_1455_ _1455_/Q Tile_X0Y1_FrameData[20] Tile_X0Y3_FrameStrobe[0] VPWR VGND sg13cmos5l_dlhq_1
X_1386_ _1386_/Q Tile_X0Y0_FrameData[1] Tile_X0Y3_FrameStrobe[5] VPWR VGND sg13cmos5l_dlhq_1
XANTENNA__0521__A1 Tile_X0Y0_W6END[8] VPWR VGND sg13cmos5l_antennanp
XANTENNA__2438__A Tile_X0Y0_FrameData[24] VPWR VGND sg13cmos5l_antennanp
XANTENNA__1197__GATE Tile_X0Y3_FrameStrobe[0] VPWR VGND sg13cmos5l_antennanp
XFILLER_67_286 VPWR VGND sg13cmos5l_fill_1
XANTENNA__1699__D Tile_X0Y2_FrameData[24] VPWR VGND sg13cmos5l_antennanp
X_2007_ _2007_/Q Tile_X0Y3_FrameData[28] Tile_X0Y3_FrameStrobe[2] VPWR VGND sg13cmos5l_dlhq_1
XFILLER_82_267 VPWR VGND sg13cmos5l_decap_8
XFILLER_222_97 VPWR VGND sg13cmos5l_fill_2
XFILLER_222_86 VPWR VGND sg13cmos5l_fill_1
XFILLER_208_281 VPWR VGND sg13cmos5l_fill_2
XFILLER_223_240 VPWR VGND sg13cmos5l_decap_4
XANTENNA__1750__GATE Tile_X0Y3_FrameStrobe[1] VPWR VGND sg13cmos5l_antennanp
XFILLER_50_164 VPWR VGND sg13cmos5l_decap_8
XANTENNA__0588__A1 Tile_X0Y1_W2END[3] VPWR VGND sg13cmos5l_antennanp
XANTENNA__2460__X Tile_X0Y0_EE4BEG[14] VPWR VGND sg13cmos5l_antennanp
XFILLER_136_214 VPWR VGND sg13cmos5l_fill_1
XANTENNA__1765__GATE Tile_X0Y3_FrameStrobe[2] VPWR VGND sg13cmos5l_antennanp
XFILLER_104_100 VPWR VGND sg13cmos5l_fill_2
XFILLER_144_280 VPWR VGND sg13cmos5l_decap_4
XFILLER_183_16 VPWR VGND sg13cmos5l_decap_8
XANTENNA__0760__A1 Tile_X0Y0_S1END[0] VPWR VGND sg13cmos5l_antennanp
XFILLER_76_14 VPWR VGND sg13cmos5l_fill_1
XFILLER_116_98 VPWR VGND sg13cmos5l_decap_8
XFILLER_76_58 VPWR VGND sg13cmos5l_decap_8
XANTENNA__2348__A Tile_X0Y2_FrameData[24] VPWR VGND sg13cmos5l_antennanp
XANTENNA__1703__GATE Tile_X0Y3_FrameStrobe[0] VPWR VGND sg13cmos5l_antennanp
XFILLER_206_218 VPWR VGND sg13cmos5l_decap_8
XFILLER_92_13 VPWR VGND sg13cmos5l_decap_8
XANTENNA__1402__D Tile_X0Y0_FrameData[17] VPWR VGND sg13cmos5l_antennanp
XFILLER_92_57 VPWR VGND sg13cmos5l_decap_8
XFILLER_26_194 VPWR VGND sg13cmos5l_decap_8
XFILLER_214_262 VPWR VGND sg13cmos5l_fill_1
XANTENNA__1718__GATE Tile_X0Y3_FrameStrobe[0] VPWR VGND sg13cmos5l_antennanp
XFILLER_148_0 VPWR VGND sg13cmos5l_fill_2
XFILLER_41_142 VPWR VGND sg13cmos5l_decap_8
XANTENNA__0579__A1 Tile_X0Y3_N2END[0] VPWR VGND sg13cmos5l_antennanp
XANTENNA__2370__X Tile_X0Y0_N4BEG[12] VPWR VGND sg13cmos5l_antennanp
XFILLER_142_217 VPWR VGND sg13cmos5l_decap_8
XFILLER_44_8 VPWR VGND sg13cmos5l_decap_8
XFILLER_150_294 VPWR VGND sg13cmos5l_fill_1
X_1240_ _1240_/Q Tile_X0Y0_FrameData[19] Tile_X0Y3_FrameStrobe[1] VPWR VGND sg13cmos5l_dlhq_1
XFILLER_2_11 VPWR VGND sg13cmos5l_fill_1
XFILLER_1_293 VPWR VGND sg13cmos5l_fill_2
XFILLER_173_82 VPWR VGND sg13cmos5l_decap_8
XANTENNA__2258__A Tile_X0Y1_FrameData[15] VPWR VGND sg13cmos5l_antennanp
X_1171_ _2365_/A _1164_/Y _1168_/X _1170_/Y VPWR VGND sg13cmos5l_a21oi_1
XFILLER_49_286 VPWR VGND sg13cmos5l_fill_1
XANTENNA__1059__A2 Tile_X0Y3_N4END[4] VPWR VGND sg13cmos5l_antennanp
XANTENNA__1312__D Tile_X0Y0_FrameData[11] VPWR VGND sg13cmos5l_antennanp
XANTENNA__2545__X Tile_X0Y3_FrameData_O[3] VPWR VGND sg13cmos5l_antennanp
XFILLER_17_183 VPWR VGND sg13cmos5l_decap_8
XFILLER_32_142 VPWR VGND sg13cmos5l_decap_4
XFILLER_177_103 VPWR VGND sg13cmos5l_fill_1
XFILLER_32_186 VPWR VGND sg13cmos5l_decap_8
XFILLER_177_158 VPWR VGND sg13cmos5l_decap_4
XANTENNA__2143__D Tile_X0Y3_FrameData[20] VPWR VGND sg13cmos5l_antennanp
X_0955_ _2203_/A AXIL_S_SOC_WDATA20 AXIL_S_SOC_WDATA28 _0868_/X _0869_/X _1603_/Q
+ _1602_/Q VPWR VGND sg13cmos5l_mux4_1
XANTENNA__2280__X Tile_X0Y2_E2BEG[0] VPWR VGND sg13cmos5l_antennanp
X_0886_ _2458_/A AXIL_S_SOC_WVALID AXIL_S_SOC_AWADDR6 _0794_/B _0712_/X _1307_/Q _1306_/Q
+ VPWR VGND sg13cmos5l_mux4_1
XANTENNA__1982__D Tile_X0Y3_FrameData[21] VPWR VGND sg13cmos5l_antennanp
XFILLER_63_0 VPWR VGND sg13cmos5l_fill_2
XFILLER_133_217 VPWR VGND sg13cmos5l_fill_1
X_2556_ Tile_X0Y3_FrameData_O[14] Tile_X0Y3_FrameData[14] VPWR VGND sg13cmos5l_buf_1
XFILLER_217_53 VPWR VGND sg13cmos5l_fill_1
X_1507_ _1507_/Q Tile_X0Y1_FrameData[0] Tile_X0Y3_FrameStrobe[1] VPWR VGND sg13cmos5l_dlhq_1
X_2487_ Tile_X0Y0_E2BEG[5] _2487_/A VPWR VGND sg13cmos5l_buf_1
XFILLER_141_294 VPWR VGND sg13cmos5l_fill_1
X_1438_ _1438_/Q Tile_X0Y0_FrameData[13] Tile_X0Y3_FrameStrobe[7] VPWR VGND sg13cmos5l_dlhq_1
X_1369_ _1369_/Q Tile_X0Y0_FrameData[18] Tile_X0Y3_FrameStrobe[5] VPWR VGND sg13cmos5l_dlhq_1
XANTENNA__1222__D Tile_X0Y0_FrameData[5] VPWR VGND sg13cmos5l_antennanp
XANTENNA__2455__X Tile_X0Y0_EE4BEG[9] VPWR VGND sg13cmos5l_antennanp
XFILLER_102_67 VPWR VGND sg13cmos5l_fill_1
XFILLER_70_248 VPWR VGND sg13cmos5l_decap_8
XFILLER_168_103 VPWR VGND sg13cmos5l_fill_1
XFILLER_23_142 VPWR VGND sg13cmos5l_decap_8
XFILLER_211_254 VPWR VGND sg13cmos5l_decap_8
XANTENNA__2053__D Tile_X0Y3_FrameData[14] VPWR VGND sg13cmos5l_antennanp
XANTENNA__0703__X AXIL_S_SOC_RDATA2 VPWR VGND sg13cmos5l_antennanp
XFILLER_109_225 VPWR VGND sg13cmos5l_fill_1
XFILLER_109_236 VPWR VGND sg13cmos5l_decap_8
XFILLER_109_247 VPWR VGND sg13cmos5l_decap_8
XANTENNA__1892__D Tile_X0Y2_FrameData[23] VPWR VGND sg13cmos5l_antennanp
XANTENNA__0981__A1 Tile_X0Y1_WW4END[14] VPWR VGND sg13cmos5l_antennanp
XFILLER_124_217 VPWR VGND sg13cmos5l_decap_8
XANTENNA__0733__A1 Tile_X0Y0_W2END[2] VPWR VGND sg13cmos5l_antennanp
XFILLER_132_294 VPWR VGND sg13cmos5l_fill_1
XANTENNA__1642__GATE Tile_X0Y3_FrameStrobe[6] VPWR VGND sg13cmos5l_antennanp
XANTENNA__2365__X Tile_X0Y0_N4BEG[7] VPWR VGND sg13cmos5l_antennanp
XANTENNA__1657__GATE Tile_X0Y3_FrameStrobe[6] VPWR VGND sg13cmos5l_antennanp
XFILLER_14_120 VPWR VGND sg13cmos5l_decap_8
XFILLER_159_125 VPWR VGND sg13cmos5l_fill_2
XFILLER_199_283 VPWR VGND sg13cmos5l_fill_1
XFILLER_52_71 VPWR VGND sg13cmos5l_decap_8
XFILLER_168_71 VPWR VGND sg13cmos5l_fill_1
X_0740_ _0740_/X Tile_X0Y0_W1END[0] Tile_X0Y0_W2END[3] Tile_X0Y0_W2MID[3] _0739_/X
+ _1390_/Q _1391_/Q VPWR VGND sg13cmos5l_mux4_1
X_2410_ Tile_X0Y0_FrameStrobe_O[16] Tile_X0Y3_FrameStrobe[16] VPWR VGND sg13cmos5l_buf_1
X_0671_ _2512_/A AXIL_S_SOC_ARADDR1 AXIL_S_SOC_ARADDR9 _0584_/X _0598_/X _2079_/Q
+ _2078_/Q VPWR VGND sg13cmos5l_mux4_1
XANTENNA__0724__A1 Tile_X0Y3_W2END[5] VPWR VGND sg13cmos5l_antennanp
XANTENNA__1307__D Tile_X0Y0_FrameData[16] VPWR VGND sg13cmos5l_antennanp
X_2341_ Tile_X0Y2_FrameData_O[17] Tile_X0Y2_FrameData[17] VPWR VGND sg13cmos5l_buf_1
XFILLER_123_294 VPWR VGND sg13cmos5l_fill_1
X_2272_ Tile_X0Y1_FrameData_O[29] Tile_X0Y1_FrameData[29] VPWR VGND sg13cmos5l_buf_1
XFILLER_96_123 VPWR VGND sg13cmos5l_fill_1
X_1223_ _1223_/Q Tile_X0Y0_FrameData[4] Tile_X0Y3_FrameStrobe[0] VPWR VGND sg13cmos5l_dlhq_1
XFILLER_203_11 VPWR VGND sg13cmos5l_fill_2
X_1154_ _1155_/C _1870_/Q _0500_/X _1153_/X VPWR VGND sg13cmos5l_o21ai_1
XANTENNA__2138__D Tile_X0Y3_FrameData[25] VPWR VGND sg13cmos5l_antennanp
XANTENNA__2275__X Tile_X0Y1_UserCLKo VPWR VGND sg13cmos5l_antennanp
X_1085_ _2279_/A _0937_/X _0501_/B AXIL_S_SOC_WDATA1 AXIL_S_SOC_WDATA4 _1861_/Q _1860_/Q
+ VPWR VGND sg13cmos5l_mux4_1
XFILLER_37_289 VPWR VGND sg13cmos5l_decap_4
XFILLER_52_259 VPWR VGND sg13cmos5l_decap_8
XFILLER_52_237 VPWR VGND sg13cmos5l_decap_8
XANTENNA__1977__D Tile_X0Y3_FrameData[26] VPWR VGND sg13cmos5l_antennanp
XFILLER_20_112 VPWR VGND sg13cmos5l_fill_1
XFILLER_20_101 VPWR VGND sg13cmos5l_decap_8
XANTENNA__0660__A0 AXIL_S_SOC_RREADY VPWR VGND sg13cmos5l_antennanp
X_1987_ _1987_/Q Tile_X0Y3_FrameData[16] Tile_X0Y3_FrameStrobe[1] VPWR VGND sg13cmos5l_dlhq_1
X_0938_ _0939_/B Tile_X0Y1_W1END[0] Tile_X0Y1_WW4END[12] Tile_X0Y1_W6END[4] _0906_/A
+ _1631_/Q _1630_/Q VPWR VGND sg13cmos5l_mux4_1
X_0869_ _0869_/X _0737_/X _0740_/X _0741_/X Tile_X0Y0_S2MID[4] _1458_/Q _1459_/Q VPWR
+ VGND sg13cmos5l_mux4_1
X_2608_ Tile_X0Y3_S4BEG[14] _2608_/A VPWR VGND sg13cmos5l_buf_1
XANTENNA__1217__D Tile_X0Y0_FrameData[10] VPWR VGND sg13cmos5l_antennanp
XFILLER_114_261 VPWR VGND sg13cmos5l_fill_1
X_2539_ Tile_X0Y3_EE4BEG[13] _2539_/A VPWR VGND sg13cmos5l_buf_1
XFILLER_114_283 VPWR VGND sg13cmos5l_fill_1
XFILLER_114_294 VPWR VGND sg13cmos5l_fill_1
XFILLER_87_145 VPWR VGND sg13cmos5l_decap_8
XFILLER_57_27 VPWR VGND sg13cmos5l_decap_4
XANTENNA__0479__A0 Tile_X0Y3_N1END[2] VPWR VGND sg13cmos5l_antennanp
XFILLER_28_212 VPWR VGND sg13cmos5l_decap_8
XFILLER_113_44 VPWR VGND sg13cmos5l_fill_2
XFILLER_113_55 VPWR VGND sg13cmos5l_fill_2
XANTENNA__2048__D Tile_X0Y3_FrameData[19] VPWR VGND sg13cmos5l_antennanp
XFILLER_189_37 VPWR VGND sg13cmos5l_fill_2
XANTENNA__1887__D Tile_X0Y2_FrameData[28] VPWR VGND sg13cmos5l_antennanp
XANTENNA__0651__A0 Tile_X0Y2_W2MID[5] VPWR VGND sg13cmos5l_antennanp
XFILLER_156_139 VPWR VGND sg13cmos5l_decap_4
XFILLER_7_116 VPWR VGND sg13cmos5l_decap_8
XFILLER_22_52 VPWR VGND sg13cmos5l_decap_8
XANTENNA__0954__A1 AXIL_S_SOC_WDATA29 VPWR VGND sg13cmos5l_antennanp
XFILLER_105_261 VPWR VGND sg13cmos5l_fill_1
XFILLER_98_78 VPWR VGND sg13cmos5l_decap_8
XANTENNA__0706__A1 Tile_X0Y3_W6END[9] VPWR VGND sg13cmos5l_antennanp
XFILLER_105_283 VPWR VGND sg13cmos5l_fill_1
XANTENNA__1581__GATE Tile_X0Y3_FrameStrobe[4] VPWR VGND sg13cmos5l_antennanp
XFILLER_154_84 VPWR VGND sg13cmos5l_decap_8
XFILLER_170_50 VPWR VGND sg13cmos5l_fill_2
XFILLER_47_82 VPWR VGND sg13cmos5l_decap_8
XANTENNA__1596__GATE Tile_X0Y3_FrameStrobe[4] VPWR VGND sg13cmos5l_antennanp
XANTENNA__0485__A3 Tile_X0Y0_S4END[14] VPWR VGND sg13cmos5l_antennanp
XANTENNA__0890__A0 Tile_X0Y0_W1END[3] VPWR VGND sg13cmos5l_antennanp
XANTENNA__1797__D Tile_X0Y2_FrameData[22] VPWR VGND sg13cmos5l_antennanp
X_1910_ _1910_/Q Tile_X0Y2_FrameData[5] Tile_X0Y3_FrameStrobe[6] VPWR VGND sg13cmos5l_dlhq_1
XANTENNA__0642__A0 Tile_X0Y1_W2MID[7] VPWR VGND sg13cmos5l_antennanp
X_1841_ _1841_/Q Tile_X0Y2_FrameData[10] Tile_X0Y3_FrameStrobe[4] VPWR VGND sg13cmos5l_dlhq_1
XANTENNA__2271__A Tile_X0Y1_FrameData[28] VPWR VGND sg13cmos5l_antennanp
X_1772_ _1772_/Q Tile_X0Y2_FrameData[15] Tile_X0Y3_FrameStrobe[2] VPWR VGND sg13cmos5l_dlhq_1
XFILLER_8_87 VPWR VGND sg13cmos5l_decap_4
XANTENNA__1534__GATE Tile_X0Y3_FrameStrobe[2] VPWR VGND sg13cmos5l_antennanp
X_0723_ _0723_/X Tile_X0Y0_W2MID[5] Tile_X0Y0_W2END[5] Tile_X0Y0_W6END[10] _0653_/X
+ _1395_/Q _1394_/Q VPWR VGND sg13cmos5l_mux4_1
X_0654_ _0654_/X Tile_X0Y0_W2MID[2] Tile_X0Y0_W2END[2] Tile_X0Y0_W6END[2] _0653_/X
+ _1271_/Q _1270_/Q VPWR VGND sg13cmos5l_mux4_1
XANTENNA__1174__X AXIL_S_SOC_RDATA13 VPWR VGND sg13cmos5l_antennanp
XANTENNA__1549__GATE Tile_X0Y3_FrameStrobe[3] VPWR VGND sg13cmos5l_antennanp
X_2324_ Tile_X0Y2_FrameData_O[0] Tile_X0Y2_FrameData[0] VPWR VGND sg13cmos5l_buf_1
X_0585_ _2579_/A Tile_X0Y3_W2MID[6] Tile_X0Y3_W2END[6] Tile_X0Y3_W6END[9] _0584_/X
+ _2141_/Q _2140_/Q VPWR VGND sg13cmos5l_mux4_1
XFILLER_26_0 VPWR VGND sg13cmos5l_decap_8
XFILLER_111_286 VPWR VGND sg13cmos5l_fill_1
X_2255_ Tile_X0Y1_FrameData_O[12] Tile_X0Y1_FrameData[12] VPWR VGND sg13cmos5l_buf_1
XFILLER_84_104 VPWR VGND sg13cmos5l_decap_4
X_1206_ _1206_/Q Tile_X0Y0_FrameData[21] Tile_X0Y3_FrameStrobe[0] VPWR VGND sg13cmos5l_dlhq_1
X_2186_ _2186_/Q Tile_X0Y3_FrameData[9] Tile_X0Y3_FrameStrobe[7] VPWR VGND sg13cmos5l_dlhq_1
XFILLER_214_87 VPWR VGND sg13cmos5l_decap_8
X_1137_ _1137_/X _1108_/X _1101_/X _0471_/X _0729_/X _1873_/Q _1872_/Q VPWR VGND sg13cmos5l_mux4_1
XANTENNA__0881__A0 AXIL_S_SOC_AWVALID VPWR VGND sg13cmos5l_antennanp
X_1068_ _1068_/Y _1068_/A VPWR VGND sg13cmos5l_inv_1
XANTENNA__1500__D Tile_X0Y1_FrameData[7] VPWR VGND sg13cmos5l_antennanp
XFILLER_193_212 VPWR VGND sg13cmos5l_decap_8
XANTENNA__0936__A1 Tile_X0Y3_W6END[6] VPWR VGND sg13cmos5l_antennanp
XFILLER_175_28 VPWR VGND sg13cmos5l_fill_1
XFILLER_68_15 VPWR VGND sg13cmos5l_decap_8
XFILLER_68_48 VPWR VGND sg13cmos5l_fill_2
XFILLER_84_14 VPWR VGND sg13cmos5l_fill_2
XFILLER_90_107 VPWR VGND sg13cmos5l_fill_2
XFILLER_216_143 VPWR VGND sg13cmos5l_decap_8
XANTENNA__0872__A0 Tile_X0Y3_N4END[14] VPWR VGND sg13cmos5l_antennanp
XANTENNA__2356__A Tile_X0Y2_UserCLK VPWR VGND sg13cmos5l_antennanp
XFILLER_16_237 VPWR VGND sg13cmos5l_fill_1
XFILLER_140_75 VPWR VGND sg13cmos5l_fill_2
XFILLER_31_207 VPWR VGND sg13cmos5l_decap_8
XFILLER_17_85 VPWR VGND sg13cmos5l_fill_1
XANTENNA__1410__D Tile_X0Y0_FrameData[9] VPWR VGND sg13cmos5l_antennanp
XFILLER_169_220 VPWR VGND sg13cmos5l_fill_2
XANTENNA__0624__A0 Tile_X0Y3_W1END[3] VPWR VGND sg13cmos5l_antennanp
XFILLER_129_106 VPWR VGND sg13cmos5l_decap_8
XFILLER_169_253 VPWR VGND sg13cmos5l_fill_2
XFILLER_169_275 VPWR VGND sg13cmos5l_fill_1
XFILLER_24_292 VPWR VGND sg13cmos5l_fill_2
XFILLER_130_0 VPWR VGND sg13cmos5l_fill_1
XFILLER_184_234 VPWR VGND sg13cmos5l_decap_4
XFILLER_137_161 VPWR VGND sg13cmos5l_decap_8
XFILLER_152_175 VPWR VGND sg13cmos5l_fill_2
XFILLER_98_218 VPWR VGND sg13cmos5l_decap_8
X_2040_ _2040_/Q Tile_X0Y3_FrameData[27] Tile_X0Y3_FrameStrobe[3] VPWR VGND sg13cmos5l_dlhq_1
XANTENNA__1104__A1 AXIL_S_SOC_WDATA8 VPWR VGND sg13cmos5l_antennanp
XANTENNA__2266__A Tile_X0Y1_FrameData[23] VPWR VGND sg13cmos5l_antennanp
XFILLER_74_170 VPWR VGND sg13cmos5l_fill_1
XFILLER_222_102 VPWR VGND sg13cmos5l_decap_8
XANTENNA__0863__A0 Tile_X0Y0_W1END[0] VPWR VGND sg13cmos5l_antennanp
XFILLER_207_187 VPWR VGND sg13cmos5l_fill_1
XANTENNA__1320__D Tile_X0Y0_FrameData[3] VPWR VGND sg13cmos5l_antennanp
XANTENNA__2553__X Tile_X0Y3_FrameData_O[11] VPWR VGND sg13cmos5l_antennanp
XANTENNA__1473__GATE Tile_X0Y3_FrameStrobe[0] VPWR VGND sg13cmos5l_antennanp
X_1824_ _1824_/Q Tile_X0Y2_FrameData[27] Tile_X0Y3_FrameStrobe[4] VPWR VGND sg13cmos5l_dlhq_1
XFILLER_175_256 VPWR VGND sg13cmos5l_fill_1
X_1755_ _1755_/Q Tile_X0Y2_FrameData[0] Tile_X0Y3_FrameStrobe[1] VPWR VGND sg13cmos5l_dlhq_1
XFILLER_190_204 VPWR VGND sg13cmos5l_decap_8
XANTENNA__1040__A0 AXIL_S_SOC_WDATA20 VPWR VGND sg13cmos5l_antennanp
XANTENNA__2151__D Tile_X0Y3_FrameData[12] VPWR VGND sg13cmos5l_antennanp
X_0706_ AXIL_S_SOC_RDATA5 Tile_X0Y3_W1END[1] Tile_X0Y3_W6END[9] Tile_X0Y3_WW4END[14]
+ _0565_/Y _2000_/Q _2001_/Q VPWR VGND sg13cmos5l_mux4_1
XFILLER_209_76 VPWR VGND sg13cmos5l_fill_1
XANTENNA__1488__GATE Tile_X0Y3_FrameStrobe[1] VPWR VGND sg13cmos5l_antennanp
X_1686_ _1686_/Q Tile_X0Y1_FrameData[13] Tile_X0Y3_FrameStrobe[7] VPWR VGND sg13cmos5l_dlhq_1
XANTENNA__1990__D Tile_X0Y3_FrameData[13] VPWR VGND sg13cmos5l_antennanp
X_0637_ _0637_/Y _0627_/B _0636_/X _2193_/Q VPWR VGND sg13cmos5l_a21oi_1
XFILLER_225_20 VPWR VGND sg13cmos5l_decap_8
X_0568_ _0568_/Y Tile_X0Y3_W6END[2] _1943_/Q _0567_/Y VPWR VGND sg13cmos5l_a21oi_1
XFILLER_97_240 VPWR VGND sg13cmos5l_decap_8
XANTENNA__1411__GATE Tile_X0Y3_FrameStrobe[6] VPWR VGND sg13cmos5l_antennanp
X_2307_ Tile_X0Y2_E6BEG[11] _2307_/A VPWR VGND sg13cmos5l_buf_1
XFILLER_97_262 VPWR VGND sg13cmos5l_fill_2
X_2238_ Tile_X0Y1_EE4BEG[11] _2238_/A VPWR VGND sg13cmos5l_buf_1
X_0499_ _0501_/B Tile_X0Y1_W1END[3] Tile_X0Y1_W6END[11] _0493_/X _0498_/X _1649_/Q
+ _1648_/Q VPWR VGND sg13cmos5l_mux4_1
X_2169_ _2169_/Q Tile_X0Y3_FrameData[26] Tile_X0Y3_FrameStrobe[7] VPWR VGND sg13cmos5l_dlhq_1
XFILLER_72_129 VPWR VGND sg13cmos5l_decap_8
XFILLER_65_181 VPWR VGND sg13cmos5l_decap_8
XANTENNA__0854__A0 AXIL_S_SOC_WSTRB0 VPWR VGND sg13cmos5l_antennanp
XANTENNA__1426__GATE Tile_X0Y3_FrameStrobe[7] VPWR VGND sg13cmos5l_antennanp
XFILLER_213_135 VPWR VGND sg13cmos5l_decap_8
XFILLER_213_124 VPWR VGND sg13cmos5l_fill_1
XFILLER_213_113 VPWR VGND sg13cmos5l_fill_1
XANTENNA__1230__D Tile_X0Y0_FrameData[29] VPWR VGND sg13cmos5l_antennanp
XANTENNA__2463__X Tile_X0Y0_E6BEG[1] VPWR VGND sg13cmos5l_antennanp
XFILLER_119_161 VPWR VGND sg13cmos5l_decap_8
XFILLER_119_32 VPWR VGND sg13cmos5l_decap_4
XANTENNA__1031__A0 AXIL_S_SOC_WDATA19 VPWR VGND sg13cmos5l_antennanp
XANTENNA__2061__D Tile_X0Y3_FrameData[6] VPWR VGND sg13cmos5l_antennanp
XFILLER_79_14 VPWR VGND sg13cmos5l_decap_8
XFILLER_135_31 VPWR VGND sg13cmos5l_fill_2
XANTENNA__1405__D Tile_X0Y0_FrameData[14] VPWR VGND sg13cmos5l_antennanp
XFILLER_95_79 VPWR VGND sg13cmos5l_decap_8
XFILLER_48_137 VPWR VGND sg13cmos5l_decap_8
XANTENNA__1098__A0 AXIL_S_SOC_WDATA4 VPWR VGND sg13cmos5l_antennanp
XFILLER_28_84 VPWR VGND sg13cmos5l_decap_8
XFILLER_28_51 VPWR VGND sg13cmos5l_decap_8
XFILLER_151_63 VPWR VGND sg13cmos5l_fill_1
XANTENNA__0845__A0 AXIL_S_SOC_AWADDR0 VPWR VGND sg13cmos5l_antennanp
XANTENNA__2373__X Tile_X0Y0_N4BEG[15] VPWR VGND sg13cmos5l_antennanp
XFILLER_71_162 VPWR VGND sg13cmos5l_decap_8
XFILLER_44_61 VPWR VGND sg13cmos5l_fill_1
XFILLER_44_83 VPWR VGND sg13cmos5l_decap_8
XFILLER_212_190 VPWR VGND sg13cmos5l_decap_8
XFILLER_8_266 VPWR VGND sg13cmos5l_decap_8
XFILLER_172_215 VPWR VGND sg13cmos5l_decap_8
XANTENNA__1022__A0 AXIL_S_SOC_WDATA22 VPWR VGND sg13cmos5l_antennanp
X_1540_ _1540_/Q Tile_X0Y1_FrameData[31] Tile_X0Y3_FrameStrobe[3] VPWR VGND sg13cmos5l_dlhq_1
XFILLER_140_101 VPWR VGND sg13cmos5l_fill_2
X_1471_ _1471_/Q Tile_X0Y1_FrameData[4] Tile_X0Y3_FrameStrobe[0] VPWR VGND sg13cmos5l_dlhq_1
XFILLER_79_251 VPWR VGND sg13cmos5l_decap_8
XFILLER_5_99 VPWR VGND sg13cmos5l_decap_8
XANTENNA__2548__X Tile_X0Y3_FrameData_O[6] VPWR VGND sg13cmos5l_antennanp
XANTENNA__1315__D Tile_X0Y0_FrameData[8] VPWR VGND sg13cmos5l_antennanp
XANTENNA__2141__GATE Tile_X0Y3_FrameStrobe[6] VPWR VGND sg13cmos5l_antennanp
XANTENNA__1089__A0 AXIL_S_SOC_WDATA7 VPWR VGND sg13cmos5l_antennanp
XFILLER_54_118 VPWR VGND sg13cmos5l_fill_2
X_2023_ _2023_/Q Tile_X0Y3_FrameData[12] Tile_X0Y3_FrameStrobe[2] VPWR VGND sg13cmos5l_dlhq_1
XFILLER_47_181 VPWR VGND sg13cmos5l_fill_2
XANTENNA__2146__D Tile_X0Y3_FrameData[17] VPWR VGND sg13cmos5l_antennanp
XANTENNA__2156__GATE Tile_X0Y3_FrameStrobe[6] VPWR VGND sg13cmos5l_antennanp
XANTENNA__2283__X Tile_X0Y2_E2BEG[3] VPWR VGND sg13cmos5l_antennanp
XFILLER_93_0 VPWR VGND sg13cmos5l_fill_1
XANTENNA__1985__D Tile_X0Y3_FrameData[18] VPWR VGND sg13cmos5l_antennanp
XFILLER_148_223 VPWR VGND sg13cmos5l_fill_2
XFILLER_210_138 VPWR VGND sg13cmos5l_decap_8
XFILLER_108_109 VPWR VGND sg13cmos5l_decap_4
X_1807_ _1807_/Q Tile_X0Y2_FrameData[12] Tile_X0Y3_FrameStrobe[3] VPWR VGND sg13cmos5l_dlhq_1
XANTENNA__1013__A0 Tile_X0Y1_W2MID[5] VPWR VGND sg13cmos5l_antennanp
XFILLER_156_19 VPWR VGND sg13cmos5l_fill_2
X_1738_ _1738_/Q Tile_X0Y2_FrameData[17] Tile_X0Y3_FrameStrobe[1] VPWR VGND sg13cmos5l_dlhq_1
X_1669_ _1669_/Q Tile_X0Y1_FrameData[30] Tile_X0Y3_FrameStrobe[7] VPWR VGND sg13cmos5l_dlhq_1
XFILLER_49_39 VPWR VGND sg13cmos5l_decap_8
XANTENNA__1350__GATE Tile_X0Y3_FrameStrobe[4] VPWR VGND sg13cmos5l_antennanp
XANTENNA__2458__X Tile_X0Y0_EE4BEG[12] VPWR VGND sg13cmos5l_antennanp
XFILLER_131_189 VPWR VGND sg13cmos5l_fill_1
XANTENNA__1225__D Tile_X0Y0_FrameData[2] VPWR VGND sg13cmos5l_antennanp
XANTENNA__1980__GATE Tile_X0Y3_FrameStrobe[1] VPWR VGND sg13cmos5l_antennanp
XANTENNA__2109__GATE Tile_X0Y3_FrameStrobe[5] VPWR VGND sg13cmos5l_antennanp
XFILLER_85_221 VPWR VGND sg13cmos5l_decap_8
XFILLER_218_216 VPWR VGND sg13cmos5l_decap_4
XFILLER_85_276 VPWR VGND sg13cmos5l_fill_1
XFILLER_65_16 VPWR VGND sg13cmos5l_fill_1
XANTENNA__1365__GATE Tile_X0Y3_FrameStrobe[5] VPWR VGND sg13cmos5l_antennanp
XANTENNA__0827__A0 AXIL_S_SOC_WSTRB1 VPWR VGND sg13cmos5l_antennanp
XANTENNA__1995__GATE Tile_X0Y3_FrameStrobe[1] VPWR VGND sg13cmos5l_antennanp
XFILLER_38_192 VPWR VGND sg13cmos5l_decap_8
XANTENNA__0706__X AXIL_S_SOC_RDATA5 VPWR VGND sg13cmos5l_antennanp
XANTENNA__2056__D Tile_X0Y3_FrameData[11] VPWR VGND sg13cmos5l_antennanp
XFILLER_121_77 VPWR VGND sg13cmos5l_decap_8
XFILLER_53_184 VPWR VGND sg13cmos5l_fill_2
XFILLER_81_48 VPWR VGND sg13cmos5l_decap_8
XFILLER_201_105 VPWR VGND sg13cmos5l_decap_8
XFILLER_197_15 VPWR VGND sg13cmos5l_fill_1
XANTENNA__1895__D Tile_X0Y2_FrameData[20] VPWR VGND sg13cmos5l_antennanp
XFILLER_14_31 VPWR VGND sg13cmos5l_fill_1
XFILLER_139_267 VPWR VGND sg13cmos5l_decap_4
XANTENNA__1004__A0 AXIL_S_SOC_WDATA19 VPWR VGND sg13cmos5l_antennanp
XANTENNA__1303__GATE Tile_X0Y3_FrameStrobe[3] VPWR VGND sg13cmos5l_antennanp
XANTENNA__1933__GATE Tile_X0Y3_FrameStrobe[7] VPWR VGND sg13cmos5l_antennanp
XANTENNA__1318__GATE Tile_X0Y3_FrameStrobe[3] VPWR VGND sg13cmos5l_antennanp
XANTENNA__1948__GATE Tile_X0Y3_FrameStrobe[0] VPWR VGND sg13cmos5l_antennanp
XANTENNA__2368__X Tile_X0Y0_N4BEG[10] VPWR VGND sg13cmos5l_antennanp
XFILLER_76_243 VPWR VGND sg13cmos5l_decap_8
XFILLER_39_61 VPWR VGND sg13cmos5l_decap_4
XFILLER_217_293 VPWR VGND sg13cmos5l_fill_2
XFILLER_55_93 VPWR VGND sg13cmos5l_decap_8
XFILLER_44_151 VPWR VGND sg13cmos5l_decap_8
XANTENNA__2544__A Tile_X0Y3_FrameData[2] VPWR VGND sg13cmos5l_antennanp
X_0971_ _0971_/Y _1622_/Q _0945_/X _0970_/Y VPWR VGND sg13cmos5l_o21ai_1
XANTENNA__0597__A2 Tile_X0Y2_W2MID[1] VPWR VGND sg13cmos5l_antennanp
XFILLER_200_182 VPWR VGND sg13cmos5l_decap_8
XFILLER_145_259 VPWR VGND sg13cmos5l_decap_8
X_2572_ Tile_X0Y3_FrameData_O[30] Tile_X0Y3_FrameData[30] VPWR VGND sg13cmos5l_buf_1
XFILLER_153_281 VPWR VGND sg13cmos5l_decap_4
X_1523_ _1523_/Q Tile_X0Y1_FrameData[16] Tile_X0Y3_FrameStrobe[2] VPWR VGND sg13cmos5l_dlhq_1
XFILLER_113_145 VPWR VGND sg13cmos5l_fill_2
X_1454_ _1454_/Q Tile_X0Y1_FrameData[21] Tile_X0Y3_FrameStrobe[0] VPWR VGND sg13cmos5l_dlhq_1
XANTENNA__1182__X AXIL_S_SOC_RDATA8 VPWR VGND sg13cmos5l_antennanp
XANTENNA__2080__GATE Tile_X0Y3_FrameStrobe[4] VPWR VGND sg13cmos5l_antennanp
XANTENNA__2278__X Tile_X0Y2_E1BEG[2] VPWR VGND sg13cmos5l_antennanp
X_1385_ _1385_/Q Tile_X0Y0_FrameData[2] Tile_X0Y3_FrameStrobe[5] VPWR VGND sg13cmos5l_dlhq_1
XFILLER_67_221 VPWR VGND sg13cmos5l_fill_1
XFILLER_206_99 VPWR VGND sg13cmos5l_fill_2
XFILLER_82_202 VPWR VGND sg13cmos5l_decap_8
XFILLER_67_276 VPWR VGND sg13cmos5l_fill_2
XFILLER_222_54 VPWR VGND sg13cmos5l_fill_2
XANTENNA__2095__GATE Tile_X0Y3_FrameStrobe[4] VPWR VGND sg13cmos5l_antennanp
X_2006_ _2006_/Q Tile_X0Y3_FrameData[29] Tile_X0Y3_FrameStrobe[2] VPWR VGND sg13cmos5l_dlhq_1
XFILLER_222_65 VPWR VGND sg13cmos5l_decap_8
XFILLER_208_293 VPWR VGND sg13cmos5l_fill_2
XFILLER_35_184 VPWR VGND sg13cmos5l_decap_8
XFILLER_167_18 VPWR VGND sg13cmos5l_decap_4
XFILLER_195_148 VPWR VGND sg13cmos5l_decap_8
XANTENNA__0588__A2 Tile_X0Y1_W2MID[3] VPWR VGND sg13cmos5l_antennanp
XFILLER_167_29 VPWR VGND sg13cmos5l_decap_4
XANTENNA__2033__GATE Tile_X0Y3_FrameStrobe[2] VPWR VGND sg13cmos5l_antennanp
XFILLER_151_207 VPWR VGND sg13cmos5l_decap_8
XANTENNA__0760__A2 Tile_X0Y3_N4END[12] VPWR VGND sg13cmos5l_antennanp
XANTENNA__2048__GATE Tile_X0Y3_FrameStrobe[3] VPWR VGND sg13cmos5l_antennanp
XFILLER_58_265 VPWR VGND sg13cmos5l_decap_8
XFILLER_92_36 VPWR VGND sg13cmos5l_decap_8
XFILLER_26_173 VPWR VGND sg13cmos5l_decap_8
XFILLER_155_2 VPWR VGND sg13cmos5l_fill_1
XFILLER_25_85 VPWR VGND sg13cmos5l_fill_2
XFILLER_186_126 VPWR VGND sg13cmos5l_decap_4
XFILLER_41_198 VPWR VGND sg13cmos5l_decap_8
XFILLER_186_148 VPWR VGND sg13cmos5l_decap_4
XANTENNA__1242__GATE Tile_X0Y3_FrameStrobe[1] VPWR VGND sg13cmos5l_antennanp
XANTENNA__1872__GATE Tile_X0Y3_FrameStrobe[5] VPWR VGND sg13cmos5l_antennanp
XFILLER_127_237 VPWR VGND sg13cmos5l_decap_8
XFILLER_127_248 VPWR VGND sg13cmos5l_fill_1
XFILLER_210_0 VPWR VGND sg13cmos5l_fill_1
XFILLER_157_84 VPWR VGND sg13cmos5l_decap_8
XANTENNA__1257__GATE Tile_X0Y3_FrameStrobe[1] VPWR VGND sg13cmos5l_antennanp
XANTENNA__1887__GATE Tile_X0Y3_FrameStrobe[6] VPWR VGND sg13cmos5l_antennanp
XANTENNA__0751__A2 Tile_X0Y0_S2MID[6] VPWR VGND sg13cmos5l_antennanp
XFILLER_110_104 VPWR VGND sg13cmos5l_decap_4
XFILLER_173_61 VPWR VGND sg13cmos5l_decap_4
XFILLER_2_34 VPWR VGND sg13cmos5l_fill_1
XANTENNA__1810__GATE Tile_X0Y3_FrameStrobe[3] VPWR VGND sg13cmos5l_antennanp
X_1170_ _1170_/Y _1904_/Q _1170_/B VPWR VGND sg13cmos5l_nor2_1
XFILLER_49_243 VPWR VGND sg13cmos5l_decap_8
XFILLER_2_56 VPWR VGND sg13cmos5l_decap_8
XFILLER_64_224 VPWR VGND sg13cmos5l_decap_8
XFILLER_2_89 VPWR VGND sg13cmos5l_decap_8
XANTENNA__1059__A3 Tile_X0Y0_S4END[8] VPWR VGND sg13cmos5l_antennanp
XFILLER_17_162 VPWR VGND sg13cmos5l_decap_8
XFILLER_17_140 VPWR VGND sg13cmos5l_fill_1
XANTENNA__1825__GATE Tile_X0Y3_FrameStrobe[4] VPWR VGND sg13cmos5l_antennanp
XANTENNA__2274__A Tile_X0Y1_FrameData[31] VPWR VGND sg13cmos5l_antennanp
XFILLER_32_110 VPWR VGND sg13cmos5l_decap_4
XFILLER_82_91 VPWR VGND sg13cmos5l_decap_8
XFILLER_32_165 VPWR VGND sg13cmos5l_decap_8
XANTENNA__2561__X Tile_X0Y3_FrameData_O[19] VPWR VGND sg13cmos5l_antennanp
XFILLER_220_277 VPWR VGND sg13cmos5l_decap_4
XFILLER_198_91 VPWR VGND sg13cmos5l_decap_8
X_0954_ _2204_/A AXIL_S_SOC_WDATA21 AXIL_S_SOC_WDATA29 _0867_/X _0865_/X _1601_/Q
+ _1600_/Q VPWR VGND sg13cmos5l_mux4_1
X_0885_ _2459_/A AXIL_S_SOC_WSTRB0 AXIL_S_SOC_AWADDR7 _0785_/X _0653_/X _1305_/Q _1304_/Q
+ VPWR VGND sg13cmos5l_mux4_1
XFILLER_56_0 VPWR VGND sg13cmos5l_fill_2
XFILLER_217_43 VPWR VGND sg13cmos5l_fill_1
X_2555_ Tile_X0Y3_FrameData_O[13] Tile_X0Y3_FrameData[13] VPWR VGND sg13cmos5l_buf_1
XANTENNA__0742__A2 Tile_X0Y3_N2MID[4] VPWR VGND sg13cmos5l_antennanp
XFILLER_141_251 VPWR VGND sg13cmos5l_decap_8
X_1506_ _1506_/Q Tile_X0Y1_FrameData[1] Tile_X0Y3_FrameStrobe[1] VPWR VGND sg13cmos5l_dlhq_1
X_2486_ Tile_X0Y0_E2BEG[4] _2486_/A VPWR VGND sg13cmos5l_buf_1
XFILLER_141_284 VPWR VGND sg13cmos5l_fill_2
X_1437_ _1437_/Q Tile_X0Y0_FrameData[14] Tile_X0Y3_FrameStrobe[7] VPWR VGND sg13cmos5l_dlhq_1
X_1368_ _1368_/Q Tile_X0Y0_FrameData[19] Tile_X0Y3_FrameStrobe[5] VPWR VGND sg13cmos5l_dlhq_1
XFILLER_46_29 VPWR VGND sg13cmos5l_fill_1
XANTENNA__1503__D Tile_X0Y1_FrameData[4] VPWR VGND sg13cmos5l_antennanp
X_1299_ _1299_/Q Tile_X0Y0_FrameData[24] Tile_X0Y3_FrameStrobe[3] VPWR VGND sg13cmos5l_dlhq_1
XFILLER_102_46 VPWR VGND sg13cmos5l_fill_1
XFILLER_55_268 VPWR VGND sg13cmos5l_fill_1
XFILLER_211_211 VPWR VGND sg13cmos5l_decap_8
XFILLER_178_17 VPWR VGND sg13cmos5l_decap_4
XANTENNA__2471__X Tile_X0Y0_E6BEG[9] VPWR VGND sg13cmos5l_antennanp
XFILLER_23_176 VPWR VGND sg13cmos5l_decap_4
XFILLER_211_277 VPWR VGND sg13cmos5l_fill_1
XFILLER_109_204 VPWR VGND sg13cmos5l_decap_8
XANTENNA__0432__A Tile_X0Y0_W1END[2] VPWR VGND sg13cmos5l_antennanp
XFILLER_191_173 VPWR VGND sg13cmos5l_decap_4
XFILLER_117_281 VPWR VGND sg13cmos5l_fill_1
XANTENNA__0733__A2 Tile_X0Y0_W6END[2] VPWR VGND sg13cmos5l_antennanp
XFILLER_143_20 VPWR VGND sg13cmos5l_fill_1
XANTENNA__1413__D Tile_X0Y0_FrameData[6] VPWR VGND sg13cmos5l_antennanp
XFILLER_160_0 VPWR VGND sg13cmos5l_decap_4
XFILLER_61_249 VPWR VGND sg13cmos5l_decap_8
XFILLER_159_104 VPWR VGND sg13cmos5l_decap_8
XFILLER_202_222 VPWR VGND sg13cmos5l_fill_2
XANTENNA__2381__X Tile_X0Y0_N2BEGb[7] VPWR VGND sg13cmos5l_antennanp
XFILLER_159_148 VPWR VGND sg13cmos5l_decap_8
XFILLER_159_159 VPWR VGND sg13cmos5l_fill_1
XFILLER_52_61 VPWR VGND sg13cmos5l_decap_8
XFILLER_167_181 VPWR VGND sg13cmos5l_fill_2
X_0670_ _2511_/A AXIL_S_SOC_ARADDR0 AXIL_S_SOC_ARADDR8 _0483_/X _0594_/X _2081_/Q
+ _2080_/Q VPWR VGND sg13cmos5l_mux4_1
XFILLER_182_151 VPWR VGND sg13cmos5l_fill_2
X_2340_ Tile_X0Y2_FrameData_O[16] Tile_X0Y2_FrameData[16] VPWR VGND sg13cmos5l_buf_1
XANTENNA__0724__A2 Tile_X0Y3_W6END[5] VPWR VGND sg13cmos5l_antennanp
XANTENNA__2269__A Tile_X0Y1_FrameData[26] VPWR VGND sg13cmos5l_antennanp
X_2271_ Tile_X0Y1_FrameData_O[28] Tile_X0Y1_FrameData[28] VPWR VGND sg13cmos5l_buf_1
X_1222_ _1222_/Q Tile_X0Y0_FrameData[5] Tile_X0Y3_FrameStrobe[0] VPWR VGND sg13cmos5l_dlhq_1
XANTENNA__0488__A1 Tile_X0Y0_S1END[3] VPWR VGND sg13cmos5l_antennanp
XANTENNA__1323__D Tile_X0Y0_FrameData[0] VPWR VGND sg13cmos5l_antennanp
XANTENNA__2556__X Tile_X0Y3_FrameData_O[14] VPWR VGND sg13cmos5l_antennanp
X_1153_ _1153_/X _1869_/Q _1153_/B VPWR VGND sg13cmos5l_and2_1
XANTENNA__1764__GATE Tile_X0Y3_FrameStrobe[2] VPWR VGND sg13cmos5l_antennanp
X_1084_ _2280_/A AXIL_S_SOC_WDATA0 AXIL_S_SOC_WDATA8 _0719_/X _0758_/X _1859_/Q _1858_/Q
+ VPWR VGND sg13cmos5l_mux4_1
XFILLER_45_290 VPWR VGND sg13cmos5l_decap_4
XANTENNA__2154__D Tile_X0Y3_FrameData[9] VPWR VGND sg13cmos5l_antennanp
XFILLER_60_282 VPWR VGND sg13cmos5l_fill_2
XANTENNA__0660__A1 AXIL_S_SOC_ARADDR6 VPWR VGND sg13cmos5l_antennanp
XANTENNA__1779__GATE Tile_X0Y3_FrameStrobe[2] VPWR VGND sg13cmos5l_antennanp
XANTENNA__2291__X Tile_X0Y2_E2BEGb[3] VPWR VGND sg13cmos5l_antennanp
X_1986_ _1986_/Q Tile_X0Y3_FrameData[17] Tile_X0Y3_FrameStrobe[1] VPWR VGND sg13cmos5l_dlhq_1
XFILLER_60_293 VPWR VGND sg13cmos5l_fill_2
XANTENNA__1993__D Tile_X0Y3_FrameData[10] VPWR VGND sg13cmos5l_antennanp
X_0937_ _0937_/X Tile_X0Y3_W1END[3] Tile_X0Y3_W6END[7] _0508_/X _0575_/Y _2181_/Q
+ _2180_/Q VPWR VGND sg13cmos5l_mux4_1
XFILLER_20_179 VPWR VGND sg13cmos5l_fill_2
XANTENNA__0963__A2 AXIL_S_SOC_WDATA19 VPWR VGND sg13cmos5l_antennanp
XANTENNA__1702__GATE Tile_X0Y3_FrameStrobe[0] VPWR VGND sg13cmos5l_antennanp
X_0868_ _0868_/X _0711_/X _0744_/X _0745_/X Tile_X0Y0_S2MID[3] _1460_/Q _1461_/Q VPWR
+ VGND sg13cmos5l_mux4_1
X_2607_ Tile_X0Y3_S4BEG[13] _2607_/A VPWR VGND sg13cmos5l_buf_1
X_0799_ _0799_/Y _0794_/Y _0795_/Y _1410_/Q VPWR VGND sg13cmos5l_o21ai_1
X_2538_ Tile_X0Y3_EE4BEG[12] _2538_/A VPWR VGND sg13cmos5l_buf_1
XANTENNA__0715__A2 Tile_X0Y3_N2MID[1] VPWR VGND sg13cmos5l_antennanp
XANTENNA__1717__GATE Tile_X0Y3_FrameStrobe[0] VPWR VGND sg13cmos5l_antennanp
XFILLER_57_17 VPWR VGND sg13cmos5l_fill_1
X_2469_ Tile_X0Y0_E6BEG[7] _2469_/A VPWR VGND sg13cmos5l_buf_1
XANTENNA__0479__A1 Tile_X0Y3_N4END[2] VPWR VGND sg13cmos5l_antennanp
XANTENNA__1233__D Tile_X0Y0_FrameData[26] VPWR VGND sg13cmos5l_antennanp
XANTENNA__2466__X Tile_X0Y0_E6BEG[4] VPWR VGND sg13cmos5l_antennanp
XFILLER_113_67 VPWR VGND sg13cmos5l_decap_8
XFILLER_113_78 VPWR VGND sg13cmos5l_fill_2
XANTENNA__2064__D Tile_X0Y3_FrameData[3] VPWR VGND sg13cmos5l_antennanp
XANTENNA__0651__A1 Tile_X0Y2_W2END[5] VPWR VGND sg13cmos5l_antennanp
XFILLER_156_118 VPWR VGND sg13cmos5l_decap_8
XFILLER_51_293 VPWR VGND sg13cmos5l_fill_2
XFILLER_22_31 VPWR VGND sg13cmos5l_decap_8
XFILLER_164_140 VPWR VGND sg13cmos5l_decap_8
XFILLER_138_64 VPWR VGND sg13cmos5l_decap_4
XFILLER_164_162 VPWR VGND sg13cmos5l_fill_1
XANTENNA__1408__D Tile_X0Y0_FrameData[11] VPWR VGND sg13cmos5l_antennanp
XFILLER_105_240 VPWR VGND sg13cmos5l_decap_8
XFILLER_105_251 VPWR VGND sg13cmos5l_fill_2
XFILLER_154_30 VPWR VGND sg13cmos5l_fill_1
XANTENNA__0706__A2 Tile_X0Y3_WW4END[14] VPWR VGND sg13cmos5l_antennanp
XFILLER_154_52 VPWR VGND sg13cmos5l_fill_1
XFILLER_78_124 VPWR VGND sg13cmos5l_fill_2
XFILLER_93_127 VPWR VGND sg13cmos5l_fill_1
XFILLER_19_202 VPWR VGND sg13cmos5l_decap_4
XANTENNA__2376__X Tile_X0Y0_N2BEGb[2] VPWR VGND sg13cmos5l_antennanp
XFILLER_93_149 VPWR VGND sg13cmos5l_fill_2
XFILLER_19_224 VPWR VGND sg13cmos5l_decap_8
XFILLER_170_84 VPWR VGND sg13cmos5l_decap_4
XANTENNA__0890__A1 Tile_X0Y0_WW4END[12] VPWR VGND sg13cmos5l_antennanp
XFILLER_27_290 VPWR VGND sg13cmos5l_decap_4
XANTENNA__0642__A1 Tile_X0Y1_W2END[7] VPWR VGND sg13cmos5l_antennanp
XANTENNA__2552__A Tile_X0Y3_FrameData[10] VPWR VGND sg13cmos5l_antennanp
X_1840_ _1840_/Q Tile_X0Y2_FrameData[11] Tile_X0Y3_FrameStrobe[4] VPWR VGND sg13cmos5l_dlhq_1
XFILLER_8_22 VPWR VGND sg13cmos5l_fill_2
XFILLER_8_11 VPWR VGND sg13cmos5l_fill_1
XFILLER_42_293 VPWR VGND sg13cmos5l_fill_2
XFILLER_187_276 VPWR VGND sg13cmos5l_decap_4
X_1771_ _1771_/Q Tile_X0Y2_FrameData[16] Tile_X0Y3_FrameStrobe[2] VPWR VGND sg13cmos5l_dlhq_1
XANTENNA__0945__A2 Tile_X0Y3_N4END[11] VPWR VGND sg13cmos5l_antennanp
XFILLER_155_151 VPWR VGND sg13cmos5l_decap_8
X_0722_ _2392_/A Tile_X0Y0_W1END[2] Tile_X0Y0_W6END[6] _0463_/A _0461_/Y _1439_/Q
+ _1438_/Q VPWR VGND sg13cmos5l_mux4_1
XANTENNA__1318__D Tile_X0Y0_FrameData[5] VPWR VGND sg13cmos5l_antennanp
X_0653_ _0653_/X _2376_/A _0651_/X Tile_X0Y0_S2MID[2] Tile_X0Y0_S2END[2] _1215_/Q
+ _1214_/Q VPWR VGND sg13cmos5l_mux4_1
X_0584_ _0584_/X Tile_X0Y3_N2MID[1] Tile_X0Y3_N2END[1] _2587_/A _0582_/X _1961_/Q
+ _1960_/Q VPWR VGND sg13cmos5l_mux4_1
X_2323_ Tile_X0Y2_EE4BEG[15] _2323_/A VPWR VGND sg13cmos5l_buf_1
XFILLER_69_113 VPWR VGND sg13cmos5l_fill_2
X_2254_ Tile_X0Y1_FrameData_O[11] Tile_X0Y1_FrameData[11] VPWR VGND sg13cmos5l_buf_1
XANTENNA__2149__D Tile_X0Y3_FrameData[14] VPWR VGND sg13cmos5l_antennanp
XANTENNA__2286__X Tile_X0Y2_E2BEG[6] VPWR VGND sg13cmos5l_antennanp
X_1205_ _1205_/Q Tile_X0Y0_FrameData[22] Tile_X0Y3_FrameStrobe[0] VPWR VGND sg13cmos5l_dlhq_1
X_2185_ _2185_/Q Tile_X0Y3_FrameData[10] Tile_X0Y3_FrameStrobe[7] VPWR VGND sg13cmos5l_dlhq_1
XFILLER_225_100 VPWR VGND sg13cmos5l_decap_4
XFILLER_19_0 VPWR VGND sg13cmos5l_fill_2
X_1136_ _1136_/X Tile_X0Y2_W1END[2] Tile_X0Y2_WW4END[14] Tile_X0Y2_W6END[6] _1110_/X
+ _1873_/Q _1872_/Q VPWR VGND sg13cmos5l_mux4_1
XFILLER_25_205 VPWR VGND sg13cmos5l_decap_8
XANTENNA__1988__D Tile_X0Y3_FrameData[15] VPWR VGND sg13cmos5l_antennanp
XANTENNA__0881__A1 AXIL_S_SOC_AWADDR3 VPWR VGND sg13cmos5l_antennanp
X_1067_ _1068_/A _0889_/X _0528_/X Tile_X0Y3_N4END[4] Tile_X0Y0_S4END[8] _1730_/Q
+ _1731_/Q VPWR VGND sg13cmos5l_mux4_1
XFILLER_18_290 VPWR VGND sg13cmos5l_decap_4
XFILLER_178_265 VPWR VGND sg13cmos5l_decap_8
XANTENNA__1641__GATE Tile_X0Y3_FrameStrobe[6] VPWR VGND sg13cmos5l_antennanp
X_1969_ _1969_/Q Tile_X0Y3_FrameData[2] Tile_X0Y3_FrameStrobe[0] VPWR VGND sg13cmos5l_dlhq_1
XFILLER_4_109 VPWR VGND sg13cmos5l_fill_2
XFILLER_193_279 VPWR VGND sg13cmos5l_fill_2
XANTENNA__1228__D Tile_X0Y0_FrameData[31] VPWR VGND sg13cmos5l_antennanp
XFILLER_104_8 VPWR VGND sg13cmos5l_fill_2
XFILLER_108_12 VPWR VGND sg13cmos5l_fill_1
XFILLER_108_34 VPWR VGND sg13cmos5l_fill_2
XFILLER_146_184 VPWR VGND sg13cmos5l_decap_8
XANTENNA__1656__GATE Tile_X0Y3_FrameStrobe[6] VPWR VGND sg13cmos5l_antennanp
XFILLER_108_56 VPWR VGND sg13cmos5l_fill_2
XFILLER_161_165 VPWR VGND sg13cmos5l_fill_2
XFILLER_102_210 VPWR VGND sg13cmos5l_decap_8
XFILLER_191_39 VPWR VGND sg13cmos5l_decap_8
XFILLER_102_265 VPWR VGND sg13cmos5l_fill_2
XANTENNA__2059__D Tile_X0Y3_FrameData[8] VPWR VGND sg13cmos5l_antennanp
XANTENNA__2196__X Tile_X0Y1_E1BEG[1] VPWR VGND sg13cmos5l_antennanp
XFILLER_68_190 VPWR VGND sg13cmos5l_decap_8
XANTENNA__1113__A2 AXIL_S_SOC_WDATA12 VPWR VGND sg13cmos5l_antennanp
XANTENNA__1898__D Tile_X0Y2_FrameData[17] VPWR VGND sg13cmos5l_antennanp
XFILLER_17_42 VPWR VGND sg13cmos5l_decap_4
XANTENNA__0624__A1 Tile_X0Y3_W6END[7] VPWR VGND sg13cmos5l_antennanp
XANTENNA__1609__GATE Tile_X0Y3_FrameStrobe[5] VPWR VGND sg13cmos5l_antennanp
XFILLER_123_0 VPWR VGND sg13cmos5l_fill_2
XFILLER_149_85 VPWR VGND sg13cmos5l_decap_8
XFILLER_33_96 VPWR VGND sg13cmos5l_fill_2
XFILLER_152_121 VPWR VGND sg13cmos5l_fill_2
XFILLER_3_186 VPWR VGND sg13cmos5l_decap_4
XANTENNA__0560__A0 Tile_X0Y2_W1END[1] VPWR VGND sg13cmos5l_antennanp
XANTENNA__2547__A Tile_X0Y3_FrameData[5] VPWR VGND sg13cmos5l_antennanp
XANTENNA__1601__D Tile_X0Y1_FrameData[2] VPWR VGND sg13cmos5l_antennanp
XFILLER_222_136 VPWR VGND sg13cmos5l_fill_2
XFILLER_15_282 VPWR VGND sg13cmos5l_fill_2
XFILLER_15_293 VPWR VGND sg13cmos5l_fill_2
XFILLER_30_263 VPWR VGND sg13cmos5l_decap_8
X_1823_ _1823_/Q Tile_X0Y2_FrameData[28] Tile_X0Y3_FrameStrobe[4] VPWR VGND sg13cmos5l_dlhq_1
XFILLER_128_151 VPWR VGND sg13cmos5l_decap_4
XFILLER_128_173 VPWR VGND sg13cmos5l_decap_4
X_1754_ _1754_/Q Tile_X0Y2_FrameData[1] Tile_X0Y3_FrameStrobe[1] VPWR VGND sg13cmos5l_dlhq_1
XANTENNA__1040__A1 AXIL_S_SOC_WDATA24 VPWR VGND sg13cmos5l_antennanp
XFILLER_128_195 VPWR VGND sg13cmos5l_decap_8
XFILLER_143_110 VPWR VGND sg13cmos5l_decap_8
X_0705_ AXIL_S_SOC_RDATA4 Tile_X0Y3_W1END[0] Tile_X0Y3_W6END[8] Tile_X0Y3_WW4END[15]
+ _0540_/Y _2002_/Q _2003_/Q VPWR VGND sg13cmos5l_mux4_1
XFILLER_209_55 VPWR VGND sg13cmos5l_fill_2
XFILLER_190_249 VPWR VGND sg13cmos5l_decap_4
X_1685_ _1685_/Q Tile_X0Y1_FrameData[14] Tile_X0Y3_FrameStrobe[7] VPWR VGND sg13cmos5l_dlhq_1
X_0636_ _0636_/X Tile_X0Y3_W2MID[3] Tile_X0Y3_W2END[3] Tile_X0Y3_W6END[3] _0511_/X
+ _2013_/Q _2012_/Q VPWR VGND sg13cmos5l_mux4_1
X_0567_ _0567_/Y _1943_/Q Tile_X0Y3_N1END[2] VPWR VGND sg13cmos5l_nor2b_1
X_2306_ Tile_X0Y2_E6BEG[10] _2306_/A VPWR VGND sg13cmos5l_buf_1
XFILLER_225_76 VPWR VGND sg13cmos5l_decap_8
X_2237_ Tile_X0Y1_EE4BEG[10] _2237_/A VPWR VGND sg13cmos5l_buf_1
X_0498_ _0498_/X _0492_/X _0494_/Y _0497_/Y VPWR VGND sg13cmos5l_a21o_1
X_2168_ _2168_/Q Tile_X0Y3_FrameData[27] Tile_X0Y3_FrameStrobe[7] VPWR VGND sg13cmos5l_dlhq_1
XANTENNA__0854__A1 AXIL_S_SOC_AWADDR7 VPWR VGND sg13cmos5l_antennanp
XANTENNA__1511__D Tile_X0Y1_FrameData[28] VPWR VGND sg13cmos5l_antennanp
X_1119_ _2299_/A Tile_X0Y3_N4END[7] _1068_/A Tile_X0Y0_S4END[11] _0529_/X _1788_/Q
+ _1789_/Q VPWR VGND sg13cmos5l_mux4_1
X_2099_ _2099_/Q Tile_X0Y3_FrameData[0] Tile_X0Y3_FrameStrobe[4] VPWR VGND sg13cmos5l_dlhq_1
XFILLER_80_152 VPWR VGND sg13cmos5l_decap_8
XFILLER_110_35 VPWR VGND sg13cmos5l_fill_2
XFILLER_110_46 VPWR VGND sg13cmos5l_decap_4
XANTENNA__1580__GATE Tile_X0Y3_FrameStrobe[4] VPWR VGND sg13cmos5l_antennanp
XFILLER_166_213 VPWR VGND sg13cmos5l_decap_8
XFILLER_119_11 VPWR VGND sg13cmos5l_fill_1
XFILLER_119_140 VPWR VGND sg13cmos5l_decap_8
XFILLER_166_279 VPWR VGND sg13cmos5l_fill_1
XFILLER_181_216 VPWR VGND sg13cmos5l_decap_4
XANTENNA__1031__A1 AXIL_S_SOC_WDATA27 VPWR VGND sg13cmos5l_antennanp
XANTENNA__1595__GATE Tile_X0Y3_FrameStrobe[4] VPWR VGND sg13cmos5l_antennanp
XANTENNA__0790__A0 Tile_X0Y0_W6END[4] VPWR VGND sg13cmos5l_antennanp
XFILLER_134_187 VPWR VGND sg13cmos5l_decap_4
XFILLER_0_167 VPWR VGND sg13cmos5l_fill_1
XFILLER_88_263 VPWR VGND sg13cmos5l_decap_4
XFILLER_0_189 VPWR VGND sg13cmos5l_decap_8
XFILLER_95_58 VPWR VGND sg13cmos5l_decap_8
XANTENNA__1098__A1 AXIL_S_SOC_WDATA8 VPWR VGND sg13cmos5l_antennanp
XANTENNA__1533__GATE Tile_X0Y3_FrameStrobe[2] VPWR VGND sg13cmos5l_antennanp
XANTENNA__0845__A1 AXIL_S_SOC_AWADDR8 VPWR VGND sg13cmos5l_antennanp
XANTENNA__1421__D Tile_X0Y0_FrameData[30] VPWR VGND sg13cmos5l_antennanp
XFILLER_204_169 VPWR VGND sg13cmos5l_decap_8
XANTENNA__1548__GATE Tile_X0Y3_FrameStrobe[3] VPWR VGND sg13cmos5l_antennanp
XFILLER_12_252 VPWR VGND sg13cmos5l_fill_2
XFILLER_157_202 VPWR VGND sg13cmos5l_fill_2
XFILLER_8_212 VPWR VGND sg13cmos5l_fill_2
XFILLER_12_285 VPWR VGND sg13cmos5l_fill_2
XANTENNA__0902__X AXIL_S_SOC_RVALID VPWR VGND sg13cmos5l_antennanp
XANTENNA__1022__A1 AXIL_S_SOC_WDATA26 VPWR VGND sg13cmos5l_antennanp
XFILLER_125_110 VPWR VGND sg13cmos5l_decap_8
XFILLER_165_290 VPWR VGND sg13cmos5l_decap_4
XFILLER_125_154 VPWR VGND sg13cmos5l_decap_4
XANTENNA__0781__A0 Tile_X0Y0_W6END[9] VPWR VGND sg13cmos5l_antennanp
X_1470_ _1470_/Q Tile_X0Y1_FrameData[5] Tile_X0Y3_FrameStrobe[0] VPWR VGND sg13cmos5l_dlhq_1
XFILLER_69_92 VPWR VGND sg13cmos5l_decap_8
XFILLER_140_168 VPWR VGND sg13cmos5l_fill_2
XFILLER_94_200 VPWR VGND sg13cmos5l_decap_8
XANTENNA__1089__A1 AXIL_S_SOC_WDATA15 VPWR VGND sg13cmos5l_antennanp
X_2022_ _2022_/Q Tile_X0Y3_FrameData[13] Tile_X0Y3_FrameStrobe[2] VPWR VGND sg13cmos5l_dlhq_1
XANTENNA__1331__D Tile_X0Y0_FrameData[24] VPWR VGND sg13cmos5l_antennanp
XANTENNA__2564__X Tile_X0Y3_FrameData_O[22] VPWR VGND sg13cmos5l_antennanp
XFILLER_211_34 VPWR VGND sg13cmos5l_fill_2
XFILLER_211_67 VPWR VGND sg13cmos5l_fill_1
XFILLER_211_56 VPWR VGND sg13cmos5l_fill_2
XFILLER_148_202 VPWR VGND sg13cmos5l_decap_8
XFILLER_86_0 VPWR VGND sg13cmos5l_fill_2
XFILLER_203_180 VPWR VGND sg13cmos5l_decap_8
XFILLER_148_257 VPWR VGND sg13cmos5l_decap_8
XANTENNA__2162__D Tile_X0Y3_FrameData[1] VPWR VGND sg13cmos5l_antennanp
XFILLER_148_279 VPWR VGND sg13cmos5l_fill_1
XFILLER_163_205 VPWR VGND sg13cmos5l_decap_4
X_1806_ _1806_/Q Tile_X0Y2_FrameData[13] Tile_X0Y3_FrameStrobe[3] VPWR VGND sg13cmos5l_dlhq_1
XANTENNA__1013__A1 Tile_X0Y1_W2END[5] VPWR VGND sg13cmos5l_antennanp
X_1737_ _1737_/Q Tile_X0Y2_FrameData[18] Tile_X0Y3_FrameStrobe[1] VPWR VGND sg13cmos5l_dlhq_1
XFILLER_116_198 VPWR VGND sg13cmos5l_decap_8
X_1668_ _1668_/Q Tile_X0Y1_FrameData[31] Tile_X0Y3_FrameStrobe[7] VPWR VGND sg13cmos5l_dlhq_1
XANTENNA__1506__D Tile_X0Y1_FrameData[1] VPWR VGND sg13cmos5l_antennanp
X_0619_ _2607_/A _0613_/Y _0615_/Y _0618_/Y VPWR VGND sg13cmos5l_a21oi_1
X_1599_ _1599_/Q Tile_X0Y1_FrameData[4] Tile_X0Y3_FrameStrobe[4] VPWR VGND sg13cmos5l_dlhq_1
XFILLER_105_68 VPWR VGND sg13cmos5l_fill_2
XFILLER_38_171 VPWR VGND sg13cmos5l_decap_8
XANTENNA__0827__A1 AXIL_S_SOC_AWADDR4 VPWR VGND sg13cmos5l_antennanp
XANTENNA__1241__D Tile_X0Y0_FrameData[18] VPWR VGND sg13cmos5l_antennanp
XANTENNA__2474__X Tile_X0Y0_E2BEGb[0] VPWR VGND sg13cmos5l_antennanp
XFILLER_53_141 VPWR VGND sg13cmos5l_decap_8
XFILLER_198_124 VPWR VGND sg13cmos5l_fill_1
XANTENNA__2072__D Tile_X0Y3_FrameData[27] VPWR VGND sg13cmos5l_antennanp
XFILLER_5_237 VPWR VGND sg13cmos5l_decap_4
XFILLER_30_31 VPWR VGND sg13cmos5l_decap_4
XFILLER_146_31 VPWR VGND sg13cmos5l_fill_2
XANTENNA__1416__D Tile_X0Y0_FrameData[3] VPWR VGND sg13cmos5l_antennanp
XFILLER_122_146 VPWR VGND sg13cmos5l_fill_2
XFILLER_162_293 VPWR VGND sg13cmos5l_fill_2
XFILLER_39_73 VPWR VGND sg13cmos5l_fill_1
XFILLER_190_0 VPWR VGND sg13cmos5l_decap_8
XANTENNA__1472__GATE Tile_X0Y3_FrameStrobe[0] VPWR VGND sg13cmos5l_antennanp
XFILLER_162_74 VPWR VGND sg13cmos5l_fill_1
XFILLER_162_96 VPWR VGND sg13cmos5l_fill_1
XANTENNA__0818__A1 AXIL_S_SOC_WSTRB2 VPWR VGND sg13cmos5l_antennanp
XANTENNA__2384__X Tile_X0Y0_N2BEG[2] VPWR VGND sg13cmos5l_antennanp
XFILLER_91_269 VPWR VGND sg13cmos5l_decap_8
XFILLER_217_261 VPWR VGND sg13cmos5l_fill_2
XANTENNA__1487__GATE Tile_X0Y3_FrameStrobe[1] VPWR VGND sg13cmos5l_antennanp
X_0970_ _0970_/Y _1622_/Q _0947_/Y _1621_/Q VPWR VGND sg13cmos5l_a21oi_1
XFILLER_197_190 VPWR VGND sg13cmos5l_fill_2
XANTENNA__1410__GATE Tile_X0Y3_FrameStrobe[6] VPWR VGND sg13cmos5l_antennanp
XANTENNA__2560__A Tile_X0Y3_FrameData[18] VPWR VGND sg13cmos5l_antennanp
XFILLER_200_161 VPWR VGND sg13cmos5l_decap_8
XFILLER_145_227 VPWR VGND sg13cmos5l_decap_8
X_2571_ Tile_X0Y3_FrameData_O[29] Tile_X0Y3_FrameData[29] VPWR VGND sg13cmos5l_buf_1
XANTENNA__0754__A0 Tile_X0Y2_W2MID[0] VPWR VGND sg13cmos5l_antennanp
X_1522_ _1522_/Q Tile_X0Y1_FrameData[17] Tile_X0Y3_FrameStrobe[2] VPWR VGND sg13cmos5l_dlhq_1
XANTENNA__1326__D Tile_X0Y0_FrameData[29] VPWR VGND sg13cmos5l_antennanp
XANTENNA__1425__GATE Tile_X0Y3_FrameStrobe[7] VPWR VGND sg13cmos5l_antennanp
XANTENNA__2559__X Tile_X0Y3_FrameData_O[17] VPWR VGND sg13cmos5l_antennanp
X_1453_ _1453_/Q Tile_X0Y1_FrameData[22] Tile_X0Y3_FrameStrobe[0] VPWR VGND sg13cmos5l_dlhq_1
XFILLER_206_56 VPWR VGND sg13cmos5l_decap_4
XANTENNA__0506__A0 Tile_X0Y3_N1END[3] VPWR VGND sg13cmos5l_antennanp
X_1384_ _1384_/Q Tile_X0Y0_FrameData[3] Tile_X0Y3_FrameStrobe[5] VPWR VGND sg13cmos5l_dlhq_1
XFILLER_222_11 VPWR VGND sg13cmos5l_decap_8
XFILLER_222_33 VPWR VGND sg13cmos5l_decap_4
XFILLER_208_250 VPWR VGND sg13cmos5l_decap_8
XANTENNA__2157__D Tile_X0Y3_FrameData[6] VPWR VGND sg13cmos5l_antennanp
XANTENNA__2294__X Tile_X0Y2_E2BEGb[6] VPWR VGND sg13cmos5l_antennanp
X_2005_ _2005_/Q Tile_X0Y3_FrameData[30] Tile_X0Y3_FrameStrobe[2] VPWR VGND sg13cmos5l_dlhq_1
XFILLER_208_283 VPWR VGND sg13cmos5l_fill_1
XFILLER_35_163 VPWR VGND sg13cmos5l_decap_8
XFILLER_35_141 VPWR VGND sg13cmos5l_fill_1
XANTENNA__1996__D Tile_X0Y3_FrameData[7] VPWR VGND sg13cmos5l_antennanp
XFILLER_223_264 VPWR VGND sg13cmos5l_fill_2
XFILLER_188_190 VPWR VGND sg13cmos5l_fill_2
XFILLER_136_205 VPWR VGND sg13cmos5l_decap_8
XANTENNA__0745__A0 Tile_X0Y3_W2MID[4] VPWR VGND sg13cmos5l_antennanp
XFILLER_104_102 VPWR VGND sg13cmos5l_fill_1
XFILLER_183_29 VPWR VGND sg13cmos5l_decap_4
XANTENNA__1236__D Tile_X0Y0_FrameData[23] VPWR VGND sg13cmos5l_antennanp
XANTENNA__2469__X Tile_X0Y0_E6BEG[7] VPWR VGND sg13cmos5l_antennanp
XFILLER_116_12 VPWR VGND sg13cmos5l_fill_1
XFILLER_116_23 VPWR VGND sg13cmos5l_decap_4
XANTENNA__0760__A3 Tile_X0Y0_S4END[0] VPWR VGND sg13cmos5l_antennanp
XFILLER_76_38 VPWR VGND sg13cmos5l_decap_8
XFILLER_58_222 VPWR VGND sg13cmos5l_fill_1
XFILLER_58_244 VPWR VGND sg13cmos5l_decap_8
XFILLER_18_119 VPWR VGND sg13cmos5l_decap_8
XANTENNA__2067__D Tile_X0Y3_FrameData[0] VPWR VGND sg13cmos5l_antennanp
XFILLER_92_26 VPWR VGND sg13cmos5l_fill_1
XFILLER_73_236 VPWR VGND sg13cmos5l_fill_2
XFILLER_26_141 VPWR VGND sg13cmos5l_decap_8
XFILLER_214_242 VPWR VGND sg13cmos5l_fill_2
XFILLER_214_231 VPWR VGND sg13cmos5l_decap_8
XFILLER_81_280 VPWR VGND sg13cmos5l_fill_1
XFILLER_25_53 VPWR VGND sg13cmos5l_decap_4
XFILLER_25_42 VPWR VGND sg13cmos5l_decap_4
XFILLER_214_275 VPWR VGND sg13cmos5l_decap_4
XFILLER_214_253 VPWR VGND sg13cmos5l_decap_8
XFILLER_214_286 VPWR VGND sg13cmos5l_fill_1
XFILLER_41_177 VPWR VGND sg13cmos5l_decap_8
XFILLER_127_205 VPWR VGND sg13cmos5l_fill_1
XANTENNA__2140__GATE Tile_X0Y3_FrameStrobe[6] VPWR VGND sg13cmos5l_antennanp
XFILLER_41_63 VPWR VGND sg13cmos5l_fill_2
XFILLER_41_96 VPWR VGND sg13cmos5l_decap_8
XFILLER_41_85 VPWR VGND sg13cmos5l_fill_1
XFILLER_203_0 VPWR VGND sg13cmos5l_fill_2
XANTENNA__2155__GATE Tile_X0Y3_FrameStrobe[6] VPWR VGND sg13cmos5l_antennanp
XANTENNA__2379__X Tile_X0Y0_N2BEGb[5] VPWR VGND sg13cmos5l_antennanp
XFILLER_135_293 VPWR VGND sg13cmos5l_fill_2
XANTENNA__0751__A3 Tile_X0Y0_S2END[6] VPWR VGND sg13cmos5l_antennanp
XFILLER_150_241 VPWR VGND sg13cmos5l_fill_1
XFILLER_1_251 VPWR VGND sg13cmos5l_decap_4
XFILLER_64_203 VPWR VGND sg13cmos5l_decap_8
XANTENNA__2555__A Tile_X0Y3_FrameData[13] VPWR VGND sg13cmos5l_antennanp
XFILLER_205_275 VPWR VGND sg13cmos5l_decap_4
XFILLER_205_253 VPWR VGND sg13cmos5l_fill_2
XFILLER_220_234 VPWR VGND sg13cmos5l_fill_2
XFILLER_220_223 VPWR VGND sg13cmos5l_decap_8
XFILLER_198_70 VPWR VGND sg13cmos5l_decap_8
X_0953_ _2205_/A AXIL_S_SOC_WDATA22 AXIL_S_SOC_WDATA30 _0864_/X _0866_/X _1599_/Q
+ _1598_/Q VPWR VGND sg13cmos5l_mux4_1
XANTENNA__2108__GATE Tile_X0Y3_FrameStrobe[5] VPWR VGND sg13cmos5l_antennanp
X_0884_ _2460_/A AXIL_S_SOC_WSTRB1 AXIL_S_SOC_AWADDR8 _0775_/X _0646_/X _1303_/Q _1302_/Q
+ VPWR VGND sg13cmos5l_mux4_1
XFILLER_118_249 VPWR VGND sg13cmos5l_decap_8
XANTENNA__0727__A0 Tile_X0Y0_W1END[2] VPWR VGND sg13cmos5l_antennanp
XANTENNA__1364__GATE Tile_X0Y3_FrameStrobe[5] VPWR VGND sg13cmos5l_antennanp
XFILLER_126_271 VPWR VGND sg13cmos5l_decap_8
X_2554_ Tile_X0Y3_FrameData_O[12] Tile_X0Y3_FrameData[12] VPWR VGND sg13cmos5l_buf_1
XANTENNA__1994__GATE Tile_X0Y3_FrameStrobe[1] VPWR VGND sg13cmos5l_antennanp
XANTENNA__2289__X Tile_X0Y2_E2BEGb[1] VPWR VGND sg13cmos5l_antennanp
XFILLER_126_282 VPWR VGND sg13cmos5l_fill_2
XFILLER_141_230 VPWR VGND sg13cmos5l_decap_8
X_1505_ _1505_/Q Tile_X0Y1_FrameData[2] Tile_X0Y3_FrameStrobe[1] VPWR VGND sg13cmos5l_dlhq_1
X_2485_ Tile_X0Y0_E2BEG[3] _2485_/A VPWR VGND sg13cmos5l_buf_1
XANTENNA__1379__GATE Tile_X0Y3_FrameStrobe[5] VPWR VGND sg13cmos5l_antennanp
XFILLER_101_127 VPWR VGND sg13cmos5l_fill_2
X_1436_ _1436_/Q Tile_X0Y0_FrameData[15] Tile_X0Y3_FrameStrobe[7] VPWR VGND sg13cmos5l_dlhq_1
XFILLER_99_199 VPWR VGND sg13cmos5l_fill_2
X_1367_ _1367_/Q Tile_X0Y0_FrameData[20] Tile_X0Y3_FrameStrobe[5] VPWR VGND sg13cmos5l_dlhq_1
XANTENNA__1302__GATE Tile_X0Y3_FrameStrobe[3] VPWR VGND sg13cmos5l_antennanp
X_1298_ _1298_/Q Tile_X0Y0_FrameData[25] Tile_X0Y3_FrameStrobe[3] VPWR VGND sg13cmos5l_dlhq_1
XFILLER_55_236 VPWR VGND sg13cmos5l_decap_4
XANTENNA__1932__GATE Tile_X0Y3_FrameStrobe[7] VPWR VGND sg13cmos5l_antennanp
XFILLER_102_36 VPWR VGND sg13cmos5l_decap_8
XFILLER_102_58 VPWR VGND sg13cmos5l_fill_2
XFILLER_63_280 VPWR VGND sg13cmos5l_fill_2
XANTENNA__1317__GATE Tile_X0Y3_FrameStrobe[3] VPWR VGND sg13cmos5l_antennanp
XFILLER_141_9 VPWR VGND sg13cmos5l_fill_1
XANTENNA__1947__GATE Tile_X0Y3_FrameStrobe[0] VPWR VGND sg13cmos5l_antennanp
XFILLER_11_22 VPWR VGND sg13cmos5l_decap_8
XANTENNA__0718__A0 Tile_X0Y3_W2MID[7] VPWR VGND sg13cmos5l_antennanp
XFILLER_117_260 VPWR VGND sg13cmos5l_decap_8
XFILLER_11_44 VPWR VGND sg13cmos5l_fill_2
XFILLER_117_293 VPWR VGND sg13cmos5l_fill_2
XFILLER_132_230 VPWR VGND sg13cmos5l_fill_1
XANTENNA__2199__X Tile_X0Y1_E2BEG[0] VPWR VGND sg13cmos5l_antennanp
XFILLER_132_252 VPWR VGND sg13cmos5l_decap_4
XFILLER_36_63 VPWR VGND sg13cmos5l_fill_2
XFILLER_153_0 VPWR VGND sg13cmos5l_fill_2
XFILLER_202_201 VPWR VGND sg13cmos5l_decap_4
XFILLER_14_199 VPWR VGND sg13cmos5l_decap_8
XANTENNA__0957__A0 AXIL_S_SOC_WDATA18 VPWR VGND sg13cmos5l_antennanp
XFILLER_168_62 VPWR VGND sg13cmos5l_fill_1
XFILLER_108_260 VPWR VGND sg13cmos5l_decap_8
XANTENNA__0709__A0 Tile_X0Y1_W1END[0] VPWR VGND sg13cmos5l_antennanp
XANTENNA__2094__GATE Tile_X0Y3_FrameStrobe[4] VPWR VGND sg13cmos5l_antennanp
XFILLER_108_293 VPWR VGND sg13cmos5l_fill_2
XFILLER_184_72 VPWR VGND sg13cmos5l_decap_8
XFILLER_182_196 VPWR VGND sg13cmos5l_decap_8
X_2270_ Tile_X0Y1_FrameData_O[27] Tile_X0Y1_FrameData[27] VPWR VGND sg13cmos5l_buf_1
XANTENNA__1604__D Tile_X0Y1_FrameData[31] VPWR VGND sg13cmos5l_antennanp
X_1221_ _1221_/Q Tile_X0Y0_FrameData[6] Tile_X0Y3_FrameStrobe[0] VPWR VGND sg13cmos5l_dlhq_1
XFILLER_96_169 VPWR VGND sg13cmos5l_fill_2
XANTENNA__0488__A2 Tile_X0Y3_N4END[15] VPWR VGND sg13cmos5l_antennanp
X_1152_ _1153_/B _0758_/X _1870_/Q VPWR VGND sg13cmos5l_nand2b_1
XFILLER_37_236 VPWR VGND sg13cmos5l_fill_2
XANTENNA__2032__GATE Tile_X0Y3_FrameStrobe[2] VPWR VGND sg13cmos5l_antennanp
X_1083_ _2281_/A AXIL_S_SOC_WDATA1 AXIL_S_SOC_WDATA9 _0715_/X _0729_/X _1857_/Q _1856_/Q
+ VPWR VGND sg13cmos5l_mux4_1
XFILLER_37_269 VPWR VGND sg13cmos5l_decap_4
XFILLER_203_57 VPWR VGND sg13cmos5l_decap_4
XANTENNA__2572__X Tile_X0Y3_FrameData_O[30] VPWR VGND sg13cmos5l_antennanp
XANTENNA__2047__GATE Tile_X0Y3_FrameStrobe[3] VPWR VGND sg13cmos5l_antennanp
X_1985_ _1985_/Q Tile_X0Y3_FrameData[18] Tile_X0Y3_FrameStrobe[1] VPWR VGND sg13cmos5l_dlhq_1
X_0936_ _0936_/X Tile_X0Y3_W1END[2] Tile_X0Y3_W6END[6] _0480_/X _0570_/Y _2183_/Q
+ _2182_/Q VPWR VGND sg13cmos5l_mux4_1
XANTENNA__0963__A3 AXIL_S_SOC_WDATA22 VPWR VGND sg13cmos5l_antennanp
XANTENNA__2170__D Tile_X0Y3_FrameData[25] VPWR VGND sg13cmos5l_antennanp
X_2606_ Tile_X0Y3_S4BEG[12] _2606_/A VPWR VGND sg13cmos5l_buf_1
X_0867_ _0867_/X _0651_/X _0723_/X _0724_/X Tile_X0Y0_S2MID[2] _1462_/Q _1463_/Q VPWR
+ VGND sg13cmos5l_mux4_1
X_0798_ _0800_/B _0443_/Y _0796_/X _0797_/Y VPWR VGND sg13cmos5l_o21ai_1
XFILLER_173_185 VPWR VGND sg13cmos5l_decap_8
XFILLER_114_252 VPWR VGND sg13cmos5l_decap_8
X_2537_ Tile_X0Y3_EE4BEG[11] _2537_/A VPWR VGND sg13cmos5l_buf_1
X_2468_ Tile_X0Y0_E6BEG[6] _2468_/A VPWR VGND sg13cmos5l_buf_1
X_1419_ _1419_/Q Tile_X0Y0_FrameData[0] Tile_X0Y3_FrameStrobe[6] VPWR VGND sg13cmos5l_dlhq_1
XANTENNA__1125__A0 AXIL_S_SOC_WDATA0 VPWR VGND sg13cmos5l_antennanp
XANTENNA__1241__GATE Tile_X0Y3_FrameStrobe[1] VPWR VGND sg13cmos5l_antennanp
XANTENNA__1514__D Tile_X0Y1_FrameData[25] VPWR VGND sg13cmos5l_antennanp
X_2399_ Tile_X0Y0_FrameStrobe_O[5] Tile_X0Y3_FrameStrobe[5] VPWR VGND sg13cmos5l_buf_1
XANTENNA__1871__GATE Tile_X0Y3_FrameStrobe[5] VPWR VGND sg13cmos5l_antennanp
XFILLER_28_247 VPWR VGND sg13cmos5l_decap_8
XFILLER_73_28 VPWR VGND sg13cmos5l_fill_1
XFILLER_73_17 VPWR VGND sg13cmos5l_decap_8
XFILLER_28_258 VPWR VGND sg13cmos5l_fill_1
XFILLER_73_39 VPWR VGND sg13cmos5l_decap_8
XFILLER_189_17 VPWR VGND sg13cmos5l_fill_2
XANTENNA__1256__GATE Tile_X0Y3_FrameStrobe[1] VPWR VGND sg13cmos5l_antennanp
XANTENNA__2482__X Tile_X0Y0_E2BEG[0] VPWR VGND sg13cmos5l_antennanp
XFILLER_189_39 VPWR VGND sg13cmos5l_fill_1
XANTENNA__1886__GATE Tile_X0Y3_FrameStrobe[6] VPWR VGND sg13cmos5l_antennanp
XANTENNA__0651__A2 Tile_X0Y2_W6END[5] VPWR VGND sg13cmos5l_antennanp
XANTENNA__2080__D Tile_X0Y3_FrameData[19] VPWR VGND sg13cmos5l_antennanp
XFILLER_138_87 VPWR VGND sg13cmos5l_decap_4
XFILLER_98_58 VPWR VGND sg13cmos5l_fill_2
XANTENNA__1824__GATE Tile_X0Y3_FrameStrobe[4] VPWR VGND sg13cmos5l_antennanp
XFILLER_120_222 VPWR VGND sg13cmos5l_fill_2
XFILLER_154_64 VPWR VGND sg13cmos5l_fill_2
XFILLER_78_103 VPWR VGND sg13cmos5l_decap_8
XANTENNA__1116__A0 Tile_X0Y3_N4END[6] VPWR VGND sg13cmos5l_antennanp
XANTENNA__1209__GATE Tile_X0Y3_FrameStrobe[0] VPWR VGND sg13cmos5l_antennanp
XANTENNA__1424__D Tile_X0Y0_FrameData[27] VPWR VGND sg13cmos5l_antennanp
XFILLER_93_106 VPWR VGND sg13cmos5l_decap_8
XANTENNA__1839__GATE Tile_X0Y3_FrameStrobe[4] VPWR VGND sg13cmos5l_antennanp
XFILLER_219_153 VPWR VGND sg13cmos5l_fill_1
XFILLER_170_52 VPWR VGND sg13cmos5l_fill_1
XFILLER_170_63 VPWR VGND sg13cmos5l_decap_8
XFILLER_219_197 VPWR VGND sg13cmos5l_decap_8
XANTENNA__0890__A2 Tile_X0Y0_W6END[11] VPWR VGND sg13cmos5l_antennanp
XANTENNA__2392__X Tile_X0Y0_N1BEG[2] VPWR VGND sg13cmos5l_antennanp
XFILLER_187_233 VPWR VGND sg13cmos5l_decap_4
XANTENNA__0642__A2 Tile_X0Y1_W6END[7] VPWR VGND sg13cmos5l_antennanp
XFILLER_147_108 VPWR VGND sg13cmos5l_decap_8
XFILLER_179_94 VPWR VGND sg13cmos5l_decap_8
X_1770_ _1770_/Q Tile_X0Y2_FrameData[17] Tile_X0Y3_FrameStrobe[2] VPWR VGND sg13cmos5l_dlhq_1
X_0721_ _2393_/A Tile_X0Y0_W1END[3] _0488_/X Tile_X0Y0_W6END[7] _0491_/Y _1436_/Q
+ _1437_/Q VPWR VGND sg13cmos5l_mux4_1
XANTENNA__0945__A3 Tile_X0Y0_S4END[7] VPWR VGND sg13cmos5l_antennanp
XFILLER_155_196 VPWR VGND sg13cmos5l_decap_8
X_0652_ _2376_/A Tile_X0Y1_W2MID[5] Tile_X0Y1_W2END[5] Tile_X0Y1_W6END[5] _0867_/X
+ _1679_/Q _1678_/Q VPWR VGND sg13cmos5l_mux4_1
XFILLER_6_184 VPWR VGND sg13cmos5l_decap_8
X_0583_ _2587_/A Tile_X0Y2_W2MID[6] Tile_X0Y2_W2END[6] Tile_X0Y2_W6END[9] _0715_/X
+ _1893_/Q _1892_/Q VPWR VGND sg13cmos5l_mux4_1
XFILLER_170_188 VPWR VGND sg13cmos5l_decap_8
X_2322_ Tile_X0Y2_EE4BEG[14] _2322_/A VPWR VGND sg13cmos5l_buf_1
XFILLER_214_12 VPWR VGND sg13cmos5l_fill_2
XANTENNA__1107__A0 AXIL_S_SOC_WDATA6 VPWR VGND sg13cmos5l_antennanp
XANTENNA__1334__D Tile_X0Y0_FrameData[21] VPWR VGND sg13cmos5l_antennanp
XANTENNA__2567__X Tile_X0Y3_FrameData_O[25] VPWR VGND sg13cmos5l_antennanp
X_2253_ Tile_X0Y1_FrameData_O[10] Tile_X0Y1_FrameData[10] VPWR VGND sg13cmos5l_buf_1
X_1204_ _1204_/Q Tile_X0Y0_FrameData[23] Tile_X0Y3_FrameStrobe[0] VPWR VGND sg13cmos5l_dlhq_1
X_2184_ _2184_/Q Tile_X0Y3_FrameData[11] Tile_X0Y3_FrameStrobe[7] VPWR VGND sg13cmos5l_dlhq_1
XFILLER_214_67 VPWR VGND sg13cmos5l_fill_2
X_1135_ _2602_/A _1877_/Q _1128_/Y _1134_/Y VPWR VGND sg13cmos5l_a21oi_1
XFILLER_92_194 VPWR VGND sg13cmos5l_decap_8
XFILLER_225_156 VPWR VGND sg13cmos5l_fill_2
XFILLER_225_145 VPWR VGND sg13cmos5l_decap_8
XANTENNA__2165__D Tile_X0Y3_FrameData[30] VPWR VGND sg13cmos5l_antennanp
X_1066_ _1066_/Y _1913_/Q _1066_/B _1066_/C VPWR VGND sg13cmos5l_nor3_1
XFILLER_18_280 VPWR VGND sg13cmos5l_decap_8
XFILLER_178_211 VPWR VGND sg13cmos5l_decap_4
XFILLER_33_294 VPWR VGND sg13cmos5l_fill_1
XFILLER_33_283 VPWR VGND sg13cmos5l_fill_1
X_1968_ _1968_/Q Tile_X0Y3_FrameData[3] Tile_X0Y3_FrameStrobe[0] VPWR VGND sg13cmos5l_dlhq_1
XFILLER_193_258 VPWR VGND sg13cmos5l_decap_8
XANTENNA__1509__D Tile_X0Y1_FrameData[30] VPWR VGND sg13cmos5l_antennanp
XFILLER_146_163 VPWR VGND sg13cmos5l_decap_8
X_1899_ _1899_/Q Tile_X0Y2_FrameData[16] Tile_X0Y3_FrameStrobe[6] VPWR VGND sg13cmos5l_dlhq_1
X_0919_ _0919_/X _0522_/X _0859_/X _1667_/Q VPWR VGND sg13cmos5l_mux2_1
XFILLER_108_46 VPWR VGND sg13cmos5l_decap_8
XFILLER_124_12 VPWR VGND sg13cmos5l_decap_8
XANTENNA__1244__D Tile_X0Y0_FrameData[15] VPWR VGND sg13cmos5l_antennanp
XANTENNA__2477__X Tile_X0Y0_E2BEGb[3] VPWR VGND sg13cmos5l_antennanp
XFILLER_102_255 VPWR VGND sg13cmos5l_decap_8
XFILLER_75_117 VPWR VGND sg13cmos5l_decap_4
XFILLER_124_89 VPWR VGND sg13cmos5l_fill_1
XFILLER_84_16 VPWR VGND sg13cmos5l_fill_1
XANTENNA__0438__A Tile_X0Y0_W1END[1] VPWR VGND sg13cmos5l_antennanp
XFILLER_16_206 VPWR VGND sg13cmos5l_decap_8
XFILLER_90_109 VPWR VGND sg13cmos5l_fill_1
XFILLER_216_112 VPWR VGND sg13cmos5l_fill_1
XANTENNA__0872__A2 Tile_X0Y0_S4END[2] VPWR VGND sg13cmos5l_antennanp
XANTENNA__2075__D Tile_X0Y3_FrameData[24] VPWR VGND sg13cmos5l_antennanp
XANTENNA__0624__A2 Tile_X0Y3_WW4END[15] VPWR VGND sg13cmos5l_antennanp
XFILLER_169_255 VPWR VGND sg13cmos5l_fill_1
XFILLER_24_294 VPWR VGND sg13cmos5l_fill_1
XANTENNA__1419__D Tile_X0Y0_FrameData[0] VPWR VGND sg13cmos5l_antennanp
XFILLER_116_0 VPWR VGND sg13cmos5l_decap_4
XFILLER_3_110 VPWR VGND sg13cmos5l_fill_1
XANTENNA__1763__GATE Tile_X0Y3_FrameStrobe[2] VPWR VGND sg13cmos5l_antennanp
XFILLER_152_144 VPWR VGND sg13cmos5l_decap_8
XANTENNA__0560__A1 Tile_X0Y2_W6END[9] VPWR VGND sg13cmos5l_antennanp
XANTENNA__1778__GATE Tile_X0Y3_FrameStrobe[2] VPWR VGND sg13cmos5l_antennanp
XANTENNA__2387__X Tile_X0Y0_N2BEG[5] VPWR VGND sg13cmos5l_antennanp
XFILLER_12_8 VPWR VGND sg13cmos5l_decap_8
XFILLER_181_84 VPWR VGND sg13cmos5l_decap_8
XFILLER_207_134 VPWR VGND sg13cmos5l_decap_8
XFILLER_181_95 VPWR VGND sg13cmos5l_fill_1
XANTENNA__1701__GATE Tile_X0Y3_FrameStrobe[0] VPWR VGND sg13cmos5l_antennanp
XFILLER_207_145 VPWR VGND sg13cmos5l_fill_1
XANTENNA__0863__A2 Tile_X0Y0_W6END[4] VPWR VGND sg13cmos5l_antennanp
XFILLER_222_126 VPWR VGND sg13cmos5l_decap_4
XANTENNA__2563__A Tile_X0Y3_FrameData[21] VPWR VGND sg13cmos5l_antennanp
XFILLER_222_148 VPWR VGND sg13cmos5l_decap_8
XANTENNA__1716__GATE Tile_X0Y3_FrameStrobe[0] VPWR VGND sg13cmos5l_antennanp
X_1822_ _1822_/Q Tile_X0Y2_FrameData[29] Tile_X0Y3_FrameStrobe[4] VPWR VGND sg13cmos5l_dlhq_1
XFILLER_30_242 VPWR VGND sg13cmos5l_decap_8
XANTENNA__1329__D Tile_X0Y0_FrameData[26] VPWR VGND sg13cmos5l_antennanp
X_1753_ _1753_/Q Tile_X0Y2_FrameData[2] Tile_X0Y3_FrameStrobe[1] VPWR VGND sg13cmos5l_dlhq_1
XFILLER_190_228 VPWR VGND sg13cmos5l_decap_8
X_1684_ _1684_/Q Tile_X0Y1_FrameData[15] Tile_X0Y3_FrameStrobe[7] VPWR VGND sg13cmos5l_dlhq_1
X_0704_ AXIL_S_SOC_RDATA3 Tile_X0Y3_W2MID[7] Tile_X0Y3_W2END[7] Tile_X0Y3_W6END[7]
+ _0602_/X _2005_/Q _2004_/Q VPWR VGND sg13cmos5l_mux4_1
XFILLER_209_67 VPWR VGND sg13cmos5l_decap_8
XFILLER_183_280 VPWR VGND sg13cmos5l_fill_1
X_0635_ _0635_/Y _2194_/Q _0635_/B VPWR VGND sg13cmos5l_nand2_1
X_0566_ _2575_/A Tile_X0Y3_W1END[1] Tile_X0Y3_W6END[9] _0561_/X _0565_/Y _2149_/Q
+ _2148_/Q VPWR VGND sg13cmos5l_mux4_1
XFILLER_31_0 VPWR VGND sg13cmos5l_decap_4
XFILLER_225_55 VPWR VGND sg13cmos5l_decap_8
XANTENNA__2297__X Tile_X0Y2_E6BEG[1] VPWR VGND sg13cmos5l_antennanp
X_2305_ Tile_X0Y2_E6BEG[9] _2305_/A VPWR VGND sg13cmos5l_buf_1
X_0497_ _0497_/Y _1692_/Q _0497_/B _0497_/C VPWR VGND sg13cmos5l_nor3_1
XFILLER_97_286 VPWR VGND sg13cmos5l_fill_1
XFILLER_97_275 VPWR VGND sg13cmos5l_decap_8
XANTENNA__1999__D Tile_X0Y3_FrameData[4] VPWR VGND sg13cmos5l_antennanp
X_2236_ Tile_X0Y1_EE4BEG[9] _2236_/A VPWR VGND sg13cmos5l_buf_1
X_2167_ _2167_/Q Tile_X0Y3_FrameData[28] Tile_X0Y3_FrameStrobe[7] VPWR VGND sg13cmos5l_dlhq_1
XFILLER_65_161 VPWR VGND sg13cmos5l_fill_2
X_1118_ _2296_/A Tile_X0Y3_N4END[4] Tile_X0Y0_S4END[8] _1097_/A _0500_/X _1795_/Q
+ _1794_/Q VPWR VGND sg13cmos5l_mux4_1
X_2098_ _2098_/Q Tile_X0Y3_FrameData[1] Tile_X0Y3_FrameStrobe[4] VPWR VGND sg13cmos5l_dlhq_1
XFILLER_13_209 VPWR VGND sg13cmos5l_decap_8
X_1049_ _1049_/X _0888_/X _0553_/X Tile_X0Y3_N4END[5] Tile_X0Y0_S4END[9] _1736_/Q
+ _1737_/Q VPWR VGND sg13cmos5l_mux4_1
XFILLER_166_236 VPWR VGND sg13cmos5l_decap_8
XFILLER_186_29 VPWR VGND sg13cmos5l_fill_2
XANTENNA__1239__D Tile_X0Y0_FrameData[20] VPWR VGND sg13cmos5l_antennanp
XFILLER_214_8 VPWR VGND sg13cmos5l_fill_1
XFILLER_79_49 VPWR VGND sg13cmos5l_decap_8
XFILLER_0_113 VPWR VGND sg13cmos5l_fill_2
XANTENNA__0542__A1 Tile_X0Y0_S1END[1] VPWR VGND sg13cmos5l_antennanp
XFILLER_0_146 VPWR VGND sg13cmos5l_decap_8
XFILLER_135_88 VPWR VGND sg13cmos5l_decap_8
XFILLER_95_26 VPWR VGND sg13cmos5l_fill_2
XFILLER_95_15 VPWR VGND sg13cmos5l_decap_8
XFILLER_88_253 VPWR VGND sg13cmos5l_fill_1
XFILLER_28_20 VPWR VGND sg13cmos5l_decap_8
XANTENNA__1702__D Tile_X0Y2_FrameData[21] VPWR VGND sg13cmos5l_antennanp
XFILLER_56_183 VPWR VGND sg13cmos5l_decap_4
XFILLER_204_104 VPWR VGND sg13cmos5l_decap_8
XFILLER_12_275 VPWR VGND sg13cmos5l_decap_4
XFILLER_157_236 VPWR VGND sg13cmos5l_decap_8
XFILLER_60_51 VPWR VGND sg13cmos5l_fill_2
XFILLER_5_24 VPWR VGND sg13cmos5l_decap_8
XFILLER_125_177 VPWR VGND sg13cmos5l_decap_8
XFILLER_69_60 VPWR VGND sg13cmos5l_fill_1
XFILLER_180_294 VPWR VGND sg13cmos5l_fill_1
XANTENNA__2558__A Tile_X0Y3_FrameData[16] VPWR VGND sg13cmos5l_antennanp
XANTENNA__1640__GATE Tile_X0Y3_FrameStrobe[6] VPWR VGND sg13cmos5l_antennanp
X_2021_ _2021_/Q Tile_X0Y3_FrameData[14] Tile_X0Y3_FrameStrobe[2] VPWR VGND sg13cmos5l_dlhq_1
XFILLER_94_267 VPWR VGND sg13cmos5l_fill_1
XANTENNA__1612__D Tile_X0Y1_FrameData[23] VPWR VGND sg13cmos5l_antennanp
XFILLER_47_183 VPWR VGND sg13cmos5l_fill_1
XFILLER_211_46 VPWR VGND sg13cmos5l_fill_2
XANTENNA__1655__GATE Tile_X0Y3_FrameStrobe[6] VPWR VGND sg13cmos5l_antennanp
XANTENNA__2580__X Tile_X0Y3_S2BEG[2] VPWR VGND sg13cmos5l_antennanp
XFILLER_148_225 VPWR VGND sg13cmos5l_fill_1
X_1805_ _1805_/Q Tile_X0Y2_FrameData[14] Tile_X0Y3_FrameStrobe[3] VPWR VGND sg13cmos5l_dlhq_1
XFILLER_79_0 VPWR VGND sg13cmos5l_fill_2
XANTENNA__1013__A2 Tile_X0Y1_W6END[5] VPWR VGND sg13cmos5l_antennanp
XANTENNA__1196__X AXIL_S_SOC_RDATA19 VPWR VGND sg13cmos5l_antennanp
X_1736_ _1736_/Q Tile_X0Y2_FrameData[19] Tile_X0Y3_FrameStrobe[1] VPWR VGND sg13cmos5l_dlhq_1
XFILLER_7_290 VPWR VGND sg13cmos5l_decap_4
XANTENNA__0772__A1 Tile_X0Y0_S1END[1] VPWR VGND sg13cmos5l_antennanp
XFILLER_131_103 VPWR VGND sg13cmos5l_decap_4
X_1667_ _1667_/Q Tile_X0Y1_FrameData[0] Tile_X0Y3_FrameStrobe[6] VPWR VGND sg13cmos5l_dlhq_1
XFILLER_131_136 VPWR VGND sg13cmos5l_decap_8
X_1598_ _1598_/Q Tile_X0Y1_FrameData[5] Tile_X0Y3_FrameStrobe[4] VPWR VGND sg13cmos5l_dlhq_1
X_0618_ _0618_/Y _2122_/Q _0618_/B VPWR VGND sg13cmos5l_nor2_1
XFILLER_171_294 VPWR VGND sg13cmos5l_fill_1
XFILLER_131_169 VPWR VGND sg13cmos5l_fill_2
X_0549_ _0551_/B Tile_X0Y1_W6END[1] _1449_/Q VPWR VGND sg13cmos5l_nor2b_1
XFILLER_105_47 VPWR VGND sg13cmos5l_fill_2
XANTENNA__1608__GATE Tile_X0Y3_FrameStrobe[5] VPWR VGND sg13cmos5l_antennanp
XANTENNA__1522__D Tile_X0Y1_FrameData[17] VPWR VGND sg13cmos5l_antennanp
X_2219_ Tile_X0Y1_E6BEG[4] _2219_/A VPWR VGND sg13cmos5l_buf_1
XFILLER_38_150 VPWR VGND sg13cmos5l_decap_8
XFILLER_201_129 VPWR VGND sg13cmos5l_decap_8
XANTENNA__2490__X Tile_X0Y0_E1BEG[0] VPWR VGND sg13cmos5l_antennanp
XFILLER_154_206 VPWR VGND sg13cmos5l_fill_2
XFILLER_107_100 VPWR VGND sg13cmos5l_fill_1
XFILLER_5_216 VPWR VGND sg13cmos5l_decap_8
XFILLER_146_21 VPWR VGND sg13cmos5l_decap_8
XFILLER_76_223 VPWR VGND sg13cmos5l_fill_2
XFILLER_130_191 VPWR VGND sg13cmos5l_fill_2
XFILLER_183_0 VPWR VGND sg13cmos5l_decap_4
XANTENNA__1432__D Tile_X0Y0_FrameData[19] VPWR VGND sg13cmos5l_antennanp
XFILLER_91_226 VPWR VGND sg13cmos5l_decap_8
XFILLER_76_278 VPWR VGND sg13cmos5l_fill_2
XANTENNA__0818__A2 Tile_X0Y0_S1END[1] VPWR VGND sg13cmos5l_antennanp
XFILLER_217_273 VPWR VGND sg13cmos5l_decap_4
XFILLER_44_186 VPWR VGND sg13cmos5l_decap_8
XFILLER_145_206 VPWR VGND sg13cmos5l_decap_8
X_2570_ Tile_X0Y3_FrameData_O[28] Tile_X0Y3_FrameData[28] VPWR VGND sg13cmos5l_buf_1
XANTENNA__0754__A1 Tile_X0Y2_W2END[0] VPWR VGND sg13cmos5l_antennanp
XANTENNA__1607__D Tile_X0Y1_FrameData[28] VPWR VGND sg13cmos5l_antennanp
XFILLER_153_250 VPWR VGND sg13cmos5l_decap_8
X_1521_ _1521_/Q Tile_X0Y1_FrameData[18] Tile_X0Y3_FrameStrobe[2] VPWR VGND sg13cmos5l_dlhq_1
XFILLER_113_125 VPWR VGND sg13cmos5l_fill_2
XFILLER_113_147 VPWR VGND sg13cmos5l_fill_1
XFILLER_153_294 VPWR VGND sg13cmos5l_fill_1
X_1452_ _1452_/Q Tile_X0Y1_FrameData[23] Tile_X0Y3_FrameStrobe[0] VPWR VGND sg13cmos5l_dlhq_1
XFILLER_206_46 VPWR VGND sg13cmos5l_fill_2
XANTENNA__0506__A1 Tile_X0Y3_N4END[3] VPWR VGND sg13cmos5l_antennanp
X_1383_ _1383_/Q Tile_X0Y0_FrameData[4] Tile_X0Y3_FrameStrobe[5] VPWR VGND sg13cmos5l_dlhq_1
XFILLER_67_212 VPWR VGND sg13cmos5l_decap_8
XANTENNA__1342__D Tile_X0Y0_FrameData[13] VPWR VGND sg13cmos5l_antennanp
XANTENNA__2575__X Tile_X0Y3_S1BEG[1] VPWR VGND sg13cmos5l_antennanp
X_2004_ _2004_/Q Tile_X0Y3_FrameData[31] Tile_X0Y3_FrameStrobe[2] VPWR VGND sg13cmos5l_dlhq_1
XFILLER_82_248 VPWR VGND sg13cmos5l_fill_2
XFILLER_222_56 VPWR VGND sg13cmos5l_fill_1
XANTENNA__1594__GATE Tile_X0Y3_FrameStrobe[4] VPWR VGND sg13cmos5l_antennanp
XFILLER_223_232 VPWR VGND sg13cmos5l_fill_1
XFILLER_223_221 VPWR VGND sg13cmos5l_fill_1
XANTENNA__0690__A0 Tile_X0Y3_N4END[1] VPWR VGND sg13cmos5l_antennanp
XFILLER_50_123 VPWR VGND sg13cmos5l_decap_8
XANTENNA__2173__D Tile_X0Y3_FrameData[22] VPWR VGND sg13cmos5l_antennanp
XANTENNA__0745__A1 Tile_X0Y3_W2END[4] VPWR VGND sg13cmos5l_antennanp
XANTENNA__1517__D Tile_X0Y1_FrameData[22] VPWR VGND sg13cmos5l_antennanp
XANTENNA__1532__GATE Tile_X0Y3_FrameStrobe[2] VPWR VGND sg13cmos5l_antennanp
X_1719_ _1719_/Q Tile_X0Y2_FrameData[4] Tile_X0Y3_FrameStrobe[0] VPWR VGND sg13cmos5l_dlhq_1
XFILLER_144_294 VPWR VGND sg13cmos5l_fill_1
XFILLER_116_35 VPWR VGND sg13cmos5l_fill_1
XANTENNA__1547__GATE Tile_X0Y3_FrameStrobe[3] VPWR VGND sg13cmos5l_antennanp
XANTENNA__1252__D Tile_X0Y0_FrameData[7] VPWR VGND sg13cmos5l_antennanp
XANTENNA__2485__X Tile_X0Y0_E2BEG[3] VPWR VGND sg13cmos5l_antennanp
XFILLER_25_21 VPWR VGND sg13cmos5l_fill_1
XFILLER_214_210 VPWR VGND sg13cmos5l_decap_8
XANTENNA__0446__A Tile_X0Y1_W6END[7] VPWR VGND sg13cmos5l_antennanp
XANTENNA__0681__A0 AXIL_S_SOC_ARVALID VPWR VGND sg13cmos5l_antennanp
XFILLER_41_156 VPWR VGND sg13cmos5l_decap_8
XANTENNA__2083__D Tile_X0Y3_FrameData[16] VPWR VGND sg13cmos5l_antennanp
XFILLER_157_20 VPWR VGND sg13cmos5l_fill_2
XFILLER_157_31 VPWR VGND sg13cmos5l_decap_8
XFILLER_157_53 VPWR VGND sg13cmos5l_fill_1
XANTENNA__1427__D Tile_X0Y0_FrameData[24] VPWR VGND sg13cmos5l_antennanp
XFILLER_9_0 VPWR VGND sg13cmos5l_fill_2
XFILLER_173_30 VPWR VGND sg13cmos5l_fill_1
XANTENNA__2395__X Tile_X0Y0_FrameStrobe_O[1] VPWR VGND sg13cmos5l_antennanp
XFILLER_72_281 VPWR VGND sg13cmos5l_fill_2
XANTENNA__0672__A0 AXIL_S_SOC_ARADDR2 VPWR VGND sg13cmos5l_antennanp
XFILLER_82_60 VPWR VGND sg13cmos5l_decap_8
XANTENNA__2571__A Tile_X0Y3_FrameData[29] VPWR VGND sg13cmos5l_antennanp
X_0952_ _2208_/A AXIL_S_SOC_WDATA17 AXIL_S_SOC_WDATA25 _0864_/X _0866_/X _1593_/Q
+ _1592_/Q VPWR VGND sg13cmos5l_mux4_1
X_0883_ _2453_/A AXIL_S_SOC_AWADDR1 _0760_/X AXIL_S_SOC_AWADDR5 _0643_/X _1316_/Q
+ _1317_/Q VPWR VGND sg13cmos5l_mux4_1
XANTENNA__1337__D Tile_X0Y0_FrameData[18] VPWR VGND sg13cmos5l_antennanp
XFILLER_126_250 VPWR VGND sg13cmos5l_decap_8
X_2553_ Tile_X0Y3_FrameData_O[11] Tile_X0Y3_FrameData[11] VPWR VGND sg13cmos5l_buf_1
XANTENNA__0727__A1 Tile_X0Y0_W2END[1] VPWR VGND sg13cmos5l_antennanp
XFILLER_126_294 VPWR VGND sg13cmos5l_fill_1
X_1504_ _1504_/Q Tile_X0Y1_FrameData[3] Tile_X0Y3_FrameStrobe[1] VPWR VGND sg13cmos5l_dlhq_1
X_2484_ Tile_X0Y0_E2BEG[2] _2484_/A VPWR VGND sg13cmos5l_buf_1
XFILLER_99_178 VPWR VGND sg13cmos5l_decap_8
XFILLER_217_89 VPWR VGND sg13cmos5l_fill_1
XFILLER_141_286 VPWR VGND sg13cmos5l_fill_1
X_1435_ _1435_/Q Tile_X0Y0_FrameData[16] Tile_X0Y3_FrameStrobe[7] VPWR VGND sg13cmos5l_dlhq_1
X_1366_ _1366_/Q Tile_X0Y0_FrameData[21] Tile_X0Y3_FrameStrobe[5] VPWR VGND sg13cmos5l_dlhq_1
XANTENNA__2168__D Tile_X0Y3_FrameData[27] VPWR VGND sg13cmos5l_antennanp
XFILLER_55_204 VPWR VGND sg13cmos5l_decap_8
X_1297_ _1297_/Q Tile_X0Y0_FrameData[26] Tile_X0Y3_FrameStrobe[3] VPWR VGND sg13cmos5l_dlhq_1
XFILLER_55_259 VPWR VGND sg13cmos5l_decap_8
XANTENNA__1800__D Tile_X0Y2_FrameData[19] VPWR VGND sg13cmos5l_antennanp
XANTENNA__0663__A0 AXIL_S_SOC_ARADDR1 VPWR VGND sg13cmos5l_antennanp
XFILLER_23_156 VPWR VGND sg13cmos5l_decap_8
XFILLER_211_268 VPWR VGND sg13cmos5l_decap_8
XANTENNA__1471__GATE Tile_X0Y3_FrameStrobe[0] VPWR VGND sg13cmos5l_antennanp
XFILLER_191_142 VPWR VGND sg13cmos5l_fill_2
XFILLER_176_194 VPWR VGND sg13cmos5l_decap_4
XANTENNA__1247__D Tile_X0Y0_FrameData[12] VPWR VGND sg13cmos5l_antennanp
XANTENNA__0718__A1 Tile_X0Y3_W2END[7] VPWR VGND sg13cmos5l_antennanp
XFILLER_11_89 VPWR VGND sg13cmos5l_fill_2
XFILLER_127_45 VPWR VGND sg13cmos5l_decap_8
XFILLER_127_56 VPWR VGND sg13cmos5l_fill_1
XANTENNA__1486__GATE Tile_X0Y3_FrameStrobe[1] VPWR VGND sg13cmos5l_antennanp
XANTENNA__2078__D Tile_X0Y3_FrameData[21] VPWR VGND sg13cmos5l_antennanp
XFILLER_100_161 VPWR VGND sg13cmos5l_decap_8
XFILLER_143_66 VPWR VGND sg13cmos5l_fill_2
XFILLER_36_20 VPWR VGND sg13cmos5l_fill_1
XFILLER_46_259 VPWR VGND sg13cmos5l_decap_8
XANTENNA__1710__D Tile_X0Y2_FrameData[13] VPWR VGND sg13cmos5l_antennanp
XANTENNA__0654__A0 Tile_X0Y0_W2MID[2] VPWR VGND sg13cmos5l_antennanp
XANTENNA__1424__GATE Tile_X0Y3_FrameStrobe[7] VPWR VGND sg13cmos5l_antennanp
XFILLER_14_134 VPWR VGND sg13cmos5l_decap_8
XFILLER_199_253 VPWR VGND sg13cmos5l_fill_1
XFILLER_146_0 VPWR VGND sg13cmos5l_decap_4
XFILLER_14_178 VPWR VGND sg13cmos5l_decap_8
XFILLER_52_41 VPWR VGND sg13cmos5l_decap_8
XFILLER_168_41 VPWR VGND sg13cmos5l_fill_1
XFILLER_52_85 VPWR VGND sg13cmos5l_decap_8
XFILLER_202_268 VPWR VGND sg13cmos5l_fill_2
XANTENNA__0957__A1 AXIL_S_SOC_WDATA26 VPWR VGND sg13cmos5l_antennanp
XFILLER_167_150 VPWR VGND sg13cmos5l_decap_8
XFILLER_167_183 VPWR VGND sg13cmos5l_fill_1
XFILLER_168_52 VPWR VGND sg13cmos5l_decap_4
XFILLER_168_85 VPWR VGND sg13cmos5l_fill_1
XANTENNA__1439__GATE Tile_X0Y3_FrameStrobe[7] VPWR VGND sg13cmos5l_antennanp
XFILLER_168_96 VPWR VGND sg13cmos5l_decap_8
XFILLER_182_142 VPWR VGND sg13cmos5l_decap_4
XFILLER_108_283 VPWR VGND sg13cmos5l_fill_1
XFILLER_42_8 VPWR VGND sg13cmos5l_fill_1
XFILLER_96_104 VPWR VGND sg13cmos5l_decap_4
X_1220_ _1220_/Q Tile_X0Y0_FrameData[7] Tile_X0Y3_FrameStrobe[0] VPWR VGND sg13cmos5l_dlhq_1
XFILLER_96_148 VPWR VGND sg13cmos5l_decap_8
XANTENNA__2566__A Tile_X0Y3_FrameData[24] VPWR VGND sg13cmos5l_antennanp
X_1151_ _1155_/B _1869_/Q _1151_/B VPWR VGND sg13cmos5l_nand2b_1
XFILLER_37_204 VPWR VGND sg13cmos5l_decap_4
XANTENNA__0488__A3 Tile_X0Y0_S4END[3] VPWR VGND sg13cmos5l_antennanp
XANTENNA__0893__A0 Tile_X0Y0_W2MID[7] VPWR VGND sg13cmos5l_antennanp
XFILLER_37_248 VPWR VGND sg13cmos5l_decap_8
X_1082_ _2282_/A AXIL_S_SOC_WDATA2 AXIL_S_SOC_WDATA10 _0725_/X _0732_/X _1855_/Q _1854_/Q
+ VPWR VGND sg13cmos5l_mux4_1
XANTENNA__1620__D Tile_X0Y1_FrameData[15] VPWR VGND sg13cmos5l_antennanp
XANTENNA__0645__A0 Tile_X0Y2_W2MID[6] VPWR VGND sg13cmos5l_antennanp
X_1984_ _1984_/Q Tile_X0Y3_FrameData[19] Tile_X0Y3_FrameStrobe[1] VPWR VGND sg13cmos5l_dlhq_1
XFILLER_158_172 VPWR VGND sg13cmos5l_decap_8
X_0935_ _2368_/A _0930_/X _0934_/X _1659_/Q VPWR VGND sg13cmos5l_mux2_1
XFILLER_9_160 VPWR VGND sg13cmos5l_decap_8
X_0866_ _0866_/X _0750_/X _0728_/X _0727_/X Tile_X0Y0_S2MID[6] _1455_/Q _1454_/Q VPWR
+ VGND sg13cmos5l_mux4_1
X_2605_ Tile_X0Y3_S4BEG[11] _2605_/A VPWR VGND sg13cmos5l_buf_1
XFILLER_61_0 VPWR VGND sg13cmos5l_fill_2
XFILLER_173_164 VPWR VGND sg13cmos5l_decap_8
X_0797_ _0797_/Y _0443_/Y _0444_/Y _1409_/Q VPWR VGND sg13cmos5l_a21oi_1
X_2536_ Tile_X0Y3_EE4BEG[10] _2536_/A VPWR VGND sg13cmos5l_buf_1
X_2467_ Tile_X0Y0_E6BEG[5] _2467_/A VPWR VGND sg13cmos5l_buf_1
X_1418_ _1418_/Q Tile_X0Y0_FrameData[1] Tile_X0Y3_FrameStrobe[6] VPWR VGND sg13cmos5l_dlhq_1
X_2398_ Tile_X0Y0_FrameStrobe_O[4] Tile_X0Y3_FrameStrobe[4] VPWR VGND sg13cmos5l_buf_1
XANTENNA__0479__A3 Tile_X0Y0_S4END[14] VPWR VGND sg13cmos5l_antennanp
XANTENNA__0884__A0 AXIL_S_SOC_WSTRB1 VPWR VGND sg13cmos5l_antennanp
X_1349_ _1349_/Q Tile_X0Y0_FrameData[6] Tile_X0Y3_FrameStrobe[4] VPWR VGND sg13cmos5l_dlhq_1
XFILLER_95_181 VPWR VGND sg13cmos5l_decap_8
XFILLER_28_226 VPWR VGND sg13cmos5l_decap_8
XANTENNA__1530__D Tile_X0Y1_FrameData[9] VPWR VGND sg13cmos5l_antennanp
XANTENNA__0636__A0 Tile_X0Y3_W2MID[3] VPWR VGND sg13cmos5l_antennanp
XANTENNA__2154__GATE Tile_X0Y3_FrameStrobe[6] VPWR VGND sg13cmos5l_antennanp
XFILLER_51_262 VPWR VGND sg13cmos5l_fill_1
XFILLER_196_234 VPWR VGND sg13cmos5l_fill_2
XFILLER_11_115 VPWR VGND sg13cmos5l_decap_8
XFILLER_11_126 VPWR VGND sg13cmos5l_fill_2
XFILLER_196_278 VPWR VGND sg13cmos5l_fill_1
XFILLER_149_194 VPWR VGND sg13cmos5l_decap_8
XFILLER_22_66 VPWR VGND sg13cmos5l_decap_4
XANTENNA__2169__GATE Tile_X0Y3_FrameStrobe[7] VPWR VGND sg13cmos5l_antennanp
XFILLER_98_15 VPWR VGND sg13cmos5l_decap_4
XANTENNA__1705__D Tile_X0Y2_FrameData[18] VPWR VGND sg13cmos5l_antennanp
XFILLER_154_43 VPWR VGND sg13cmos5l_decap_4
XFILLER_78_126 VPWR VGND sg13cmos5l_fill_1
XFILLER_120_245 VPWR VGND sg13cmos5l_decap_8
XFILLER_120_256 VPWR VGND sg13cmos5l_fill_1
XFILLER_120_278 VPWR VGND sg13cmos5l_fill_2
XFILLER_154_98 VPWR VGND sg13cmos5l_decap_8
XFILLER_219_121 VPWR VGND sg13cmos5l_decap_4
XANTENNA__2107__GATE Tile_X0Y3_FrameStrobe[5] VPWR VGND sg13cmos5l_antennanp
XFILLER_86_192 VPWR VGND sg13cmos5l_decap_8
XFILLER_219_176 VPWR VGND sg13cmos5l_decap_8
XFILLER_219_165 VPWR VGND sg13cmos5l_decap_8
XANTENNA__0875__A0 AXIL_S_SOC_WSTRB2 VPWR VGND sg13cmos5l_antennanp
XFILLER_47_96 VPWR VGND sg13cmos5l_decap_8
XFILLER_19_259 VPWR VGND sg13cmos5l_decap_8
XANTENNA__1363__GATE Tile_X0Y3_FrameStrobe[5] VPWR VGND sg13cmos5l_antennanp
XANTENNA__1440__D Tile_X0Y0_FrameData[11] VPWR VGND sg13cmos5l_antennanp
XFILLER_34_218 VPWR VGND sg13cmos5l_fill_1
XANTENNA__1993__GATE Tile_X0Y3_FrameStrobe[1] VPWR VGND sg13cmos5l_antennanp
XFILLER_179_73 VPWR VGND sg13cmos5l_decap_8
XANTENNA__1378__GATE Tile_X0Y3_FrameStrobe[5] VPWR VGND sg13cmos5l_antennanp
X_0720_ _2382_/A Tile_X0Y0_W2MID[7] Tile_X0Y0_W2END[7] Tile_X0Y0_W6END[7] _0643_/X
+ _1435_/Q _1434_/Q VPWR VGND sg13cmos5l_mux4_1
XANTENNA__1301__GATE Tile_X0Y3_FrameStrobe[3] VPWR VGND sg13cmos5l_antennanp
XFILLER_170_112 VPWR VGND sg13cmos5l_decap_8
X_0651_ _0651_/X Tile_X0Y2_W2MID[5] Tile_X0Y2_W2END[5] Tile_X0Y2_W6END[5] _0725_/X
+ _1927_/Q _1926_/Q VPWR VGND sg13cmos5l_mux4_1
XFILLER_195_94 VPWR VGND sg13cmos5l_decap_8
XANTENNA__1931__GATE Tile_X0Y3_FrameStrobe[7] VPWR VGND sg13cmos5l_antennanp
XFILLER_170_167 VPWR VGND sg13cmos5l_decap_4
X_0582_ _0582_/X Tile_X0Y1_W2MID[6] Tile_X0Y1_W2END[6] Tile_X0Y1_W6END[9] _0864_/X
+ _1645_/Q _1644_/Q VPWR VGND sg13cmos5l_mux4_1
XANTENNA__1615__D Tile_X0Y1_FrameData[20] VPWR VGND sg13cmos5l_antennanp
X_2321_ Tile_X0Y2_EE4BEG[13] _2321_/A VPWR VGND sg13cmos5l_buf_1
XFILLER_88_70 VPWR VGND sg13cmos5l_fill_1
XANTENNA__1316__GATE Tile_X0Y3_FrameStrobe[3] VPWR VGND sg13cmos5l_antennanp
XFILLER_111_245 VPWR VGND sg13cmos5l_decap_8
X_2252_ Tile_X0Y1_FrameData_O[9] Tile_X0Y1_FrameData[9] VPWR VGND sg13cmos5l_buf_1
XANTENNA__1107__A1 AXIL_S_SOC_WDATA10 VPWR VGND sg13cmos5l_antennanp
XANTENNA__1946__GATE Tile_X0Y3_FrameStrobe[0] VPWR VGND sg13cmos5l_antennanp
XFILLER_111_256 VPWR VGND sg13cmos5l_fill_1
X_1203_ _1203_/Q Tile_X0Y0_FrameData[24] Tile_X0Y3_FrameStrobe[0] VPWR VGND sg13cmos5l_dlhq_1
X_2183_ _2183_/Q Tile_X0Y3_FrameData[12] Tile_X0Y3_FrameStrobe[7] VPWR VGND sg13cmos5l_dlhq_1
XFILLER_84_129 VPWR VGND sg13cmos5l_decap_4
XFILLER_77_192 VPWR VGND sg13cmos5l_decap_8
X_1134_ _1134_/Y _1877_/Q _1134_/B _1134_/C VPWR VGND sg13cmos5l_nor3_1
XFILLER_225_135 VPWR VGND sg13cmos5l_decap_4
XANTENNA__1350__D Tile_X0Y0_FrameData[5] VPWR VGND sg13cmos5l_antennanp
XANTENNA__2583__X Tile_X0Y3_S2BEG[5] VPWR VGND sg13cmos5l_antennanp
X_1065_ _1066_/C _1914_/Q _1065_/B _1065_/C VPWR VGND sg13cmos5l_nor3_1
XFILLER_92_162 VPWR VGND sg13cmos5l_decap_8
XFILLER_225_168 VPWR VGND sg13cmos5l_decap_4
XFILLER_33_262 VPWR VGND sg13cmos5l_decap_8
XANTENNA__2181__D Tile_X0Y3_FrameData[14] VPWR VGND sg13cmos5l_antennanp
X_1967_ _1967_/Q Tile_X0Y3_FrameData[4] Tile_X0Y3_FrameStrobe[0] VPWR VGND sg13cmos5l_dlhq_1
X_1898_ _1898_/Q Tile_X0Y2_FrameData[17] Tile_X0Y3_FrameStrobe[6] VPWR VGND sg13cmos5l_dlhq_1
X_0918_ _0918_/Y _1666_/Q _0918_/B VPWR VGND sg13cmos5l_nand2b_1
X_0849_ _2477_/A AXIL_S_SOC_WSTRB2 AXIL_S_SOC_AWADDR5 _0712_/X _0739_/X _1341_/Q _1340_/Q
+ VPWR VGND sg13cmos5l_mux4_1
XFILLER_108_36 VPWR VGND sg13cmos5l_fill_1
XFILLER_108_58 VPWR VGND sg13cmos5l_fill_1
XFILLER_161_167 VPWR VGND sg13cmos5l_fill_1
XANTENNA__1525__D Tile_X0Y1_FrameData[14] VPWR VGND sg13cmos5l_antennanp
X_2519_ Tile_X0Y3_E6BEG[5] _2519_/A VPWR VGND sg13cmos5l_buf_1
XFILLER_68_29 VPWR VGND sg13cmos5l_fill_2
XFILLER_102_234 VPWR VGND sg13cmos5l_decap_4
XFILLER_124_35 VPWR VGND sg13cmos5l_fill_1
XFILLER_124_46 VPWR VGND sg13cmos5l_decap_8
XANTENNA__0857__A0 AXIL_S_SOC_AWADDR0 VPWR VGND sg13cmos5l_antennanp
XFILLER_216_124 VPWR VGND sg13cmos5l_fill_2
XANTENNA__1260__D Tile_X0Y0_FrameData[31] VPWR VGND sg13cmos5l_antennanp
XANTENNA__2493__X Tile_X0Y0_E1BEG[3] VPWR VGND sg13cmos5l_antennanp
XFILLER_216_157 VPWR VGND sg13cmos5l_fill_1
XFILLER_204_90 VPWR VGND sg13cmos5l_decap_8
XANTENNA__2093__GATE Tile_X0Y3_FrameStrobe[4] VPWR VGND sg13cmos5l_antennanp
XFILLER_33_32 VPWR VGND sg13cmos5l_decap_8
XFILLER_24_284 VPWR VGND sg13cmos5l_fill_2
XFILLER_149_21 VPWR VGND sg13cmos5l_decap_4
XFILLER_149_43 VPWR VGND sg13cmos5l_decap_8
XANTENNA__1034__A0 AXIL_S_SOC_WDATA17 VPWR VGND sg13cmos5l_antennanp
XANTENNA__2091__D Tile_X0Y3_FrameData[8] VPWR VGND sg13cmos5l_antennanp
XFILLER_152_101 VPWR VGND sg13cmos5l_fill_2
XFILLER_165_20 VPWR VGND sg13cmos5l_decap_4
XANTENNA__2031__GATE Tile_X0Y3_FrameStrobe[2] VPWR VGND sg13cmos5l_antennanp
XFILLER_109_0 VPWR VGND sg13cmos5l_fill_1
XFILLER_165_53 VPWR VGND sg13cmos5l_decap_4
XFILLER_3_166 VPWR VGND sg13cmos5l_decap_8
XANTENNA__1435__D Tile_X0Y0_FrameData[16] VPWR VGND sg13cmos5l_antennanp
XANTENNA__2046__GATE Tile_X0Y3_FrameStrobe[3] VPWR VGND sg13cmos5l_antennanp
XFILLER_58_62 VPWR VGND sg13cmos5l_fill_1
XFILLER_58_51 VPWR VGND sg13cmos5l_decap_8
XFILLER_59_181 VPWR VGND sg13cmos5l_decap_4
XFILLER_58_84 VPWR VGND sg13cmos5l_decap_4
XFILLER_181_63 VPWR VGND sg13cmos5l_decap_8
XANTENNA__0848__A0 AXIL_S_SOC_WSTRB3 VPWR VGND sg13cmos5l_antennanp
XFILLER_207_113 VPWR VGND sg13cmos5l_decap_8
XFILLER_74_162 VPWR VGND sg13cmos5l_fill_2
XFILLER_74_195 VPWR VGND sg13cmos5l_decap_8
X_1821_ _1821_/Q Tile_X0Y2_FrameData[30] Tile_X0Y3_FrameStrobe[4] VPWR VGND sg13cmos5l_dlhq_1
XANTENNA__1025__A0 AXIL_S_SOC_WDATA21 VPWR VGND sg13cmos5l_antennanp
XFILLER_90_93 VPWR VGND sg13cmos5l_decap_8
XANTENNA__1240__GATE Tile_X0Y3_FrameStrobe[1] VPWR VGND sg13cmos5l_antennanp
X_1752_ _1752_/Q Tile_X0Y2_FrameData[3] Tile_X0Y3_FrameStrobe[1] VPWR VGND sg13cmos5l_dlhq_1
XFILLER_209_24 VPWR VGND sg13cmos5l_fill_1
XANTENNA__1870__GATE Tile_X0Y3_FrameStrobe[5] VPWR VGND sg13cmos5l_antennanp
X_1683_ _1683_/Q Tile_X0Y1_FrameData[16] Tile_X0Y3_FrameStrobe[7] VPWR VGND sg13cmos5l_dlhq_1
X_0703_ AXIL_S_SOC_RDATA2 Tile_X0Y3_W2MID[6] Tile_X0Y3_W2END[6] Tile_X0Y3_W6END[6]
+ _0598_/X _2007_/Q _2006_/Q VPWR VGND sg13cmos5l_mux4_1
XFILLER_209_57 VPWR VGND sg13cmos5l_fill_1
XFILLER_143_145 VPWR VGND sg13cmos5l_decap_8
X_0634_ _0635_/B Tile_X0Y3_W2MID[2] Tile_X0Y3_W2END[2] Tile_X0Y3_W6END[2] _0483_/X
+ _2015_/Q _2014_/Q VPWR VGND sg13cmos5l_mux4_1
XANTENNA__2578__X Tile_X0Y3_S2BEG[0] VPWR VGND sg13cmos5l_antennanp
XFILLER_143_178 VPWR VGND sg13cmos5l_decap_8
XANTENNA__1255__GATE Tile_X0Y3_FrameStrobe[1] VPWR VGND sg13cmos5l_antennanp
XANTENNA__1345__D Tile_X0Y0_FrameData[10] VPWR VGND sg13cmos5l_antennanp
X_0565_ _0565_/Y _1944_/Q _0563_/Y _0564_/Y VPWR VGND sg13cmos5l_o21ai_1
XFILLER_225_45 VPWR VGND sg13cmos5l_fill_2
XFILLER_225_34 VPWR VGND sg13cmos5l_decap_8
XANTENNA__1885__GATE Tile_X0Y3_FrameStrobe[6] VPWR VGND sg13cmos5l_antennanp
X_2304_ Tile_X0Y2_E6BEG[8] _2304_/A VPWR VGND sg13cmos5l_buf_1
X_0496_ _0497_/C _1445_/Q _0858_/X VPWR VGND sg13cmos5l_nor2_1
XFILLER_97_254 VPWR VGND sg13cmos5l_fill_2
XFILLER_24_0 VPWR VGND sg13cmos5l_fill_2
X_2235_ Tile_X0Y1_EE4BEG[8] _2235_/A VPWR VGND sg13cmos5l_buf_1
XANTENNA__0839__A0 AXIL_S_SOC_WVALID VPWR VGND sg13cmos5l_antennanp
X_2166_ _2166_/Q Tile_X0Y3_FrameData[29] Tile_X0Y3_FrameStrobe[7] VPWR VGND sg13cmos5l_dlhq_1
XANTENNA__2176__D Tile_X0Y3_FrameData[19] VPWR VGND sg13cmos5l_antennanp
X_1117_ _2297_/A Tile_X0Y3_N4END[5] Tile_X0Y0_S4END[9] _1101_/X _0471_/X _1793_/Q
+ _1792_/Q VPWR VGND sg13cmos5l_mux4_1
X_2097_ _2097_/Q Tile_X0Y3_FrameData[2] Tile_X0Y3_FrameStrobe[4] VPWR VGND sg13cmos5l_dlhq_1
XFILLER_65_195 VPWR VGND sg13cmos5l_decap_8
X_1048_ _1048_/Y _1910_/Q _1048_/B _1048_/C VPWR VGND sg13cmos5l_nor3_1
XFILLER_213_149 VPWR VGND sg13cmos5l_fill_1
XFILLER_206_190 VPWR VGND sg13cmos5l_decap_8
XANTENNA__1823__GATE Tile_X0Y3_FrameStrobe[4] VPWR VGND sg13cmos5l_antennanp
XANTENNA__1016__A0 Tile_X0Y1_W1END[3] VPWR VGND sg13cmos5l_antennanp
XANTENNA__1208__GATE Tile_X0Y3_FrameStrobe[0] VPWR VGND sg13cmos5l_antennanp
XANTENNA__1838__GATE Tile_X0Y3_FrameStrobe[4] VPWR VGND sg13cmos5l_antennanp
XFILLER_119_175 VPWR VGND sg13cmos5l_fill_2
XFILLER_79_28 VPWR VGND sg13cmos5l_decap_8
XANTENNA__1255__D Tile_X0Y0_FrameData[4] VPWR VGND sg13cmos5l_antennanp
XANTENNA__2488__X Tile_X0Y0_E2BEG[6] VPWR VGND sg13cmos5l_antennanp
XFILLER_0_136 VPWR VGND sg13cmos5l_decap_4
XFILLER_88_243 VPWR VGND sg13cmos5l_fill_2
XFILLER_88_232 VPWR VGND sg13cmos5l_decap_8
XFILLER_95_38 VPWR VGND sg13cmos5l_fill_2
XANTENNA__0542__A2 Tile_X0Y3_N4END[13] VPWR VGND sg13cmos5l_antennanp
XFILLER_151_11 VPWR VGND sg13cmos5l_fill_2
XFILLER_151_33 VPWR VGND sg13cmos5l_fill_2
XANTENNA__2086__D Tile_X0Y3_FrameData[13] VPWR VGND sg13cmos5l_antennanp
XFILLER_151_88 VPWR VGND sg13cmos5l_decap_4
XFILLER_71_176 VPWR VGND sg13cmos5l_fill_2
XFILLER_71_143 VPWR VGND sg13cmos5l_fill_1
XFILLER_44_31 VPWR VGND sg13cmos5l_decap_4
XFILLER_44_97 VPWR VGND sg13cmos5l_decap_8
XFILLER_212_160 VPWR VGND sg13cmos5l_fill_2
XANTENNA__1007__A0 Tile_X0Y1_W2MID[2] VPWR VGND sg13cmos5l_antennanp
XFILLER_60_30 VPWR VGND sg13cmos5l_decap_8
XFILLER_165_270 VPWR VGND sg13cmos5l_fill_2
XFILLER_60_96 VPWR VGND sg13cmos5l_decap_8
XFILLER_176_74 VPWR VGND sg13cmos5l_decap_8
XFILLER_172_229 VPWR VGND sg13cmos5l_decap_4
XANTENNA__2398__X Tile_X0Y0_FrameStrobe_O[4] VPWR VGND sg13cmos5l_antennanp
XFILLER_140_148 VPWR VGND sg13cmos5l_fill_2
XFILLER_79_276 VPWR VGND sg13cmos5l_fill_2
XFILLER_79_265 VPWR VGND sg13cmos5l_decap_8
XFILLER_192_73 VPWR VGND sg13cmos5l_decap_8
XFILLER_94_235 VPWR VGND sg13cmos5l_decap_8
X_2020_ _2020_/Q Tile_X0Y3_FrameData[15] Tile_X0Y3_FrameStrobe[2] VPWR VGND sg13cmos5l_dlhq_1
XFILLER_47_195 VPWR VGND sg13cmos5l_decap_8
XFILLER_211_14 VPWR VGND sg13cmos5l_fill_1
XFILLER_62_165 VPWR VGND sg13cmos5l_fill_2
XFILLER_210_108 VPWR VGND sg13cmos5l_fill_2
X_1804_ _1804_/Q Tile_X0Y2_FrameData[15] Tile_X0Y3_FrameStrobe[3] VPWR VGND sg13cmos5l_dlhq_1
X_1735_ _1735_/Q Tile_X0Y2_FrameData[20] Tile_X0Y3_FrameStrobe[1] VPWR VGND sg13cmos5l_dlhq_1
XANTENNA__0772__A2 Tile_X0Y3_N4END[13] VPWR VGND sg13cmos5l_antennanp
XFILLER_116_178 VPWR VGND sg13cmos5l_fill_2
XFILLER_171_273 VPWR VGND sg13cmos5l_decap_8
X_1666_ _1666_/Q Tile_X0Y1_FrameData[1] Tile_X0Y3_FrameStrobe[6] VPWR VGND sg13cmos5l_dlhq_1
X_1597_ _1597_/Q Tile_X0Y1_FrameData[6] Tile_X0Y3_FrameStrobe[4] VPWR VGND sg13cmos5l_dlhq_1
X_0617_ _0618_/B Tile_X0Y3_W1END[1] Tile_X0Y3_W6END[5] Tile_X0Y3_WW4END[13] _0616_/X
+ _2123_/Q _2124_/Q VPWR VGND sg13cmos5l_mux4_1
XFILLER_171_284 VPWR VGND sg13cmos5l_fill_1
X_0548_ _0548_/Y _1449_/Q _1448_/Q VPWR VGND sg13cmos5l_nor2b_1
XFILLER_105_37 VPWR VGND sg13cmos5l_fill_1
XANTENNA__1803__D Tile_X0Y2_FrameData[16] VPWR VGND sg13cmos5l_antennanp
X_0479_ _0479_/X Tile_X0Y3_N1END[2] Tile_X0Y3_N4END[2] _0569_/B Tile_X0Y0_S4END[14]
+ _1975_/Q _1974_/Q VPWR VGND sg13cmos5l_mux4_1
XFILLER_85_246 VPWR VGND sg13cmos5l_decap_8
X_2218_ Tile_X0Y1_E6BEG[3] _2218_/A VPWR VGND sg13cmos5l_buf_1
X_2149_ _2149_/Q Tile_X0Y3_FrameData[14] Tile_X0Y3_FrameStrobe[6] VPWR VGND sg13cmos5l_dlhq_1
XANTENNA__1762__GATE Tile_X0Y3_FrameStrobe[2] VPWR VGND sg13cmos5l_antennanp
XFILLER_53_198 VPWR VGND sg13cmos5l_decap_8
XFILLER_201_80 VPWR VGND sg13cmos5l_fill_1
XFILLER_139_237 VPWR VGND sg13cmos5l_fill_2
XANTENNA__1777__GATE Tile_X0Y3_FrameStrobe[2] VPWR VGND sg13cmos5l_antennanp
XANTENNA__1700__GATE Tile_X0Y3_FrameStrobe[0] VPWR VGND sg13cmos5l_antennanp
XFILLER_107_178 VPWR VGND sg13cmos5l_fill_2
XFILLER_162_273 VPWR VGND sg13cmos5l_decap_8
XFILLER_122_148 VPWR VGND sg13cmos5l_fill_1
XANTENNA__1715__GATE Tile_X0Y3_FrameStrobe[0] VPWR VGND sg13cmos5l_antennanp
XANTENNA__1713__D Tile_X0Y2_FrameData[10] VPWR VGND sg13cmos5l_antennanp
XFILLER_76_257 VPWR VGND sg13cmos5l_decap_4
XFILLER_39_86 VPWR VGND sg13cmos5l_decap_4
XFILLER_91_205 VPWR VGND sg13cmos5l_decap_8
XANTENNA__0818__A3 AXIL_S_SOC_AWADDR0 VPWR VGND sg13cmos5l_antennanp
XANTENNA__2394__A Tile_X0Y3_FrameStrobe[0] VPWR VGND sg13cmos5l_antennanp
XFILLER_84_290 VPWR VGND sg13cmos5l_decap_4
XFILLER_29_195 VPWR VGND sg13cmos5l_decap_8
XFILLER_176_0 VPWR VGND sg13cmos5l_fill_2
XFILLER_55_63 VPWR VGND sg13cmos5l_decap_8
XFILLER_44_165 VPWR VGND sg13cmos5l_decap_8
XFILLER_189_115 VPWR VGND sg13cmos5l_decap_8
XFILLER_200_196 VPWR VGND sg13cmos5l_decap_8
XFILLER_187_95 VPWR VGND sg13cmos5l_decap_4
XANTENNA__0754__A2 Tile_X0Y2_W6END[0] VPWR VGND sg13cmos5l_antennanp
XFILLER_113_104 VPWR VGND sg13cmos5l_decap_4
X_1520_ _1520_/Q Tile_X0Y1_FrameData[19] Tile_X0Y3_FrameStrobe[2] VPWR VGND sg13cmos5l_dlhq_1
XANTENNA__2569__A Tile_X0Y3_FrameData[27] VPWR VGND sg13cmos5l_antennanp
X_1451_ _1451_/Q Tile_X0Y1_FrameData[24] Tile_X0Y3_FrameStrobe[0] VPWR VGND sg13cmos5l_dlhq_1
XFILLER_4_294 VPWR VGND sg13cmos5l_fill_1
XFILLER_4_283 VPWR VGND sg13cmos5l_decap_8
XFILLER_113_159 VPWR VGND sg13cmos5l_decap_8
X_1382_ _1382_/Q Tile_X0Y0_FrameData[5] Tile_X0Y3_FrameStrobe[5] VPWR VGND sg13cmos5l_dlhq_1
XFILLER_121_170 VPWR VGND sg13cmos5l_fill_1
XANTENNA__1623__D Tile_X0Y1_FrameData[12] VPWR VGND sg13cmos5l_antennanp
XFILLER_67_257 VPWR VGND sg13cmos5l_fill_2
X_2003_ _2003_/Q Tile_X0Y3_FrameData[0] Tile_X0Y3_FrameStrobe[1] VPWR VGND sg13cmos5l_dlhq_1
XFILLER_222_79 VPWR VGND sg13cmos5l_decap_8
XFILLER_208_274 VPWR VGND sg13cmos5l_decap_8
XFILLER_35_132 VPWR VGND sg13cmos5l_decap_8
XANTENNA__2591__X Tile_X0Y3_S2BEGb[5] VPWR VGND sg13cmos5l_antennanp
XFILLER_50_102 VPWR VGND sg13cmos5l_decap_8
XFILLER_223_244 VPWR VGND sg13cmos5l_fill_2
XANTENNA__0690__A1 Tile_X0Y0_S4END[13] VPWR VGND sg13cmos5l_antennanp
XFILLER_91_0 VPWR VGND sg13cmos5l_fill_2
XFILLER_223_277 VPWR VGND sg13cmos5l_fill_2
XFILLER_144_273 VPWR VGND sg13cmos5l_decap_8
X_1718_ _1718_/Q Tile_X0Y2_FrameData[5] Tile_X0Y3_FrameStrobe[0] VPWR VGND sg13cmos5l_dlhq_1
XANTENNA__0745__A2 Tile_X0Y3_W6END[4] VPWR VGND sg13cmos5l_antennanp
X_1649_ _1649_/Q Tile_X0Y1_FrameData[18] Tile_X0Y3_FrameStrobe[6] VPWR VGND sg13cmos5l_dlhq_1
XFILLER_104_148 VPWR VGND sg13cmos5l_decap_8
XANTENNA__1533__D Tile_X0Y1_FrameData[6] VPWR VGND sg13cmos5l_antennanp
XFILLER_58_279 VPWR VGND sg13cmos5l_fill_1
XFILLER_26_121 VPWR VGND sg13cmos5l_fill_2
XFILLER_26_187 VPWR VGND sg13cmos5l_decap_8
XFILLER_212_90 VPWR VGND sg13cmos5l_decap_4
XANTENNA__0681__A1 AXIL_S_SOC_ARADDR3 VPWR VGND sg13cmos5l_antennanp
XFILLER_81_293 VPWR VGND sg13cmos5l_fill_2
XFILLER_41_135 VPWR VGND sg13cmos5l_decap_8
XFILLER_41_21 VPWR VGND sg13cmos5l_decap_8
XFILLER_41_65 VPWR VGND sg13cmos5l_fill_1
XANTENNA__1708__D Tile_X0Y2_FrameData[15] VPWR VGND sg13cmos5l_antennanp
XFILLER_157_43 VPWR VGND sg13cmos5l_fill_2
XFILLER_157_98 VPWR VGND sg13cmos5l_decap_8
XANTENNA__0736__A2 Tile_X0Y0_S2MID[5] VPWR VGND sg13cmos5l_antennanp
XANTENNA__1654__GATE Tile_X0Y3_FrameStrobe[6] VPWR VGND sg13cmos5l_antennanp
XFILLER_110_118 VPWR VGND sg13cmos5l_decap_4
XFILLER_150_276 VPWR VGND sg13cmos5l_decap_4
XFILLER_2_26 VPWR VGND sg13cmos5l_decap_4
XANTENNA__1443__D Tile_X0Y0_FrameData[8] VPWR VGND sg13cmos5l_antennanp
XFILLER_49_279 VPWR VGND sg13cmos5l_fill_2
XANTENNA__1669__GATE Tile_X0Y3_FrameStrobe[7] VPWR VGND sg13cmos5l_antennanp
XFILLER_66_95 VPWR VGND sg13cmos5l_fill_2
XFILLER_64_238 VPWR VGND sg13cmos5l_decap_4
XFILLER_17_110 VPWR VGND sg13cmos5l_decap_4
XFILLER_205_211 VPWR VGND sg13cmos5l_fill_2
XFILLER_205_255 VPWR VGND sg13cmos5l_fill_1
XFILLER_17_176 VPWR VGND sg13cmos5l_decap_8
XANTENNA__0672__A1 AXIL_S_SOC_BREADY VPWR VGND sg13cmos5l_antennanp
XFILLER_32_146 VPWR VGND sg13cmos5l_fill_2
XFILLER_32_135 VPWR VGND sg13cmos5l_decap_8
X_0951_ _2369_/A _0950_/X _0948_/X _1656_/Q VPWR VGND sg13cmos5l_mux2_1
XFILLER_32_179 VPWR VGND sg13cmos5l_decap_8
X_0882_ _2454_/A AXIL_S_SOC_WSTRB3 _0801_/X AXIL_S_SOC_AWADDR2 _0755_/X _1314_/Q _1315_/Q
+ VPWR VGND sg13cmos5l_mux4_1
XFILLER_185_162 VPWR VGND sg13cmos5l_decap_4
XANTENNA__1607__GATE Tile_X0Y3_FrameStrobe[5] VPWR VGND sg13cmos5l_antennanp
XANTENNA__1618__D Tile_X0Y1_FrameData[17] VPWR VGND sg13cmos5l_antennanp
X_2552_ Tile_X0Y3_FrameData_O[10] Tile_X0Y3_FrameData[10] VPWR VGND sg13cmos5l_buf_1
XFILLER_99_102 VPWR VGND sg13cmos5l_decap_8
XANTENNA__0727__A2 Tile_X0Y0_W2MID[1] VPWR VGND sg13cmos5l_antennanp
X_1503_ _1503_/Q Tile_X0Y1_FrameData[4] Tile_X0Y3_FrameStrobe[1] VPWR VGND sg13cmos5l_dlhq_1
X_2483_ Tile_X0Y0_E2BEG[1] _2483_/A VPWR VGND sg13cmos5l_buf_1
XFILLER_141_265 VPWR VGND sg13cmos5l_decap_8
X_1434_ _1434_/Q Tile_X0Y0_FrameData[17] Tile_X0Y3_FrameStrobe[7] VPWR VGND sg13cmos5l_dlhq_1
XANTENNA__1353__D Tile_X0Y0_FrameData[2] VPWR VGND sg13cmos5l_antennanp
XANTENNA__2586__X Tile_X0Y3_S2BEGb[0] VPWR VGND sg13cmos5l_antennanp
X_1365_ _1365_/Q Tile_X0Y0_FrameData[22] Tile_X0Y3_FrameStrobe[5] VPWR VGND sg13cmos5l_dlhq_1
X_1296_ _1296_/Q Tile_X0Y0_FrameData[27] Tile_X0Y3_FrameStrobe[3] VPWR VGND sg13cmos5l_dlhq_1
XFILLER_102_27 VPWR VGND sg13cmos5l_fill_2
XANTENNA__2184__D Tile_X0Y3_FrameData[11] VPWR VGND sg13cmos5l_antennanp
XANTENNA__0663__A1 AXIL_S_SOC_ARADDR9 VPWR VGND sg13cmos5l_antennanp
XFILLER_63_293 VPWR VGND sg13cmos5l_fill_2
XFILLER_211_247 VPWR VGND sg13cmos5l_decap_8
XFILLER_109_218 VPWR VGND sg13cmos5l_decap_8
XFILLER_127_9 VPWR VGND sg13cmos5l_fill_2
XFILLER_176_162 VPWR VGND sg13cmos5l_decap_8
XANTENNA__1528__D Tile_X0Y1_FrameData[11] VPWR VGND sg13cmos5l_antennanp
XFILLER_11_13 VPWR VGND sg13cmos5l_decap_4
XFILLER_191_121 VPWR VGND sg13cmos5l_decap_8
XFILLER_191_165 VPWR VGND sg13cmos5l_decap_4
XANTENNA__0718__A2 Tile_X0Y3_W6END[7] VPWR VGND sg13cmos5l_antennanp
XFILLER_191_198 VPWR VGND sg13cmos5l_decap_8
XFILLER_127_79 VPWR VGND sg13cmos5l_decap_4
XANTENNA__1263__D Tile_X0Y0_FrameData[28] VPWR VGND sg13cmos5l_antennanp
XANTENNA__2496__X Tile_X0Y3_E1BEG[2] VPWR VGND sg13cmos5l_antennanp
XFILLER_98_190 VPWR VGND sg13cmos5l_decap_8
XFILLER_100_140 VPWR VGND sg13cmos5l_decap_8
XFILLER_14_113 VPWR VGND sg13cmos5l_decap_8
XFILLER_54_260 VPWR VGND sg13cmos5l_decap_4
XFILLER_199_210 VPWR VGND sg13cmos5l_fill_1
XANTENNA__0654__A1 Tile_X0Y0_W2END[2] VPWR VGND sg13cmos5l_antennanp
XANTENNA__2094__D Tile_X0Y3_FrameData[5] VPWR VGND sg13cmos5l_antennanp
XFILLER_153_2 VPWR VGND sg13cmos5l_fill_1
XFILLER_54_293 VPWR VGND sg13cmos5l_fill_2
XFILLER_199_276 VPWR VGND sg13cmos5l_decap_4
XFILLER_199_265 VPWR VGND sg13cmos5l_decap_4
XFILLER_159_118 VPWR VGND sg13cmos5l_decap_8
XFILLER_139_0 VPWR VGND sg13cmos5l_fill_2
XANTENNA__1438__D Tile_X0Y0_FrameData[13] VPWR VGND sg13cmos5l_antennanp
XANTENNA__0709__A2 Tile_X0Y1_W6END[4] VPWR VGND sg13cmos5l_antennanp
XANTENNA__1593__GATE Tile_X0Y3_FrameStrobe[4] VPWR VGND sg13cmos5l_antennanp
XFILLER_123_243 VPWR VGND sg13cmos5l_fill_1
XANTENNA__0590__A0 Tile_X0Y3_N2MID[4] VPWR VGND sg13cmos5l_antennanp
XFILLER_96_116 VPWR VGND sg13cmos5l_decap_8
XFILLER_77_72 VPWR VGND sg13cmos5l_fill_2
X_1150_ _1151_/B _1103_/X _1097_/A _1870_/Q VPWR VGND sg13cmos5l_mux2_1
XANTENNA__0893__A1 Tile_X0Y0_W2END[7] VPWR VGND sg13cmos5l_antennanp
XANTENNA__1901__D Tile_X0Y2_FrameData[14] VPWR VGND sg13cmos5l_antennanp
X_1081_ _2283_/A AXIL_S_SOC_WDATA3 AXIL_S_SOC_WDATA11 _0746_/X _0742_/X _1853_/Q _1852_/Q
+ VPWR VGND sg13cmos5l_mux4_1
XANTENNA__1531__GATE Tile_X0Y3_FrameStrobe[2] VPWR VGND sg13cmos5l_antennanp
XANTENNA__0645__A1 Tile_X0Y2_W2END[6] VPWR VGND sg13cmos5l_antennanp
X_1983_ _1983_/Q Tile_X0Y3_FrameData[20] Tile_X0Y3_FrameStrobe[1] VPWR VGND sg13cmos5l_dlhq_1
XANTENNA__1546__GATE Tile_X0Y3_FrameStrobe[3] VPWR VGND sg13cmos5l_antennanp
X_0934_ _0934_/X _0933_/X _0932_/A _0465_/X _0867_/X _1661_/Q _1660_/Q VPWR VGND sg13cmos5l_mux4_1
XANTENNA__1348__D Tile_X0Y0_FrameData[7] VPWR VGND sg13cmos5l_antennanp
X_0865_ _0865_/X _0734_/X _0731_/X _0730_/X Tile_X0Y0_S2MID[5] _1457_/Q _1456_/Q VPWR
+ VGND sg13cmos5l_mux4_1
XFILLER_9_194 VPWR VGND sg13cmos5l_decap_8
XFILLER_173_110 VPWR VGND sg13cmos5l_decap_8
X_2604_ Tile_X0Y3_S4BEG[10] _2604_/A VPWR VGND sg13cmos5l_buf_1
X_0796_ _0796_/X _0771_/X Tile_X0Y0_S1END[3] Tile_X0Y3_N4END[15] Tile_X0Y0_S4END[3]
+ _1228_/Q _1229_/Q VPWR VGND sg13cmos5l_mux4_1
XFILLER_54_0 VPWR VGND sg13cmos5l_fill_2
X_2535_ Tile_X0Y3_EE4BEG[9] _2535_/A VPWR VGND sg13cmos5l_buf_1
XANTENNA__0581__A0 Tile_X0Y3_W2MID[7] VPWR VGND sg13cmos5l_antennanp
X_2466_ Tile_X0Y0_E6BEG[4] _2466_/A VPWR VGND sg13cmos5l_buf_1
XANTENNA__2179__D Tile_X0Y3_FrameData[16] VPWR VGND sg13cmos5l_antennanp
X_1417_ _1417_/Q Tile_X0Y0_FrameData[2] Tile_X0Y3_FrameStrobe[6] VPWR VGND sg13cmos5l_dlhq_1
XFILLER_87_138 VPWR VGND sg13cmos5l_decap_8
X_2397_ Tile_X0Y0_FrameStrobe_O[3] Tile_X0Y3_FrameStrobe[3] VPWR VGND sg13cmos5l_buf_1
X_1348_ _1348_/Q Tile_X0Y0_FrameData[7] Tile_X0Y3_FrameStrobe[4] VPWR VGND sg13cmos5l_dlhq_1
XANTENNA__0884__A1 AXIL_S_SOC_AWADDR8 VPWR VGND sg13cmos5l_antennanp
XANTENNA__1811__D Tile_X0Y2_FrameData[8] VPWR VGND sg13cmos5l_antennanp
X_1279_ _1279_/Q Tile_X0Y0_FrameData[12] Tile_X0Y3_FrameStrobe[2] VPWR VGND sg13cmos5l_dlhq_1
XFILLER_43_219 VPWR VGND sg13cmos5l_fill_1
XFILLER_36_271 VPWR VGND sg13cmos5l_decap_8
XFILLER_189_19 VPWR VGND sg13cmos5l_fill_1
XANTENNA__0636__A1 Tile_X0Y3_W2END[3] VPWR VGND sg13cmos5l_antennanp
XFILLER_36_293 VPWR VGND sg13cmos5l_fill_2
XFILLER_36_282 VPWR VGND sg13cmos5l_fill_2
XFILLER_51_241 VPWR VGND sg13cmos5l_fill_1
XANTENNA__1061__A1 Tile_X0Y2_W6END[8] VPWR VGND sg13cmos5l_antennanp
XANTENNA__1258__D Tile_X0Y0_FrameData[1] VPWR VGND sg13cmos5l_antennanp
XFILLER_138_12 VPWR VGND sg13cmos5l_decap_4
XFILLER_164_110 VPWR VGND sg13cmos5l_fill_2
XFILLER_22_45 VPWR VGND sg13cmos5l_decap_8
XFILLER_164_154 VPWR VGND sg13cmos5l_fill_2
XFILLER_164_187 VPWR VGND sg13cmos5l_decap_8
XFILLER_98_38 VPWR VGND sg13cmos5l_fill_1
XFILLER_98_27 VPWR VGND sg13cmos5l_fill_1
XANTENNA__2089__D Tile_X0Y3_FrameData[10] VPWR VGND sg13cmos5l_antennanp
XFILLER_154_66 VPWR VGND sg13cmos5l_fill_1
XANTENNA__1116__A2 Tile_X0Y0_S4END[10] VPWR VGND sg13cmos5l_antennanp
XFILLER_170_21 VPWR VGND sg13cmos5l_fill_2
XANTENNA__0875__A1 AXIL_S_SOC_AWADDR9 VPWR VGND sg13cmos5l_antennanp
XANTENNA__1721__D Tile_X0Y2_FrameData[2] VPWR VGND sg13cmos5l_antennanp
XFILLER_170_98 VPWR VGND sg13cmos5l_decap_8
XFILLER_27_282 VPWR VGND sg13cmos5l_fill_2
XFILLER_63_52 VPWR VGND sg13cmos5l_decap_8
XFILLER_179_41 VPWR VGND sg13cmos5l_fill_2
XFILLER_10_171 VPWR VGND sg13cmos5l_fill_2
XFILLER_155_165 VPWR VGND sg13cmos5l_decap_8
XFILLER_6_142 VPWR VGND sg13cmos5l_fill_1
X_0650_ _2496_/A Tile_X0Y3_N1END[2] _0569_/B _0649_/X AXIL_S_SOC_ARADDR0 _2111_/Q
+ _2110_/Q VPWR VGND sg13cmos5l_mux4_1
X_0581_ _2578_/A Tile_X0Y3_W2MID[7] Tile_X0Y3_W2END[7] Tile_X0Y3_W6END[8] _0580_/A
+ _2143_/Q _2142_/Q VPWR VGND sg13cmos5l_mux4_1
X_2320_ Tile_X0Y2_EE4BEG[12] _2320_/A VPWR VGND sg13cmos5l_buf_1
XFILLER_111_213 VPWR VGND sg13cmos5l_decap_4
X_2251_ Tile_X0Y1_FrameData_O[8] Tile_X0Y1_FrameData[8] VPWR VGND sg13cmos5l_buf_1
X_1202_ _1202_/Q Tile_X0Y0_FrameData[25] Tile_X0Y3_FrameStrobe[0] VPWR VGND sg13cmos5l_dlhq_1
XFILLER_214_47 VPWR VGND sg13cmos5l_fill_2
X_2182_ _2182_/Q Tile_X0Y3_FrameData[13] Tile_X0Y3_FrameStrobe[7] VPWR VGND sg13cmos5l_dlhq_1
XANTENNA__1631__D Tile_X0Y1_FrameData[4] VPWR VGND sg13cmos5l_antennanp
X_1133_ _1134_/C _1878_/Q _1133_/B _1133_/C VPWR VGND sg13cmos5l_nor3_1
XFILLER_92_141 VPWR VGND sg13cmos5l_decap_8
XANTENNA__1470__GATE Tile_X0Y3_FrameStrobe[0] VPWR VGND sg13cmos5l_antennanp
X_1064_ _1065_/C Tile_X0Y2_W1END[0] _1915_/Q VPWR VGND sg13cmos5l_nor2_1
XANTENNA__1485__GATE Tile_X0Y3_FrameStrobe[1] VPWR VGND sg13cmos5l_antennanp
X_1966_ _1966_/Q Tile_X0Y3_FrameData[5] Tile_X0Y3_FrameStrobe[0] VPWR VGND sg13cmos5l_dlhq_1
XFILLER_193_205 VPWR VGND sg13cmos5l_decap_8
XFILLER_178_279 VPWR VGND sg13cmos5l_decap_4
XANTENNA__1043__A1 Tile_X0Y2_W6END[9] VPWR VGND sg13cmos5l_antennanp
X_0917_ _0918_/B _1667_/Q _0914_/Y _0916_/Y VPWR VGND sg13cmos5l_a21oi_1
X_1897_ _1897_/Q Tile_X0Y2_FrameData[18] Tile_X0Y3_FrameStrobe[6] VPWR VGND sg13cmos5l_dlhq_1
XFILLER_146_198 VPWR VGND sg13cmos5l_decap_8
X_0848_ _2478_/A AXIL_S_SOC_WSTRB3 AXIL_S_SOC_AWADDR6 _0712_/X _0739_/X _1339_/Q _1338_/Q
+ VPWR VGND sg13cmos5l_mux4_1
XANTENNA__1806__D Tile_X0Y2_FrameData[13] VPWR VGND sg13cmos5l_antennanp
XFILLER_161_146 VPWR VGND sg13cmos5l_fill_2
X_0779_ _0779_/Y _0776_/S _0438_/Y _1415_/Q VPWR VGND sg13cmos5l_a21oi_1
X_2518_ Tile_X0Y3_E6BEG[4] _2518_/A VPWR VGND sg13cmos5l_buf_1
XANTENNA__1423__GATE Tile_X0Y3_FrameStrobe[7] VPWR VGND sg13cmos5l_antennanp
X_2449_ Tile_X0Y0_EE4BEG[3] _2449_/A VPWR VGND sg13cmos5l_buf_1
XANTENNA__0857__A1 AXIL_S_SOC_AWADDR8 VPWR VGND sg13cmos5l_antennanp
XANTENNA__1438__GATE Tile_X0Y3_FrameStrobe[7] VPWR VGND sg13cmos5l_antennanp
XANTENNA__1541__D Tile_X0Y1_FrameData[30] VPWR VGND sg13cmos5l_antennanp
XFILLER_110_290 VPWR VGND sg13cmos5l_decap_4
XFILLER_83_174 VPWR VGND sg13cmos5l_decap_4
XFILLER_216_136 VPWR VGND sg13cmos5l_decap_8
XFILLER_17_67 VPWR VGND sg13cmos5l_fill_1
XFILLER_140_68 VPWR VGND sg13cmos5l_decap_8
XFILLER_169_246 VPWR VGND sg13cmos5l_decap_8
XFILLER_33_11 VPWR VGND sg13cmos5l_fill_2
XFILLER_149_11 VPWR VGND sg13cmos5l_decap_8
XFILLER_184_238 VPWR VGND sg13cmos5l_fill_1
XFILLER_184_227 VPWR VGND sg13cmos5l_decap_8
XFILLER_137_154 VPWR VGND sg13cmos5l_decap_8
XFILLER_149_99 VPWR VGND sg13cmos5l_decap_8
XANTENNA__1716__D Tile_X0Y2_FrameData[7] VPWR VGND sg13cmos5l_antennanp
XFILLER_165_43 VPWR VGND sg13cmos5l_decap_4
XFILLER_152_168 VPWR VGND sg13cmos5l_decap_8
XFILLER_165_76 VPWR VGND sg13cmos5l_fill_1
XFILLER_3_145 VPWR VGND sg13cmos5l_decap_4
XANTENNA__2397__A Tile_X0Y3_FrameStrobe[3] VPWR VGND sg13cmos5l_antennanp
XFILLER_181_42 VPWR VGND sg13cmos5l_decap_8
XFILLER_181_31 VPWR VGND sg13cmos5l_fill_1
XFILLER_66_119 VPWR VGND sg13cmos5l_fill_1
XANTENNA__0848__A1 AXIL_S_SOC_AWADDR6 VPWR VGND sg13cmos5l_antennanp
XANTENNA__1451__D Tile_X0Y1_FrameData[24] VPWR VGND sg13cmos5l_antennanp
X_1820_ _1820_/Q Tile_X0Y2_FrameData[31] Tile_X0Y3_FrameStrobe[4] VPWR VGND sg13cmos5l_dlhq_1
XFILLER_90_72 VPWR VGND sg13cmos5l_decap_8
XFILLER_175_205 VPWR VGND sg13cmos5l_decap_4
XANTENNA__1025__A1 AXIL_S_SOC_WDATA25 VPWR VGND sg13cmos5l_antennanp
XFILLER_30_277 VPWR VGND sg13cmos5l_decap_4
X_1751_ _1751_/Q Tile_X0Y2_FrameData[4] Tile_X0Y3_FrameStrobe[1] VPWR VGND sg13cmos5l_dlhq_1
X_1682_ _1682_/Q Tile_X0Y1_FrameData[17] Tile_X0Y3_FrameStrobe[7] VPWR VGND sg13cmos5l_dlhq_1
X_0702_ AXIL_S_SOC_RDATA1 Tile_X0Y3_W2MID[5] Tile_X0Y3_W2END[5] Tile_X0Y3_W6END[5]
+ _0594_/X _2009_/Q _2008_/Q VPWR VGND sg13cmos5l_mux4_1
XANTENNA__1626__D Tile_X0Y1_FrameData[9] VPWR VGND sg13cmos5l_antennanp
X_0633_ _0633_/Y _0629_/Y _0632_/Y _0627_/Y VPWR VGND sg13cmos5l_o21ai_1
XFILLER_183_293 VPWR VGND sg13cmos5l_fill_2
XANTENNA__0536__A0 Tile_X0Y3_N1END[0] VPWR VGND sg13cmos5l_antennanp
X_2303_ Tile_X0Y2_E6BEG[7] _2303_/A VPWR VGND sg13cmos5l_buf_1
X_0564_ _0564_/Y _1945_/Q _0564_/B _1944_/Q VPWR VGND sg13cmos5l_nand3b_1
XFILLER_97_233 VPWR VGND sg13cmos5l_decap_8
XANTENNA__2153__GATE Tile_X0Y3_FrameStrobe[6] VPWR VGND sg13cmos5l_antennanp
X_0495_ _0497_/B Tile_X0Y1_W6END[3] _1445_/Q VPWR VGND sg13cmos5l_nor2b_1
X_2234_ Tile_X0Y1_EE4BEG[7] _2234_/A VPWR VGND sg13cmos5l_buf_1
XANTENNA__0839__A1 AXIL_S_SOC_AWADDR2 VPWR VGND sg13cmos5l_antennanp
XANTENNA__1361__D Tile_X0Y0_FrameData[26] VPWR VGND sg13cmos5l_antennanp
XANTENNA__2594__X Tile_X0Y3_S4BEG[0] VPWR VGND sg13cmos5l_antennanp
X_2165_ _2165_/Q Tile_X0Y3_FrameData[30] Tile_X0Y3_FrameStrobe[7] VPWR VGND sg13cmos5l_dlhq_1
XFILLER_17_0 VPWR VGND sg13cmos5l_fill_2
XANTENNA__2168__GATE Tile_X0Y3_FrameStrobe[7] VPWR VGND sg13cmos5l_antennanp
X_1116_ _2298_/A Tile_X0Y3_N4END[6] _1051_/A Tile_X0Y0_S4END[10] _0554_/X _1790_/Q
+ _1791_/Q VPWR VGND sg13cmos5l_mux4_1
XFILLER_80_100 VPWR VGND sg13cmos5l_fill_2
XFILLER_65_163 VPWR VGND sg13cmos5l_fill_1
X_2096_ _2096_/Q Tile_X0Y3_FrameData[3] Tile_X0Y3_FrameStrobe[4] VPWR VGND sg13cmos5l_dlhq_1
XFILLER_213_117 VPWR VGND sg13cmos5l_decap_8
XANTENNA__1003__X AXIL_S_SOC_RDATA20 VPWR VGND sg13cmos5l_antennanp
X_1047_ _1048_/C _1911_/Q _1047_/B _1047_/C VPWR VGND sg13cmos5l_nor3_1
XFILLER_80_166 VPWR VGND sg13cmos5l_decap_8
XFILLER_213_128 VPWR VGND sg13cmos5l_decap_8
XANTENNA__2192__D Tile_X0Y3_FrameData[5] VPWR VGND sg13cmos5l_antennanp
XANTENNA__1016__A1 Tile_X0Y1_W6END[11] VPWR VGND sg13cmos5l_antennanp
XFILLER_166_227 VPWR VGND sg13cmos5l_decap_4
XFILLER_21_277 VPWR VGND sg13cmos5l_decap_4
XFILLER_119_154 VPWR VGND sg13cmos5l_decap_8
X_1949_ _1949_/Q Tile_X0Y3_FrameData[22] Tile_X0Y3_FrameStrobe[0] VPWR VGND sg13cmos5l_dlhq_1
XANTENNA__2106__GATE Tile_X0Y3_FrameStrobe[5] VPWR VGND sg13cmos5l_antennanp
XANTENNA__1536__D Tile_X0Y1_FrameData[3] VPWR VGND sg13cmos5l_antennanp
XFILLER_102_8 VPWR VGND sg13cmos5l_decap_4
XFILLER_119_198 VPWR VGND sg13cmos5l_decap_8
XFILLER_174_293 VPWR VGND sg13cmos5l_fill_2
XANTENNA__1362__GATE Tile_X0Y3_FrameStrobe[5] VPWR VGND sg13cmos5l_antennanp
XANTENNA__1992__GATE Tile_X0Y3_FrameStrobe[1] VPWR VGND sg13cmos5l_antennanp
XFILLER_135_68 VPWR VGND sg13cmos5l_fill_2
XANTENNA__0542__A3 Tile_X0Y0_S4END[1] VPWR VGND sg13cmos5l_antennanp
XANTENNA__1377__GATE Tile_X0Y3_FrameStrobe[5] VPWR VGND sg13cmos5l_antennanp
XANTENNA__1271__D Tile_X0Y0_FrameData[20] VPWR VGND sg13cmos5l_antennanp
XFILLER_28_44 VPWR VGND sg13cmos5l_decap_8
XFILLER_151_56 VPWR VGND sg13cmos5l_decap_8
XFILLER_28_77 VPWR VGND sg13cmos5l_decap_8
XANTENNA__1300__GATE Tile_X0Y3_FrameStrobe[3] VPWR VGND sg13cmos5l_antennanp
XANTENNA__1930__GATE Tile_X0Y3_FrameStrobe[7] VPWR VGND sg13cmos5l_antennanp
XFILLER_71_155 VPWR VGND sg13cmos5l_decap_8
XFILLER_44_54 VPWR VGND sg13cmos5l_decap_8
XFILLER_212_183 VPWR VGND sg13cmos5l_decap_8
XANTENNA__1007__A1 Tile_X0Y1_W2END[2] VPWR VGND sg13cmos5l_antennanp
XANTENNA__1315__GATE Tile_X0Y3_FrameStrobe[3] VPWR VGND sg13cmos5l_antennanp
XANTENNA__1945__GATE Tile_X0Y3_FrameStrobe[0] VPWR VGND sg13cmos5l_antennanp
XFILLER_121_0 VPWR VGND sg13cmos5l_fill_2
XFILLER_8_259 VPWR VGND sg13cmos5l_decap_8
XFILLER_165_282 VPWR VGND sg13cmos5l_decap_4
XFILLER_219_0 VPWR VGND sg13cmos5l_fill_2
XANTENNA__1446__D Tile_X0Y1_FrameData[29] VPWR VGND sg13cmos5l_antennanp
XFILLER_125_124 VPWR VGND sg13cmos5l_fill_1
XFILLER_125_146 VPWR VGND sg13cmos5l_decap_4
XFILLER_180_230 VPWR VGND sg13cmos5l_decap_8
XFILLER_69_51 VPWR VGND sg13cmos5l_decap_8
XANTENNA__1191__A0 Tile_X0Y3_W1END[0] VPWR VGND sg13cmos5l_antennanp
XFILLER_62_122 VPWR VGND sg13cmos5l_fill_1
XFILLER_62_111 VPWR VGND sg13cmos5l_decap_8
XFILLER_211_48 VPWR VGND sg13cmos5l_fill_1
XFILLER_62_199 VPWR VGND sg13cmos5l_fill_1
XFILLER_148_216 VPWR VGND sg13cmos5l_decap_8
XFILLER_203_194 VPWR VGND sg13cmos5l_fill_2
X_1803_ _1803_/Q Tile_X0Y2_FrameData[16] Tile_X0Y3_FrameStrobe[3] VPWR VGND sg13cmos5l_dlhq_1
XANTENNA__0757__A0 Tile_X0Y3_W2MID[0] VPWR VGND sg13cmos5l_antennanp
X_1734_ _1734_/Q Tile_X0Y2_FrameData[21] Tile_X0Y3_FrameStrobe[1] VPWR VGND sg13cmos5l_dlhq_1
XANTENNA__2589__X Tile_X0Y3_S2BEGb[3] VPWR VGND sg13cmos5l_antennanp
XFILLER_156_293 VPWR VGND sg13cmos5l_fill_2
XANTENNA__0772__A3 Tile_X0Y0_S4END[1] VPWR VGND sg13cmos5l_antennanp
XANTENNA__1356__D Tile_X0Y0_FrameData[31] VPWR VGND sg13cmos5l_antennanp
XFILLER_116_168 VPWR VGND sg13cmos5l_decap_4
X_1665_ _1665_/Q Tile_X0Y1_FrameData[2] Tile_X0Y3_FrameStrobe[6] VPWR VGND sg13cmos5l_dlhq_1
XANTENNA__0509__A0 Tile_X0Y2_W2MID[4] VPWR VGND sg13cmos5l_antennanp
XANTENNA__2092__GATE Tile_X0Y3_FrameStrobe[4] VPWR VGND sg13cmos5l_antennanp
X_1596_ _1596_/Q Tile_X0Y1_FrameData[7] Tile_X0Y3_FrameStrobe[4] VPWR VGND sg13cmos5l_dlhq_1
X_0616_ _0616_/X Tile_X0Y3_N1END[1] Tile_X0Y3_N4END[1] _0564_/B Tile_X0Y0_S4END[13]
+ _1993_/Q _1992_/Q VPWR VGND sg13cmos5l_mux4_1
XANTENNA__1182__A0 Tile_X0Y2_W2MID[0] VPWR VGND sg13cmos5l_antennanp
X_0547_ _0547_/X _0871_/X _0546_/X Tile_X0Y3_N4END[9] Tile_X0Y0_S4END[5] _1472_/Q
+ _1473_/Q VPWR VGND sg13cmos5l_mux4_1
XANTENNA__2187__D Tile_X0Y3_FrameData[8] VPWR VGND sg13cmos5l_antennanp
X_2217_ Tile_X0Y1_E6BEG[2] _2217_/A VPWR VGND sg13cmos5l_buf_1
X_0478_ _0478_/X Tile_X0Y3_N1END[2] Tile_X0Y3_N4END[2] _0569_/B Tile_X0Y0_S4END[14]
+ _1983_/Q _1982_/Q VPWR VGND sg13cmos5l_mux4_1
X_2148_ _2148_/Q Tile_X0Y3_FrameData[15] Tile_X0Y3_FrameStrobe[6] VPWR VGND sg13cmos5l_dlhq_1
XFILLER_38_185 VPWR VGND sg13cmos5l_decap_8
XANTENNA__2030__GATE Tile_X0Y3_FrameStrobe[2] VPWR VGND sg13cmos5l_antennanp
X_2079_ _2079_/Q Tile_X0Y3_FrameData[20] Tile_X0Y3_FrameStrobe[4] VPWR VGND sg13cmos5l_dlhq_1
XFILLER_198_105 VPWR VGND sg13cmos5l_fill_1
XFILLER_14_24 VPWR VGND sg13cmos5l_fill_2
XANTENNA__0996__A0 Tile_X0Y3_N4END[11] VPWR VGND sg13cmos5l_antennanp
XANTENNA__2045__GATE Tile_X0Y3_FrameStrobe[3] VPWR VGND sg13cmos5l_antennanp
XANTENNA__0748__A0 Tile_X0Y0_W2MID[4] VPWR VGND sg13cmos5l_antennanp
XANTENNA__2499__X Tile_X0Y3_E2BEG[1] VPWR VGND sg13cmos5l_antennanp
XFILLER_107_146 VPWR VGND sg13cmos5l_decap_4
XFILLER_146_12 VPWR VGND sg13cmos5l_fill_2
XFILLER_147_282 VPWR VGND sg13cmos5l_fill_2
XFILLER_147_293 VPWR VGND sg13cmos5l_fill_2
XANTENNA__1266__D Tile_X0Y0_FrameData[25] VPWR VGND sg13cmos5l_antennanp
XFILLER_162_263 VPWR VGND sg13cmos5l_decap_4
XFILLER_122_138 VPWR VGND sg13cmos5l_decap_4
XFILLER_146_78 VPWR VGND sg13cmos5l_fill_1
XANTENNA__1173__A0 Tile_X0Y2_W2MID[6] VPWR VGND sg13cmos5l_antennanp
XFILLER_39_32 VPWR VGND sg13cmos5l_decap_8
XFILLER_130_160 VPWR VGND sg13cmos5l_decap_8
XFILLER_76_225 VPWR VGND sg13cmos5l_fill_1
XFILLER_39_43 VPWR VGND sg13cmos5l_fill_1
XANTENNA__2097__D Tile_X0Y3_FrameData[2] VPWR VGND sg13cmos5l_antennanp
XFILLER_55_42 VPWR VGND sg13cmos5l_decap_4
XFILLER_169_0 VPWR VGND sg13cmos5l_fill_2
XFILLER_55_86 VPWR VGND sg13cmos5l_decap_8
XANTENNA__1254__GATE Tile_X0Y3_FrameStrobe[1] VPWR VGND sg13cmos5l_antennanp
XANTENNA__1884__GATE Tile_X0Y3_FrameStrobe[6] VPWR VGND sg13cmos5l_antennanp
XFILLER_138_271 VPWR VGND sg13cmos5l_decap_8
XFILLER_200_175 VPWR VGND sg13cmos5l_decap_8
XANTENNA__1269__GATE Tile_X0Y3_FrameStrobe[2] VPWR VGND sg13cmos5l_antennanp
XFILLER_138_282 VPWR VGND sg13cmos5l_fill_2
XFILLER_138_293 VPWR VGND sg13cmos5l_fill_2
XANTENNA__1899__GATE Tile_X0Y3_FrameStrobe[6] VPWR VGND sg13cmos5l_antennanp
XANTENNA__2202__X Tile_X0Y1_E2BEG[3] VPWR VGND sg13cmos5l_antennanp
XFILLER_113_127 VPWR VGND sg13cmos5l_fill_1
XFILLER_153_285 VPWR VGND sg13cmos5l_fill_2
X_1450_ _1450_/Q Tile_X0Y1_FrameData[25] Tile_X0Y3_FrameStrobe[0] VPWR VGND sg13cmos5l_dlhq_1
XFILLER_4_273 VPWR VGND sg13cmos5l_fill_1
XANTENNA__1904__D Tile_X0Y2_FrameData[11] VPWR VGND sg13cmos5l_antennanp
XFILLER_106_190 VPWR VGND sg13cmos5l_fill_1
X_1381_ _1381_/Q Tile_X0Y0_FrameData[6] Tile_X0Y3_FrameStrobe[5] VPWR VGND sg13cmos5l_dlhq_1
XFILLER_206_48 VPWR VGND sg13cmos5l_fill_1
XFILLER_206_26 VPWR VGND sg13cmos5l_decap_4
XANTENNA__0506__A3 Tile_X0Y0_S4END[15] VPWR VGND sg13cmos5l_antennanp
XANTENNA__1822__GATE Tile_X0Y3_FrameStrobe[4] VPWR VGND sg13cmos5l_antennanp
XFILLER_96_60 VPWR VGND sg13cmos5l_decap_8
XANTENNA__1207__GATE Tile_X0Y3_FrameStrobe[0] VPWR VGND sg13cmos5l_antennanp
XFILLER_222_25 VPWR VGND sg13cmos5l_decap_4
XANTENNA__1837__GATE Tile_X0Y3_FrameStrobe[4] VPWR VGND sg13cmos5l_antennanp
X_2002_ _2002_/Q Tile_X0Y3_FrameData[1] Tile_X0Y3_FrameStrobe[1] VPWR VGND sg13cmos5l_dlhq_1
XFILLER_222_47 VPWR VGND sg13cmos5l_decap_4
XFILLER_208_264 VPWR VGND sg13cmos5l_decap_8
XFILLER_90_272 VPWR VGND sg13cmos5l_decap_8
XFILLER_35_177 VPWR VGND sg13cmos5l_decap_8
XFILLER_84_0 VPWR VGND sg13cmos5l_decap_4
XFILLER_144_241 VPWR VGND sg13cmos5l_fill_1
XFILLER_144_252 VPWR VGND sg13cmos5l_decap_8
X_1717_ _1717_/Q Tile_X0Y2_FrameData[6] Tile_X0Y3_FrameStrobe[0] VPWR VGND sg13cmos5l_dlhq_1
X_1648_ _1648_/Q Tile_X0Y1_FrameData[19] Tile_X0Y3_FrameStrobe[6] VPWR VGND sg13cmos5l_dlhq_1
XANTENNA__1814__D Tile_X0Y2_FrameData[5] VPWR VGND sg13cmos5l_antennanp
X_1579_ _1579_/Q Tile_X0Y1_FrameData[24] Tile_X0Y3_FrameStrobe[4] VPWR VGND sg13cmos5l_dlhq_1
XANTENNA__0902__A0 Tile_X0Y0_W2MID[3] VPWR VGND sg13cmos5l_antennanp
XFILLER_58_258 VPWR VGND sg13cmos5l_decap_8
XFILLER_41_103 VPWR VGND sg13cmos5l_decap_4
XFILLER_26_166 VPWR VGND sg13cmos5l_decap_8
XFILLER_214_267 VPWR VGND sg13cmos5l_decap_4
XFILLER_212_80 VPWR VGND sg13cmos5l_decap_8
XFILLER_25_78 VPWR VGND sg13cmos5l_decap_8
XFILLER_186_119 VPWR VGND sg13cmos5l_decap_8
XFILLER_179_193 VPWR VGND sg13cmos5l_fill_2
XFILLER_157_77 VPWR VGND sg13cmos5l_decap_4
XANTENNA__0736__A3 Tile_X0Y0_S2END[5] VPWR VGND sg13cmos5l_antennanp
XFILLER_1_232 VPWR VGND sg13cmos5l_fill_1
XANTENNA__1724__D Tile_X0Y2_FrameData[31] VPWR VGND sg13cmos5l_antennanp
XFILLER_110_108 VPWR VGND sg13cmos5l_fill_1
XFILLER_49_258 VPWR VGND sg13cmos5l_decap_4
XFILLER_66_74 VPWR VGND sg13cmos5l_decap_4
XFILLER_64_217 VPWR VGND sg13cmos5l_decap_8
XFILLER_57_280 VPWR VGND sg13cmos5l_fill_1
XFILLER_17_133 VPWR VGND sg13cmos5l_decap_8
XFILLER_205_234 VPWR VGND sg13cmos5l_fill_2
XFILLER_82_84 VPWR VGND sg13cmos5l_decap_8
XFILLER_72_283 VPWR VGND sg13cmos5l_fill_1
X_0950_ _0950_/X Tile_X0Y1_W1END[3] Tile_X0Y1_WW4END[3] Tile_X0Y1_W6END[11] _0949_/X
+ _1658_/Q _1657_/Q VPWR VGND sg13cmos5l_mux4_1
XFILLER_198_84 VPWR VGND sg13cmos5l_decap_8
X_0881_ _2455_/A AXIL_S_SOC_AWVALID AXIL_S_SOC_AWADDR3 _0786_/X _0751_/X _1313_/Q
+ _1312_/Q VPWR VGND sg13cmos5l_mux4_1
X_2551_ Tile_X0Y3_FrameData_O[9] Tile_X0Y3_FrameData[9] VPWR VGND sg13cmos5l_buf_1
X_1502_ _1502_/Q Tile_X0Y1_FrameData[5] Tile_X0Y3_FrameStrobe[1] VPWR VGND sg13cmos5l_dlhq_1
X_2482_ Tile_X0Y0_E2BEG[0] _2482_/A VPWR VGND sg13cmos5l_buf_1
XANTENNA__1761__GATE Tile_X0Y3_FrameStrobe[2] VPWR VGND sg13cmos5l_antennanp
XFILLER_141_244 VPWR VGND sg13cmos5l_decap_8
X_1433_ _1433_/Q Tile_X0Y0_FrameData[18] Tile_X0Y3_FrameStrobe[7] VPWR VGND sg13cmos5l_dlhq_1
XFILLER_99_147 VPWR VGND sg13cmos5l_decap_8
XANTENNA__1634__D Tile_X0Y1_FrameData[1] VPWR VGND sg13cmos5l_antennanp
X_1364_ _1364_/Q Tile_X0Y0_FrameData[23] Tile_X0Y3_FrameStrobe[5] VPWR VGND sg13cmos5l_dlhq_1
XANTENNA__1776__GATE Tile_X0Y3_FrameStrobe[2] VPWR VGND sg13cmos5l_antennanp
X_1295_ _1295_/Q Tile_X0Y0_FrameData[28] Tile_X0Y3_FrameStrobe[3] VPWR VGND sg13cmos5l_dlhq_1
XFILLER_48_280 VPWR VGND sg13cmos5l_fill_1
XANTENNA__1011__X AXIL_S_SOC_RDATA27 VPWR VGND sg13cmos5l_antennanp
XFILLER_176_141 VPWR VGND sg13cmos5l_decap_8
XANTENNA__1714__GATE Tile_X0Y3_FrameStrobe[0] VPWR VGND sg13cmos5l_antennanp
XANTENNA__1809__D Tile_X0Y2_FrameData[10] VPWR VGND sg13cmos5l_antennanp
XFILLER_127_14 VPWR VGND sg13cmos5l_decap_4
XFILLER_117_274 VPWR VGND sg13cmos5l_decap_8
XANTENNA__1729__GATE Tile_X0Y3_FrameStrobe[1] VPWR VGND sg13cmos5l_antennanp
XANTENNA__1544__D Tile_X0Y1_FrameData[27] VPWR VGND sg13cmos5l_antennanp
XFILLER_132_277 VPWR VGND sg13cmos5l_fill_2
XFILLER_143_13 VPWR VGND sg13cmos5l_decap_8
XFILLER_160_4 VPWR VGND sg13cmos5l_fill_1
XFILLER_54_250 VPWR VGND sg13cmos5l_decap_4
XANTENNA__0654__A2 Tile_X0Y0_W6END[2] VPWR VGND sg13cmos5l_antennanp
XFILLER_54_283 VPWR VGND sg13cmos5l_fill_1
XANTENNA__0473__A Tile_X0Y2_W6END[2] VPWR VGND sg13cmos5l_antennanp
XFILLER_14_169 VPWR VGND sg13cmos5l_decap_4
XFILLER_52_10 VPWR VGND sg13cmos5l_fill_1
XFILLER_202_248 VPWR VGND sg13cmos5l_fill_2
XANTENNA__1719__D Tile_X0Y2_FrameData[4] VPWR VGND sg13cmos5l_antennanp
XFILLER_167_174 VPWR VGND sg13cmos5l_decap_8
XFILLER_108_274 VPWR VGND sg13cmos5l_decap_4
XFILLER_123_200 VPWR VGND sg13cmos5l_decap_4
XFILLER_201_0 VPWR VGND sg13cmos5l_fill_1
XFILLER_184_86 VPWR VGND sg13cmos5l_decap_8
XANTENNA__0590__A1 Tile_X0Y3_N2END[4] VPWR VGND sg13cmos5l_antennanp
XANTENNA__1119__A0 Tile_X0Y3_N4END[7] VPWR VGND sg13cmos5l_antennanp
XANTENNA__1454__D Tile_X0Y1_FrameData[21] VPWR VGND sg13cmos5l_antennanp
XFILLER_77_62 VPWR VGND sg13cmos5l_fill_2
XFILLER_77_51 VPWR VGND sg13cmos5l_fill_2
XANTENNA__0893__A2 Tile_X0Y0_W6END[7] VPWR VGND sg13cmos5l_antennanp
X_1080_ _2284_/A AXIL_S_SOC_WDATA4 AXIL_S_SOC_WDATA12 _0746_/X _0742_/X _1851_/Q _1850_/Q
+ VPWR VGND sg13cmos5l_mux4_1
XFILLER_93_50 VPWR VGND sg13cmos5l_fill_2
XANTENNA__0645__A2 Tile_X0Y2_W6END[6] VPWR VGND sg13cmos5l_antennanp
XFILLER_93_94 VPWR VGND sg13cmos5l_fill_1
XFILLER_45_294 VPWR VGND sg13cmos5l_fill_1
XFILLER_45_283 VPWR VGND sg13cmos5l_decap_4
X_1982_ _1982_/Q Tile_X0Y3_FrameData[21] Tile_X0Y3_FrameStrobe[1] VPWR VGND sg13cmos5l_dlhq_1
XFILLER_60_275 VPWR VGND sg13cmos5l_decap_8
XANTENNA__1629__D Tile_X0Y1_FrameData[6] VPWR VGND sg13cmos5l_antennanp
X_0933_ _0933_/X _0860_/X _0466_/B Tile_X0Y3_N4END[10] Tile_X0Y0_S4END[6] _1486_/Q
+ _1487_/Q VPWR VGND sg13cmos5l_mux4_1
X_0864_ _0864_/X _0645_/X _0713_/X _0714_/X Tile_X0Y0_S2MID[1] _1464_/Q _1465_/Q VPWR
+ VGND sg13cmos5l_mux4_1
X_2603_ Tile_X0Y3_S4BEG[9] _2603_/A VPWR VGND sg13cmos5l_buf_1
X_2534_ Tile_X0Y3_EE4BEG[8] _2534_/A VPWR VGND sg13cmos5l_buf_1
X_0795_ _0795_/Y _0443_/Y _0712_/X _1409_/Q VPWR VGND sg13cmos5l_o21ai_1
XFILLER_173_199 VPWR VGND sg13cmos5l_decap_8
XFILLER_114_222 VPWR VGND sg13cmos5l_decap_8
XFILLER_114_233 VPWR VGND sg13cmos5l_fill_2
XFILLER_47_0 VPWR VGND sg13cmos5l_fill_2
XANTENNA__0581__A1 Tile_X0Y3_W2END[7] VPWR VGND sg13cmos5l_antennanp
XANTENNA__1364__D Tile_X0Y0_FrameData[23] VPWR VGND sg13cmos5l_antennanp
XANTENNA__2597__X Tile_X0Y3_S4BEG[3] VPWR VGND sg13cmos5l_antennanp
X_2465_ Tile_X0Y0_E6BEG[3] _2465_/A VPWR VGND sg13cmos5l_buf_1
X_1416_ _1416_/Q Tile_X0Y0_FrameData[3] Tile_X0Y3_FrameStrobe[6] VPWR VGND sg13cmos5l_dlhq_1
X_2396_ Tile_X0Y0_FrameStrobe_O[2] Tile_X0Y3_FrameStrobe[2] VPWR VGND sg13cmos5l_buf_1
XFILLER_87_128 VPWR VGND sg13cmos5l_decap_8
X_1347_ _1347_/Q Tile_X0Y0_FrameData[8] Tile_X0Y3_FrameStrobe[4] VPWR VGND sg13cmos5l_dlhq_1
XFILLER_113_49 VPWR VGND sg13cmos5l_fill_2
X_1278_ _1278_/Q Tile_X0Y0_FrameData[13] Tile_X0Y3_FrameStrobe[2] VPWR VGND sg13cmos5l_dlhq_1
XFILLER_36_250 VPWR VGND sg13cmos5l_decap_8
XANTENNA__0636__A2 Tile_X0Y3_W6END[3] VPWR VGND sg13cmos5l_antennanp
XANTENNA__1653__GATE Tile_X0Y3_FrameStrobe[6] VPWR VGND sg13cmos5l_antennanp
XFILLER_149_130 VPWR VGND sg13cmos5l_decap_8
XFILLER_196_236 VPWR VGND sg13cmos5l_fill_1
XANTENNA__1539__D Tile_X0Y1_FrameData[0] VPWR VGND sg13cmos5l_antennanp
XFILLER_149_141 VPWR VGND sg13cmos5l_fill_2
XFILLER_22_24 VPWR VGND sg13cmos5l_decap_8
XFILLER_164_100 VPWR VGND sg13cmos5l_fill_1
XFILLER_138_57 VPWR VGND sg13cmos5l_decap_8
XFILLER_138_68 VPWR VGND sg13cmos5l_fill_2
XANTENNA__1668__GATE Tile_X0Y3_FrameStrobe[7] VPWR VGND sg13cmos5l_antennanp
XFILLER_105_233 VPWR VGND sg13cmos5l_decap_8
XANTENNA__1274__D Tile_X0Y0_FrameData[17] VPWR VGND sg13cmos5l_antennanp
XFILLER_154_23 VPWR VGND sg13cmos5l_decap_4
XFILLER_154_34 VPWR VGND sg13cmos5l_decap_4
XFILLER_78_117 VPWR VGND sg13cmos5l_decap_8
XANTENNA__2300__X Tile_X0Y2_E6BEG[4] VPWR VGND sg13cmos5l_antennanp
XFILLER_154_56 VPWR VGND sg13cmos5l_fill_1
XFILLER_219_101 VPWR VGND sg13cmos5l_decap_4
XFILLER_86_172 VPWR VGND sg13cmos5l_fill_2
XFILLER_19_206 VPWR VGND sg13cmos5l_fill_1
XANTENNA__1606__GATE Tile_X0Y3_FrameStrobe[5] VPWR VGND sg13cmos5l_antennanp
XFILLER_170_77 VPWR VGND sg13cmos5l_decap_8
XFILLER_42_220 VPWR VGND sg13cmos5l_decap_4
XFILLER_27_294 VPWR VGND sg13cmos5l_fill_1
XFILLER_151_0 VPWR VGND sg13cmos5l_fill_2
XFILLER_42_242 VPWR VGND sg13cmos5l_decap_8
XFILLER_8_15 VPWR VGND sg13cmos5l_decap_8
XFILLER_179_53 VPWR VGND sg13cmos5l_fill_2
XANTENNA__1449__D Tile_X0Y1_FrameData[26] VPWR VGND sg13cmos5l_antennanp
XFILLER_6_154 VPWR VGND sg13cmos5l_fill_2
X_0580_ _0580_/Y _0580_/A VPWR VGND sg13cmos5l_inv_1
XFILLER_6_198 VPWR VGND sg13cmos5l_fill_2
XANTENNA__0563__A1 Tile_X0Y3_W6END[1] VPWR VGND sg13cmos5l_antennanp
XFILLER_69_106 VPWR VGND sg13cmos5l_decap_8
XANTENNA__2210__X Tile_X0Y1_E2BEGb[3] VPWR VGND sg13cmos5l_antennanp
X_2250_ Tile_X0Y1_FrameData_O[7] Tile_X0Y1_FrameData[7] VPWR VGND sg13cmos5l_buf_1
X_1201_ _1201_/Q Tile_X0Y0_FrameData[26] Tile_X0Y3_FrameStrobe[0] VPWR VGND sg13cmos5l_dlhq_1
XANTENNA__1912__D Tile_X0Y2_FrameData[3] VPWR VGND sg13cmos5l_antennanp
X_2181_ _2181_/Q Tile_X0Y3_FrameData[14] Tile_X0Y3_FrameStrobe[7] VPWR VGND sg13cmos5l_dlhq_1
X_1132_ _1133_/C Tile_X0Y2_W1END[0] _1879_/Q VPWR VGND sg13cmos5l_nor2_1
XFILLER_92_120 VPWR VGND sg13cmos5l_decap_8
XFILLER_225_115 VPWR VGND sg13cmos5l_decap_8
XFILLER_225_104 VPWR VGND sg13cmos5l_fill_1
X_1063_ _1065_/B Tile_X0Y2_WW4END[0] _1915_/Q VPWR VGND sg13cmos5l_nor2b_1
XFILLER_18_294 VPWR VGND sg13cmos5l_fill_1
XFILLER_33_242 VPWR VGND sg13cmos5l_fill_2
XFILLER_178_258 VPWR VGND sg13cmos5l_decap_8
XANTENNA__1359__D Tile_X0Y0_FrameData[28] VPWR VGND sg13cmos5l_antennanp
X_1965_ _1965_/Q Tile_X0Y3_FrameData[6] Tile_X0Y3_FrameStrobe[0] VPWR VGND sg13cmos5l_dlhq_1
X_0916_ _0916_/Y _1667_/Q _0916_/B VPWR VGND sg13cmos5l_nor2_1
X_1896_ _1896_/Q Tile_X0Y2_FrameData[19] Tile_X0Y3_FrameStrobe[6] VPWR VGND sg13cmos5l_dlhq_1
XFILLER_146_177 VPWR VGND sg13cmos5l_decap_8
X_0847_ _2486_/A AXIL_S_SOC_WSTRB3 AXIL_S_SOC_AWADDR6 _0712_/X _0739_/X _1355_/Q _1354_/Q
+ VPWR VGND sg13cmos5l_mux4_1
X_0778_ _0778_/X _0752_/X Tile_X0Y0_S1END[1] Tile_X0Y3_N4END[13] Tile_X0Y0_S4END[1]
+ _1240_/Q _1241_/Q VPWR VGND sg13cmos5l_mux4_1
XFILLER_102_203 VPWR VGND sg13cmos5l_decap_8
X_2517_ Tile_X0Y3_E6BEG[3] _2517_/A VPWR VGND sg13cmos5l_buf_1
X_2448_ Tile_X0Y0_EE4BEG[2] _2448_/A VPWR VGND sg13cmos5l_buf_1
XANTENNA__1822__D Tile_X0Y2_FrameData[29] VPWR VGND sg13cmos5l_antennanp
X_2379_ Tile_X0Y0_N2BEGb[5] _2379_/A VPWR VGND sg13cmos5l_buf_1
XFILLER_83_120 VPWR VGND sg13cmos5l_fill_2
XFILLER_68_183 VPWR VGND sg13cmos5l_decap_8
XFILLER_17_35 VPWR VGND sg13cmos5l_decap_8
XANTENNA__1592__GATE Tile_X0Y3_FrameStrobe[4] VPWR VGND sg13cmos5l_antennanp
XFILLER_24_253 VPWR VGND sg13cmos5l_decap_8
XANTENNA__1269__D Tile_X0Y0_FrameData[22] VPWR VGND sg13cmos5l_antennanp
XANTENNA__1034__A2 AXIL_S_SOC_WDATA29 VPWR VGND sg13cmos5l_antennanp
XFILLER_149_67 VPWR VGND sg13cmos5l_fill_1
XFILLER_33_89 VPWR VGND sg13cmos5l_decap_8
XANTENNA__0793__A1 Tile_X0Y0_S1END[3] VPWR VGND sg13cmos5l_antennanp
XFILLER_152_103 VPWR VGND sg13cmos5l_fill_1
XFILLER_3_135 VPWR VGND sg13cmos5l_decap_4
XANTENNA__1530__GATE Tile_X0Y3_FrameStrobe[2] VPWR VGND sg13cmos5l_antennanp
XFILLER_3_179 VPWR VGND sg13cmos5l_decap_4
XANTENNA__1545__GATE Tile_X0Y3_FrameStrobe[3] VPWR VGND sg13cmos5l_antennanp
XANTENNA__1732__D Tile_X0Y2_FrameData[23] VPWR VGND sg13cmos5l_antennanp
XFILLER_59_150 VPWR VGND sg13cmos5l_decap_8
XFILLER_199_0 VPWR VGND sg13cmos5l_fill_2
XANTENNA__0909__A_N Tile_X0Y1_WW4END[0] VPWR VGND sg13cmos5l_antennanp
XFILLER_74_96 VPWR VGND sg13cmos5l_fill_1
XFILLER_215_170 VPWR VGND sg13cmos5l_decap_4
XFILLER_95_8 VPWR VGND sg13cmos5l_fill_1
XANTENNA__0481__A0 Tile_X0Y2_W2MID[5] VPWR VGND sg13cmos5l_antennanp
XFILLER_90_51 VPWR VGND sg13cmos5l_decap_4
XANTENNA__2205__X Tile_X0Y1_E2BEG[6] VPWR VGND sg13cmos5l_antennanp
XFILLER_128_100 VPWR VGND sg13cmos5l_decap_8
XFILLER_128_111 VPWR VGND sg13cmos5l_fill_2
X_1750_ _1750_/Q Tile_X0Y2_FrameData[5] Tile_X0Y3_FrameStrobe[1] VPWR VGND sg13cmos5l_dlhq_1
XFILLER_30_256 VPWR VGND sg13cmos5l_decap_8
X_0701_ AXIL_S_SOC_RDATA0 Tile_X0Y3_W2MID[4] Tile_X0Y3_W2END[4] Tile_X0Y3_W6END[4]
+ _0590_/X _2011_/Q _2010_/Q VPWR VGND sg13cmos5l_mux4_1
XANTENNA__0784__A1 Tile_X0Y3_N4END[14] VPWR VGND sg13cmos5l_antennanp
XANTENNA__1907__D Tile_X0Y2_FrameData[8] VPWR VGND sg13cmos5l_antennanp
XFILLER_128_166 VPWR VGND sg13cmos5l_decap_8
XFILLER_128_177 VPWR VGND sg13cmos5l_fill_1
X_1681_ _1681_/Q Tile_X0Y1_FrameData[18] Tile_X0Y3_FrameStrobe[7] VPWR VGND sg13cmos5l_dlhq_1
X_0632_ _0632_/Y _2018_/Q _0631_/Y _2194_/Q VPWR VGND sg13cmos5l_o21ai_1
X_0563_ _0563_/Y Tile_X0Y3_W6END[1] _1945_/Q _0562_/Y VPWR VGND sg13cmos5l_a21oi_1
XANTENNA__0536__A1 Tile_X0Y3_N4END[0] VPWR VGND sg13cmos5l_antennanp
X_2302_ Tile_X0Y2_E6BEG[6] _2302_/A VPWR VGND sg13cmos5l_buf_1
X_0494_ _0494_/Y _1445_/Q _1692_/Q VPWR VGND sg13cmos5l_nor2b_1
XFILLER_97_256 VPWR VGND sg13cmos5l_fill_1
XANTENNA__1642__D Tile_X0Y1_FrameData[25] VPWR VGND sg13cmos5l_antennanp
X_2233_ Tile_X0Y1_EE4BEG[6] _2233_/A VPWR VGND sg13cmos5l_buf_1
X_2164_ _2164_/Q Tile_X0Y3_FrameData[31] Tile_X0Y3_FrameStrobe[7] VPWR VGND sg13cmos5l_dlhq_1
X_1115_ _2322_/A AXIL_S_SOC_WDATA2 _1042_/A AXIL_S_SOC_WDATA14 _0715_/X _1798_/Q _1799_/Q
+ VPWR VGND sg13cmos5l_mux4_1
X_2095_ _2095_/Q Tile_X0Y3_FrameData[4] Tile_X0Y3_FrameStrobe[4] VPWR VGND sg13cmos5l_dlhq_1
XFILLER_80_123 VPWR VGND sg13cmos5l_fill_1
X_1046_ _1047_/C Tile_X0Y2_WW4END[1] _1912_/Q VPWR VGND sg13cmos5l_nor2b_1
XFILLER_80_145 VPWR VGND sg13cmos5l_decap_8
XFILLER_21_201 VPWR VGND sg13cmos5l_decap_8
XFILLER_21_234 VPWR VGND sg13cmos5l_decap_4
XANTENNA__1016__A2 Tile_X0Y1_WW4END[12] VPWR VGND sg13cmos5l_antennanp
XFILLER_119_15 VPWR VGND sg13cmos5l_fill_2
X_1948_ _1948_/Q Tile_X0Y3_FrameData[23] Tile_X0Y3_FrameStrobe[0] VPWR VGND sg13cmos5l_dlhq_1
XANTENNA__0775__A1 Tile_X0Y0_S1END[1] VPWR VGND sg13cmos5l_antennanp
XANTENNA__1817__D Tile_X0Y2_FrameData[2] VPWR VGND sg13cmos5l_antennanp
XFILLER_119_188 VPWR VGND sg13cmos5l_fill_2
XFILLER_119_48 VPWR VGND sg13cmos5l_decap_4
X_1879_ _1879_/Q Tile_X0Y2_FrameData[4] Tile_X0Y3_FrameStrobe[5] VPWR VGND sg13cmos5l_dlhq_1
XFILLER_134_136 VPWR VGND sg13cmos5l_fill_2
XFILLER_88_212 VPWR VGND sg13cmos5l_fill_2
XFILLER_88_267 VPWR VGND sg13cmos5l_fill_1
XANTENNA__1552__D Tile_X0Y1_FrameData[19] VPWR VGND sg13cmos5l_antennanp
XFILLER_28_34 VPWR VGND sg13cmos5l_fill_1
XFILLER_151_35 VPWR VGND sg13cmos5l_fill_1
XFILLER_151_46 VPWR VGND sg13cmos5l_decap_8
XFILLER_71_112 VPWR VGND sg13cmos5l_decap_4
XFILLER_204_118 VPWR VGND sg13cmos5l_decap_4
XFILLER_12_245 VPWR VGND sg13cmos5l_decap_8
XFILLER_8_205 VPWR VGND sg13cmos5l_decap_8
XANTENNA__1007__A2 Tile_X0Y1_W6END[2] VPWR VGND sg13cmos5l_antennanp
XFILLER_8_238 VPWR VGND sg13cmos5l_decap_4
XANTENNA__1727__D Tile_X0Y2_FrameData[28] VPWR VGND sg13cmos5l_antennanp
XFILLER_176_43 VPWR VGND sg13cmos5l_fill_2
XFILLER_114_0 VPWR VGND sg13cmos5l_fill_2
XFILLER_165_294 VPWR VGND sg13cmos5l_fill_1
XFILLER_109_92 VPWR VGND sg13cmos5l_fill_1
XFILLER_125_158 VPWR VGND sg13cmos5l_fill_2
XFILLER_79_212 VPWR VGND sg13cmos5l_decap_4
XANTENNA__1191__A1 Tile_X0Y3_W6END[8] VPWR VGND sg13cmos5l_antennanp
XFILLER_69_85 VPWR VGND sg13cmos5l_decap_8
XANTENNA__1462__D Tile_X0Y1_FrameData[13] VPWR VGND sg13cmos5l_antennanp
XANTENNA__1484__GATE Tile_X0Y3_FrameStrobe[1] VPWR VGND sg13cmos5l_antennanp
XFILLER_85_84 VPWR VGND sg13cmos5l_fill_1
XANTENNA__1499__GATE Tile_X0Y3_FrameStrobe[1] VPWR VGND sg13cmos5l_antennanp
XANTENNA__1422__GATE Tile_X0Y3_FrameStrobe[7] VPWR VGND sg13cmos5l_antennanp
XFILLER_203_173 VPWR VGND sg13cmos5l_decap_8
X_1802_ _1802_/Q Tile_X0Y2_FrameData[17] Tile_X0Y3_FrameStrobe[3] VPWR VGND sg13cmos5l_dlhq_1
XANTENNA__0757__A1 Tile_X0Y3_W2END[0] VPWR VGND sg13cmos5l_antennanp
XANTENNA__1637__D Tile_X0Y1_FrameData[30] VPWR VGND sg13cmos5l_antennanp
XFILLER_156_272 VPWR VGND sg13cmos5l_decap_4
X_1733_ _1733_/Q Tile_X0Y2_FrameData[22] Tile_X0Y3_FrameStrobe[1] VPWR VGND sg13cmos5l_dlhq_1
XANTENNA__1437__GATE Tile_X0Y3_FrameStrobe[7] VPWR VGND sg13cmos5l_antennanp
X_1664_ _1664_/Q Tile_X0Y1_FrameData[3] Tile_X0Y3_FrameStrobe[6] VPWR VGND sg13cmos5l_dlhq_1
XANTENNA__0509__A1 Tile_X0Y2_W2END[4] VPWR VGND sg13cmos5l_antennanp
X_1595_ _1595_/Q Tile_X0Y1_FrameData[8] Tile_X0Y3_FrameStrobe[4] VPWR VGND sg13cmos5l_dlhq_1
X_0615_ _0615_/Y _2123_/Q _0614_/X _0428_/Y VPWR VGND sg13cmos5l_a21oi_1
XANTENNA__1182__A1 Tile_X0Y2_W2END[0] VPWR VGND sg13cmos5l_antennanp
X_0546_ _0546_/X Tile_X0Y0_W1END[1] Tile_X0Y0_W6END[9] _0542_/X _0545_/Y _1405_/Q
+ _1404_/Q VPWR VGND sg13cmos5l_mux4_1
XANTENNA__1372__D Tile_X0Y0_FrameData[15] VPWR VGND sg13cmos5l_antennanp
X_0477_ _0569_/B Tile_X0Y2_W1END[2] Tile_X0Y2_W6END[10] _0471_/X _0476_/X _1899_/Q
+ _1898_/Q VPWR VGND sg13cmos5l_mux4_1
X_2216_ Tile_X0Y1_E6BEG[1] _2216_/A VPWR VGND sg13cmos5l_buf_1
XFILLER_38_164 VPWR VGND sg13cmos5l_decap_8
XANTENNA__1014__X AXIL_S_SOC_RDATA24 VPWR VGND sg13cmos5l_antennanp
X_2147_ _2147_/Q Tile_X0Y3_FrameData[16] Tile_X0Y3_FrameStrobe[6] VPWR VGND sg13cmos5l_dlhq_1
XANTENNA__0693__A0 AXIL_S_SOC_ARVALID VPWR VGND sg13cmos5l_antennanp
X_2078_ _2078_/Q Tile_X0Y3_FrameData[21] Tile_X0Y3_FrameStrobe[4] VPWR VGND sg13cmos5l_dlhq_1
X_1029_ _2241_/A AXIL_S_SOC_WDATA18 _0923_/A AXIL_S_SOC_WDATA30 _0864_/X _1550_/Q
+ _1551_/Q VPWR VGND sg13cmos5l_mux4_1
XFILLER_139_239 VPWR VGND sg13cmos5l_fill_1
XANTENNA__1547__D Tile_X0Y1_FrameData[24] VPWR VGND sg13cmos5l_antennanp
XANTENNA__0748__A1 Tile_X0Y0_W2END[4] VPWR VGND sg13cmos5l_antennanp
XFILLER_30_35 VPWR VGND sg13cmos5l_fill_2
XFILLER_30_24 VPWR VGND sg13cmos5l_fill_1
XANTENNA__1173__A1 Tile_X0Y2_W2END[6] VPWR VGND sg13cmos5l_antennanp
XANTENNA__1282__D Tile_X0Y0_FrameData[9] VPWR VGND sg13cmos5l_antennanp
XFILLER_162_67 VPWR VGND sg13cmos5l_decap_8
XFILLER_217_232 VPWR VGND sg13cmos5l_decap_4
XFILLER_29_175 VPWR VGND sg13cmos5l_fill_2
XFILLER_217_254 VPWR VGND sg13cmos5l_decap_8
XFILLER_176_2 VPWR VGND sg13cmos5l_fill_1
XANTENNA__0684__A0 AXIL_S_SOC_ARADDR2 VPWR VGND sg13cmos5l_antennanp
XFILLER_71_31 VPWR VGND sg13cmos5l_decap_8
XANTENNA__2152__GATE Tile_X0Y3_FrameStrobe[6] VPWR VGND sg13cmos5l_antennanp
XFILLER_200_132 VPWR VGND sg13cmos5l_fill_2
XFILLER_200_121 VPWR VGND sg13cmos5l_fill_2
XFILLER_197_172 VPWR VGND sg13cmos5l_fill_2
XANTENNA__1457__D Tile_X0Y1_FrameData[18] VPWR VGND sg13cmos5l_antennanp
XFILLER_138_250 VPWR VGND sg13cmos5l_decap_8
XFILLER_187_86 VPWR VGND sg13cmos5l_decap_4
XANTENNA__2167__GATE Tile_X0Y3_FrameStrobe[7] VPWR VGND sg13cmos5l_antennanp
XFILLER_153_264 VPWR VGND sg13cmos5l_fill_2
X_1380_ _1380_/Q Tile_X0Y0_FrameData[7] Tile_X0Y3_FrameStrobe[5] VPWR VGND sg13cmos5l_dlhq_1
X_2001_ _2001_/Q Tile_X0Y3_FrameData[2] Tile_X0Y3_FrameStrobe[1] VPWR VGND sg13cmos5l_dlhq_1
XFILLER_208_221 VPWR VGND sg13cmos5l_fill_2
XFILLER_208_210 VPWR VGND sg13cmos5l_decap_8
XANTENNA__1920__D Tile_X0Y2_FrameData[27] VPWR VGND sg13cmos5l_antennanp
XANTENNA__2105__GATE Tile_X0Y3_FrameStrobe[5] VPWR VGND sg13cmos5l_antennanp
XFILLER_208_243 VPWR VGND sg13cmos5l_decap_8
XFILLER_223_202 VPWR VGND sg13cmos5l_fill_1
XANTENNA__1361__GATE Tile_X0Y3_FrameStrobe[5] VPWR VGND sg13cmos5l_antennanp
XANTENNA__1991__GATE Tile_X0Y3_FrameStrobe[1] VPWR VGND sg13cmos5l_antennanp
XFILLER_223_279 VPWR VGND sg13cmos5l_fill_1
XFILLER_188_150 VPWR VGND sg13cmos5l_fill_1
XANTENNA__1367__D Tile_X0Y0_FrameData[20] VPWR VGND sg13cmos5l_antennanp
XANTENNA__1376__GATE Tile_X0Y3_FrameStrobe[5] VPWR VGND sg13cmos5l_antennanp
XFILLER_77_0 VPWR VGND sg13cmos5l_fill_2
X_1716_ _1716_/Q Tile_X0Y2_FrameData[7] Tile_X0Y3_FrameStrobe[0] VPWR VGND sg13cmos5l_dlhq_1
XANTENNA__1009__X AXIL_S_SOC_RDATA30 VPWR VGND sg13cmos5l_antennanp
XFILLER_104_106 VPWR VGND sg13cmos5l_fill_1
X_1647_ _1647_/Q Tile_X0Y1_FrameData[20] Tile_X0Y3_FrameStrobe[6] VPWR VGND sg13cmos5l_dlhq_1
XFILLER_116_16 VPWR VGND sg13cmos5l_decap_8
XFILLER_116_27 VPWR VGND sg13cmos5l_fill_2
X_1578_ _1578_/Q Tile_X0Y1_FrameData[25] Tile_X0Y3_FrameStrobe[4] VPWR VGND sg13cmos5l_dlhq_1
XANTENNA__0902__A1 Tile_X0Y0_W2END[3] VPWR VGND sg13cmos5l_antennanp
X_0529_ _0529_/X _0889_/X _0528_/X Tile_X0Y3_N4END[4] Tile_X0Y0_S4END[8] _1722_/Q
+ _1723_/Q VPWR VGND sg13cmos5l_mux4_1
XANTENNA__1314__GATE Tile_X0Y3_FrameStrobe[3] VPWR VGND sg13cmos5l_antennanp
XANTENNA__1944__GATE Tile_X0Y3_FrameStrobe[0] VPWR VGND sg13cmos5l_antennanp
XFILLER_73_207 VPWR VGND sg13cmos5l_decap_4
XANTENNA__1830__D Tile_X0Y2_FrameData[21] VPWR VGND sg13cmos5l_antennanp
XFILLER_73_229 VPWR VGND sg13cmos5l_decap_8
XFILLER_26_123 VPWR VGND sg13cmos5l_fill_1
XFILLER_214_224 VPWR VGND sg13cmos5l_decap_8
XANTENNA__1329__GATE Tile_X0Y3_FrameStrobe[4] VPWR VGND sg13cmos5l_antennanp
XANTENNA__1959__GATE Tile_X0Y3_FrameStrobe[0] VPWR VGND sg13cmos5l_antennanp
XFILLER_25_57 VPWR VGND sg13cmos5l_fill_1
XFILLER_25_46 VPWR VGND sg13cmos5l_fill_1
XFILLER_222_290 VPWR VGND sg13cmos5l_decap_4
XFILLER_179_172 VPWR VGND sg13cmos5l_decap_8
XFILLER_179_150 VPWR VGND sg13cmos5l_decap_4
XANTENNA__1091__A0 AXIL_S_SOC_WDATA5 VPWR VGND sg13cmos5l_antennanp
XFILLER_194_142 VPWR VGND sg13cmos5l_decap_8
XFILLER_41_56 VPWR VGND sg13cmos5l_decap_8
XANTENNA__1277__D Tile_X0Y0_FrameData[14] VPWR VGND sg13cmos5l_antennanp
XFILLER_157_45 VPWR VGND sg13cmos5l_fill_1
XFILLER_41_89 VPWR VGND sg13cmos5l_decap_8
XANTENNA__2303__X Tile_X0Y2_E6BEG[7] VPWR VGND sg13cmos5l_antennanp
XFILLER_135_253 VPWR VGND sg13cmos5l_decap_4
XFILLER_181_0 VPWR VGND sg13cmos5l_fill_2
XANTENNA__1740__D Tile_X0Y2_FrameData[15] VPWR VGND sg13cmos5l_antennanp
XFILLER_66_97 VPWR VGND sg13cmos5l_fill_1
XANTENNA__2091__GATE Tile_X0Y3_FrameStrobe[4] VPWR VGND sg13cmos5l_antennanp
XFILLER_220_216 VPWR VGND sg13cmos5l_decap_8
XFILLER_205_279 VPWR VGND sg13cmos5l_fill_2
XFILLER_205_268 VPWR VGND sg13cmos5l_decap_8
XFILLER_198_30 VPWR VGND sg13cmos5l_fill_1
XFILLER_213_290 VPWR VGND sg13cmos5l_decap_4
XFILLER_198_63 VPWR VGND sg13cmos5l_decap_8
XANTENNA__1082__A0 AXIL_S_SOC_WDATA2 VPWR VGND sg13cmos5l_antennanp
X_0880_ _2456_/A AXIL_S_SOC_AWADDR0 AXIL_S_SOC_AWADDR4 _0778_/X _0736_/X _1311_/Q
+ _1310_/Q VPWR VGND sg13cmos5l_mux4_1
XANTENNA__2213__X Tile_X0Y1_E2BEGb[6] VPWR VGND sg13cmos5l_antennanp
X_2550_ Tile_X0Y3_FrameData_O[8] Tile_X0Y3_FrameData[8] VPWR VGND sg13cmos5l_buf_1
XANTENNA__1915__D Tile_X0Y2_FrameData[0] VPWR VGND sg13cmos5l_antennanp
XFILLER_126_264 VPWR VGND sg13cmos5l_decap_8
X_1501_ _1501_/Q Tile_X0Y1_FrameData[6] Tile_X0Y3_FrameStrobe[1] VPWR VGND sg13cmos5l_dlhq_1
X_2481_ Tile_X0Y0_E2BEGb[7] _2481_/A VPWR VGND sg13cmos5l_buf_1
XFILLER_141_223 VPWR VGND sg13cmos5l_decap_8
X_1432_ _1432_/Q Tile_X0Y0_FrameData[19] Tile_X0Y3_FrameStrobe[7] VPWR VGND sg13cmos5l_dlhq_1
X_1363_ _1363_/Q Tile_X0Y0_FrameData[24] Tile_X0Y3_FrameStrobe[5] VPWR VGND sg13cmos5l_dlhq_1
XANTENNA__0896__A0 Tile_X0Y0_W2MID[4] VPWR VGND sg13cmos5l_antennanp
XANTENNA__2044__GATE Tile_X0Y3_FrameStrobe[3] VPWR VGND sg13cmos5l_antennanp
X_1294_ _1294_/Q Tile_X0Y0_FrameData[29] Tile_X0Y3_FrameStrobe[3] VPWR VGND sg13cmos5l_dlhq_1
XANTENNA__1650__D Tile_X0Y1_FrameData[17] VPWR VGND sg13cmos5l_antennanp
XFILLER_55_218 VPWR VGND sg13cmos5l_fill_1
XANTENNA__0648__A0 Tile_X0Y0_W2MID[1] VPWR VGND sg13cmos5l_antennanp
XFILLER_102_29 VPWR VGND sg13cmos5l_fill_1
XANTENNA__2059__GATE Tile_X0Y3_FrameStrobe[3] VPWR VGND sg13cmos5l_antennanp
XANTENNA__0820__A0 Tile_X0Y0_W1END[3] VPWR VGND sg13cmos5l_antennanp
XFILLER_11_37 VPWR VGND sg13cmos5l_decap_8
XANTENNA__1825__D Tile_X0Y2_FrameData[26] VPWR VGND sg13cmos5l_antennanp
XFILLER_117_286 VPWR VGND sg13cmos5l_fill_1
XANTENNA__1253__GATE Tile_X0Y3_FrameStrobe[1] VPWR VGND sg13cmos5l_antennanp
XFILLER_207_92 VPWR VGND sg13cmos5l_fill_1
XANTENNA__0887__A0 AXIL_S_SOC_AWADDR1 VPWR VGND sg13cmos5l_antennanp
XANTENNA__1883__GATE Tile_X0Y3_FrameStrobe[5] VPWR VGND sg13cmos5l_antennanp
XANTENNA__1560__D Tile_X0Y1_FrameData[11] VPWR VGND sg13cmos5l_antennanp
XFILLER_46_218 VPWR VGND sg13cmos5l_fill_2
XFILLER_36_12 VPWR VGND sg13cmos5l_decap_4
XANTENNA__0639__A0 Tile_X0Y3_N1END[0] VPWR VGND sg13cmos5l_antennanp
XANTENNA__1268__GATE Tile_X0Y3_FrameStrobe[2] VPWR VGND sg13cmos5l_antennanp
XFILLER_36_45 VPWR VGND sg13cmos5l_decap_4
XANTENNA__1898__GATE Tile_X0Y3_FrameStrobe[6] VPWR VGND sg13cmos5l_antennanp
XFILLER_14_148 VPWR VGND sg13cmos5l_decap_4
XFILLER_52_33 VPWR VGND sg13cmos5l_fill_2
XANTENNA__1821__GATE Tile_X0Y3_FrameStrobe[4] VPWR VGND sg13cmos5l_antennanp
XFILLER_52_99 VPWR VGND sg13cmos5l_decap_8
XFILLER_22_181 VPWR VGND sg13cmos5l_decap_8
XFILLER_210_293 VPWR VGND sg13cmos5l_fill_2
XFILLER_182_101 VPWR VGND sg13cmos5l_fill_2
XANTENNA__1206__GATE Tile_X0Y3_FrameStrobe[0] VPWR VGND sg13cmos5l_antennanp
XFILLER_108_253 VPWR VGND sg13cmos5l_decap_8
XANTENNA__1735__D Tile_X0Y2_FrameData[20] VPWR VGND sg13cmos5l_antennanp
XANTENNA__1836__GATE Tile_X0Y3_FrameStrobe[4] VPWR VGND sg13cmos5l_antennanp
XFILLER_184_32 VPWR VGND sg13cmos5l_fill_2
XFILLER_182_189 VPWR VGND sg13cmos5l_decap_8
XFILLER_184_65 VPWR VGND sg13cmos5l_decap_8
XFILLER_123_278 VPWR VGND sg13cmos5l_decap_4
XFILLER_89_192 VPWR VGND sg13cmos5l_decap_4
XFILLER_77_41 VPWR VGND sg13cmos5l_fill_1
XANTENNA__0878__A0 AXIL_S_SOC_WSTRB3 VPWR VGND sg13cmos5l_antennanp
XANTENNA__1470__D Tile_X0Y1_FrameData[5] VPWR VGND sg13cmos5l_antennanp
XANTENNA__2208__X Tile_X0Y1_E2BEGb[1] VPWR VGND sg13cmos5l_antennanp
X_1981_ _1981_/Q Tile_X0Y3_FrameData[22] Tile_X0Y3_FrameStrobe[1] VPWR VGND sg13cmos5l_dlhq_1
XANTENNA__0802__A0 Tile_X0Y0_W1END[3] VPWR VGND sg13cmos5l_antennanp
XFILLER_13_170 VPWR VGND sg13cmos5l_fill_1
X_0932_ _0932_/Y _0932_/A VPWR VGND sg13cmos5l_inv_1
XFILLER_158_186 VPWR VGND sg13cmos5l_fill_1
X_0863_ _2390_/A Tile_X0Y0_W1END[0] _0520_/A Tile_X0Y0_W6END[4] _0518_/Y _1442_/Q
+ _1443_/Q VPWR VGND sg13cmos5l_mux4_1
XFILLER_201_293 VPWR VGND sg13cmos5l_fill_2
XFILLER_201_282 VPWR VGND sg13cmos5l_fill_2
X_2602_ Tile_X0Y3_S4BEG[8] _2602_/A VPWR VGND sg13cmos5l_buf_1
XFILLER_173_145 VPWR VGND sg13cmos5l_fill_2
X_2533_ Tile_X0Y3_EE4BEG[7] _2533_/A VPWR VGND sg13cmos5l_buf_1
X_0794_ _0794_/Y _1408_/Q _0794_/B VPWR VGND sg13cmos5l_nor2_1
XFILLER_173_178 VPWR VGND sg13cmos5l_decap_8
XANTENNA__1645__D Tile_X0Y1_FrameData[22] VPWR VGND sg13cmos5l_antennanp
XANTENNA__0581__A2 Tile_X0Y3_W6END[8] VPWR VGND sg13cmos5l_antennanp
X_2464_ Tile_X0Y0_E6BEG[2] _2464_/A VPWR VGND sg13cmos5l_buf_1
X_1415_ _1415_/Q Tile_X0Y0_FrameData[4] Tile_X0Y3_FrameStrobe[6] VPWR VGND sg13cmos5l_dlhq_1
X_2395_ Tile_X0Y0_FrameStrobe_O[1] Tile_X0Y3_FrameStrobe[1] VPWR VGND sg13cmos5l_buf_1
X_1346_ _1346_/Q Tile_X0Y0_FrameData[9] Tile_X0Y3_FrameStrobe[4] VPWR VGND sg13cmos5l_dlhq_1
XANTENNA__1380__D Tile_X0Y0_FrameData[7] VPWR VGND sg13cmos5l_antennanp
XFILLER_113_17 VPWR VGND sg13cmos5l_decap_4
X_1277_ _1277_/Q Tile_X0Y0_FrameData[14] Tile_X0Y3_FrameStrobe[2] VPWR VGND sg13cmos5l_dlhq_1
XFILLER_51_221 VPWR VGND sg13cmos5l_fill_1
XFILLER_22_14 VPWR VGND sg13cmos5l_decap_4
XFILLER_164_112 VPWR VGND sg13cmos5l_fill_1
XFILLER_164_123 VPWR VGND sg13cmos5l_fill_1
XANTENNA__1555__D Tile_X0Y1_FrameData[16] VPWR VGND sg13cmos5l_antennanp
XFILLER_105_212 VPWR VGND sg13cmos5l_decap_4
XFILLER_120_215 VPWR VGND sg13cmos5l_decap_8
XFILLER_47_11 VPWR VGND sg13cmos5l_decap_4
XFILLER_170_12 VPWR VGND sg13cmos5l_decap_4
XANTENNA__1290__D Tile_X0Y0_FrameData[1] VPWR VGND sg13cmos5l_antennanp
XFILLER_170_34 VPWR VGND sg13cmos5l_fill_1
XFILLER_103_61 VPWR VGND sg13cmos5l_fill_1
XFILLER_103_94 VPWR VGND sg13cmos5l_fill_1
XANTENNA__1760__GATE Tile_X0Y3_FrameStrobe[2] VPWR VGND sg13cmos5l_antennanp
XANTENNA__1037__A0 AXIL_S_SOC_WDATA22 VPWR VGND sg13cmos5l_antennanp
XFILLER_187_237 VPWR VGND sg13cmos5l_fill_1
XFILLER_179_87 VPWR VGND sg13cmos5l_decap_8
XFILLER_155_112 VPWR VGND sg13cmos5l_fill_1
XFILLER_195_281 VPWR VGND sg13cmos5l_fill_2
XANTENNA__1775__GATE Tile_X0Y3_FrameStrobe[2] VPWR VGND sg13cmos5l_antennanp
XFILLER_10_173 VPWR VGND sg13cmos5l_fill_1
XFILLER_195_292 VPWR VGND sg13cmos5l_fill_2
XFILLER_155_189 VPWR VGND sg13cmos5l_decap_8
XFILLER_6_177 VPWR VGND sg13cmos5l_decap_8
XANTENNA__1465__D Tile_X0Y1_FrameData[10] VPWR VGND sg13cmos5l_antennanp
XFILLER_40_8 VPWR VGND sg13cmos5l_decap_8
X_1200_ _1200_/Q Tile_X0Y0_FrameData[27] Tile_X0Y3_FrameStrobe[0] VPWR VGND sg13cmos5l_dlhq_1
X_2180_ _2180_/Q Tile_X0Y3_FrameData[15] Tile_X0Y3_FrameStrobe[7] VPWR VGND sg13cmos5l_dlhq_1
XANTENNA__0866__A3 Tile_X0Y0_S2MID[6] VPWR VGND sg13cmos5l_antennanp
XANTENNA__1713__GATE Tile_X0Y3_FrameStrobe[0] VPWR VGND sg13cmos5l_antennanp
X_1131_ _1133_/B Tile_X0Y2_WW4END[12] _1879_/Q VPWR VGND sg13cmos5l_nor2b_1
X_1062_ _1066_/B _1915_/Q _1060_/Y _1061_/Y VPWR VGND sg13cmos5l_a21oi_1
XFILLER_92_187 VPWR VGND sg13cmos5l_decap_8
XANTENNA__1728__GATE Tile_X0Y3_FrameStrobe[1] VPWR VGND sg13cmos5l_antennanp
XFILLER_178_215 VPWR VGND sg13cmos5l_fill_1
XFILLER_178_204 VPWR VGND sg13cmos5l_decap_8
XANTENNA__1028__A0 AXIL_S_SOC_WDATA19 VPWR VGND sg13cmos5l_antennanp
XFILLER_33_276 VPWR VGND sg13cmos5l_decap_8
X_1964_ _1964_/Q Tile_X0Y3_FrameData[7] Tile_X0Y3_FrameStrobe[0] VPWR VGND sg13cmos5l_dlhq_1
X_0915_ _0916_/B _0870_/X _0521_/X Tile_X0Y3_N4END[8] Tile_X0Y0_S4END[4] _1490_/Q
+ _1491_/Q VPWR VGND sg13cmos5l_mux4_1
XFILLER_186_281 VPWR VGND sg13cmos5l_fill_1
XFILLER_146_156 VPWR VGND sg13cmos5l_decap_8
X_1895_ _1895_/Q Tile_X0Y2_FrameData[20] Tile_X0Y3_FrameStrobe[6] VPWR VGND sg13cmos5l_dlhq_1
X_0846_ _2487_/A AXIL_S_SOC_AWVALID AXIL_S_SOC_AWADDR7 _0653_/X _0736_/X _1353_/Q
+ _1352_/Q VPWR VGND sg13cmos5l_mux4_1
XANTENNA__1375__D Tile_X0Y0_FrameData[12] VPWR VGND sg13cmos5l_antennanp
X_0777_ _0777_/Y _1415_/Q _0776_/X _0435_/Y VPWR VGND sg13cmos5l_a21oi_1
XANTENNA__2401__X Tile_X0Y0_FrameStrobe_O[7] VPWR VGND sg13cmos5l_antennanp
X_2516_ Tile_X0Y3_E6BEG[2] _2516_/A VPWR VGND sg13cmos5l_buf_1
XANTENNA__0554__A2 Tile_X0Y3_N4END[5] VPWR VGND sg13cmos5l_antennanp
X_2447_ Tile_X0Y0_EE4BEG[1] _2447_/A VPWR VGND sg13cmos5l_buf_1
X_2378_ Tile_X0Y0_N2BEGb[4] _2378_/A VPWR VGND sg13cmos5l_buf_1
XFILLER_68_162 VPWR VGND sg13cmos5l_decap_8
X_1329_ _1329_/Q Tile_X0Y0_FrameData[26] Tile_X0Y3_FrameStrobe[4] VPWR VGND sg13cmos5l_dlhq_1
XFILLER_216_116 VPWR VGND sg13cmos5l_fill_1
XANTENNA__1019__A0 AXIL_S_SOC_WDATA21 VPWR VGND sg13cmos5l_antennanp
XFILLER_169_226 VPWR VGND sg13cmos5l_fill_2
XFILLER_33_46 VPWR VGND sg13cmos5l_decap_4
XANTENNA__0793__A2 Tile_X0Y3_N4END[15] VPWR VGND sg13cmos5l_antennanp
XFILLER_116_4 VPWR VGND sg13cmos5l_fill_1
XFILLER_165_12 VPWR VGND sg13cmos5l_decap_4
XANTENNA__1285__D Tile_X0Y0_FrameData[6] VPWR VGND sg13cmos5l_antennanp
XFILLER_152_137 VPWR VGND sg13cmos5l_decap_8
XANTENNA__2311__X Tile_X0Y2_EE4BEG[3] VPWR VGND sg13cmos5l_antennanp
XFILLER_160_170 VPWR VGND sg13cmos5l_fill_1
XFILLER_160_192 VPWR VGND sg13cmos5l_decap_4
XFILLER_181_11 VPWR VGND sg13cmos5l_decap_4
XFILLER_101_281 VPWR VGND sg13cmos5l_fill_2
XFILLER_101_292 VPWR VGND sg13cmos5l_fill_2
XFILLER_74_132 VPWR VGND sg13cmos5l_decap_4
XFILLER_181_77 VPWR VGND sg13cmos5l_decap_8
XFILLER_74_31 VPWR VGND sg13cmos5l_decap_8
XFILLER_207_127 VPWR VGND sg13cmos5l_decap_8
XFILLER_15_232 VPWR VGND sg13cmos5l_decap_8
XFILLER_222_119 VPWR VGND sg13cmos5l_decap_4
XFILLER_130_81 VPWR VGND sg13cmos5l_decap_8
XFILLER_215_193 VPWR VGND sg13cmos5l_decap_8
XANTENNA__0481__A1 Tile_X0Y2_W2END[5] VPWR VGND sg13cmos5l_antennanp
XFILLER_30_235 VPWR VGND sg13cmos5l_decap_8
X_0700_ _2525_/A AXIL_S_SOC_RREADY _0605_/X _0607_/X _0602_/X _2020_/Q _2021_/Q VPWR
+ VGND sg13cmos5l_mux4_1
XANTENNA__0784__A2 Tile_X0Y0_S1END[2] VPWR VGND sg13cmos5l_antennanp
X_1680_ _1680_/Q Tile_X0Y1_FrameData[19] Tile_X0Y3_FrameStrobe[7] VPWR VGND sg13cmos5l_dlhq_1
XFILLER_209_38 VPWR VGND sg13cmos5l_fill_2
XFILLER_183_262 VPWR VGND sg13cmos5l_fill_1
X_0631_ _0631_/Y Tile_X0Y3_W2END[0] _2019_/Q _0630_/Y VPWR VGND sg13cmos5l_a21oi_1
XANTENNA__2221__X Tile_X0Y1_E6BEG[6] VPWR VGND sg13cmos5l_antennanp
X_0562_ _0562_/Y _1945_/Q Tile_X0Y3_N1END[1] VPWR VGND sg13cmos5l_nor2b_1
XFILLER_151_170 VPWR VGND sg13cmos5l_decap_8
X_2301_ Tile_X0Y2_E6BEG[5] _2301_/A VPWR VGND sg13cmos5l_buf_1
XANTENNA__1923__D Tile_X0Y2_FrameData[24] VPWR VGND sg13cmos5l_antennanp
X_0493_ _0493_/X _0858_/X _0492_/X Tile_X0Y3_N4END[11] Tile_X0Y0_S4END[7] _1468_/Q
+ _1469_/Q VPWR VGND sg13cmos5l_mux4_1
XFILLER_97_268 VPWR VGND sg13cmos5l_decap_8
XFILLER_31_4 VPWR VGND sg13cmos5l_fill_1
XANTENNA__1652__GATE Tile_X0Y3_FrameStrobe[6] VPWR VGND sg13cmos5l_antennanp
X_2232_ Tile_X0Y1_EE4BEG[5] _2232_/A VPWR VGND sg13cmos5l_buf_1
X_2163_ _2163_/Q Tile_X0Y3_FrameData[0] Tile_X0Y3_FrameStrobe[6] VPWR VGND sg13cmos5l_dlhq_1
X_1114_ _2319_/A AXIL_S_SOC_WDATA7 _1069_/X AXIL_S_SOC_WDATA11 _0742_/X _1804_/Q _1805_/Q
+ VPWR VGND sg13cmos5l_mux4_1
XFILLER_65_143 VPWR VGND sg13cmos5l_fill_1
XANTENNA__1667__GATE Tile_X0Y3_FrameStrobe[6] VPWR VGND sg13cmos5l_antennanp
X_2094_ _2094_/Q Tile_X0Y3_FrameData[5] Tile_X0Y3_FrameStrobe[4] VPWR VGND sg13cmos5l_dlhq_1
XFILLER_0_72 VPWR VGND sg13cmos5l_decap_8
XFILLER_0_83 VPWR VGND sg13cmos5l_fill_2
X_1045_ _1047_/B Tile_X0Y2_W1END[1] _1912_/Q VPWR VGND sg13cmos5l_nor2_1
XFILLER_206_160 VPWR VGND sg13cmos5l_fill_2
XFILLER_221_130 VPWR VGND sg13cmos5l_fill_1
XFILLER_166_207 VPWR VGND sg13cmos5l_fill_2
X_1947_ _1947_/Q Tile_X0Y3_FrameData[24] Tile_X0Y3_FrameStrobe[0] VPWR VGND sg13cmos5l_dlhq_1
XFILLER_9_92 VPWR VGND sg13cmos5l_decap_8
XANTENNA__0775__A2 Tile_X0Y3_N4END[13] VPWR VGND sg13cmos5l_antennanp
X_1878_ _1878_/Q Tile_X0Y2_FrameData[5] Tile_X0Y3_FrameStrobe[5] VPWR VGND sg13cmos5l_dlhq_1
XANTENNA__1605__GATE Tile_X0Y3_FrameStrobe[5] VPWR VGND sg13cmos5l_antennanp
XFILLER_134_115 VPWR VGND sg13cmos5l_decap_4
X_0829_ _0829_/Y _0828_/S _0441_/Y _1376_/Q VPWR VGND sg13cmos5l_a21oi_1
XFILLER_134_159 VPWR VGND sg13cmos5l_decap_4
XFILLER_0_106 VPWR VGND sg13cmos5l_decap_8
XFILLER_135_15 VPWR VGND sg13cmos5l_decap_4
XANTENNA__1833__D Tile_X0Y2_FrameData[18] VPWR VGND sg13cmos5l_antennanp
XFILLER_0_128 VPWR VGND sg13cmos5l_decap_4
XFILLER_56_143 VPWR VGND sg13cmos5l_fill_2
XFILLER_56_187 VPWR VGND sg13cmos5l_fill_2
XANTENNA__2306__X Tile_X0Y2_E6BEG[10] VPWR VGND sg13cmos5l_antennanp
XFILLER_12_279 VPWR VGND sg13cmos5l_fill_2
XFILLER_157_229 VPWR VGND sg13cmos5l_decap_8
XFILLER_60_44 VPWR VGND sg13cmos5l_decap_8
XFILLER_176_55 VPWR VGND sg13cmos5l_fill_2
XFILLER_176_88 VPWR VGND sg13cmos5l_decap_8
XFILLER_107_0 VPWR VGND sg13cmos5l_fill_2
XFILLER_69_31 VPWR VGND sg13cmos5l_fill_2
XANTENNA__1191__A2 Tile_X0Y3_WW4END[0] VPWR VGND sg13cmos5l_antennanp
XANTENNA__1743__D Tile_X0Y2_FrameData[12] VPWR VGND sg13cmos5l_antennanp
XFILLER_192_98 VPWR VGND sg13cmos5l_fill_1
XFILLER_94_249 VPWR VGND sg13cmos5l_fill_2
XFILLER_87_290 VPWR VGND sg13cmos5l_decap_4
XFILLER_85_30 VPWR VGND sg13cmos5l_fill_1
XFILLER_47_121 VPWR VGND sg13cmos5l_fill_1
XFILLER_47_110 VPWR VGND sg13cmos5l_decap_8
XFILLER_141_80 VPWR VGND sg13cmos5l_decap_8
XFILLER_211_39 VPWR VGND sg13cmos5l_fill_1
XFILLER_18_90 VPWR VGND sg13cmos5l_decap_8
XANTENNA__2216__X Tile_X0Y1_E6BEG[1] VPWR VGND sg13cmos5l_antennanp
XFILLER_203_152 VPWR VGND sg13cmos5l_decap_8
X_1801_ _1801_/Q Tile_X0Y2_FrameData[18] Tile_X0Y3_FrameStrobe[3] VPWR VGND sg13cmos5l_dlhq_1
XANTENNA__1918__D Tile_X0Y2_FrameData[29] VPWR VGND sg13cmos5l_antennanp
X_1732_ _1732_/Q Tile_X0Y2_FrameData[23] Tile_X0Y3_FrameStrobe[1] VPWR VGND sg13cmos5l_dlhq_1
XANTENNA__0757__A2 Tile_X0Y3_W6END[0] VPWR VGND sg13cmos5l_antennanp
X_1663_ _1663_/Q Tile_X0Y1_FrameData[4] Tile_X0Y3_FrameStrobe[6] VPWR VGND sg13cmos5l_dlhq_1
XFILLER_171_254 VPWR VGND sg13cmos5l_fill_2
X_0614_ _0614_/X _0561_/X _0594_/X _2124_/Q VPWR VGND sg13cmos5l_mux2_1
XFILLER_7_294 VPWR VGND sg13cmos5l_fill_1
XANTENNA__0509__A2 Tile_X0Y2_W6END[11] VPWR VGND sg13cmos5l_antennanp
XFILLER_131_107 VPWR VGND sg13cmos5l_fill_1
XFILLER_131_129 VPWR VGND sg13cmos5l_decap_8
X_1594_ _1594_/Q Tile_X0Y1_FrameData[9] Tile_X0Y3_FrameStrobe[4] VPWR VGND sg13cmos5l_dlhq_1
XANTENNA__1182__A2 Tile_X0Y2_W6END[0] VPWR VGND sg13cmos5l_antennanp
XANTENNA__1591__GATE Tile_X0Y3_FrameStrobe[4] VPWR VGND sg13cmos5l_antennanp
XANTENNA__1653__D Tile_X0Y1_FrameData[14] VPWR VGND sg13cmos5l_antennanp
X_0545_ _0545_/Y _0434_/Y _1200_/Q _1201_/Q _0543_/Y _0544_/Y VPWR VGND sg13cmos5l_a221oi_1
X_0476_ _0476_/X _0470_/X _0472_/Y _0475_/Y VPWR VGND sg13cmos5l_a21o_1
XFILLER_22_0 VPWR VGND sg13cmos5l_decap_8
X_2215_ Tile_X0Y1_E6BEG[0] _2215_/A VPWR VGND sg13cmos5l_buf_1
XFILLER_38_132 VPWR VGND sg13cmos5l_fill_1
X_2146_ _2146_/Q Tile_X0Y3_FrameData[17] Tile_X0Y3_FrameStrobe[6] VPWR VGND sg13cmos5l_dlhq_1
XFILLER_93_271 VPWR VGND sg13cmos5l_decap_4
X_2077_ _2077_/Q Tile_X0Y3_FrameData[22] Tile_X0Y3_FrameStrobe[4] VPWR VGND sg13cmos5l_dlhq_1
XFILLER_93_293 VPWR VGND sg13cmos5l_fill_2
X_1028_ _2242_/A AXIL_S_SOC_WDATA19 AXIL_S_SOC_WDATA31 _0906_/A _0859_/X _1549_/Q
+ _1548_/Q VPWR VGND sg13cmos5l_mux4_1
XANTENNA__0996__A2 Tile_X0Y0_S4END[7] VPWR VGND sg13cmos5l_antennanp
XFILLER_61_190 VPWR VGND sg13cmos5l_decap_8
XANTENNA__1828__D Tile_X0Y2_FrameData[23] VPWR VGND sg13cmos5l_antennanp
XANTENNA__1544__GATE Tile_X0Y3_FrameStrobe[3] VPWR VGND sg13cmos5l_antennanp
XFILLER_5_209 VPWR VGND sg13cmos5l_decap_8
XANTENNA__0748__A2 Tile_X0Y0_W6END[4] VPWR VGND sg13cmos5l_antennanp
XFILLER_107_104 VPWR VGND sg13cmos5l_fill_1
XFILLER_122_118 VPWR VGND sg13cmos5l_fill_2
XANTENNA__1559__GATE Tile_X0Y3_FrameStrobe[3] VPWR VGND sg13cmos5l_antennanp
XANTENNA__1563__D Tile_X0Y1_FrameData[8] VPWR VGND sg13cmos5l_antennanp
XFILLER_115_181 VPWR VGND sg13cmos5l_decap_8
XFILLER_115_192 VPWR VGND sg13cmos5l_fill_1
XANTENNA__1173__A2 Tile_X0Y2_W6END[6] VPWR VGND sg13cmos5l_antennanp
XFILLER_76_216 VPWR VGND sg13cmos5l_decap_8
XFILLER_130_184 VPWR VGND sg13cmos5l_decap_8
XFILLER_69_290 VPWR VGND sg13cmos5l_decap_4
XFILLER_29_154 VPWR VGND sg13cmos5l_decap_4
XFILLER_183_4 VPWR VGND sg13cmos5l_fill_2
XFILLER_91_219 VPWR VGND sg13cmos5l_decap_8
XFILLER_84_282 VPWR VGND sg13cmos5l_decap_4
XANTENNA__0684__A1 AXIL_S_SOC_ARADDR6 VPWR VGND sg13cmos5l_antennanp
XFILLER_217_277 VPWR VGND sg13cmos5l_fill_1
XFILLER_44_179 VPWR VGND sg13cmos5l_decap_8
XFILLER_189_129 VPWR VGND sg13cmos5l_decap_4
XFILLER_71_21 VPWR VGND sg13cmos5l_decap_8
XFILLER_111_94 VPWR VGND sg13cmos5l_fill_2
XFILLER_71_65 VPWR VGND sg13cmos5l_fill_2
XANTENNA__1738__D Tile_X0Y2_FrameData[17] VPWR VGND sg13cmos5l_antennanp
XFILLER_224_0 VPWR VGND sg13cmos5l_fill_2
XANTENNA__0739__A2 Tile_X0Y0_S2MID[4] VPWR VGND sg13cmos5l_antennanp
XFILLER_153_243 VPWR VGND sg13cmos5l_decap_8
XANTENNA__1473__D Tile_X0Y1_FrameData[2] VPWR VGND sg13cmos5l_antennanp
X_2000_ _2000_/Q Tile_X0Y3_FrameData[3] Tile_X0Y3_FrameStrobe[1] VPWR VGND sg13cmos5l_dlhq_1
XFILLER_75_293 VPWR VGND sg13cmos5l_fill_2
XFILLER_223_225 VPWR VGND sg13cmos5l_decap_8
XFILLER_223_236 VPWR VGND sg13cmos5l_fill_1
XFILLER_50_116 VPWR VGND sg13cmos5l_decap_8
XFILLER_43_190 VPWR VGND sg13cmos5l_fill_1
XANTENNA__1648__D Tile_X0Y1_FrameData[19] VPWR VGND sg13cmos5l_antennanp
X_1715_ _1715_/Q Tile_X0Y2_FrameData[8] Tile_X0Y3_FrameStrobe[0] VPWR VGND sg13cmos5l_dlhq_1
X_1646_ _1646_/Q Tile_X0Y1_FrameData[21] Tile_X0Y3_FrameStrobe[6] VPWR VGND sg13cmos5l_dlhq_1
XANTENNA__1383__D Tile_X0Y0_FrameData[4] VPWR VGND sg13cmos5l_antennanp
XFILLER_116_39 VPWR VGND sg13cmos5l_decap_8
X_1577_ _1577_/Q Tile_X0Y1_FrameData[26] Tile_X0Y3_FrameStrobe[4] VPWR VGND sg13cmos5l_dlhq_1
X_0528_ _0528_/X Tile_X0Y1_W1END[0] Tile_X0Y1_W6END[8] _0522_/X _0527_/X _1655_/Q
+ _1654_/Q VPWR VGND sg13cmos5l_mux4_1
XANTENNA__0902__A2 Tile_X0Y0_W6END[3] VPWR VGND sg13cmos5l_antennanp
XFILLER_112_173 VPWR VGND sg13cmos5l_decap_8
X_0459_ _0459_/Y _1199_/Q Tile_X0Y0_S1END[2] VPWR VGND sg13cmos5l_nand2b_1
XFILLER_66_260 VPWR VGND sg13cmos5l_decap_8
X_2129_ _2129_/Q Tile_X0Y3_FrameData[2] Tile_X0Y3_FrameStrobe[5] VPWR VGND sg13cmos5l_dlhq_1
XFILLER_66_293 VPWR VGND sg13cmos5l_fill_2
XFILLER_25_25 VPWR VGND sg13cmos5l_decap_4
XFILLER_41_149 VPWR VGND sg13cmos5l_decap_8
XANTENNA__1091__A1 AXIL_S_SOC_WDATA13 VPWR VGND sg13cmos5l_antennanp
XANTENNA__1483__GATE Tile_X0Y3_FrameStrobe[1] VPWR VGND sg13cmos5l_antennanp
XANTENNA__1558__D Tile_X0Y1_FrameData[13] VPWR VGND sg13cmos5l_antennanp
XFILLER_179_195 VPWR VGND sg13cmos5l_fill_1
XFILLER_157_57 VPWR VGND sg13cmos5l_decap_8
XFILLER_135_221 VPWR VGND sg13cmos5l_decap_8
XANTENNA__1498__GATE Tile_X0Y3_FrameStrobe[1] VPWR VGND sg13cmos5l_antennanp
XANTENNA__1293__D Tile_X0Y0_FrameData[30] VPWR VGND sg13cmos5l_antennanp
XFILLER_173_34 VPWR VGND sg13cmos5l_fill_1
XFILLER_173_12 VPWR VGND sg13cmos5l_decap_4
XFILLER_173_56 VPWR VGND sg13cmos5l_fill_2
XANTENNA__1421__GATE Tile_X0Y3_FrameStrobe[7] VPWR VGND sg13cmos5l_antennanp
XFILLER_173_89 VPWR VGND sg13cmos5l_decap_4
XFILLER_106_94 VPWR VGND sg13cmos5l_decap_8
XANTENNA__1436__GATE Tile_X0Y3_FrameStrobe[7] VPWR VGND sg13cmos5l_antennanp
XFILLER_57_293 VPWR VGND sg13cmos5l_fill_2
XFILLER_174_0 VPWR VGND sg13cmos5l_fill_2
XFILLER_72_263 VPWR VGND sg13cmos5l_fill_1
XFILLER_82_42 VPWR VGND sg13cmos5l_fill_1
XFILLER_198_42 VPWR VGND sg13cmos5l_decap_8
XANTENNA__1082__A1 AXIL_S_SOC_WDATA10 VPWR VGND sg13cmos5l_antennanp
XANTENNA__1468__D Tile_X0Y1_FrameData[7] VPWR VGND sg13cmos5l_antennanp
XFILLER_15_80 VPWR VGND sg13cmos5l_decap_8
XANTENNA__0593__A0 Tile_X0Y1_W1END[1] VPWR VGND sg13cmos5l_antennanp
XFILLER_141_202 VPWR VGND sg13cmos5l_decap_8
X_1500_ _1500_/Q Tile_X0Y1_FrameData[7] Tile_X0Y3_FrameStrobe[1] VPWR VGND sg13cmos5l_dlhq_1
X_2480_ Tile_X0Y0_E2BEGb[6] _2480_/A VPWR VGND sg13cmos5l_buf_1
XFILLER_99_116 VPWR VGND sg13cmos5l_decap_8
XFILLER_31_90 VPWR VGND sg13cmos5l_fill_1
X_1431_ _1431_/Q Tile_X0Y0_FrameData[20] Tile_X0Y3_FrameStrobe[7] VPWR VGND sg13cmos5l_dlhq_1
X_1362_ _1362_/Q Tile_X0Y0_FrameData[25] Tile_X0Y3_FrameStrobe[5] VPWR VGND sg13cmos5l_dlhq_1
XANTENNA__0896__A1 Tile_X0Y0_W2END[4] VPWR VGND sg13cmos5l_antennanp
XANTENNA__1931__D Tile_X0Y2_FrameData[16] VPWR VGND sg13cmos5l_antennanp
X_1293_ _1293_/Q Tile_X0Y0_FrameData[30] Tile_X0Y3_FrameStrobe[3] VPWR VGND sg13cmos5l_dlhq_1
XFILLER_48_271 VPWR VGND sg13cmos5l_decap_8
XFILLER_48_260 VPWR VGND sg13cmos5l_decap_8
XANTENNA__0648__A1 Tile_X0Y0_W2END[1] VPWR VGND sg13cmos5l_antennanp
XFILLER_48_293 VPWR VGND sg13cmos5l_fill_2
XFILLER_23_149 VPWR VGND sg13cmos5l_decap_8
XANTENNA__1378__D Tile_X0Y0_FrameData[9] VPWR VGND sg13cmos5l_antennanp
XANTENNA__0820__A1 Tile_X0Y0_WW4END[15] VPWR VGND sg13cmos5l_antennanp
XANTENNA__2404__X Tile_X0Y0_FrameStrobe_O[10] VPWR VGND sg13cmos5l_antennanp
XFILLER_31_193 VPWR VGND sg13cmos5l_decap_8
XFILLER_176_198 VPWR VGND sg13cmos5l_fill_1
XFILLER_176_187 VPWR VGND sg13cmos5l_decap_8
XFILLER_117_221 VPWR VGND sg13cmos5l_fill_1
XFILLER_191_135 VPWR VGND sg13cmos5l_decap_8
XANTENNA__0584__A0 Tile_X0Y3_N2MID[1] VPWR VGND sg13cmos5l_antennanp
XFILLER_127_27 VPWR VGND sg13cmos5l_fill_1
X_1629_ _1629_/Q Tile_X0Y1_FrameData[6] Tile_X0Y3_FrameStrobe[5] VPWR VGND sg13cmos5l_dlhq_1
XANTENNA__2002__D Tile_X0Y3_FrameData[1] VPWR VGND sg13cmos5l_antennanp
XFILLER_132_279 VPWR VGND sg13cmos5l_fill_1
XANTENNA__1841__D Tile_X0Y2_FrameData[10] VPWR VGND sg13cmos5l_antennanp
XANTENNA__2151__GATE Tile_X0Y3_FrameStrobe[6] VPWR VGND sg13cmos5l_antennanp
XFILLER_100_154 VPWR VGND sg13cmos5l_decap_8
XFILLER_39_293 VPWR VGND sg13cmos5l_fill_2
XFILLER_36_24 VPWR VGND sg13cmos5l_decap_4
XANTENNA__2166__GATE Tile_X0Y3_FrameStrobe[7] VPWR VGND sg13cmos5l_antennanp
XFILLER_14_127 VPWR VGND sg13cmos5l_decap_8
XANTENNA__1288__D Tile_X0Y0_FrameData[3] VPWR VGND sg13cmos5l_antennanp
XFILLER_146_4 VPWR VGND sg13cmos5l_fill_1
XFILLER_22_160 VPWR VGND sg13cmos5l_decap_8
XANTENNA__2314__X Tile_X0Y2_EE4BEG[6] VPWR VGND sg13cmos5l_antennanp
XFILLER_168_45 VPWR VGND sg13cmos5l_decap_8
XFILLER_52_78 VPWR VGND sg13cmos5l_decap_8
XFILLER_168_89 VPWR VGND sg13cmos5l_decap_8
XFILLER_182_146 VPWR VGND sg13cmos5l_fill_1
XANTENNA__2104__GATE Tile_X0Y3_FrameStrobe[5] VPWR VGND sg13cmos5l_antennanp
XANTENNA__1119__A2 Tile_X0Y0_S4END[11] VPWR VGND sg13cmos5l_antennanp
XANTENNA__1360__GATE Tile_X0Y3_FrameStrobe[5] VPWR VGND sg13cmos5l_antennanp
XFILLER_96_108 VPWR VGND sg13cmos5l_fill_1
XANTENNA__1990__GATE Tile_X0Y3_FrameStrobe[1] VPWR VGND sg13cmos5l_antennanp
XANTENNA__2119__GATE Tile_X0Y3_FrameStrobe[5] VPWR VGND sg13cmos5l_antennanp
XFILLER_89_171 VPWR VGND sg13cmos5l_decap_8
XANTENNA__1751__D Tile_X0Y2_FrameData[4] VPWR VGND sg13cmos5l_antennanp
XFILLER_131_290 VPWR VGND sg13cmos5l_decap_4
XFILLER_37_208 VPWR VGND sg13cmos5l_fill_1
XANTENNA__1375__GATE Tile_X0Y3_FrameStrobe[5] VPWR VGND sg13cmos5l_antennanp
XFILLER_45_241 VPWR VGND sg13cmos5l_fill_1
XFILLER_60_211 VPWR VGND sg13cmos5l_decap_4
X_1980_ _1980_/Q Tile_X0Y3_FrameData[23] Tile_X0Y3_FrameStrobe[1] VPWR VGND sg13cmos5l_dlhq_1
X_0931_ _0932_/A _0860_/X _0466_/B Tile_X0Y3_N4END[10] Tile_X0Y0_S4END[6] _1478_/Q
+ _1479_/Q VPWR VGND sg13cmos5l_mux4_1
XFILLER_20_108 VPWR VGND sg13cmos5l_decap_4
XFILLER_198_290 VPWR VGND sg13cmos5l_decap_4
XANTENNA__0802__A1 Tile_X0Y0_W6END[11] VPWR VGND sg13cmos5l_antennanp
XANTENNA__1198__D Tile_X0Y0_FrameData[29] VPWR VGND sg13cmos5l_antennanp
XFILLER_201_272 VPWR VGND sg13cmos5l_fill_2
XANTENNA__1313__GATE Tile_X0Y3_FrameStrobe[3] VPWR VGND sg13cmos5l_antennanp
XANTENNA__2224__X Tile_X0Y1_E6BEG[9] VPWR VGND sg13cmos5l_antennanp
XFILLER_158_165 VPWR VGND sg13cmos5l_decap_8
X_0862_ _0862_/X _0754_/X _0756_/X _0757_/X Tile_X0Y0_S2MID[7] _1452_/Q _1453_/Q VPWR
+ VGND sg13cmos5l_mux4_1
XFILLER_9_153 VPWR VGND sg13cmos5l_decap_8
XANTENNA__1926__D Tile_X0Y2_FrameData[21] VPWR VGND sg13cmos5l_antennanp
XANTENNA__1943__GATE Tile_X0Y3_FrameStrobe[0] VPWR VGND sg13cmos5l_antennanp
X_2601_ Tile_X0Y3_S4BEG[7] _2601_/A VPWR VGND sg13cmos5l_buf_1
X_0793_ _0794_/B _0771_/X Tile_X0Y0_S1END[3] Tile_X0Y3_N4END[15] Tile_X0Y0_S4END[3]
+ _1244_/Q _1245_/Q VPWR VGND sg13cmos5l_mux4_1
XANTENNA__0566__A0 Tile_X0Y3_W1END[1] VPWR VGND sg13cmos5l_antennanp
X_2532_ Tile_X0Y3_EE4BEG[6] _2532_/A VPWR VGND sg13cmos5l_buf_1
XANTENNA__1328__GATE Tile_X0Y3_FrameStrobe[4] VPWR VGND sg13cmos5l_antennanp
X_2463_ Tile_X0Y0_E6BEG[1] _2463_/A VPWR VGND sg13cmos5l_buf_1
XANTENNA__1958__GATE Tile_X0Y3_FrameStrobe[0] VPWR VGND sg13cmos5l_antennanp
XANTENNA__2400__A Tile_X0Y3_FrameStrobe[6] VPWR VGND sg13cmos5l_antennanp
XFILLER_114_279 VPWR VGND sg13cmos5l_decap_4
X_1414_ _1414_/Q Tile_X0Y0_FrameData[5] Tile_X0Y3_FrameStrobe[6] VPWR VGND sg13cmos5l_dlhq_1
X_2394_ Tile_X0Y0_FrameStrobe_O[0] Tile_X0Y3_FrameStrobe[0] VPWR VGND sg13cmos5l_buf_1
XANTENNA__1661__D Tile_X0Y1_FrameData[6] VPWR VGND sg13cmos5l_antennanp
XFILLER_122_290 VPWR VGND sg13cmos5l_decap_4
X_1345_ _1345_/Q Tile_X0Y0_FrameData[10] Tile_X0Y3_FrameStrobe[4] VPWR VGND sg13cmos5l_dlhq_1
XFILLER_3_72 VPWR VGND sg13cmos5l_fill_2
XFILLER_3_61 VPWR VGND sg13cmos5l_fill_1
XFILLER_3_50 VPWR VGND sg13cmos5l_decap_8
XFILLER_95_174 VPWR VGND sg13cmos5l_decap_8
XFILLER_28_219 VPWR VGND sg13cmos5l_decap_8
X_1276_ _1276_/Q Tile_X0Y0_FrameData[15] Tile_X0Y3_FrameStrobe[2] VPWR VGND sg13cmos5l_dlhq_1
XFILLER_11_108 VPWR VGND sg13cmos5l_fill_2
XFILLER_51_277 VPWR VGND sg13cmos5l_decap_8
XFILLER_149_187 VPWR VGND sg13cmos5l_decap_8
XANTENNA__1836__D Tile_X0Y2_FrameData[15] VPWR VGND sg13cmos5l_antennanp
XFILLER_22_59 VPWR VGND sg13cmos5l_decap_8
XFILLER_98_19 VPWR VGND sg13cmos5l_fill_2
XFILLER_105_268 VPWR VGND sg13cmos5l_decap_8
XANTENNA__2090__GATE Tile_X0Y3_FrameStrobe[4] VPWR VGND sg13cmos5l_antennanp
XANTENNA__1571__D Tile_X0Y1_FrameData[0] VPWR VGND sg13cmos5l_antennanp
XFILLER_113_290 VPWR VGND sg13cmos5l_decap_4
XFILLER_86_174 VPWR VGND sg13cmos5l_fill_1
XFILLER_47_34 VPWR VGND sg13cmos5l_fill_1
XFILLER_219_158 VPWR VGND sg13cmos5l_decap_8
XFILLER_47_89 VPWR VGND sg13cmos5l_decap_8
XANTENNA__2309__X Tile_X0Y2_EE4BEG[1] VPWR VGND sg13cmos5l_antennanp
XANTENNA__1037__A1 AXIL_S_SOC_WDATA30 VPWR VGND sg13cmos5l_antennanp
XFILLER_179_55 VPWR VGND sg13cmos5l_fill_1
XANTENNA__1746__D Tile_X0Y2_FrameData[9] VPWR VGND sg13cmos5l_antennanp
XANTENNA__2043__GATE Tile_X0Y3_FrameStrobe[3] VPWR VGND sg13cmos5l_antennanp
XFILLER_12_81 VPWR VGND sg13cmos5l_decap_8
XFILLER_170_105 VPWR VGND sg13cmos5l_decap_8
XFILLER_195_87 VPWR VGND sg13cmos5l_decap_8
XFILLER_88_63 VPWR VGND sg13cmos5l_decap_8
XFILLER_88_41 VPWR VGND sg13cmos5l_fill_1
XANTENNA__2058__GATE Tile_X0Y3_FrameStrobe[3] VPWR VGND sg13cmos5l_antennanp
XANTENNA__1481__D Tile_X0Y1_FrameData[26] VPWR VGND sg13cmos5l_antennanp
XFILLER_104_290 VPWR VGND sg13cmos5l_decap_4
XFILLER_111_238 VPWR VGND sg13cmos5l_decap_8
XFILLER_26_7 VPWR VGND sg13cmos5l_fill_1
XFILLER_144_91 VPWR VGND sg13cmos5l_fill_2
X_1130_ _1134_/B _1879_/Q _1060_/Y _1129_/Y VPWR VGND sg13cmos5l_a21oi_1
XANTENNA__0720__A0 Tile_X0Y0_W2MID[7] VPWR VGND sg13cmos5l_antennanp
XFILLER_77_185 VPWR VGND sg13cmos5l_decap_8
XANTENNA__2219__X Tile_X0Y1_E6BEG[4] VPWR VGND sg13cmos5l_antennanp
X_1061_ _1061_/Y Tile_X0Y2_W6END[8] _1915_/Q _1914_/Q VPWR VGND sg13cmos5l_o21ai_1
XFILLER_92_155 VPWR VGND sg13cmos5l_decap_8
XFILLER_225_128 VPWR VGND sg13cmos5l_decap_8
XFILLER_218_180 VPWR VGND sg13cmos5l_decap_8
XFILLER_33_244 VPWR VGND sg13cmos5l_fill_1
XANTENNA__1028__A1 AXIL_S_SOC_WDATA31 VPWR VGND sg13cmos5l_antennanp
XANTENNA__1252__GATE Tile_X0Y3_FrameStrobe[1] VPWR VGND sg13cmos5l_antennanp
X_1963_ _1963_/Q Tile_X0Y3_FrameData[8] Tile_X0Y3_FrameStrobe[0] VPWR VGND sg13cmos5l_dlhq_1
XANTENNA__0787__A0 Tile_X0Y0_W1END[2] VPWR VGND sg13cmos5l_antennanp
XANTENNA__1882__GATE Tile_X0Y3_FrameStrobe[5] VPWR VGND sg13cmos5l_antennanp
X_1894_ _1894_/Q Tile_X0Y2_FrameData[21] Tile_X0Y3_FrameStrobe[6] VPWR VGND sg13cmos5l_dlhq_1
X_0914_ _0914_/Y _0914_/A VPWR VGND sg13cmos5l_inv_1
XANTENNA__1656__D Tile_X0Y1_FrameData[11] VPWR VGND sg13cmos5l_antennanp
X_0845_ _2488_/A AXIL_S_SOC_AWADDR0 AXIL_S_SOC_AWADDR8 _0646_/X _0751_/X _1351_/Q
+ _1350_/Q VPWR VGND sg13cmos5l_mux4_1
XFILLER_186_293 VPWR VGND sg13cmos5l_fill_2
XANTENNA__1267__GATE Tile_X0Y3_FrameStrobe[2] VPWR VGND sg13cmos5l_antennanp
X_0776_ _0776_/X _0646_/X _0775_/X _0776_/S VPWR VGND sg13cmos5l_mux2_1
XFILLER_52_0 VPWR VGND sg13cmos5l_fill_2
XANTENNA__1897__GATE Tile_X0Y3_FrameStrobe[6] VPWR VGND sg13cmos5l_antennanp
X_2515_ Tile_X0Y3_E6BEG[1] _2515_/A VPWR VGND sg13cmos5l_buf_1
XANTENNA__0554__A3 Tile_X0Y0_S4END[9] VPWR VGND sg13cmos5l_antennanp
X_2446_ Tile_X0Y0_EE4BEG[0] _2446_/A VPWR VGND sg13cmos5l_buf_1
XANTENNA__1391__D Tile_X0Y0_FrameData[28] VPWR VGND sg13cmos5l_antennanp
XANTENNA__1820__GATE Tile_X0Y3_FrameStrobe[4] VPWR VGND sg13cmos5l_antennanp
XFILLER_124_39 VPWR VGND sg13cmos5l_decap_8
X_2377_ Tile_X0Y0_N2BEGb[3] _2377_/A VPWR VGND sg13cmos5l_buf_1
XFILLER_68_152 VPWR VGND sg13cmos5l_decap_4
XANTENNA__0711__A0 Tile_X0Y2_W2MID[4] VPWR VGND sg13cmos5l_antennanp
X_1328_ _1328_/Q Tile_X0Y0_FrameData[27] Tile_X0Y3_FrameStrobe[4] VPWR VGND sg13cmos5l_dlhq_1
XANTENNA__1205__GATE Tile_X0Y3_FrameStrobe[0] VPWR VGND sg13cmos5l_antennanp
X_1259_ _1259_/Q Tile_X0Y0_FrameData[0] Tile_X0Y3_FrameStrobe[1] VPWR VGND sg13cmos5l_dlhq_1
XFILLER_204_83 VPWR VGND sg13cmos5l_decap_8
XANTENNA__1835__GATE Tile_X0Y3_FrameStrobe[4] VPWR VGND sg13cmos5l_antennanp
XFILLER_224_172 VPWR VGND sg13cmos5l_fill_1
XANTENNA__1019__A1 AXIL_S_SOC_WDATA25 VPWR VGND sg13cmos5l_antennanp
XFILLER_169_216 VPWR VGND sg13cmos5l_decap_4
XFILLER_24_277 VPWR VGND sg13cmos5l_decap_8
XFILLER_149_25 VPWR VGND sg13cmos5l_fill_1
XFILLER_149_36 VPWR VGND sg13cmos5l_decap_8
XFILLER_137_135 VPWR VGND sg13cmos5l_fill_2
XFILLER_192_241 VPWR VGND sg13cmos5l_decap_8
XFILLER_177_293 VPWR VGND sg13cmos5l_fill_2
XANTENNA__0793__A3 Tile_X0Y0_S4END[3] VPWR VGND sg13cmos5l_antennanp
XANTENNA__1566__D Tile_X0Y1_FrameData[5] VPWR VGND sg13cmos5l_antennanp
XFILLER_137_168 VPWR VGND sg13cmos5l_fill_2
XFILLER_165_35 VPWR VGND sg13cmos5l_fill_2
XFILLER_165_57 VPWR VGND sg13cmos5l_fill_2
XANTENNA__0950__A0 Tile_X0Y1_W1END[3] VPWR VGND sg13cmos5l_antennanp
XFILLER_58_88 VPWR VGND sg13cmos5l_fill_1
XFILLER_199_2 VPWR VGND sg13cmos5l_fill_1
XFILLER_181_56 VPWR VGND sg13cmos5l_decap_8
XANTENNA__0702__A0 Tile_X0Y3_W2MID[5] VPWR VGND sg13cmos5l_antennanp
XFILLER_101_271 VPWR VGND sg13cmos5l_fill_2
XFILLER_207_106 VPWR VGND sg13cmos5l_decap_8
XANTENNA__0495__A Tile_X0Y1_W6END[3] VPWR VGND sg13cmos5l_antennanp
XFILLER_74_188 VPWR VGND sg13cmos5l_decap_8
XFILLER_222_109 VPWR VGND sg13cmos5l_decap_8
XFILLER_130_60 VPWR VGND sg13cmos5l_decap_8
XANTENNA__0481__A2 Tile_X0Y2_W6END[10] VPWR VGND sg13cmos5l_antennanp
XFILLER_90_86 VPWR VGND sg13cmos5l_decap_8
XFILLER_168_293 VPWR VGND sg13cmos5l_fill_2
XANTENNA__1476__D Tile_X0Y1_FrameData[31] VPWR VGND sg13cmos5l_antennanp
XFILLER_99_40 VPWR VGND sg13cmos5l_fill_2
XFILLER_209_28 VPWR VGND sg13cmos5l_fill_1
XFILLER_183_241 VPWR VGND sg13cmos5l_decap_8
XANTENNA__0784__A3 Tile_X0Y0_S4END[2] VPWR VGND sg13cmos5l_antennanp
XANTENNA__2502__X Tile_X0Y3_E2BEG[4] VPWR VGND sg13cmos5l_antennanp
XFILLER_143_138 VPWR VGND sg13cmos5l_decap_8
X_0630_ _0630_/Y _2019_/Q Tile_X0Y3_W2MID[0] VPWR VGND sg13cmos5l_nor2b_1
XFILLER_99_73 VPWR VGND sg13cmos5l_fill_2
XFILLER_99_51 VPWR VGND sg13cmos5l_decap_4
XANTENNA__1194__A0 Tile_X0Y2_W1END[2] VPWR VGND sg13cmos5l_antennanp
X_0561_ _0561_/X Tile_X0Y3_N1END[1] Tile_X0Y3_N4END[1] _0564_/B Tile_X0Y0_S4END[13]
+ _1969_/Q _1968_/Q VPWR VGND sg13cmos5l_mux4_1
XANTENNA__0536__A3 Tile_X0Y0_S4END[12] VPWR VGND sg13cmos5l_antennanp
X_2300_ Tile_X0Y2_E6BEG[4] _2300_/A VPWR VGND sg13cmos5l_buf_1
XFILLER_225_27 VPWR VGND sg13cmos5l_decap_8
XFILLER_155_90 VPWR VGND sg13cmos5l_fill_1
X_2231_ Tile_X0Y1_EE4BEG[4] _2231_/A VPWR VGND sg13cmos5l_buf_1
X_0492_ _0492_/X Tile_X0Y0_W1END[3] Tile_X0Y0_W6END[11] _0488_/X _0491_/Y _1401_/Q
+ _1400_/Q VPWR VGND sg13cmos5l_mux4_1
XFILLER_97_247 VPWR VGND sg13cmos5l_decap_8
XFILLER_2_181 VPWR VGND sg13cmos5l_fill_1
XANTENNA__2100__D Tile_X0Y3_FrameData[31] VPWR VGND sg13cmos5l_antennanp
X_2162_ _2162_/Q Tile_X0Y3_FrameData[1] Tile_X0Y3_FrameStrobe[6] VPWR VGND sg13cmos5l_dlhq_1
XFILLER_65_100 VPWR VGND sg13cmos5l_decap_8
X_1113_ _2320_/A AXIL_S_SOC_WDATA0 _1112_/X AXIL_S_SOC_WDATA12 _0746_/X _1802_/Q _1803_/Q
+ VPWR VGND sg13cmos5l_mux4_1
X_2093_ _2093_/Q Tile_X0Y3_FrameData[6] Tile_X0Y3_FrameStrobe[4] VPWR VGND sg13cmos5l_dlhq_1
X_1044_ _1048_/B _1912_/Q _1042_/Y _1043_/Y VPWR VGND sg13cmos5l_a21oi_1
XFILLER_65_188 VPWR VGND sg13cmos5l_decap_8
XFILLER_206_183 VPWR VGND sg13cmos5l_decap_8
XFILLER_119_135 VPWR VGND sg13cmos5l_fill_1
XFILLER_159_293 VPWR VGND sg13cmos5l_fill_2
X_1946_ _1946_/Q Tile_X0Y3_FrameData[25] Tile_X0Y3_FrameStrobe[0] VPWR VGND sg13cmos5l_dlhq_1
XFILLER_174_230 VPWR VGND sg13cmos5l_fill_1
XANTENNA__1386__D Tile_X0Y0_FrameData[1] VPWR VGND sg13cmos5l_antennanp
XFILLER_119_168 VPWR VGND sg13cmos5l_decap_8
X_1877_ _1877_/Q Tile_X0Y2_FrameData[6] Tile_X0Y3_FrameStrobe[5] VPWR VGND sg13cmos5l_dlhq_1
XANTENNA__0775__A3 Tile_X0Y0_S4END[1] VPWR VGND sg13cmos5l_antennanp
XANTENNA__2412__X Tile_X0Y0_FrameStrobe_O[18] VPWR VGND sg13cmos5l_antennanp
XFILLER_134_138 VPWR VGND sg13cmos5l_fill_1
X_0828_ _0828_/X _0751_/X _0785_/X _0828_/S VPWR VGND sg13cmos5l_mux2_1
XFILLER_174_285 VPWR VGND sg13cmos5l_fill_2
XFILLER_174_274 VPWR VGND sg13cmos5l_decap_8
X_0759_ _2389_/A Tile_X0Y0_W2MID[0] Tile_X0Y0_W2END[0] Tile_X0Y0_W6END[0] _0755_/X
+ _1421_/Q _1420_/Q VPWR VGND sg13cmos5l_mux4_1
XFILLER_135_27 VPWR VGND sg13cmos5l_decap_4
XFILLER_142_171 VPWR VGND sg13cmos5l_decap_8
XFILLER_88_214 VPWR VGND sg13cmos5l_fill_1
XANTENNA__2010__D Tile_X0Y3_FrameData[25] VPWR VGND sg13cmos5l_antennanp
X_2429_ Tile_X0Y0_FrameData_O[15] Tile_X0Y0_FrameData[15] VPWR VGND sg13cmos5l_buf_1
XFILLER_151_26 VPWR VGND sg13cmos5l_decap_8
XANTENNA__1774__GATE Tile_X0Y3_FrameStrobe[2] VPWR VGND sg13cmos5l_antennanp
XFILLER_44_35 VPWR VGND sg13cmos5l_fill_2
XFILLER_44_24 VPWR VGND sg13cmos5l_decap_8
XANTENNA__0999__A0 AXIL_S_SOC_WDATA23 VPWR VGND sg13cmos5l_antennanp
XFILLER_71_169 VPWR VGND sg13cmos5l_decap_8
XANTENNA__1789__GATE Tile_X0Y3_FrameStrobe[3] VPWR VGND sg13cmos5l_antennanp
XFILLER_212_197 VPWR VGND sg13cmos5l_decap_8
XANTENNA__1296__D Tile_X0Y0_FrameData[27] VPWR VGND sg13cmos5l_antennanp
XANTENNA__1712__GATE Tile_X0Y3_FrameStrobe[0] VPWR VGND sg13cmos5l_antennanp
XFILLER_165_263 VPWR VGND sg13cmos5l_decap_8
XFILLER_60_89 VPWR VGND sg13cmos5l_decap_8
XFILLER_176_23 VPWR VGND sg13cmos5l_fill_2
XANTENNA__2322__X Tile_X0Y2_EE4BEG[14] VPWR VGND sg13cmos5l_antennanp
XANTENNA__1176__A0 Tile_X0Y2_W1END[0] VPWR VGND sg13cmos5l_antennanp
XFILLER_109_61 VPWR VGND sg13cmos5l_decap_8
XFILLER_109_83 VPWR VGND sg13cmos5l_fill_2
XFILLER_69_21 VPWR VGND sg13cmos5l_decap_8
XANTENNA__1727__GATE Tile_X0Y3_FrameStrobe[1] VPWR VGND sg13cmos5l_antennanp
XFILLER_79_258 VPWR VGND sg13cmos5l_decap_8
XFILLER_192_66 VPWR VGND sg13cmos5l_decap_8
XFILLER_94_228 VPWR VGND sg13cmos5l_decap_8
XFILLER_85_42 VPWR VGND sg13cmos5l_decap_8
XFILLER_47_188 VPWR VGND sg13cmos5l_decap_8
XANTENNA__1100__A0 AXIL_S_SOC_WDATA2 VPWR VGND sg13cmos5l_antennanp
XFILLER_203_131 VPWR VGND sg13cmos5l_decap_8
X_1800_ _1800_/Q Tile_X0Y2_FrameData[19] Tile_X0Y3_FrameStrobe[3] VPWR VGND sg13cmos5l_dlhq_1
XFILLER_34_90 VPWR VGND sg13cmos5l_decap_8
XFILLER_11_280 VPWR VGND sg13cmos5l_fill_1
X_1731_ _1731_/Q Tile_X0Y2_FrameData[24] Tile_X0Y3_FrameStrobe[1] VPWR VGND sg13cmos5l_dlhq_1
XANTENNA__2232__X Tile_X0Y1_EE4BEG[5] VPWR VGND sg13cmos5l_antennanp
XFILLER_171_211 VPWR VGND sg13cmos5l_decap_4
X_1662_ _1662_/Q Tile_X0Y1_FrameData[5] Tile_X0Y3_FrameStrobe[6] VPWR VGND sg13cmos5l_dlhq_1
XFILLER_7_251 VPWR VGND sg13cmos5l_decap_8
XFILLER_109_190 VPWR VGND sg13cmos5l_decap_8
X_0613_ _0613_/Y _2123_/Q _0613_/B VPWR VGND sg13cmos5l_nand2b_1
XANTENNA__1934__D Tile_X0Y2_FrameData[13] VPWR VGND sg13cmos5l_antennanp
X_1593_ _1593_/Q Tile_X0Y1_FrameData[10] Tile_X0Y3_FrameStrobe[4] VPWR VGND sg13cmos5l_dlhq_1
X_0544_ _0544_/Y _1200_/Q _1201_/Q _0752_/X VPWR VGND sg13cmos5l_nor3_1
X_0475_ _0475_/Y _1694_/Q _0475_/B _0475_/C VPWR VGND sg13cmos5l_nor3_1
X_2214_ Tile_X0Y1_E2BEGb[7] _2214_/A VPWR VGND sg13cmos5l_buf_1
XFILLER_85_228 VPWR VGND sg13cmos5l_fill_1
XFILLER_38_111 VPWR VGND sg13cmos5l_decap_8
XFILLER_15_0 VPWR VGND sg13cmos5l_fill_2
X_2145_ _2145_/Q Tile_X0Y3_FrameData[18] Tile_X0Y3_FrameStrobe[6] VPWR VGND sg13cmos5l_dlhq_1
XFILLER_93_250 VPWR VGND sg13cmos5l_decap_8
X_2076_ _2076_/Q Tile_X0Y3_FrameData[23] Tile_X0Y3_FrameStrobe[4] VPWR VGND sg13cmos5l_dlhq_1
XFILLER_38_199 VPWR VGND sg13cmos5l_decap_8
XANTENNA__2407__X Tile_X0Y0_FrameStrobe_O[13] VPWR VGND sg13cmos5l_antennanp
X_1027_ _2215_/A Tile_X0Y3_N4END[8] _0947_/A Tile_X0Y0_S4END[4] _0493_/X _1546_/Q
+ _1547_/Q VPWR VGND sg13cmos5l_mux4_1
X_1929_ _1929_/Q Tile_X0Y2_FrameData[18] Tile_X0Y3_FrameStrobe[7] VPWR VGND sg13cmos5l_dlhq_1
XANTENNA__2005__D Tile_X0Y3_FrameData[30] VPWR VGND sg13cmos5l_antennanp
XFILLER_162_211 VPWR VGND sg13cmos5l_decap_8
XFILLER_100_8 VPWR VGND sg13cmos5l_fill_1
XANTENNA__1844__D Tile_X0Y2_FrameData[7] VPWR VGND sg13cmos5l_antennanp
XFILLER_130_130 VPWR VGND sg13cmos5l_decap_4
XFILLER_39_79 VPWR VGND sg13cmos5l_decap_8
XFILLER_29_177 VPWR VGND sg13cmos5l_fill_1
XFILLER_84_294 VPWR VGND sg13cmos5l_fill_1
XFILLER_55_56 VPWR VGND sg13cmos5l_decap_8
XFILLER_217_267 VPWR VGND sg13cmos5l_fill_2
XANTENNA__2317__X Tile_X0Y2_EE4BEG[9] VPWR VGND sg13cmos5l_antennanp
XFILLER_44_158 VPWR VGND sg13cmos5l_decap_8
XFILLER_197_174 VPWR VGND sg13cmos5l_fill_1
XFILLER_187_11 VPWR VGND sg13cmos5l_fill_1
XANTENNA__1651__GATE Tile_X0Y3_FrameStrobe[6] VPWR VGND sg13cmos5l_antennanp
XFILLER_197_196 VPWR VGND sg13cmos5l_decap_8
XFILLER_200_189 VPWR VGND sg13cmos5l_decap_8
XANTENNA__0739__A3 Tile_X0Y0_S2END[4] VPWR VGND sg13cmos5l_antennanp
XFILLER_217_0 VPWR VGND sg13cmos5l_fill_2
XFILLER_153_222 VPWR VGND sg13cmos5l_decap_8
XFILLER_4_210 VPWR VGND sg13cmos5l_decap_8
XANTENNA__1149__A0 Tile_X0Y2_W1END[3] VPWR VGND sg13cmos5l_antennanp
XANTENNA__1666__GATE Tile_X0Y3_FrameStrobe[6] VPWR VGND sg13cmos5l_antennanp
XANTENNA__1754__D Tile_X0Y2_FrameData[1] VPWR VGND sg13cmos5l_antennanp
XFILLER_67_239 VPWR VGND sg13cmos5l_fill_1
XFILLER_82_209 VPWR VGND sg13cmos5l_fill_1
XFILLER_35_103 VPWR VGND sg13cmos5l_decap_4
XANTENNA__0675__A2 AXIL_S_SOC_ARADDR9 VPWR VGND sg13cmos5l_antennanp
XANTENNA__1604__GATE Tile_X0Y3_FrameStrobe[5] VPWR VGND sg13cmos5l_antennanp
XFILLER_35_125 VPWR VGND sg13cmos5l_decap_8
XANTENNA__2227__X Tile_X0Y1_EE4BEG[0] VPWR VGND sg13cmos5l_antennanp
XFILLER_223_259 VPWR VGND sg13cmos5l_fill_1
XFILLER_188_141 VPWR VGND sg13cmos5l_decap_4
XANTENNA__1929__D Tile_X0Y2_FrameData[18] VPWR VGND sg13cmos5l_antennanp
XANTENNA__1619__GATE Tile_X0Y3_FrameStrobe[5] VPWR VGND sg13cmos5l_antennanp
XANTENNA__2403__A Tile_X0Y3_FrameStrobe[9] VPWR VGND sg13cmos5l_antennanp
X_1714_ _1714_/Q Tile_X0Y2_FrameData[9] Tile_X0Y3_FrameStrobe[0] VPWR VGND sg13cmos5l_dlhq_1
XANTENNA__1664__D Tile_X0Y1_FrameData[3] VPWR VGND sg13cmos5l_antennanp
XFILLER_144_266 VPWR VGND sg13cmos5l_decap_8
X_1645_ _1645_/Q Tile_X0Y1_FrameData[22] Tile_X0Y3_FrameStrobe[6] VPWR VGND sg13cmos5l_dlhq_1
X_1576_ _1576_/Q Tile_X0Y1_FrameData[27] Tile_X0Y3_FrameStrobe[4] VPWR VGND sg13cmos5l_dlhq_1
XFILLER_112_152 VPWR VGND sg13cmos5l_decap_8
X_0527_ _0527_/X _0521_/X _0523_/Y _0526_/Y VPWR VGND sg13cmos5l_a21o_1
X_0458_ _0458_/Y _0755_/X VPWR VGND sg13cmos5l_inv_1
XANTENNA__0666__A2 AXIL_S_SOC_ARADDR4 VPWR VGND sg13cmos5l_antennanp
X_2128_ _2128_/Q Tile_X0Y3_FrameData[3] Tile_X0Y3_FrameStrobe[5] VPWR VGND sg13cmos5l_dlhq_1
X_2059_ _2059_/Q Tile_X0Y3_FrameData[8] Tile_X0Y3_FrameStrobe[3] VPWR VGND sg13cmos5l_dlhq_1
XFILLER_214_248 VPWR VGND sg13cmos5l_fill_2
XFILLER_155_9 VPWR VGND sg13cmos5l_decap_8
XANTENNA__1839__D Tile_X0Y2_FrameData[12] VPWR VGND sg13cmos5l_antennanp
XFILLER_179_141 VPWR VGND sg13cmos5l_decap_4
XFILLER_41_14 VPWR VGND sg13cmos5l_decap_8
XANTENNA__1574__D Tile_X0Y1_FrameData[29] VPWR VGND sg13cmos5l_antennanp
XANTENNA__2600__X Tile_X0Y3_S4BEG[6] VPWR VGND sg13cmos5l_antennanp
XFILLER_150_214 VPWR VGND sg13cmos5l_decap_4
XFILLER_150_269 VPWR VGND sg13cmos5l_decap_8
XFILLER_1_246 VPWR VGND sg13cmos5l_fill_1
XFILLER_2_19 VPWR VGND sg13cmos5l_decap_8
XFILLER_17_103 VPWR VGND sg13cmos5l_decap_8
XANTENNA__0657__A2 AXIL_S_SOC_ARADDR3 VPWR VGND sg13cmos5l_antennanp
XFILLER_17_114 VPWR VGND sg13cmos5l_fill_2
XFILLER_122_72 VPWR VGND sg13cmos5l_fill_1
XFILLER_167_0 VPWR VGND sg13cmos5l_fill_1
XFILLER_82_21 VPWR VGND sg13cmos5l_decap_8
XFILLER_72_242 VPWR VGND sg13cmos5l_decap_8
XFILLER_17_169 VPWR VGND sg13cmos5l_decap_8
XANTENNA__1749__D Tile_X0Y2_FrameData[6] VPWR VGND sg13cmos5l_antennanp
XFILLER_82_98 VPWR VGND sg13cmos5l_decap_8
XFILLER_25_191 VPWR VGND sg13cmos5l_decap_8
XANTENNA__1590__GATE Tile_X0Y3_FrameStrobe[4] VPWR VGND sg13cmos5l_antennanp
XFILLER_198_98 VPWR VGND sg13cmos5l_decap_8
XFILLER_40_183 VPWR VGND sg13cmos5l_decap_4
XFILLER_185_166 VPWR VGND sg13cmos5l_fill_2
XFILLER_185_155 VPWR VGND sg13cmos5l_decap_8
XFILLER_126_222 VPWR VGND sg13cmos5l_decap_8
XFILLER_63_8 VPWR VGND sg13cmos5l_fill_2
XANTENNA__0593__A1 Tile_X0Y1_W2END[2] VPWR VGND sg13cmos5l_antennanp
XANTENNA__1484__D Tile_X0Y1_FrameData[23] VPWR VGND sg13cmos5l_antennanp
XANTENNA__2510__X Tile_X0Y3_E2BEGb[4] VPWR VGND sg13cmos5l_antennanp
X_1430_ _1430_/Q Tile_X0Y0_FrameData[21] Tile_X0Y3_FrameStrobe[7] VPWR VGND sg13cmos5l_dlhq_1
XFILLER_141_258 VPWR VGND sg13cmos5l_decap_8
X_1361_ _1361_/Q Tile_X0Y0_FrameData[26] Tile_X0Y3_FrameStrobe[5] VPWR VGND sg13cmos5l_dlhq_1
XANTENNA__0896__A2 Tile_X0Y0_W6END[4] VPWR VGND sg13cmos5l_antennanp
XFILLER_163_90 VPWR VGND sg13cmos5l_decap_8
X_1292_ _1292_/Q Tile_X0Y0_FrameData[31] Tile_X0Y3_FrameStrobe[3] VPWR VGND sg13cmos5l_dlhq_1
XANTENNA__0648__A2 Tile_X0Y0_W6END[1] VPWR VGND sg13cmos5l_antennanp
XANTENNA__1543__GATE Tile_X0Y3_FrameStrobe[3] VPWR VGND sg13cmos5l_antennanp
XFILLER_63_286 VPWR VGND sg13cmos5l_fill_1
XANTENNA__1558__GATE Tile_X0Y3_FrameStrobe[3] VPWR VGND sg13cmos5l_antennanp
XANTENNA__1659__D Tile_X0Y1_FrameData[8] VPWR VGND sg13cmos5l_antennanp
XFILLER_211_218 VPWR VGND sg13cmos5l_fill_1
XFILLER_31_161 VPWR VGND sg13cmos5l_fill_1
XFILLER_31_150 VPWR VGND sg13cmos5l_decap_8
XFILLER_82_0 VPWR VGND sg13cmos5l_fill_2
XFILLER_176_155 VPWR VGND sg13cmos5l_decap_8
XFILLER_11_17 VPWR VGND sg13cmos5l_fill_2
XANTENNA__0584__A1 Tile_X0Y3_N2END[1] VPWR VGND sg13cmos5l_antennanp
XANTENNA__1394__D Tile_X0Y0_FrameData[25] VPWR VGND sg13cmos5l_antennanp
XANTENNA__2420__X Tile_X0Y0_FrameData_O[6] VPWR VGND sg13cmos5l_antennanp
X_1628_ _1628_/Q Tile_X0Y1_FrameData[7] Tile_X0Y3_FrameStrobe[5] VPWR VGND sg13cmos5l_dlhq_1
X_1559_ _1559_/Q Tile_X0Y1_FrameData[12] Tile_X0Y3_FrameStrobe[3] VPWR VGND sg13cmos5l_dlhq_1
XANTENNA__0887__A2 AXIL_S_SOC_AWADDR5 VPWR VGND sg13cmos5l_antennanp
XFILLER_39_272 VPWR VGND sg13cmos5l_decap_4
XFILLER_199_203 VPWR VGND sg13cmos5l_decap_8
XFILLER_14_106 VPWR VGND sg13cmos5l_fill_2
XFILLER_199_258 VPWR VGND sg13cmos5l_decap_8
XANTENNA__1569__D Tile_X0Y1_FrameData[2] VPWR VGND sg13cmos5l_antennanp
XFILLER_199_269 VPWR VGND sg13cmos5l_fill_1
XFILLER_167_122 VPWR VGND sg13cmos5l_decap_8
XFILLER_210_262 VPWR VGND sg13cmos5l_decap_8
XFILLER_182_103 VPWR VGND sg13cmos5l_fill_1
XFILLER_108_211 VPWR VGND sg13cmos5l_fill_1
XFILLER_108_233 VPWR VGND sg13cmos5l_fill_2
XFILLER_184_34 VPWR VGND sg13cmos5l_fill_1
XANTENNA__2330__X Tile_X0Y2_FrameData_O[6] VPWR VGND sg13cmos5l_antennanp
XFILLER_117_50 VPWR VGND sg13cmos5l_decap_8
XFILLER_89_150 VPWR VGND sg13cmos5l_decap_4
XFILLER_133_60 VPWR VGND sg13cmos5l_fill_2
XFILLER_93_31 VPWR VGND sg13cmos5l_fill_2
XANTENNA__1479__D Tile_X0Y1_FrameData[28] VPWR VGND sg13cmos5l_antennanp
XFILLER_60_234 VPWR VGND sg13cmos5l_fill_2
XANTENNA__2505__X Tile_X0Y3_E2BEG[7] VPWR VGND sg13cmos5l_antennanp
X_0930_ _0930_/X Tile_X0Y1_W1END[2] Tile_X0Y1_WW4END[2] Tile_X0Y1_W6END[10] _0929_/X
+ _1661_/Q _1660_/Q VPWR VGND sg13cmos5l_mux4_1
XFILLER_198_280 VPWR VGND sg13cmos5l_decap_8
XFILLER_201_251 VPWR VGND sg13cmos5l_decap_8
X_0861_ _2391_/A Tile_X0Y0_W1END[1] _0542_/X Tile_X0Y0_W6END[5] _0545_/Y _1440_/Q
+ _1441_/Q VPWR VGND sg13cmos5l_mux4_1
X_2600_ Tile_X0Y3_S4BEG[6] _2600_/A VPWR VGND sg13cmos5l_buf_1
X_0792_ _2594_/A _0791_/X _0790_/X _1382_/Q VPWR VGND sg13cmos5l_mux2_1
XFILLER_9_187 VPWR VGND sg13cmos5l_decap_8
X_2531_ Tile_X0Y3_EE4BEG[5] _2531_/A VPWR VGND sg13cmos5l_buf_1
XANTENNA__0566__A1 Tile_X0Y3_W6END[9] VPWR VGND sg13cmos5l_antennanp
XANTENNA__2103__D Tile_X0Y3_FrameData[28] VPWR VGND sg13cmos5l_antennanp
XANTENNA__2240__X Tile_X0Y1_EE4BEG[13] VPWR VGND sg13cmos5l_antennanp
X_2462_ Tile_X0Y0_E6BEG[0] _2462_/A VPWR VGND sg13cmos5l_buf_1
XANTENNA__1942__D Tile_X0Y3_FrameData[29] VPWR VGND sg13cmos5l_antennanp
X_1413_ _1413_/Q Tile_X0Y0_FrameData[6] Tile_X0Y3_FrameStrobe[6] VPWR VGND sg13cmos5l_dlhq_1
X_2393_ Tile_X0Y0_N1BEG[3] _2393_/A VPWR VGND sg13cmos5l_buf_1
X_1344_ _1344_/Q Tile_X0Y0_FrameData[11] Tile_X0Y3_FrameStrobe[4] VPWR VGND sg13cmos5l_dlhq_1
XFILLER_95_131 VPWR VGND sg13cmos5l_fill_2
XANTENNA__1482__GATE Tile_X0Y3_FrameStrobe[1] VPWR VGND sg13cmos5l_antennanp
X_1275_ _1275_/Q Tile_X0Y0_FrameData[16] Tile_X0Y3_FrameStrobe[2] VPWR VGND sg13cmos5l_dlhq_1
XFILLER_36_220 VPWR VGND sg13cmos5l_decap_8
XFILLER_36_231 VPWR VGND sg13cmos5l_fill_2
XANTENNA__1497__GATE Tile_X0Y3_FrameStrobe[1] VPWR VGND sg13cmos5l_antennanp
XFILLER_36_264 VPWR VGND sg13cmos5l_decap_8
XANTENNA__1389__D Tile_X0Y0_FrameData[30] VPWR VGND sg13cmos5l_antennanp
XANTENNA__2415__X Tile_X0Y0_FrameData_O[1] VPWR VGND sg13cmos5l_antennanp
XFILLER_51_267 VPWR VGND sg13cmos5l_fill_1
XANTENNA__1420__GATE Tile_X0Y3_FrameStrobe[7] VPWR VGND sg13cmos5l_antennanp
XFILLER_22_38 VPWR VGND sg13cmos5l_decap_8
XFILLER_164_136 VPWR VGND sg13cmos5l_fill_1
XFILLER_164_147 VPWR VGND sg13cmos5l_decap_8
XANTENNA__1435__GATE Tile_X0Y3_FrameStrobe[7] VPWR VGND sg13cmos5l_antennanp
XANTENNA__2013__D Tile_X0Y3_FrameData[22] VPWR VGND sg13cmos5l_antennanp
XFILLER_172_180 VPWR VGND sg13cmos5l_fill_2
XFILLER_105_247 VPWR VGND sg13cmos5l_decap_4
XFILLER_154_15 VPWR VGND sg13cmos5l_decap_4
XFILLER_218_93 VPWR VGND sg13cmos5l_fill_1
XANTENNA__1852__D Tile_X0Y2_FrameData[31] VPWR VGND sg13cmos5l_antennanp
XFILLER_219_115 VPWR VGND sg13cmos5l_fill_2
XANTENNA__1299__D Tile_X0Y0_FrameData[24] VPWR VGND sg13cmos5l_antennanp
XFILLER_179_23 VPWR VGND sg13cmos5l_fill_2
XFILLER_179_12 VPWR VGND sg13cmos5l_decap_4
XANTENNA__2325__X Tile_X0Y2_FrameData_O[1] VPWR VGND sg13cmos5l_antennanp
XFILLER_42_278 VPWR VGND sg13cmos5l_fill_2
XANTENNA__0796__A1 Tile_X0Y0_S1END[3] VPWR VGND sg13cmos5l_antennanp
XFILLER_10_164 VPWR VGND sg13cmos5l_decap_8
XFILLER_195_33 VPWR VGND sg13cmos5l_fill_2
XFILLER_195_294 VPWR VGND sg13cmos5l_fill_1
XFILLER_195_22 VPWR VGND sg13cmos5l_fill_1
XFILLER_155_158 VPWR VGND sg13cmos5l_decap_8
XFILLER_128_82 VPWR VGND sg13cmos5l_fill_1
XFILLER_128_93 VPWR VGND sg13cmos5l_decap_8
XANTENNA__1762__D Tile_X0Y2_FrameData[25] VPWR VGND sg13cmos5l_antennanp
XFILLER_77_131 VPWR VGND sg13cmos5l_decap_8
XFILLER_77_142 VPWR VGND sg13cmos5l_fill_2
XANTENNA__0720__A1 Tile_X0Y0_W2END[7] VPWR VGND sg13cmos5l_antennanp
X_1060_ _1060_/Y _1060_/A VPWR VGND sg13cmos5l_inv_1
XFILLER_92_134 VPWR VGND sg13cmos5l_decap_8
XFILLER_33_201 VPWR VGND sg13cmos5l_fill_1
XFILLER_160_91 VPWR VGND sg13cmos5l_fill_1
XANTENNA__2235__X Tile_X0Y1_EE4BEG[8] VPWR VGND sg13cmos5l_antennanp
X_1962_ _1962_/Q Tile_X0Y3_FrameData[9] Tile_X0Y3_FrameStrobe[0] VPWR VGND sg13cmos5l_dlhq_1
XANTENNA__0787__A1 Tile_X0Y0_W6END[10] VPWR VGND sg13cmos5l_antennanp
XANTENNA__1937__D Tile_X0Y2_FrameData[10] VPWR VGND sg13cmos5l_antennanp
XANTENNA__2150__GATE Tile_X0Y3_FrameStrobe[6] VPWR VGND sg13cmos5l_antennanp
X_1893_ _1893_/Q Tile_X0Y2_FrameData[22] Tile_X0Y3_FrameStrobe[6] VPWR VGND sg13cmos5l_dlhq_1
X_0913_ _0914_/A _0870_/X _0521_/X Tile_X0Y3_N4END[8] Tile_X0Y0_S4END[4] _1482_/Q
+ _1483_/Q VPWR VGND sg13cmos5l_mux4_1
X_0844_ _2489_/A AXIL_S_SOC_AWADDR1 AXIL_S_SOC_AWADDR9 _0643_/X _0755_/X _1349_/Q
+ _1348_/Q VPWR VGND sg13cmos5l_mux4_1
XFILLER_161_128 VPWR VGND sg13cmos5l_fill_2
XFILLER_161_139 VPWR VGND sg13cmos5l_decap_8
X_0775_ _0775_/X _0752_/X Tile_X0Y0_S1END[1] Tile_X0Y3_N4END[13] Tile_X0Y0_S4END[1]
+ _1248_/Q _1249_/Q VPWR VGND sg13cmos5l_mux4_1
XANTENNA__2165__GATE Tile_X0Y3_FrameStrobe[7] VPWR VGND sg13cmos5l_antennanp
XANTENNA__2411__A Tile_X0Y3_FrameStrobe[17] VPWR VGND sg13cmos5l_antennanp
X_2514_ Tile_X0Y3_E6BEG[0] _2514_/A VPWR VGND sg13cmos5l_buf_1
XFILLER_45_0 VPWR VGND sg13cmos5l_fill_1
XANTENNA__1672__D Tile_X0Y1_FrameData[27] VPWR VGND sg13cmos5l_antennanp
X_2445_ Tile_X0Y0_FrameData_O[31] Tile_X0Y0_FrameData[31] VPWR VGND sg13cmos5l_buf_1
XFILLER_68_120 VPWR VGND sg13cmos5l_fill_1
X_2376_ Tile_X0Y0_N2BEGb[2] _2376_/A VPWR VGND sg13cmos5l_buf_1
XANTENNA__0711__A1 Tile_X0Y2_W2END[4] VPWR VGND sg13cmos5l_antennanp
X_1327_ _1327_/Q Tile_X0Y0_FrameData[28] Tile_X0Y3_FrameStrobe[4] VPWR VGND sg13cmos5l_dlhq_1
XFILLER_68_197 VPWR VGND sg13cmos5l_decap_8
XFILLER_110_294 VPWR VGND sg13cmos5l_fill_1
X_1258_ _1258_/Q Tile_X0Y0_FrameData[1] Tile_X0Y3_FrameStrobe[1] VPWR VGND sg13cmos5l_dlhq_1
XFILLER_216_129 VPWR VGND sg13cmos5l_decap_4
XANTENNA__2103__GATE Tile_X0Y3_FrameStrobe[5] VPWR VGND sg13cmos5l_antennanp
X_1189_ _1190_/B _2163_/Q _0536_/X _1188_/Y VPWR VGND sg13cmos5l_o21ai_1
XFILLER_83_178 VPWR VGND sg13cmos5l_fill_1
XFILLER_83_167 VPWR VGND sg13cmos5l_decap_8
XFILLER_209_192 VPWR VGND sg13cmos5l_decap_8
XANTENNA__2008__D Tile_X0Y3_FrameData[27] VPWR VGND sg13cmos5l_antennanp
XFILLER_169_228 VPWR VGND sg13cmos5l_fill_1
XANTENNA__0778__A1 Tile_X0Y0_S1END[1] VPWR VGND sg13cmos5l_antennanp
XANTENNA__1847__D Tile_X0Y2_FrameData[4] VPWR VGND sg13cmos5l_antennanp
XANTENNA__2118__GATE Tile_X0Y3_FrameStrobe[5] VPWR VGND sg13cmos5l_antennanp
XFILLER_192_220 VPWR VGND sg13cmos5l_decap_4
XANTENNA__1374__GATE Tile_X0Y3_FrameStrobe[5] VPWR VGND sg13cmos5l_antennanp
XANTENNA__1582__D Tile_X0Y1_FrameData[21] VPWR VGND sg13cmos5l_antennanp
XANTENNA__0950__A1 Tile_X0Y1_WW4END[3] VPWR VGND sg13cmos5l_antennanp
XANTENNA__1389__GATE Tile_X0Y3_FrameStrobe[6] VPWR VGND sg13cmos5l_antennanp
XFILLER_59_120 VPWR VGND sg13cmos5l_decap_8
XFILLER_181_24 VPWR VGND sg13cmos5l_decap_8
XFILLER_101_250 VPWR VGND sg13cmos5l_decap_8
XFILLER_181_35 VPWR VGND sg13cmos5l_decap_4
XANTENNA__0702__A1 Tile_X0Y3_W2END[5] VPWR VGND sg13cmos5l_antennanp
XANTENNA__1312__GATE Tile_X0Y3_FrameStrobe[3] VPWR VGND sg13cmos5l_antennanp
XFILLER_101_294 VPWR VGND sg13cmos5l_fill_1
XFILLER_114_84 VPWR VGND sg13cmos5l_fill_2
XANTENNA__1942__GATE Tile_X0Y3_FrameStrobe[0] VPWR VGND sg13cmos5l_antennanp
XANTENNA__1327__GATE Tile_X0Y3_FrameStrobe[4] VPWR VGND sg13cmos5l_antennanp
XFILLER_15_278 VPWR VGND sg13cmos5l_decap_4
XANTENNA__1957__GATE Tile_X0Y3_FrameStrobe[0] VPWR VGND sg13cmos5l_antennanp
XANTENNA__1757__D Tile_X0Y2_FrameData[30] VPWR VGND sg13cmos5l_antennanp
XFILLER_168_261 VPWR VGND sg13cmos5l_decap_8
XFILLER_209_18 VPWR VGND sg13cmos5l_fill_2
XANTENNA__1194__A1 Tile_X0Y2_W6END[10] VPWR VGND sg13cmos5l_antennanp
X_0560_ _0564_/B Tile_X0Y2_W1END[1] Tile_X0Y2_W6END[9] _0554_/X _0559_/X _1901_/Q
+ _1900_/Q VPWR VGND sg13cmos5l_mux4_1
XANTENNA__1492__D Tile_X0Y1_FrameData[15] VPWR VGND sg13cmos5l_antennanp
X_0491_ _0491_/Y _0433_/Y _1197_/Q _1444_/Q _0489_/Y _0490_/Y VPWR VGND sg13cmos5l_a221oi_1
XFILLER_155_80 VPWR VGND sg13cmos5l_fill_2
X_2230_ Tile_X0Y1_EE4BEG[3] _2230_/A VPWR VGND sg13cmos5l_buf_1
XFILLER_97_226 VPWR VGND sg13cmos5l_decap_8
XFILLER_2_171 VPWR VGND sg13cmos5l_decap_4
X_2161_ _2161_/Q Tile_X0Y3_FrameData[2] Tile_X0Y3_FrameStrobe[6] VPWR VGND sg13cmos5l_dlhq_1
X_1112_ _1112_/X _0937_/X _0501_/B Tile_X0Y3_N4END[7] Tile_X0Y0_S4END[11] _1740_/Q
+ _1741_/Q VPWR VGND sg13cmos5l_mux4_1
X_2092_ _2092_/Q Tile_X0Y3_FrameData[7] Tile_X0Y3_FrameStrobe[4] VPWR VGND sg13cmos5l_dlhq_1
X_1043_ _1043_/Y Tile_X0Y2_W6END[9] _1912_/Q _1911_/Q VPWR VGND sg13cmos5l_o21ai_1
XFILLER_0_85 VPWR VGND sg13cmos5l_fill_1
XFILLER_0_96 VPWR VGND sg13cmos5l_decap_4
XFILLER_80_159 VPWR VGND sg13cmos5l_decap_8
XANTENNA__2406__A Tile_X0Y3_FrameStrobe[12] VPWR VGND sg13cmos5l_antennanp
XFILLER_21_215 VPWR VGND sg13cmos5l_fill_2
XANTENNA__1667__D Tile_X0Y1_FrameData[0] VPWR VGND sg13cmos5l_antennanp
XFILLER_159_261 VPWR VGND sg13cmos5l_fill_1
XFILLER_166_209 VPWR VGND sg13cmos5l_fill_1
X_1945_ _1945_/Q Tile_X0Y3_FrameData[26] Tile_X0Y3_FrameStrobe[0] VPWR VGND sg13cmos5l_dlhq_1
XFILLER_9_61 VPWR VGND sg13cmos5l_decap_8
XFILLER_119_147 VPWR VGND sg13cmos5l_decap_8
X_1876_ _1876_/Q Tile_X0Y2_FrameData[7] Tile_X0Y3_FrameStrobe[5] VPWR VGND sg13cmos5l_dlhq_1
X_0827_ _2484_/A AXIL_S_SOC_WSTRB1 AXIL_S_SOC_AWADDR4 _0653_/X _0736_/X _1359_/Q _1358_/Q
+ VPWR VGND sg13cmos5l_mux4_1
XFILLER_127_191 VPWR VGND sg13cmos5l_decap_8
X_0758_ _0758_/X _0757_/X _0601_/X Tile_X0Y3_N2MID[7] _0756_/X _1700_/Q _1701_/Q VPWR
+ VGND sg13cmos5l_mux4_1
XFILLER_142_150 VPWR VGND sg13cmos5l_decap_8
X_0689_ _2514_/A Tile_X0Y3_N4END[0] Tile_X0Y0_S4END[12] _0507_/X _0508_/X _2043_/Q
+ _2042_/Q VPWR VGND sg13cmos5l_mux4_1
X_2428_ Tile_X0Y0_FrameData_O[14] Tile_X0Y0_FrameData[14] VPWR VGND sg13cmos5l_buf_1
XFILLER_88_259 VPWR VGND sg13cmos5l_fill_1
X_2359_ Tile_X0Y0_N4BEG[1] _2359_/A VPWR VGND sg13cmos5l_buf_1
XFILLER_215_94 VPWR VGND sg13cmos5l_decap_8
XANTENNA__0696__A0 AXIL_S_SOC_ARADDR2 VPWR VGND sg13cmos5l_antennanp
XANTENNA__2042__GATE Tile_X0Y3_FrameStrobe[3] VPWR VGND sg13cmos5l_antennanp
XFILLER_71_148 VPWR VGND sg13cmos5l_decap_8
XANTENNA__2057__GATE Tile_X0Y3_FrameStrobe[3] VPWR VGND sg13cmos5l_antennanp
XANTENNA__1577__D Tile_X0Y1_FrameData[26] VPWR VGND sg13cmos5l_antennanp
XFILLER_157_209 VPWR VGND sg13cmos5l_fill_1
XANTENNA__2603__X Tile_X0Y3_S4BEG[9] VPWR VGND sg13cmos5l_antennanp
XFILLER_20_292 VPWR VGND sg13cmos5l_fill_2
XFILLER_125_117 VPWR VGND sg13cmos5l_decap_8
XFILLER_165_275 VPWR VGND sg13cmos5l_decap_8
XFILLER_165_286 VPWR VGND sg13cmos5l_fill_1
XFILLER_180_223 VPWR VGND sg13cmos5l_decap_8
XANTENNA__1176__A1 Tile_X0Y2_W6END[8] VPWR VGND sg13cmos5l_antennanp
XFILLER_69_33 VPWR VGND sg13cmos5l_fill_1
XFILLER_69_99 VPWR VGND sg13cmos5l_decap_8
XFILLER_94_207 VPWR VGND sg13cmos5l_decap_4
XANTENNA__1251__GATE Tile_X0Y3_FrameStrobe[1] VPWR VGND sg13cmos5l_antennanp
XANTENNA__1881__GATE Tile_X0Y3_FrameStrobe[5] VPWR VGND sg13cmos5l_antennanp
XFILLER_62_104 VPWR VGND sg13cmos5l_decap_8
XANTENNA__1266__GATE Tile_X0Y3_FrameStrobe[2] VPWR VGND sg13cmos5l_antennanp
XANTENNA__1896__GATE Tile_X0Y3_FrameStrobe[6] VPWR VGND sg13cmos5l_antennanp
XFILLER_148_209 VPWR VGND sg13cmos5l_decap_8
XFILLER_203_187 VPWR VGND sg13cmos5l_decap_8
XANTENNA__1487__D Tile_X0Y1_FrameData[20] VPWR VGND sg13cmos5l_antennanp
XANTENNA__0611__A0 Tile_X0Y3_N1END[1] VPWR VGND sg13cmos5l_antennanp
XANTENNA__2513__X Tile_X0Y3_E2BEGb[7] VPWR VGND sg13cmos5l_antennanp
XFILLER_11_292 VPWR VGND sg13cmos5l_fill_2
X_1730_ _1730_/Q Tile_X0Y2_FrameData[25] Tile_X0Y3_FrameStrobe[1] VPWR VGND sg13cmos5l_dlhq_1
X_1661_ _1661_/Q Tile_X0Y1_FrameData[6] Tile_X0Y3_FrameStrobe[6] VPWR VGND sg13cmos5l_dlhq_1
XANTENNA__1204__GATE Tile_X0Y3_FrameStrobe[0] VPWR VGND sg13cmos5l_antennanp
X_0612_ _0613_/B _0610_/X _0611_/X _2124_/Q VPWR VGND sg13cmos5l_mux2_1
XANTENNA__1834__GATE Tile_X0Y3_FrameStrobe[4] VPWR VGND sg13cmos5l_antennanp
X_1592_ _1592_/Q Tile_X0Y1_FrameData[11] Tile_X0Y3_FrameStrobe[4] VPWR VGND sg13cmos5l_dlhq_1
XANTENNA__2111__D Tile_X0Y3_FrameData[20] VPWR VGND sg13cmos5l_antennanp
X_0543_ _0543_/Y _1200_/Q Tile_X0Y0_W6END[1] VPWR VGND sg13cmos5l_nand2b_1
X_0474_ _0475_/C _1695_/Q _0936_/X VPWR VGND sg13cmos5l_nor2_1
XANTENNA__1219__GATE Tile_X0Y3_FrameStrobe[0] VPWR VGND sg13cmos5l_antennanp
XANTENNA__1950__D Tile_X0Y3_FrameData[21] VPWR VGND sg13cmos5l_antennanp
X_2213_ Tile_X0Y1_E2BEGb[6] _2213_/A VPWR VGND sg13cmos5l_buf_1
XANTENNA__0678__A0 AXIL_S_SOC_ARADDR0 VPWR VGND sg13cmos5l_antennanp
XANTENNA__1849__GATE Tile_X0Y3_FrameStrobe[4] VPWR VGND sg13cmos5l_antennanp
X_2144_ _2144_/Q Tile_X0Y3_FrameData[19] Tile_X0Y3_FrameStrobe[6] VPWR VGND sg13cmos5l_dlhq_1
XFILLER_38_178 VPWR VGND sg13cmos5l_decap_8
X_2075_ _2075_/Q Tile_X0Y3_FrameData[24] Tile_X0Y3_FrameStrobe[4] VPWR VGND sg13cmos5l_dlhq_1
XFILLER_53_148 VPWR VGND sg13cmos5l_fill_2
X_1026_ _2216_/A Tile_X0Y3_N4END[9] _0932_/A Tile_X0Y0_S4END[5] _0465_/X _1544_/Q
+ _1545_/Q VPWR VGND sg13cmos5l_mux4_1
XFILLER_201_41 VPWR VGND sg13cmos5l_fill_2
XANTENNA__0850__A0 AXIL_S_SOC_AWVALID VPWR VGND sg13cmos5l_antennanp
XANTENNA__1397__D Tile_X0Y0_FrameData[22] VPWR VGND sg13cmos5l_antennanp
XANTENNA__0602__A0 Tile_X0Y3_N2MID[7] VPWR VGND sg13cmos5l_antennanp
XANTENNA__2423__X Tile_X0Y0_FrameData_O[9] VPWR VGND sg13cmos5l_antennanp
X_1928_ _1928_/Q Tile_X0Y2_FrameData[19] Tile_X0Y3_FrameStrobe[7] VPWR VGND sg13cmos5l_dlhq_1
XFILLER_147_275 VPWR VGND sg13cmos5l_decap_4
X_1859_ _1859_/Q Tile_X0Y2_FrameData[24] Tile_X0Y3_FrameStrobe[5] VPWR VGND sg13cmos5l_dlhq_1
XFILLER_162_256 VPWR VGND sg13cmos5l_decap_4
XANTENNA__2021__D Tile_X0Y3_FrameData[14] VPWR VGND sg13cmos5l_antennanp
XFILLER_130_153 VPWR VGND sg13cmos5l_decap_8
XFILLER_39_25 VPWR VGND sg13cmos5l_decap_8
XANTENNA__1860__D Tile_X0Y2_FrameData[23] VPWR VGND sg13cmos5l_antennanp
XFILLER_162_59 VPWR VGND sg13cmos5l_fill_2
XFILLER_39_69 VPWR VGND sg13cmos5l_decap_4
XFILLER_190_7 VPWR VGND sg13cmos5l_decap_8
XANTENNA__0669__A0 AXIL_S_SOC_ARVALID VPWR VGND sg13cmos5l_antennanp
XFILLER_44_104 VPWR VGND sg13cmos5l_fill_2
XANTENNA__1094__A0 AXIL_S_SOC_WDATA2 VPWR VGND sg13cmos5l_antennanp
XFILLER_225_290 VPWR VGND sg13cmos5l_decap_4
XFILLER_197_120 VPWR VGND sg13cmos5l_decap_8
XANTENNA__0841__A0 AXIL_S_SOC_WSTRB0 VPWR VGND sg13cmos5l_antennanp
XFILLER_111_96 VPWR VGND sg13cmos5l_fill_1
XFILLER_71_45 VPWR VGND sg13cmos5l_fill_2
XFILLER_197_186 VPWR VGND sg13cmos5l_decap_4
XANTENNA__2333__X Tile_X0Y2_FrameData_O[9] VPWR VGND sg13cmos5l_antennanp
XFILLER_200_168 VPWR VGND sg13cmos5l_decap_8
XFILLER_138_264 VPWR VGND sg13cmos5l_decap_8
XFILLER_112_0 VPWR VGND sg13cmos5l_decap_8
XANTENNA__1149__A1 Tile_X0Y2_WW4END[15] VPWR VGND sg13cmos5l_antennanp
XFILLER_106_183 VPWR VGND sg13cmos5l_decap_8
XFILLER_96_53 VPWR VGND sg13cmos5l_decap_8
XANTENNA__1770__D Tile_X0Y2_FrameData[17] VPWR VGND sg13cmos5l_antennanp
XFILLER_222_18 VPWR VGND sg13cmos5l_fill_1
XFILLER_75_273 VPWR VGND sg13cmos5l_decap_8
XFILLER_222_29 VPWR VGND sg13cmos5l_fill_1
XANTENNA__2508__X Tile_X0Y3_E2BEGb[2] VPWR VGND sg13cmos5l_antennanp
XFILLER_208_257 VPWR VGND sg13cmos5l_decap_8
XFILLER_90_243 VPWR VGND sg13cmos5l_fill_2
XANTENNA__2106__D Tile_X0Y3_FrameData[25] VPWR VGND sg13cmos5l_antennanp
XFILLER_84_4 VPWR VGND sg13cmos5l_fill_1
XANTENNA__2243__X Tile_X0Y1_FrameData_O[0] VPWR VGND sg13cmos5l_antennanp
XFILLER_129_220 VPWR VGND sg13cmos5l_decap_4
XANTENNA__1945__D Tile_X0Y3_FrameData[26] VPWR VGND sg13cmos5l_antennanp
X_1713_ _1713_/Q Tile_X0Y2_FrameData[10] Tile_X0Y3_FrameStrobe[0] VPWR VGND sg13cmos5l_dlhq_1
XANTENNA__1773__GATE Tile_X0Y3_FrameStrobe[2] VPWR VGND sg13cmos5l_antennanp
X_1644_ _1644_/Q Tile_X0Y1_FrameData[23] Tile_X0Y3_FrameStrobe[6] VPWR VGND sg13cmos5l_dlhq_1
X_1575_ _1575_/Q Tile_X0Y1_FrameData[28] Tile_X0Y3_FrameStrobe[4] VPWR VGND sg13cmos5l_dlhq_1
XANTENNA__0899__A0 AXIL_S_SOC_WSTRB0 VPWR VGND sg13cmos5l_antennanp
X_0526_ _0526_/Y _1450_/Q _0526_/B _0526_/C VPWR VGND sg13cmos5l_nor3_1
XANTENNA__1680__D Tile_X0Y1_FrameData[19] VPWR VGND sg13cmos5l_antennanp
XANTENNA__1788__GATE Tile_X0Y3_FrameStrobe[3] VPWR VGND sg13cmos5l_antennanp
XFILLER_58_218 VPWR VGND sg13cmos5l_decap_4
XFILLER_112_197 VPWR VGND sg13cmos5l_decap_4
X_0457_ _1187_/A _2162_/Q VPWR VGND sg13cmos5l_inv_1
XANTENNA__1711__GATE Tile_X0Y3_FrameStrobe[0] VPWR VGND sg13cmos5l_antennanp
XANTENNA__2418__X Tile_X0Y0_FrameData_O[4] VPWR VGND sg13cmos5l_antennanp
X_2127_ _2127_/Q Tile_X0Y3_FrameData[4] Tile_X0Y3_FrameStrobe[5] VPWR VGND sg13cmos5l_dlhq_1
X_2058_ _2058_/Q Tile_X0Y3_FrameData[9] Tile_X0Y3_FrameStrobe[3] VPWR VGND sg13cmos5l_dlhq_1
XFILLER_26_148 VPWR VGND sg13cmos5l_fill_1
XFILLER_214_238 VPWR VGND sg13cmos5l_decap_4
XFILLER_212_73 VPWR VGND sg13cmos5l_decap_8
X_1009_ AXIL_S_SOC_RDATA30 Tile_X0Y1_W1END[2] Tile_X0Y1_W6END[10] Tile_X0Y1_WW4END[13]
+ _0469_/Y _1502_/Q _1503_/Q VPWR VGND sg13cmos5l_mux4_1
XFILLER_41_107 VPWR VGND sg13cmos5l_fill_1
XANTENNA__1726__GATE Tile_X0Y3_FrameStrobe[1] VPWR VGND sg13cmos5l_antennanp
XFILLER_194_123 VPWR VGND sg13cmos5l_fill_2
XFILLER_194_112 VPWR VGND sg13cmos5l_decap_8
XFILLER_179_186 VPWR VGND sg13cmos5l_decap_8
XANTENNA__2016__D Tile_X0Y3_FrameData[19] VPWR VGND sg13cmos5l_antennanp
XANTENNA__1855__D Tile_X0Y2_FrameData[28] VPWR VGND sg13cmos5l_antennanp
XFILLER_150_237 VPWR VGND sg13cmos5l_decap_4
XFILLER_1_203 VPWR VGND sg13cmos5l_fill_2
XANTENNA__1000__A0 AXIL_S_SOC_WDATA22 VPWR VGND sg13cmos5l_antennanp
XANTENNA__1590__D Tile_X0Y1_FrameData[13] VPWR VGND sg13cmos5l_antennanp
XFILLER_103_153 VPWR VGND sg13cmos5l_decap_4
XFILLER_106_63 VPWR VGND sg13cmos5l_decap_4
XFILLER_103_197 VPWR VGND sg13cmos5l_decap_8
XFILLER_66_67 VPWR VGND sg13cmos5l_decap_8
XANTENNA__2328__X Tile_X0Y2_FrameData_O[4] VPWR VGND sg13cmos5l_antennanp
XFILLER_174_2 VPWR VGND sg13cmos5l_fill_1
XFILLER_122_51 VPWR VGND sg13cmos5l_decap_8
XFILLER_198_11 VPWR VGND sg13cmos5l_fill_1
XFILLER_15_60 VPWR VGND sg13cmos5l_fill_2
XFILLER_198_77 VPWR VGND sg13cmos5l_decap_8
XANTENNA__1765__D Tile_X0Y2_FrameData[22] VPWR VGND sg13cmos5l_antennanp
XANTENNA__0593__A2 Tile_X0Y1_W2MID[2] VPWR VGND sg13cmos5l_antennanp
XFILLER_126_278 VPWR VGND sg13cmos5l_decap_4
XFILLER_141_237 VPWR VGND sg13cmos5l_decap_8
X_1360_ _1360_/Q Tile_X0Y0_FrameData[27] Tile_X0Y3_FrameStrobe[5] VPWR VGND sg13cmos5l_dlhq_1
X_1291_ _1291_/Q Tile_X0Y0_FrameData[0] Tile_X0Y3_FrameStrobe[2] VPWR VGND sg13cmos5l_dlhq_1
XANTENNA__2238__X Tile_X0Y1_EE4BEG[11] VPWR VGND sg13cmos5l_antennanp
XFILLER_63_254 VPWR VGND sg13cmos5l_fill_1
XFILLER_63_276 VPWR VGND sg13cmos5l_decap_4
XFILLER_204_293 VPWR VGND sg13cmos5l_fill_2
XFILLER_176_123 VPWR VGND sg13cmos5l_fill_1
XFILLER_176_112 VPWR VGND sg13cmos5l_decap_8
XANTENNA__2414__A Tile_X0Y0_FrameData[0] VPWR VGND sg13cmos5l_antennanp
XFILLER_75_0 VPWR VGND sg13cmos5l_decap_4
XFILLER_191_115 VPWR VGND sg13cmos5l_fill_2
XANTENNA__1675__D Tile_X0Y1_FrameData[24] VPWR VGND sg13cmos5l_antennanp
XFILLER_11_29 VPWR VGND sg13cmos5l_fill_2
XFILLER_117_267 VPWR VGND sg13cmos5l_decap_8
X_1627_ _1627_/Q Tile_X0Y1_FrameData[8] Tile_X0Y3_FrameStrobe[5] VPWR VGND sg13cmos5l_dlhq_1
XFILLER_100_101 VPWR VGND sg13cmos5l_fill_1
X_1558_ _1558_/Q Tile_X0Y1_FrameData[13] Tile_X0Y3_FrameStrobe[3] VPWR VGND sg13cmos5l_dlhq_1
XFILLER_140_281 VPWR VGND sg13cmos5l_fill_2
X_1489_ _1489_/Q Tile_X0Y1_FrameData[18] Tile_X0Y3_FrameStrobe[1] VPWR VGND sg13cmos5l_dlhq_1
X_0509_ _2589_/A Tile_X0Y2_W2MID[4] Tile_X0Y2_W2END[4] Tile_X0Y2_W6END[11] _0746_/X
+ _1889_/Q _1888_/Q VPWR VGND sg13cmos5l_mux4_1
XANTENNA__1650__GATE Tile_X0Y3_FrameStrobe[6] VPWR VGND sg13cmos5l_antennanp
XANTENNA__0639__A3 AXIL_S_SOC_ARADDR2 VPWR VGND sg13cmos5l_antennanp
XFILLER_54_254 VPWR VGND sg13cmos5l_fill_2
XFILLER_54_243 VPWR VGND sg13cmos5l_fill_1
XFILLER_36_59 VPWR VGND sg13cmos5l_decap_4
XANTENNA__1665__GATE Tile_X0Y3_FrameStrobe[6] VPWR VGND sg13cmos5l_antennanp
XFILLER_160_8 VPWR VGND sg13cmos5l_fill_1
XANTENNA__2324__A Tile_X0Y2_FrameData[0] VPWR VGND sg13cmos5l_antennanp
XFILLER_210_241 VPWR VGND sg13cmos5l_decap_8
XFILLER_168_69 VPWR VGND sg13cmos5l_fill_2
XFILLER_210_274 VPWR VGND sg13cmos5l_fill_1
XANTENNA__1585__D Tile_X0Y1_FrameData[18] VPWR VGND sg13cmos5l_antennanp
XFILLER_108_267 VPWR VGND sg13cmos5l_decap_8
XANTENNA__1603__GATE Tile_X0Y3_FrameStrobe[4] VPWR VGND sg13cmos5l_antennanp
XFILLER_108_278 VPWR VGND sg13cmos5l_fill_1
XFILLER_123_204 VPWR VGND sg13cmos5l_fill_1
XFILLER_184_79 VPWR VGND sg13cmos5l_decap_8
XFILLER_131_270 VPWR VGND sg13cmos5l_decap_8
XANTENNA__1618__GATE Tile_X0Y3_FrameStrobe[5] VPWR VGND sg13cmos5l_antennanp
XFILLER_45_276 VPWR VGND sg13cmos5l_decap_8
XFILLER_45_265 VPWR VGND sg13cmos5l_decap_4
XFILLER_201_230 VPWR VGND sg13cmos5l_decap_8
X_0860_ _0860_/X Tile_X0Y2_W1END[2] _0471_/X Tile_X0Y2_W6END[6] _0476_/X _1934_/Q
+ _1935_/Q VPWR VGND sg13cmos5l_mux4_1
XFILLER_201_274 VPWR VGND sg13cmos5l_fill_1
XANTENNA__1495__D Tile_X0Y1_FrameData[12] VPWR VGND sg13cmos5l_antennanp
X_0791_ _0791_/X Tile_X0Y0_W1END[0] Tile_X0Y0_WW4END[12] _0762_/X _0760_/X _1383_/Q
+ _1381_/Q VPWR VGND sg13cmos5l_mux4_1
XANTENNA__2521__X Tile_X0Y3_E6BEG[7] VPWR VGND sg13cmos5l_antennanp
X_2530_ Tile_X0Y3_EE4BEG[4] _2530_/A VPWR VGND sg13cmos5l_buf_1
X_2461_ Tile_X0Y0_EE4BEG[15] _2461_/A VPWR VGND sg13cmos5l_buf_1
XFILLER_114_259 VPWR VGND sg13cmos5l_fill_2
X_1412_ _1412_/Q Tile_X0Y0_FrameData[7] Tile_X0Y3_FrameStrobe[6] VPWR VGND sg13cmos5l_dlhq_1
X_2392_ Tile_X0Y0_N1BEG[2] _2392_/A VPWR VGND sg13cmos5l_buf_1
XANTENNA__0869__A3 Tile_X0Y0_S2MID[4] VPWR VGND sg13cmos5l_antennanp
X_1343_ _1343_/Q Tile_X0Y0_FrameData[12] Tile_X0Y3_FrameStrobe[4] VPWR VGND sg13cmos5l_dlhq_1
XFILLER_3_74 VPWR VGND sg13cmos5l_fill_1
X_1274_ _1274_/Q Tile_X0Y0_FrameData[17] Tile_X0Y3_FrameStrobe[2] VPWR VGND sg13cmos5l_dlhq_1
XANTENNA__2409__A Tile_X0Y3_FrameStrobe[15] VPWR VGND sg13cmos5l_antennanp
XFILLER_149_123 VPWR VGND sg13cmos5l_decap_8
XFILLER_164_104 VPWR VGND sg13cmos5l_fill_2
X_0989_ _0993_/A _1628_/Q _0923_/Y _0988_/Y VPWR VGND sg13cmos5l_a21oi_1
XANTENNA__2431__X Tile_X0Y0_FrameData_O[17] VPWR VGND sg13cmos5l_antennanp
XFILLER_105_259 VPWR VGND sg13cmos5l_fill_2
XFILLER_154_38 VPWR VGND sg13cmos5l_fill_2
XFILLER_86_154 VPWR VGND sg13cmos5l_fill_1
XFILLER_170_59 VPWR VGND sg13cmos5l_fill_1
XFILLER_63_13 VPWR VGND sg13cmos5l_fill_1
XANTENNA__2606__X Tile_X0Y3_S4BEG[12] VPWR VGND sg13cmos5l_antennanp
XFILLER_42_224 VPWR VGND sg13cmos5l_fill_1
XFILLER_42_213 VPWR VGND sg13cmos5l_decap_8
XFILLER_179_46 VPWR VGND sg13cmos5l_decap_8
XANTENNA__0796__A2 Tile_X0Y3_N4END[15] VPWR VGND sg13cmos5l_antennanp
XFILLER_10_143 VPWR VGND sg13cmos5l_decap_4
XFILLER_50_290 VPWR VGND sg13cmos5l_decap_4
XANTENNA__1542__GATE Tile_X0Y3_FrameStrobe[3] VPWR VGND sg13cmos5l_antennanp
XANTENNA__2341__X Tile_X0Y2_FrameData_O[17] VPWR VGND sg13cmos5l_antennanp
XFILLER_6_147 VPWR VGND sg13cmos5l_decap_8
XFILLER_88_21 VPWR VGND sg13cmos5l_decap_8
XFILLER_5_0 VPWR VGND sg13cmos5l_decap_4
XANTENNA__1557__GATE Tile_X0Y3_FrameStrobe[3] VPWR VGND sg13cmos5l_antennanp
XANTENNA__0720__A2 Tile_X0Y0_W6END[7] VPWR VGND sg13cmos5l_antennanp
XFILLER_92_113 VPWR VGND sg13cmos5l_decap_8
XFILLER_225_108 VPWR VGND sg13cmos5l_fill_1
XFILLER_18_243 VPWR VGND sg13cmos5l_fill_2
XFILLER_160_70 VPWR VGND sg13cmos5l_fill_2
XANTENNA__2516__X Tile_X0Y3_E6BEG[2] VPWR VGND sg13cmos5l_antennanp
X_1961_ _1961_/Q Tile_X0Y3_FrameData[10] Tile_X0Y3_FrameStrobe[0] VPWR VGND sg13cmos5l_dlhq_1
X_1892_ _1892_/Q Tile_X0Y2_FrameData[23] Tile_X0Y3_FrameStrobe[6] VPWR VGND sg13cmos5l_dlhq_1
X_0912_ _0912_/Y _0912_/A _0912_/B VPWR VGND sg13cmos5l_nor2_1
XANTENNA__0787__A2 Tile_X0Y0_WW4END[2] VPWR VGND sg13cmos5l_antennanp
X_0843_ _2479_/A AXIL_S_SOC_AWVALID AXIL_S_SOC_AWADDR7 _0653_/X _0736_/X _1337_/Q
+ _1336_/Q VPWR VGND sg13cmos5l_mux4_1
XANTENNA__2114__D Tile_X0Y3_FrameData[17] VPWR VGND sg13cmos5l_antennanp
XANTENNA__2251__X Tile_X0Y1_FrameData_O[8] VPWR VGND sg13cmos5l_antennanp
X_2513_ Tile_X0Y3_E2BEGb[7] _2513_/A VPWR VGND sg13cmos5l_buf_1
X_0774_ _0774_/Y _0776_/S _0772_/X _0773_/Y VPWR VGND sg13cmos5l_o21ai_1
XANTENNA__1953__D Tile_X0Y3_FrameData[18] VPWR VGND sg13cmos5l_antennanp
XFILLER_154_192 VPWR VGND sg13cmos5l_decap_8
XFILLER_5_180 VPWR VGND sg13cmos5l_fill_2
X_2444_ Tile_X0Y0_FrameData_O[30] Tile_X0Y0_FrameData[30] VPWR VGND sg13cmos5l_buf_1
XFILLER_124_19 VPWR VGND sg13cmos5l_decap_8
X_2375_ Tile_X0Y0_N2BEGb[1] _2375_/A VPWR VGND sg13cmos5l_buf_1
XFILLER_38_0 VPWR VGND sg13cmos5l_fill_2
X_1326_ _1326_/Q Tile_X0Y0_FrameData[29] Tile_X0Y3_FrameStrobe[4] VPWR VGND sg13cmos5l_dlhq_1
XFILLER_68_132 VPWR VGND sg13cmos5l_fill_2
XANTENNA__0711__A2 Tile_X0Y2_W6END[4] VPWR VGND sg13cmos5l_antennanp
XFILLER_83_113 VPWR VGND sg13cmos5l_decap_8
XFILLER_68_176 VPWR VGND sg13cmos5l_decap_8
X_1257_ _1257_/Q Tile_X0Y0_FrameData[2] Tile_X0Y3_FrameStrobe[1] VPWR VGND sg13cmos5l_dlhq_1
XFILLER_209_160 VPWR VGND sg13cmos5l_decap_4
XFILLER_17_28 VPWR VGND sg13cmos5l_decap_8
XFILLER_140_18 VPWR VGND sg13cmos5l_fill_2
X_1188_ _1188_/Y _2163_/Q _0580_/Y _1187_/A VPWR VGND sg13cmos5l_a21oi_1
XANTENNA__2426__X Tile_X0Y0_FrameData_O[12] VPWR VGND sg13cmos5l_antennanp
XFILLER_224_152 VPWR VGND sg13cmos5l_fill_2
XFILLER_24_246 VPWR VGND sg13cmos5l_decap_8
XFILLER_220_95 VPWR VGND sg13cmos5l_decap_8
XFILLER_177_251 VPWR VGND sg13cmos5l_fill_2
XFILLER_177_240 VPWR VGND sg13cmos5l_decap_8
XANTENNA__0778__A2 Tile_X0Y3_N4END[13] VPWR VGND sg13cmos5l_antennanp
XANTENNA__2024__D Tile_X0Y3_FrameData[11] VPWR VGND sg13cmos5l_antennanp
XFILLER_192_276 VPWR VGND sg13cmos5l_decap_4
XANTENNA__1863__D Tile_X0Y2_FrameData[20] VPWR VGND sg13cmos5l_antennanp
XFILLER_145_192 VPWR VGND sg13cmos5l_decap_8
XFILLER_3_139 VPWR VGND sg13cmos5l_fill_2
XFILLER_3_128 VPWR VGND sg13cmos5l_decap_8
XFILLER_58_13 VPWR VGND sg13cmos5l_fill_2
XANTENNA__0950__A2 Tile_X0Y1_W6END[11] VPWR VGND sg13cmos5l_antennanp
XFILLER_59_143 VPWR VGND sg13cmos5l_decap_8
XANTENNA__0702__A2 Tile_X0Y3_W6END[5] VPWR VGND sg13cmos5l_antennanp
XFILLER_101_273 VPWR VGND sg13cmos5l_fill_1
XFILLER_114_30 VPWR VGND sg13cmos5l_decap_8
XFILLER_114_41 VPWR VGND sg13cmos5l_fill_2
XFILLER_74_45 VPWR VGND sg13cmos5l_fill_2
XFILLER_74_168 VPWR VGND sg13cmos5l_fill_2
XANTENNA__2336__X Tile_X0Y2_FrameData_O[12] VPWR VGND sg13cmos5l_antennanp
XFILLER_215_163 VPWR VGND sg13cmos5l_decap_8
XFILLER_142_0 VPWR VGND sg13cmos5l_fill_2
XFILLER_90_44 VPWR VGND sg13cmos5l_decap_8
XFILLER_30_249 VPWR VGND sg13cmos5l_decap_8
XFILLER_23_290 VPWR VGND sg13cmos5l_decap_4
XANTENNA__1481__GATE Tile_X0Y3_FrameStrobe[1] VPWR VGND sg13cmos5l_antennanp
XFILLER_128_159 VPWR VGND sg13cmos5l_decap_8
XANTENNA__1773__D Tile_X0Y2_FrameData[14] VPWR VGND sg13cmos5l_antennanp
XFILLER_99_75 VPWR VGND sg13cmos5l_fill_1
XANTENNA__1194__A2 Tile_X0Y2_WW4END[13] VPWR VGND sg13cmos5l_antennanp
XANTENNA__1496__GATE Tile_X0Y3_FrameStrobe[1] VPWR VGND sg13cmos5l_antennanp
X_0490_ _0490_/Y _1197_/Q _1444_/Q _0771_/X VPWR VGND sg13cmos5l_nor3_1
XFILLER_151_184 VPWR VGND sg13cmos5l_decap_4
X_2160_ _2160_/Q Tile_X0Y3_FrameData[3] Tile_X0Y3_FrameStrobe[6] VPWR VGND sg13cmos5l_dlhq_1
X_1111_ _2321_/A AXIL_S_SOC_WDATA1 _1110_/X AXIL_S_SOC_WDATA13 _0725_/X _1800_/Q _1801_/Q
+ VPWR VGND sg13cmos5l_mux4_1
X_2091_ _2091_/Q Tile_X0Y3_FrameData[8] Tile_X0Y3_FrameStrobe[4] VPWR VGND sg13cmos5l_dlhq_1
X_1042_ _1042_/Y _1042_/A VPWR VGND sg13cmos5l_inv_1
XANTENNA__2109__D Tile_X0Y3_FrameData[22] VPWR VGND sg13cmos5l_antennanp
XANTENNA__2246__X Tile_X0Y1_FrameData_O[3] VPWR VGND sg13cmos5l_antennanp
XANTENNA__1434__GATE Tile_X0Y3_FrameStrobe[7] VPWR VGND sg13cmos5l_antennanp
XANTENNA__1948__D Tile_X0Y3_FrameData[23] VPWR VGND sg13cmos5l_antennanp
XFILLER_221_144 VPWR VGND sg13cmos5l_decap_4
X_1944_ _1944_/Q Tile_X0Y3_FrameData[27] Tile_X0Y3_FrameStrobe[0] VPWR VGND sg13cmos5l_dlhq_1
XFILLER_9_40 VPWR VGND sg13cmos5l_fill_1
XFILLER_21_238 VPWR VGND sg13cmos5l_fill_1
XANTENNA__1449__GATE Tile_X0Y3_FrameStrobe[0] VPWR VGND sg13cmos5l_antennanp
X_1875_ _1875_/Q Tile_X0Y2_FrameData[8] Tile_X0Y3_FrameStrobe[5] VPWR VGND sg13cmos5l_dlhq_1
XANTENNA__2422__A Tile_X0Y0_FrameData[8] VPWR VGND sg13cmos5l_antennanp
X_0826_ _2597_/A _0823_/Y _0825_/Y _0821_/Y VPWR VGND sg13cmos5l_o21ai_1
XANTENNA__1683__D Tile_X0Y1_FrameData[16] VPWR VGND sg13cmos5l_antennanp
X_0757_ _0757_/X Tile_X0Y3_W2MID[0] Tile_X0Y3_W2END[0] Tile_X0Y3_W6END[0] _0602_/X
+ _2165_/Q _2164_/Q VPWR VGND sg13cmos5l_mux4_1
XFILLER_88_205 VPWR VGND sg13cmos5l_decap_8
X_2427_ Tile_X0Y0_FrameData_O[13] Tile_X0Y0_FrameData[13] VPWR VGND sg13cmos5l_buf_1
X_0688_ _2541_/A AXIL_S_SOC_RREADY AXIL_S_SOC_BREADY _0607_/X _0580_/A _2045_/Q _2044_/Q
+ VPWR VGND sg13cmos5l_mux4_1
XFILLER_88_249 VPWR VGND sg13cmos5l_decap_4
XFILLER_215_51 VPWR VGND sg13cmos5l_fill_2
XFILLER_215_40 VPWR VGND sg13cmos5l_decap_8
X_2358_ Tile_X0Y0_N4BEG[0] _2358_/A VPWR VGND sg13cmos5l_buf_1
XFILLER_56_102 VPWR VGND sg13cmos5l_decap_8
XFILLER_28_27 VPWR VGND sg13cmos5l_decap_8
XFILLER_151_39 VPWR VGND sg13cmos5l_decap_8
X_1309_ _1309_/Q Tile_X0Y0_FrameData[14] Tile_X0Y3_FrameStrobe[3] VPWR VGND sg13cmos5l_dlhq_1
X_2289_ Tile_X0Y2_E2BEGb[1] _2289_/A VPWR VGND sg13cmos5l_buf_1
XFILLER_96_293 VPWR VGND sg13cmos5l_fill_2
XFILLER_71_105 VPWR VGND sg13cmos5l_decap_8
XANTENNA__2019__D Tile_X0Y3_FrameData[16] VPWR VGND sg13cmos5l_antennanp
XFILLER_71_116 VPWR VGND sg13cmos5l_fill_2
XFILLER_44_15 VPWR VGND sg13cmos5l_decap_4
XFILLER_212_111 VPWR VGND sg13cmos5l_decap_8
XANTENNA__1858__D Tile_X0Y2_FrameData[25] VPWR VGND sg13cmos5l_antennanp
XFILLER_12_227 VPWR VGND sg13cmos5l_fill_1
XFILLER_60_25 VPWR VGND sg13cmos5l_fill_2
XFILLER_165_232 VPWR VGND sg13cmos5l_decap_8
XANTENNA__2332__A Tile_X0Y2_FrameData[8] VPWR VGND sg13cmos5l_antennanp
XANTENNA__1593__D Tile_X0Y1_FrameData[10] VPWR VGND sg13cmos5l_antennanp
XFILLER_118_192 VPWR VGND sg13cmos5l_decap_4
XANTENNA__1176__A2 Tile_X0Y2_WW4END[15] VPWR VGND sg13cmos5l_antennanp
XFILLER_109_96 VPWR VGND sg13cmos5l_decap_4
XFILLER_133_151 VPWR VGND sg13cmos5l_decap_8
XFILLER_79_216 VPWR VGND sg13cmos5l_fill_1
XFILLER_69_78 VPWR VGND sg13cmos5l_decap_8
XFILLER_87_282 VPWR VGND sg13cmos5l_fill_2
XFILLER_85_77 VPWR VGND sg13cmos5l_decap_8
XANTENNA__1100__A2 AXIL_S_SOC_WDATA14 VPWR VGND sg13cmos5l_antennanp
XANTENNA__2164__GATE Tile_X0Y3_FrameStrobe[7] VPWR VGND sg13cmos5l_antennanp
XFILLER_141_94 VPWR VGND sg13cmos5l_decap_8
XANTENNA__1768__D Tile_X0Y2_FrameData[19] VPWR VGND sg13cmos5l_antennanp
XFILLER_203_166 VPWR VGND sg13cmos5l_decap_8
XFILLER_156_221 VPWR VGND sg13cmos5l_decap_8
XFILLER_203_199 VPWR VGND sg13cmos5l_decap_4
XANTENNA__2179__GATE Tile_X0Y3_FrameStrobe[7] VPWR VGND sg13cmos5l_antennanp
XFILLER_156_254 VPWR VGND sg13cmos5l_fill_2
XANTENNA__0611__A1 Tile_X0Y3_N4END[1] VPWR VGND sg13cmos5l_antennanp
XFILLER_156_276 VPWR VGND sg13cmos5l_fill_2
X_1660_ _1660_/Q Tile_X0Y1_FrameData[7] Tile_X0Y3_FrameStrobe[6] VPWR VGND sg13cmos5l_dlhq_1
X_1591_ _1591_/Q Tile_X0Y1_FrameData[12] Tile_X0Y3_FrameStrobe[4] VPWR VGND sg13cmos5l_dlhq_1
X_0611_ _0611_/X Tile_X0Y3_N1END[1] Tile_X0Y3_N4END[1] _0564_/B Tile_X0Y0_S4END[13]
+ _1977_/Q _1976_/Q VPWR VGND sg13cmos5l_mux4_1
XANTENNA__2102__GATE Tile_X0Y3_FrameStrobe[5] VPWR VGND sg13cmos5l_antennanp
X_0542_ _0542_/X _0752_/X Tile_X0Y0_S1END[1] Tile_X0Y3_N4END[13] Tile_X0Y0_S4END[1]
+ _1224_/Q _1225_/Q VPWR VGND sg13cmos5l_mux4_1
X_0473_ _0475_/B Tile_X0Y2_W6END[2] _1695_/Q VPWR VGND sg13cmos5l_nor2b_1
X_2212_ Tile_X0Y1_E2BEGb[5] _2212_/A VPWR VGND sg13cmos5l_buf_1
XANTENNA__0678__A1 AXIL_S_SOC_ARADDR4 VPWR VGND sg13cmos5l_antennanp
XANTENNA__2117__GATE Tile_X0Y3_FrameStrobe[5] VPWR VGND sg13cmos5l_antennanp
X_2143_ _2143_/Q Tile_X0Y3_FrameData[20] Tile_X0Y3_FrameStrobe[6] VPWR VGND sg13cmos5l_dlhq_1
XFILLER_78_293 VPWR VGND sg13cmos5l_fill_2
XFILLER_38_157 VPWR VGND sg13cmos5l_decap_8
XANTENNA__1373__GATE Tile_X0Y3_FrameStrobe[5] VPWR VGND sg13cmos5l_antennanp
X_2074_ _2074_/Q Tile_X0Y3_FrameData[25] Tile_X0Y3_FrameStrobe[4] VPWR VGND sg13cmos5l_dlhq_1
XANTENNA__2417__A Tile_X0Y0_FrameData[3] VPWR VGND sg13cmos5l_antennanp
X_1025_ _2236_/A AXIL_S_SOC_WDATA21 AXIL_S_SOC_WDATA25 _0933_/X _0866_/X _1561_/Q
+ _1560_/Q VPWR VGND sg13cmos5l_mux4_1
XFILLER_46_190 VPWR VGND sg13cmos5l_decap_4
XANTENNA__1678__D Tile_X0Y1_FrameData[21] VPWR VGND sg13cmos5l_antennanp
XANTENNA__0850__A1 AXIL_S_SOC_AWADDR3 VPWR VGND sg13cmos5l_antennanp
XANTENNA__1388__GATE Tile_X0Y3_FrameStrobe[6] VPWR VGND sg13cmos5l_antennanp
XFILLER_14_29 VPWR VGND sg13cmos5l_fill_2
X_1927_ _1927_/Q Tile_X0Y2_FrameData[20] Tile_X0Y3_FrameStrobe[7] VPWR VGND sg13cmos5l_dlhq_1
XANTENNA__0602__A1 Tile_X0Y3_N2END[7] VPWR VGND sg13cmos5l_antennanp
XANTENNA__1311__GATE Tile_X0Y3_FrameStrobe[3] VPWR VGND sg13cmos5l_antennanp
X_1858_ _1858_/Q Tile_X0Y2_FrameData[25] Tile_X0Y3_FrameStrobe[5] VPWR VGND sg13cmos5l_dlhq_1
XFILLER_30_17 VPWR VGND sg13cmos5l_decap_8
XANTENNA__1941__GATE Tile_X0Y3_FrameStrobe[0] VPWR VGND sg13cmos5l_antennanp
XFILLER_146_17 VPWR VGND sg13cmos5l_fill_1
X_0809_ _0809_/Y _1380_/Q _0805_/X _0808_/Y VPWR VGND sg13cmos5l_a21oi_1
XANTENNA__1158__A2 AXIL_S_SOC_WDATA3 VPWR VGND sg13cmos5l_antennanp
XFILLER_115_140 VPWR VGND sg13cmos5l_decap_8
X_1789_ _1789_/Q Tile_X0Y2_FrameData[30] Tile_X0Y3_FrameStrobe[3] VPWR VGND sg13cmos5l_dlhq_1
XANTENNA__0905__A2 Tile_X0Y3_N4END[8] VPWR VGND sg13cmos5l_antennanp
XANTENNA__1326__GATE Tile_X0Y3_FrameStrobe[4] VPWR VGND sg13cmos5l_antennanp
XANTENNA__1956__GATE Tile_X0Y3_FrameStrobe[0] VPWR VGND sg13cmos5l_antennanp
XANTENNA__0669__A1 AXIL_S_SOC_ARADDR7 VPWR VGND sg13cmos5l_antennanp
XANTENNA__0894__X AXIL_S_SOC_ARREADY VPWR VGND sg13cmos5l_antennanp
XFILLER_55_25 VPWR VGND sg13cmos5l_fill_2
XFILLER_217_236 VPWR VGND sg13cmos5l_fill_1
XFILLER_217_225 VPWR VGND sg13cmos5l_decap_8
XFILLER_217_269 VPWR VGND sg13cmos5l_fill_1
XANTENNA__2327__A Tile_X0Y2_FrameData[3] VPWR VGND sg13cmos5l_antennanp
XFILLER_37_190 VPWR VGND sg13cmos5l_decap_8
XANTENNA__1094__A1 AXIL_S_SOC_WDATA10 VPWR VGND sg13cmos5l_antennanp
XANTENNA__1588__D Tile_X0Y1_FrameData[15] VPWR VGND sg13cmos5l_antennanp
XFILLER_52_171 VPWR VGND sg13cmos5l_fill_2
XANTENNA__0841__A1 AXIL_S_SOC_AWADDR3 VPWR VGND sg13cmos5l_antennanp
XFILLER_138_243 VPWR VGND sg13cmos5l_decap_8
XANTENNA__1909__GATE Tile_X0Y3_FrameStrobe[6] VPWR VGND sg13cmos5l_antennanp
XANTENNA__1149__A2 Tile_X0Y2_W6END[7] VPWR VGND sg13cmos5l_antennanp
XFILLER_105_0 VPWR VGND sg13cmos5l_fill_2
XFILLER_153_257 VPWR VGND sg13cmos5l_decap_8
XFILLER_20_50 VPWR VGND sg13cmos5l_decap_4
XFILLER_106_162 VPWR VGND sg13cmos5l_decap_8
XFILLER_136_50 VPWR VGND sg13cmos5l_fill_1
XFILLER_4_278 VPWR VGND sg13cmos5l_fill_1
XFILLER_20_83 VPWR VGND sg13cmos5l_fill_1
XFILLER_20_72 VPWR VGND sg13cmos5l_decap_8
XFILLER_161_290 VPWR VGND sg13cmos5l_decap_4
XFILLER_67_219 VPWR VGND sg13cmos5l_fill_2
XFILLER_75_252 VPWR VGND sg13cmos5l_decap_4
XFILLER_208_236 VPWR VGND sg13cmos5l_decap_8
XFILLER_223_206 VPWR VGND sg13cmos5l_fill_1
XANTENNA__1141__A Tile_X0Y2_WW4END[13] VPWR VGND sg13cmos5l_antennanp
XFILLER_216_280 VPWR VGND sg13cmos5l_fill_1
XANTENNA__1498__D Tile_X0Y1_FrameData[9] VPWR VGND sg13cmos5l_antennanp
XANTENNA__0832__A1 Tile_X0Y0_W6END[6] VPWR VGND sg13cmos5l_antennanp
XANTENNA__2524__X Tile_X0Y3_E6BEG[10] VPWR VGND sg13cmos5l_antennanp
XANTENNA__0596__A0 Tile_X0Y1_W1END[2] VPWR VGND sg13cmos5l_antennanp
X_1712_ _1712_/Q Tile_X0Y2_FrameData[11] Tile_X0Y3_FrameStrobe[0] VPWR VGND sg13cmos5l_dlhq_1
XANTENNA_1 AXIL_S_SOC_AWADDR3 VPWR VGND sg13cmos5l_antennanp
XANTENNA__2041__GATE Tile_X0Y3_FrameStrobe[3] VPWR VGND sg13cmos5l_antennanp
X_1643_ _1643_/Q Tile_X0Y1_FrameData[24] Tile_X0Y3_FrameStrobe[6] VPWR VGND sg13cmos5l_dlhq_1
XFILLER_6_52 VPWR VGND sg13cmos5l_decap_8
XANTENNA__2122__D Tile_X0Y3_FrameData[9] VPWR VGND sg13cmos5l_antennanp
XFILLER_6_85 VPWR VGND sg13cmos5l_fill_1
X_1574_ _1574_/Q Tile_X0Y1_FrameData[29] Tile_X0Y3_FrameStrobe[4] VPWR VGND sg13cmos5l_dlhq_1
XANTENNA__1961__D Tile_X0Y3_FrameData[10] VPWR VGND sg13cmos5l_antennanp
XFILLER_112_143 VPWR VGND sg13cmos5l_fill_2
X_0525_ _0526_/C _1451_/Q _0870_/X VPWR VGND sg13cmos5l_nor2_1
XANTENNA__2056__GATE Tile_X0Y3_FrameStrobe[3] VPWR VGND sg13cmos5l_antennanp
X_0456_ _0977_/S _1625_/Q VPWR VGND sg13cmos5l_inv_1
XFILLER_20_0 VPWR VGND sg13cmos5l_fill_2
X_2126_ _2126_/Q Tile_X0Y3_FrameData[5] Tile_X0Y3_FrameStrobe[5] VPWR VGND sg13cmos5l_dlhq_1
XFILLER_66_274 VPWR VGND sg13cmos5l_decap_8
X_2057_ _2057_/Q Tile_X0Y3_FrameData[10] Tile_X0Y3_FrameStrobe[3] VPWR VGND sg13cmos5l_dlhq_1
XFILLER_25_17 VPWR VGND sg13cmos5l_decap_4
XFILLER_214_217 VPWR VGND sg13cmos5l_decap_8
XFILLER_212_52 VPWR VGND sg13cmos5l_decap_8
X_1008_ AXIL_S_SOC_RDATA21 Tile_X0Y1_W2MID[1] Tile_X0Y1_W2END[1] Tile_X0Y1_W6END[1]
+ _0864_/X _1521_/Q _1520_/Q VPWR VGND sg13cmos5l_mux4_1
XFILLER_222_250 VPWR VGND sg13cmos5l_decap_8
XFILLER_179_154 VPWR VGND sg13cmos5l_fill_1
XANTENNA__1201__D Tile_X0Y0_FrameData[26] VPWR VGND sg13cmos5l_antennanp
XANTENNA__2434__X Tile_X0Y0_FrameData_O[20] VPWR VGND sg13cmos5l_antennanp
XFILLER_222_294 VPWR VGND sg13cmos5l_fill_1
XANTENNA__1250__GATE Tile_X0Y3_FrameStrobe[1] VPWR VGND sg13cmos5l_antennanp
XANTENNA__0587__A0 Tile_X0Y3_W2MID[4] VPWR VGND sg13cmos5l_antennanp
XANTENNA__1880__GATE Tile_X0Y3_FrameStrobe[5] VPWR VGND sg13cmos5l_antennanp
XFILLER_157_16 VPWR VGND sg13cmos5l_decap_4
XFILLER_157_38 VPWR VGND sg13cmos5l_fill_2
XFILLER_41_49 VPWR VGND sg13cmos5l_decap_8
XANTENNA__2009__GATE Tile_X0Y3_FrameStrobe[2] VPWR VGND sg13cmos5l_antennanp
XFILLER_135_235 VPWR VGND sg13cmos5l_fill_1
XFILLER_157_49 VPWR VGND sg13cmos5l_decap_4
XANTENNA__2032__D Tile_X0Y3_FrameData[3] VPWR VGND sg13cmos5l_antennanp
XFILLER_135_257 VPWR VGND sg13cmos5l_fill_1
XFILLER_135_279 VPWR VGND sg13cmos5l_fill_1
XANTENNA__1265__GATE Tile_X0Y3_FrameStrobe[2] VPWR VGND sg13cmos5l_antennanp
XANTENNA__2610__A Tile_X0Y3_UserCLK VPWR VGND sg13cmos5l_antennanp
XANTENNA__1871__D Tile_X0Y2_FrameData[12] VPWR VGND sg13cmos5l_antennanp
XANTENNA__1895__GATE Tile_X0Y3_FrameStrobe[6] VPWR VGND sg13cmos5l_antennanp
XFILLER_49_219 VPWR VGND sg13cmos5l_decap_4
XFILLER_106_86 VPWR VGND sg13cmos5l_fill_2
XANTENNA__2609__X Tile_X0Y3_S4BEG[15] VPWR VGND sg13cmos5l_antennanp
XANTENNA__0511__A0 Tile_X0Y3_N2MID[3] VPWR VGND sg13cmos5l_antennanp
XANTENNA__1203__GATE Tile_X0Y3_FrameStrobe[0] VPWR VGND sg13cmos5l_antennanp
XANTENNA__1833__GATE Tile_X0Y3_FrameStrobe[4] VPWR VGND sg13cmos5l_antennanp
XFILLER_220_209 VPWR VGND sg13cmos5l_decap_8
XFILLER_213_261 VPWR VGND sg13cmos5l_decap_8
XFILLER_198_56 VPWR VGND sg13cmos5l_decap_8
XANTENNA__2344__X Tile_X0Y2_FrameData_O[20] VPWR VGND sg13cmos5l_antennanp
XFILLER_213_294 VPWR VGND sg13cmos5l_fill_1
XANTENNA__1218__GATE Tile_X0Y3_FrameStrobe[0] VPWR VGND sg13cmos5l_antennanp
XFILLER_15_94 VPWR VGND sg13cmos5l_decap_8
XANTENNA__0578__A0 Tile_X0Y2_W2MID[7] VPWR VGND sg13cmos5l_antennanp
XANTENNA__1848__GATE Tile_X0Y3_FrameStrobe[4] VPWR VGND sg13cmos5l_antennanp
XFILLER_222_0 VPWR VGND sg13cmos5l_fill_2
XFILLER_126_257 VPWR VGND sg13cmos5l_decap_8
XFILLER_147_71 VPWR VGND sg13cmos5l_decap_8
XFILLER_141_216 VPWR VGND sg13cmos5l_decap_8
XANTENNA__1781__D Tile_X0Y2_FrameData[6] VPWR VGND sg13cmos5l_antennanp
XANTENNA__0750__A0 Tile_X0Y2_W2MID[1] VPWR VGND sg13cmos5l_antennanp
X_1290_ _1290_/Q Tile_X0Y0_FrameData[1] Tile_X0Y3_FrameStrobe[2] VPWR VGND sg13cmos5l_dlhq_1
XANTENNA__2519__X Tile_X0Y3_E6BEG[5] VPWR VGND sg13cmos5l_antennanp
XFILLER_48_285 VPWR VGND sg13cmos5l_fill_2
XFILLER_16_160 VPWR VGND sg13cmos5l_fill_1
XANTENNA__2117__D Tile_X0Y3_FrameData[14] VPWR VGND sg13cmos5l_antennanp
XANTENNA__2254__X Tile_X0Y1_FrameData_O[11] VPWR VGND sg13cmos5l_antennanp
XANTENNA__1956__D Tile_X0Y3_FrameData[15] VPWR VGND sg13cmos5l_antennanp
XFILLER_68_0 VPWR VGND sg13cmos5l_decap_4
XANTENNA__2430__A Tile_X0Y0_FrameData[16] VPWR VGND sg13cmos5l_antennanp
X_1626_ _1626_/Q Tile_X0Y1_FrameData[9] Tile_X0Y3_FrameStrobe[5] VPWR VGND sg13cmos5l_dlhq_1
XANTENNA__1691__D Tile_X0Y1_FrameData[8] VPWR VGND sg13cmos5l_antennanp
X_1557_ _1557_/Q Tile_X0Y1_FrameData[14] Tile_X0Y3_FrameStrobe[3] VPWR VGND sg13cmos5l_dlhq_1
XFILLER_98_130 VPWR VGND sg13cmos5l_fill_1
XANTENNA__1046__A Tile_X0Y2_WW4END[1] VPWR VGND sg13cmos5l_antennanp
XFILLER_140_260 VPWR VGND sg13cmos5l_fill_2
X_0508_ _0508_/X Tile_X0Y3_N1END[3] Tile_X0Y3_N4END[3] _0574_/B Tile_X0Y0_S4END[15]
+ _1965_/Q _1964_/Q VPWR VGND sg13cmos5l_mux4_1
XFILLER_207_85 VPWR VGND sg13cmos5l_decap_8
XANTENNA__0741__A0 Tile_X0Y3_W2MID[3] VPWR VGND sg13cmos5l_antennanp
XFILLER_140_293 VPWR VGND sg13cmos5l_fill_2
X_1488_ _1488_/Q Tile_X0Y1_FrameData[19] Tile_X0Y3_FrameStrobe[1] VPWR VGND sg13cmos5l_dlhq_1
XANTENNA__2429__X Tile_X0Y0_FrameData_O[15] VPWR VGND sg13cmos5l_antennanp
XFILLER_100_168 VPWR VGND sg13cmos5l_fill_2
X_0439_ _0439_/Y Tile_X0Y0_WW4END[1] VPWR VGND sg13cmos5l_inv_1
XFILLER_36_16 VPWR VGND sg13cmos5l_fill_1
XFILLER_223_62 VPWR VGND sg13cmos5l_fill_2
X_2109_ _2109_/Q Tile_X0Y3_FrameData[22] Tile_X0Y3_FrameStrobe[5] VPWR VGND sg13cmos5l_dlhq_1
XFILLER_223_95 VPWR VGND sg13cmos5l_fill_1
XFILLER_14_108 VPWR VGND sg13cmos5l_fill_1
XFILLER_199_249 VPWR VGND sg13cmos5l_decap_4
XANTENNA__2027__D Tile_X0Y3_FrameData[8] VPWR VGND sg13cmos5l_antennanp
XFILLER_52_48 VPWR VGND sg13cmos5l_fill_1
XFILLER_52_26 VPWR VGND sg13cmos5l_decap_8
XFILLER_22_141 VPWR VGND sg13cmos5l_fill_2
XANTENNA__1866__D Tile_X0Y2_FrameData[17] VPWR VGND sg13cmos5l_antennanp
XFILLER_22_174 VPWR VGND sg13cmos5l_decap_8
XFILLER_108_202 VPWR VGND sg13cmos5l_decap_8
XFILLER_108_235 VPWR VGND sg13cmos5l_fill_1
XFILLER_184_25 VPWR VGND sg13cmos5l_fill_1
XANTENNA__2340__A Tile_X0Y2_FrameData[16] VPWR VGND sg13cmos5l_antennanp
XFILLER_77_34 VPWR VGND sg13cmos5l_decap_8
XFILLER_77_23 VPWR VGND sg13cmos5l_decap_8
XFILLER_89_185 VPWR VGND sg13cmos5l_decap_8
XANTENNA__2339__X Tile_X0Y2_FrameData_O[15] VPWR VGND sg13cmos5l_antennanp
XFILLER_45_211 VPWR VGND sg13cmos5l_decap_8
XFILLER_172_0 VPWR VGND sg13cmos5l_decap_4
XANTENNA__1772__GATE Tile_X0Y3_FrameStrobe[2] VPWR VGND sg13cmos5l_antennanp
XFILLER_93_99 VPWR VGND sg13cmos5l_decap_8
XFILLER_60_236 VPWR VGND sg13cmos5l_fill_1
XANTENNA__1787__GATE Tile_X0Y3_FrameStrobe[2] VPWR VGND sg13cmos5l_antennanp
XANTENNA__1776__D Tile_X0Y2_FrameData[11] VPWR VGND sg13cmos5l_antennanp
XFILLER_158_179 VPWR VGND sg13cmos5l_decap_8
XFILLER_9_167 VPWR VGND sg13cmos5l_fill_2
XFILLER_42_70 VPWR VGND sg13cmos5l_fill_1
XFILLER_158_70 VPWR VGND sg13cmos5l_fill_1
X_0790_ _0790_/X Tile_X0Y0_W6END[4] _0520_/A _0761_/X _0739_/X _1381_/Q _1383_/Q VPWR
+ VGND sg13cmos5l_mux4_1
XFILLER_173_138 VPWR VGND sg13cmos5l_decap_8
XANTENNA__1710__GATE Tile_X0Y3_FrameStrobe[0] VPWR VGND sg13cmos5l_antennanp
XANTENNA__2250__A Tile_X0Y1_FrameData[7] VPWR VGND sg13cmos5l_antennanp
X_2460_ Tile_X0Y0_EE4BEG[14] _2460_/A VPWR VGND sg13cmos5l_buf_1
X_1411_ _1411_/Q Tile_X0Y0_FrameData[8] Tile_X0Y3_FrameStrobe[6] VPWR VGND sg13cmos5l_dlhq_1
X_2391_ Tile_X0Y0_N1BEG[1] _2391_/A VPWR VGND sg13cmos5l_buf_1
XANTENNA__0723__A0 Tile_X0Y0_W2MID[5] VPWR VGND sg13cmos5l_antennanp
XANTENNA__1725__GATE Tile_X0Y3_FrameStrobe[1] VPWR VGND sg13cmos5l_antennanp
X_1342_ _1342_/Q Tile_X0Y0_FrameData[13] Tile_X0Y3_FrameStrobe[4] VPWR VGND sg13cmos5l_dlhq_1
XFILLER_3_42 VPWR VGND sg13cmos5l_decap_4
XANTENNA__2249__X Tile_X0Y1_FrameData_O[6] VPWR VGND sg13cmos5l_antennanp
X_1273_ _1273_/Q Tile_X0Y0_FrameData[18] Tile_X0Y3_FrameStrobe[2] VPWR VGND sg13cmos5l_dlhq_1
XFILLER_95_188 VPWR VGND sg13cmos5l_decap_4
XANTENNA__2425__A Tile_X0Y0_FrameData[11] VPWR VGND sg13cmos5l_antennanp
XFILLER_189_293 VPWR VGND sg13cmos5l_fill_2
XANTENNA__1686__D Tile_X0Y1_FrameData[13] VPWR VGND sg13cmos5l_antennanp
XFILLER_149_168 VPWR VGND sg13cmos5l_fill_2
XFILLER_164_127 VPWR VGND sg13cmos5l_fill_2
X_0988_ _0988_/Y Tile_X0Y1_W6END[5] _1628_/Q _1627_/Q VPWR VGND sg13cmos5l_o21ai_1
XFILLER_105_205 VPWR VGND sg13cmos5l_decap_8
XANTENNA__0962__A0 AXIL_S_SOC_WDATA23 VPWR VGND sg13cmos5l_antennanp
X_1609_ _1609_/Q Tile_X0Y1_FrameData[26] Tile_X0Y3_FrameStrobe[5] VPWR VGND sg13cmos5l_dlhq_1
X_2589_ Tile_X0Y3_S2BEGb[3] _2589_/A VPWR VGND sg13cmos5l_buf_1
XANTENNA__0714__A0 Tile_X0Y3_W2MID[6] VPWR VGND sg13cmos5l_antennanp
XFILLER_113_260 VPWR VGND sg13cmos5l_decap_8
XFILLER_113_271 VPWR VGND sg13cmos5l_fill_2
XFILLER_47_26 VPWR VGND sg13cmos5l_fill_2
XFILLER_47_15 VPWR VGND sg13cmos5l_fill_1
XFILLER_219_117 VPWR VGND sg13cmos5l_fill_1
XFILLER_170_16 VPWR VGND sg13cmos5l_fill_2
XFILLER_86_199 VPWR VGND sg13cmos5l_fill_2
XANTENNA__0493__A2 Tile_X0Y3_N4END[11] VPWR VGND sg13cmos5l_antennanp
XFILLER_103_87 VPWR VGND sg13cmos5l_decap_8
XFILLER_103_98 VPWR VGND sg13cmos5l_decap_8
XFILLER_179_25 VPWR VGND sg13cmos5l_fill_1
XANTENNA__2335__A Tile_X0Y2_FrameData[11] VPWR VGND sg13cmos5l_antennanp
XANTENNA__1596__D Tile_X0Y1_FrameData[7] VPWR VGND sg13cmos5l_antennanp
XFILLER_10_122 VPWR VGND sg13cmos5l_decap_8
XANTENNA__0796__A3 Tile_X0Y0_S4END[3] VPWR VGND sg13cmos5l_antennanp
XFILLER_195_35 VPWR VGND sg13cmos5l_fill_1
XFILLER_12_95 VPWR VGND sg13cmos5l_decap_4
XFILLER_170_119 VPWR VGND sg13cmos5l_decap_8
XANTENNA__0953__A0 AXIL_S_SOC_WDATA22 VPWR VGND sg13cmos5l_antennanp
XANTENNA__0705__A0 Tile_X0Y3_W1END[0] VPWR VGND sg13cmos5l_antennanp
XFILLER_104_271 VPWR VGND sg13cmos5l_fill_2
XFILLER_218_161 VPWR VGND sg13cmos5l_decap_8
XFILLER_92_169 VPWR VGND sg13cmos5l_fill_1
XANTENNA__2245__A Tile_X0Y1_FrameData[2] VPWR VGND sg13cmos5l_antennanp
XFILLER_33_269 VPWR VGND sg13cmos5l_decap_8
X_1960_ _1960_/Q Tile_X0Y3_FrameData[11] Tile_X0Y3_FrameStrobe[0] VPWR VGND sg13cmos5l_dlhq_1
XFILLER_53_80 VPWR VGND sg13cmos5l_fill_1
X_1891_ _1891_/Q Tile_X0Y2_FrameData[24] Tile_X0Y3_FrameStrobe[6] VPWR VGND sg13cmos5l_dlhq_1
X_0911_ _0912_/B _1666_/Q _0910_/Y _0448_/Y VPWR VGND sg13cmos5l_o21ai_1
XANTENNA__2532__X Tile_X0Y3_EE4BEG[6] VPWR VGND sg13cmos5l_antennanp
XFILLER_146_138 VPWR VGND sg13cmos5l_fill_1
X_0842_ _2474_/A AXIL_S_SOC_WVALID AXIL_S_SOC_AWADDR2 _0643_/X _0755_/X _1347_/Q _1346_/Q
+ VPWR VGND sg13cmos5l_mux4_1
X_0773_ _0773_/Y _0776_/S _0439_/Y _1415_/Q VPWR VGND sg13cmos5l_a21oi_1
X_2512_ Tile_X0Y3_E2BEGb[6] _2512_/A VPWR VGND sg13cmos5l_buf_1
XANTENNA__1664__GATE Tile_X0Y3_FrameStrobe[6] VPWR VGND sg13cmos5l_antennanp
XANTENNA__2130__D Tile_X0Y3_FrameData[1] VPWR VGND sg13cmos5l_antennanp
X_2443_ Tile_X0Y0_FrameData_O[29] Tile_X0Y0_FrameData[29] VPWR VGND sg13cmos5l_buf_1
X_2374_ Tile_X0Y0_N2BEGb[0] _2374_/A VPWR VGND sg13cmos5l_buf_1
X_1325_ _1325_/Q Tile_X0Y0_FrameData[30] Tile_X0Y3_FrameStrobe[4] VPWR VGND sg13cmos5l_dlhq_1
XANTENNA__1679__GATE Tile_X0Y3_FrameStrobe[7] VPWR VGND sg13cmos5l_antennanp
XFILLER_110_285 VPWR VGND sg13cmos5l_fill_2
X_1256_ _1256_/Q Tile_X0Y0_FrameData[3] Tile_X0Y3_FrameStrobe[1] VPWR VGND sg13cmos5l_dlhq_1
XFILLER_17_18 VPWR VGND sg13cmos5l_fill_1
XANTENNA__1121__A0 AXIL_S_SOC_WDATA5 VPWR VGND sg13cmos5l_antennanp
X_1187_ _1187_/Y _1187_/A _1187_/B VPWR VGND sg13cmos5l_nand2_1
XFILLER_204_97 VPWR VGND sg13cmos5l_decap_8
XANTENNA__1602__GATE Tile_X0Y3_FrameStrobe[4] VPWR VGND sg13cmos5l_antennanp
XFILLER_91_191 VPWR VGND sg13cmos5l_decap_8
XFILLER_33_39 VPWR VGND sg13cmos5l_decap_8
XFILLER_33_28 VPWR VGND sg13cmos5l_fill_1
XFILLER_220_85 VPWR VGND sg13cmos5l_fill_1
XFILLER_32_280 VPWR VGND sg13cmos5l_fill_1
XANTENNA__0778__A3 Tile_X0Y0_S4END[1] VPWR VGND sg13cmos5l_antennanp
XANTENNA__1617__GATE Tile_X0Y3_FrameStrobe[5] VPWR VGND sg13cmos5l_antennanp
XANTENNA__2442__X Tile_X0Y0_FrameData_O[28] VPWR VGND sg13cmos5l_antennanp
XFILLER_116_8 VPWR VGND sg13cmos5l_decap_4
XFILLER_165_16 VPWR VGND sg13cmos5l_fill_1
XFILLER_165_27 VPWR VGND sg13cmos5l_fill_2
XANTENNA__0897__X AXIL_S_SOC_BRESP1 VPWR VGND sg13cmos5l_antennanp
XANTENNA__2040__D Tile_X0Y3_FrameData[27] VPWR VGND sg13cmos5l_antennanp
XFILLER_58_58 VPWR VGND sg13cmos5l_decap_4
XFILLER_74_136 VPWR VGND sg13cmos5l_fill_1
XFILLER_74_125 VPWR VGND sg13cmos5l_decap_8
XFILLER_74_57 VPWR VGND sg13cmos5l_fill_1
XFILLER_74_158 VPWR VGND sg13cmos5l_decap_4
XFILLER_15_225 VPWR VGND sg13cmos5l_decap_8
XFILLER_215_186 VPWR VGND sg13cmos5l_decap_8
XFILLER_130_74 VPWR VGND sg13cmos5l_decap_8
XANTENNA__2352__X Tile_X0Y2_FrameData_O[28] VPWR VGND sg13cmos5l_antennanp
XFILLER_168_285 VPWR VGND sg13cmos5l_fill_2
XFILLER_23_94 VPWR VGND sg13cmos5l_decap_4
XFILLER_183_255 VPWR VGND sg13cmos5l_decap_8
XANTENNA__1179__A0 Tile_X0Y2_W2MID[3] VPWR VGND sg13cmos5l_antennanp
XFILLER_136_171 VPWR VGND sg13cmos5l_decap_8
XFILLER_97_206 VPWR VGND sg13cmos5l_fill_2
XFILLER_151_163 VPWR VGND sg13cmos5l_decap_8
XFILLER_155_82 VPWR VGND sg13cmos5l_fill_1
XFILLER_31_8 VPWR VGND sg13cmos5l_fill_2
XFILLER_2_162 VPWR VGND sg13cmos5l_decap_4
X_1110_ _1110_/X _0936_/X _0470_/X Tile_X0Y3_N4END[6] Tile_X0Y0_S4END[10] _1742_/Q
+ _1743_/Q VPWR VGND sg13cmos5l_mux4_1
X_2090_ _2090_/Q Tile_X0Y3_FrameData[9] Tile_X0Y3_FrameStrobe[4] VPWR VGND sg13cmos5l_dlhq_1
XFILLER_65_136 VPWR VGND sg13cmos5l_decap_8
XANTENNA__2527__X Tile_X0Y3_EE4BEG[1] VPWR VGND sg13cmos5l_antennanp
XFILLER_0_21 VPWR VGND sg13cmos5l_fill_1
XFILLER_0_32 VPWR VGND sg13cmos5l_fill_1
X_1041_ _1042_/A _0888_/X _0553_/X Tile_X0Y3_N4END[5] Tile_X0Y0_S4END[9] _1744_/Q
+ _1745_/Q VPWR VGND sg13cmos5l_mux4_1
XFILLER_206_153 VPWR VGND sg13cmos5l_decap_8
XFILLER_206_197 VPWR VGND sg13cmos5l_decap_4
X_1943_ _1943_/Q Tile_X0Y3_FrameData[28] Tile_X0Y3_FrameStrobe[0] VPWR VGND sg13cmos5l_dlhq_1
XFILLER_221_178 VPWR VGND sg13cmos5l_fill_2
XANTENNA__2125__D Tile_X0Y3_FrameData[6] VPWR VGND sg13cmos5l_antennanp
XANTENNA__2262__X Tile_X0Y1_FrameData_O[19] VPWR VGND sg13cmos5l_antennanp
X_1874_ _1874_/Q Tile_X0Y2_FrameData[9] Tile_X0Y3_FrameStrobe[5] VPWR VGND sg13cmos5l_dlhq_1
XANTENNA__1964__D Tile_X0Y3_FrameData[7] VPWR VGND sg13cmos5l_antennanp
XFILLER_134_108 VPWR VGND sg13cmos5l_decap_8
X_0825_ _0825_/Y _1372_/Q _0824_/X _1373_/Q VPWR VGND sg13cmos5l_o21ai_1
X_0756_ _0756_/X Tile_X0Y0_W1END[3] Tile_X0Y0_W2END[0] Tile_X0Y0_W2MID[0] _0755_/X
+ _1384_/Q _1385_/Q VPWR VGND sg13cmos5l_mux4_1
XFILLER_50_0 VPWR VGND sg13cmos5l_decap_8
XFILLER_135_19 VPWR VGND sg13cmos5l_fill_2
X_0687_ _2540_/A _0638_/Y _0616_/X AXIL_S_SOC_ARADDR9 _0584_/X _2046_/Q _2047_/Q VPWR
+ VGND sg13cmos5l_mux4_1
XFILLER_142_185 VPWR VGND sg13cmos5l_decap_4
X_2426_ Tile_X0Y0_FrameData_O[12] Tile_X0Y0_FrameData[12] VPWR VGND sg13cmos5l_buf_1
XFILLER_88_239 VPWR VGND sg13cmos5l_decap_4
X_2357_ Tile_X0Y0_UserCLKo Tile_X0Y0_UserCLK VPWR VGND sg13cmos5l_buf_1
XFILLER_96_272 VPWR VGND sg13cmos5l_fill_1
X_1308_ _1308_/Q Tile_X0Y0_FrameData[15] Tile_X0Y3_FrameStrobe[3] VPWR VGND sg13cmos5l_dlhq_1
X_2288_ Tile_X0Y2_E2BEGb[0] _2288_/A VPWR VGND sg13cmos5l_buf_1
XFILLER_56_136 VPWR VGND sg13cmos5l_decap_8
XANTENNA__1204__D Tile_X0Y0_FrameData[23] VPWR VGND sg13cmos5l_antennanp
XANTENNA__2437__X Tile_X0Y0_FrameData_O[23] VPWR VGND sg13cmos5l_antennanp
X_1239_ _1239_/Q Tile_X0Y0_FrameData[20] Tile_X0Y3_FrameStrobe[1] VPWR VGND sg13cmos5l_dlhq_1
XANTENNA__1541__GATE Tile_X0Y3_FrameStrobe[3] VPWR VGND sg13cmos5l_antennanp
XFILLER_71_139 VPWR VGND sg13cmos5l_decap_4
XANTENNA__1556__GATE Tile_X0Y3_FrameStrobe[3] VPWR VGND sg13cmos5l_antennanp
XANTENNA__2035__D Tile_X0Y3_FrameData[0] VPWR VGND sg13cmos5l_antennanp
XFILLER_60_37 VPWR VGND sg13cmos5l_decap_4
XFILLER_60_15 VPWR VGND sg13cmos5l_fill_1
XFILLER_20_250 VPWR VGND sg13cmos5l_decap_8
XFILLER_100_99 VPWR VGND sg13cmos5l_fill_2
XFILLER_176_15 VPWR VGND sg13cmos5l_fill_1
XANTENNA__1874__D Tile_X0Y2_FrameData[9] VPWR VGND sg13cmos5l_antennanp
XFILLER_109_20 VPWR VGND sg13cmos5l_fill_2
XFILLER_20_294 VPWR VGND sg13cmos5l_fill_1
XFILLER_176_48 VPWR VGND sg13cmos5l_decap_8
XFILLER_109_75 VPWR VGND sg13cmos5l_fill_1
XFILLER_47_103 VPWR VGND sg13cmos5l_decap_8
XANTENNA__0687__A2 AXIL_S_SOC_ARADDR9 VPWR VGND sg13cmos5l_antennanp
XFILLER_87_294 VPWR VGND sg13cmos5l_fill_1
XFILLER_85_56 VPWR VGND sg13cmos5l_decap_4
XANTENNA__1509__GATE Tile_X0Y3_FrameStrobe[2] VPWR VGND sg13cmos5l_antennanp
XANTENNA__2347__X Tile_X0Y2_FrameData_O[23] VPWR VGND sg13cmos5l_antennanp
XFILLER_141_73 VPWR VGND sg13cmos5l_decap_8
XFILLER_18_83 VPWR VGND sg13cmos5l_decap_8
XFILLER_55_191 VPWR VGND sg13cmos5l_decap_8
XFILLER_203_145 VPWR VGND sg13cmos5l_decap_8
XANTENNA__1784__D Tile_X0Y2_FrameData[3] VPWR VGND sg13cmos5l_antennanp
XFILLER_11_294 VPWR VGND sg13cmos5l_fill_1
X_1590_ _1590_/Q Tile_X0Y1_FrameData[13] Tile_X0Y3_FrameStrobe[4] VPWR VGND sg13cmos5l_dlhq_1
X_0610_ _0610_/X Tile_X0Y3_N1END[1] Tile_X0Y3_N4END[1] _0564_/B Tile_X0Y0_S4END[13]
+ _1985_/Q _1984_/Q VPWR VGND sg13cmos5l_mux4_1
XFILLER_7_276 VPWR VGND sg13cmos5l_decap_4
XFILLER_50_81 VPWR VGND sg13cmos5l_decap_4
X_0541_ _2574_/A Tile_X0Y3_W1END[0] Tile_X0Y3_W6END[8] _0536_/X _0540_/Y _2151_/Q
+ _2150_/Q VPWR VGND sg13cmos5l_mux4_1
XFILLER_124_185 VPWR VGND sg13cmos5l_decap_4
X_0472_ _0472_/Y _1695_/Q _1694_/Q VPWR VGND sg13cmos5l_nor2b_1
X_2211_ Tile_X0Y1_E2BEGb[4] _2211_/A VPWR VGND sg13cmos5l_buf_1
XFILLER_59_90 VPWR VGND sg13cmos5l_fill_1
XFILLER_182_80 VPWR VGND sg13cmos5l_decap_8
X_2142_ _2142_/Q Tile_X0Y3_FrameData[21] Tile_X0Y3_FrameStrobe[6] VPWR VGND sg13cmos5l_dlhq_1
XFILLER_38_125 VPWR VGND sg13cmos5l_decap_8
XANTENNA__2257__X Tile_X0Y1_FrameData_O[14] VPWR VGND sg13cmos5l_antennanp
X_2073_ _2073_/Q Tile_X0Y3_FrameData[26] Tile_X0Y3_FrameStrobe[4] VPWR VGND sg13cmos5l_dlhq_1
XFILLER_93_264 VPWR VGND sg13cmos5l_decap_8
XANTENNA__0567__B_N Tile_X0Y3_N1END[2] VPWR VGND sg13cmos5l_antennanp
X_1024_ _2235_/A AXIL_S_SOC_WDATA20 AXIL_S_SOC_WDATA24 _0945_/X _0862_/X _1563_/Q
+ _1562_/Q VPWR VGND sg13cmos5l_mux4_1
XFILLER_53_106 VPWR VGND sg13cmos5l_fill_1
XANTENNA__1959__D Tile_X0Y3_FrameData[12] VPWR VGND sg13cmos5l_antennanp
XFILLER_201_43 VPWR VGND sg13cmos5l_fill_1
XFILLER_98_0 VPWR VGND sg13cmos5l_decap_4
XFILLER_61_183 VPWR VGND sg13cmos5l_decap_8
XFILLER_201_98 VPWR VGND sg13cmos5l_decap_8
XANTENNA__2433__A Tile_X0Y0_FrameData[19] VPWR VGND sg13cmos5l_antennanp
XFILLER_147_200 VPWR VGND sg13cmos5l_fill_1
X_1926_ _1926_/Q Tile_X0Y2_FrameData[21] Tile_X0Y3_FrameStrobe[7] VPWR VGND sg13cmos5l_dlhq_1
XANTENNA__1694__D Tile_X0Y2_FrameData[29] VPWR VGND sg13cmos5l_antennanp
XFILLER_107_108 VPWR VGND sg13cmos5l_fill_1
X_1857_ _1857_/Q Tile_X0Y2_FrameData[26] Tile_X0Y3_FrameStrobe[5] VPWR VGND sg13cmos5l_dlhq_1
XFILLER_162_225 VPWR VGND sg13cmos5l_decap_8
X_0808_ _0808_/Y _1380_/Q _0807_/Y _1379_/Q VPWR VGND sg13cmos5l_o21ai_1
XANTENNA__1158__A3 AXIL_S_SOC_WDATA6 VPWR VGND sg13cmos5l_antennanp
X_1788_ _1788_/Q Tile_X0Y2_FrameData[31] Tile_X0Y3_FrameStrobe[3] VPWR VGND sg13cmos5l_dlhq_1
XANTENNA__0905__A3 Tile_X0Y0_S4END[4] VPWR VGND sg13cmos5l_antennanp
XFILLER_115_174 VPWR VGND sg13cmos5l_decap_8
X_0739_ _0739_/X _2378_/A _0737_/X Tile_X0Y0_S2MID[4] Tile_X0Y0_S2END[4] _1211_/Q
+ _1210_/Q VPWR VGND sg13cmos5l_mux4_1
X_2409_ Tile_X0Y0_FrameStrobe_O[15] Tile_X0Y3_FrameStrobe[15] VPWR VGND sg13cmos5l_buf_1
XFILLER_69_294 VPWR VGND sg13cmos5l_fill_1
XFILLER_69_283 VPWR VGND sg13cmos5l_fill_1
XANTENNA__1480__GATE Tile_X0Y3_FrameStrobe[1] VPWR VGND sg13cmos5l_antennanp
XFILLER_29_147 VPWR VGND sg13cmos5l_decap_8
XFILLER_84_286 VPWR VGND sg13cmos5l_fill_1
XFILLER_84_275 VPWR VGND sg13cmos5l_decap_8
XANTENNA__1869__D Tile_X0Y2_FrameData[14] VPWR VGND sg13cmos5l_antennanp
XFILLER_52_161 VPWR VGND sg13cmos5l_fill_2
XFILLER_52_150 VPWR VGND sg13cmos5l_decap_8
XANTENNA__1495__GATE Tile_X0Y3_FrameStrobe[1] VPWR VGND sg13cmos5l_antennanp
XFILLER_71_47 VPWR VGND sg13cmos5l_fill_1
XFILLER_71_14 VPWR VGND sg13cmos5l_decap_8
XFILLER_200_137 VPWR VGND sg13cmos5l_decap_8
XANTENNA__2343__A Tile_X0Y2_FrameData[19] VPWR VGND sg13cmos5l_antennanp
XFILLER_153_236 VPWR VGND sg13cmos5l_decap_8
XFILLER_4_224 VPWR VGND sg13cmos5l_fill_1
XFILLER_106_141 VPWR VGND sg13cmos5l_decap_8
XFILLER_4_246 VPWR VGND sg13cmos5l_fill_2
XANTENNA__1433__GATE Tile_X0Y3_FrameStrobe[7] VPWR VGND sg13cmos5l_antennanp
XFILLER_121_188 VPWR VGND sg13cmos5l_decap_8
XANTENNA__1448__GATE Tile_X0Y3_FrameStrobe[0] VPWR VGND sg13cmos5l_antennanp
XANTENNA__1779__D Tile_X0Y2_FrameData[8] VPWR VGND sg13cmos5l_antennanp
XFILLER_90_245 VPWR VGND sg13cmos5l_fill_1
XFILLER_35_139 VPWR VGND sg13cmos5l_fill_2
XANTENNA__1085__A2 AXIL_S_SOC_WDATA1 VPWR VGND sg13cmos5l_antennanp
XFILLER_50_109 VPWR VGND sg13cmos5l_decap_8
XFILLER_188_100 VPWR VGND sg13cmos5l_fill_2
XFILLER_43_183 VPWR VGND sg13cmos5l_decap_8
XANTENNA__2253__A Tile_X0Y1_FrameData[10] VPWR VGND sg13cmos5l_antennanp
XANTENNA__0596__A1 Tile_X0Y1_W2END[1] VPWR VGND sg13cmos5l_antennanp
X_1711_ _1711_/Q Tile_X0Y2_FrameData[12] Tile_X0Y3_FrameStrobe[0] VPWR VGND sg13cmos5l_dlhq_1
XANTENNA_2 AXIL_S_SOC_AWADDR3 VPWR VGND sg13cmos5l_antennanp
XANTENNA__2540__X Tile_X0Y3_EE4BEG[14] VPWR VGND sg13cmos5l_antennanp
X_1642_ _1642_/Q Tile_X0Y1_FrameData[25] Tile_X0Y3_FrameStrobe[6] VPWR VGND sg13cmos5l_dlhq_1
XFILLER_6_20 VPWR VGND sg13cmos5l_decap_8
X_1573_ _1573_/Q Tile_X0Y1_FrameData[30] Tile_X0Y3_FrameStrobe[4] VPWR VGND sg13cmos5l_dlhq_1
XFILLER_6_97 VPWR VGND sg13cmos5l_decap_8
XFILLER_112_122 VPWR VGND sg13cmos5l_decap_8
X_0524_ _0526_/B Tile_X0Y1_W6END[0] _1451_/Q VPWR VGND sg13cmos5l_nor2b_1
XFILLER_112_166 VPWR VGND sg13cmos5l_decap_8
X_0455_ _0455_/Y _1624_/Q VPWR VGND sg13cmos5l_inv_1
XANTENNA__2428__A Tile_X0Y0_FrameData[14] VPWR VGND sg13cmos5l_antennanp
X_2125_ _2125_/Q Tile_X0Y3_FrameData[6] Tile_X0Y3_FrameStrobe[5] VPWR VGND sg13cmos5l_dlhq_1
XFILLER_81_212 VPWR VGND sg13cmos5l_decap_8
XANTENNA__1689__D Tile_X0Y1_FrameData[10] VPWR VGND sg13cmos5l_antennanp
X_2056_ _2056_/Q Tile_X0Y3_FrameData[11] Tile_X0Y3_FrameStrobe[3] VPWR VGND sg13cmos5l_dlhq_1
X_1007_ AXIL_S_SOC_RDATA22 Tile_X0Y1_W2MID[2] Tile_X0Y1_W2END[2] Tile_X0Y1_W6END[2]
+ _0867_/X _1519_/Q _1518_/Q VPWR VGND sg13cmos5l_mux4_1
XFILLER_25_29 VPWR VGND sg13cmos5l_fill_1
XFILLER_222_262 VPWR VGND sg13cmos5l_decap_8
XFILLER_222_284 VPWR VGND sg13cmos5l_fill_2
XFILLER_41_28 VPWR VGND sg13cmos5l_decap_4
X_1909_ _1909_/Q Tile_X0Y2_FrameData[6] Tile_X0Y3_FrameStrobe[6] VPWR VGND sg13cmos5l_dlhq_1
XANTENNA__0587__A1 Tile_X0Y3_W2END[4] VPWR VGND sg13cmos5l_antennanp
XANTENNA__2450__X Tile_X0Y0_EE4BEG[4] VPWR VGND sg13cmos5l_antennanp
XFILLER_173_16 VPWR VGND sg13cmos5l_fill_2
XANTENNA__2163__GATE Tile_X0Y3_FrameStrobe[6] VPWR VGND sg13cmos5l_antennanp
XFILLER_106_10 VPWR VGND sg13cmos5l_decap_8
XFILLER_173_49 VPWR VGND sg13cmos5l_decap_8
XFILLER_173_38 VPWR VGND sg13cmos5l_fill_2
XFILLER_106_32 VPWR VGND sg13cmos5l_decap_8
XFILLER_106_54 VPWR VGND sg13cmos5l_decap_4
XFILLER_66_25 VPWR VGND sg13cmos5l_decap_4
XANTENNA__0511__A1 Tile_X0Y3_N2END[3] VPWR VGND sg13cmos5l_antennanp
XANTENNA__2178__GATE Tile_X0Y3_FrameStrobe[7] VPWR VGND sg13cmos5l_antennanp
XANTENNA__2338__A Tile_X0Y2_FrameData[14] VPWR VGND sg13cmos5l_antennanp
XFILLER_122_20 VPWR VGND sg13cmos5l_fill_1
XFILLER_122_31 VPWR VGND sg13cmos5l_decap_4
XFILLER_72_201 VPWR VGND sg13cmos5l_decap_4
XANTENNA__1599__D Tile_X0Y1_FrameData[4] VPWR VGND sg13cmos5l_antennanp
XFILLER_82_13 VPWR VGND sg13cmos5l_fill_2
XFILLER_205_207 VPWR VGND sg13cmos5l_decap_4
XANTENNA__1067__A2 Tile_X0Y3_N4END[4] VPWR VGND sg13cmos5l_antennanp
XFILLER_82_35 VPWR VGND sg13cmos5l_decap_8
XFILLER_72_256 VPWR VGND sg13cmos5l_decap_8
XFILLER_25_150 VPWR VGND sg13cmos5l_fill_2
XANTENNA__2101__GATE Tile_X0Y3_FrameStrobe[5] VPWR VGND sg13cmos5l_antennanp
XFILLER_198_35 VPWR VGND sg13cmos5l_decap_8
XFILLER_15_62 VPWR VGND sg13cmos5l_fill_1
XFILLER_40_120 VPWR VGND sg13cmos5l_fill_2
XANTENNA__2116__GATE Tile_X0Y3_FrameStrobe[5] VPWR VGND sg13cmos5l_antennanp
XANTENNA__0578__A1 Tile_X0Y2_W2END[7] VPWR VGND sg13cmos5l_antennanp
XANTENNA__2360__X Tile_X0Y0_N4BEG[2] VPWR VGND sg13cmos5l_antennanp
XFILLER_215_0 VPWR VGND sg13cmos5l_fill_1
XANTENNA__1372__GATE Tile_X0Y3_FrameStrobe[5] VPWR VGND sg13cmos5l_antennanp
XFILLER_147_50 VPWR VGND sg13cmos5l_decap_8
XFILLER_193_191 VPWR VGND sg13cmos5l_decap_8
XFILLER_99_109 VPWR VGND sg13cmos5l_decap_8
XANTENNA__0750__A1 Tile_X0Y2_W2END[1] VPWR VGND sg13cmos5l_antennanp
XANTENNA__1387__GATE Tile_X0Y3_FrameStrobe[5] VPWR VGND sg13cmos5l_antennanp
XFILLER_163_82 VPWR VGND sg13cmos5l_decap_4
XFILLER_0_293 VPWR VGND sg13cmos5l_fill_2
XFILLER_48_253 VPWR VGND sg13cmos5l_decap_8
XANTENNA__2248__A Tile_X0Y1_FrameData[5] VPWR VGND sg13cmos5l_antennanp
XANTENNA__1310__GATE Tile_X0Y3_FrameStrobe[3] VPWR VGND sg13cmos5l_antennanp
XANTENNA__1940__GATE Tile_X0Y3_FrameStrobe[0] VPWR VGND sg13cmos5l_antennanp
XANTENNA__2535__X Tile_X0Y3_EE4BEG[9] VPWR VGND sg13cmos5l_antennanp
XANTENNA__1302__D Tile_X0Y0_FrameData[21] VPWR VGND sg13cmos5l_antennanp
XANTENNA__1325__GATE Tile_X0Y3_FrameStrobe[4] VPWR VGND sg13cmos5l_antennanp
XANTENNA__1955__GATE Tile_X0Y3_FrameStrobe[0] VPWR VGND sg13cmos5l_antennanp
XFILLER_72_90 VPWR VGND sg13cmos5l_decap_8
XFILLER_31_186 VPWR VGND sg13cmos5l_decap_8
XFILLER_176_169 VPWR VGND sg13cmos5l_fill_1
XANTENNA__2133__D Tile_X0Y3_FrameData[30] VPWR VGND sg13cmos5l_antennanp
XANTENNA__2270__X Tile_X0Y1_FrameData_O[27] VPWR VGND sg13cmos5l_antennanp
XFILLER_117_214 VPWR VGND sg13cmos5l_decap_8
XFILLER_191_128 VPWR VGND sg13cmos5l_decap_8
XFILLER_191_117 VPWR VGND sg13cmos5l_fill_1
XANTENNA__1972__D Tile_X0Y3_FrameData[31] VPWR VGND sg13cmos5l_antennanp
XFILLER_132_206 VPWR VGND sg13cmos5l_fill_1
XFILLER_132_228 VPWR VGND sg13cmos5l_fill_2
X_1625_ _1625_/Q Tile_X0Y1_FrameData[10] Tile_X0Y3_FrameStrobe[5] VPWR VGND sg13cmos5l_dlhq_1
X_1556_ _1556_/Q Tile_X0Y1_FrameData[15] Tile_X0Y3_FrameStrobe[3] VPWR VGND sg13cmos5l_dlhq_1
X_0507_ _0507_/X Tile_X0Y3_N1END[3] Tile_X0Y3_N4END[3] _0574_/B Tile_X0Y0_S4END[15]
+ _1973_/Q _1972_/Q VPWR VGND sg13cmos5l_mux4_1
XANTENNA__0741__A1 Tile_X0Y3_W2END[3] VPWR VGND sg13cmos5l_antennanp
XFILLER_140_283 VPWR VGND sg13cmos5l_fill_1
X_1487_ _1487_/Q Tile_X0Y1_FrameData[20] Tile_X0Y3_FrameStrobe[1] VPWR VGND sg13cmos5l_dlhq_1
XFILLER_98_197 VPWR VGND sg13cmos5l_decap_8
XFILLER_100_147 VPWR VGND sg13cmos5l_decap_8
X_0438_ _0438_/Y Tile_X0Y0_W1END[1] VPWR VGND sg13cmos5l_inv_1
XANTENNA__1908__GATE Tile_X0Y3_FrameStrobe[6] VPWR VGND sg13cmos5l_antennanp
X_2108_ _2108_/Q Tile_X0Y3_FrameData[23] Tile_X0Y3_FrameStrobe[5] VPWR VGND sg13cmos5l_dlhq_1
XANTENNA__2445__X Tile_X0Y0_FrameData_O[31] VPWR VGND sg13cmos5l_antennanp
XANTENNA__1049__A2 Tile_X0Y3_N4END[5] VPWR VGND sg13cmos5l_antennanp
XANTENNA__1212__D Tile_X0Y0_FrameData[15] VPWR VGND sg13cmos5l_antennanp
XFILLER_153_9 VPWR VGND sg13cmos5l_decap_4
X_2039_ _2039_/Q Tile_X0Y3_FrameData[28] Tile_X0Y3_FrameStrobe[3] VPWR VGND sg13cmos5l_dlhq_1
XFILLER_146_8 VPWR VGND sg13cmos5l_decap_4
XFILLER_22_120 VPWR VGND sg13cmos5l_decap_4
XANTENNA__2043__D Tile_X0Y3_FrameData[24] VPWR VGND sg13cmos5l_antennanp
XANTENNA__1882__D Tile_X0Y2_FrameData[1] VPWR VGND sg13cmos5l_antennanp
XFILLER_190_161 VPWR VGND sg13cmos5l_fill_1
XFILLER_117_64 VPWR VGND sg13cmos5l_decap_4
XFILLER_77_68 VPWR VGND sg13cmos5l_decap_4
XFILLER_131_294 VPWR VGND sg13cmos5l_fill_1
XFILLER_45_234 VPWR VGND sg13cmos5l_fill_2
XANTENNA__2040__GATE Tile_X0Y3_FrameStrobe[3] VPWR VGND sg13cmos5l_antennanp
XFILLER_165_0 VPWR VGND sg13cmos5l_fill_2
XFILLER_60_204 VPWR VGND sg13cmos5l_decap_8
XANTENNA__2355__X Tile_X0Y2_FrameData_O[31] VPWR VGND sg13cmos5l_antennanp
XFILLER_60_215 VPWR VGND sg13cmos5l_fill_2
XANTENNA__2055__GATE Tile_X0Y3_FrameStrobe[3] VPWR VGND sg13cmos5l_antennanp
XFILLER_198_294 VPWR VGND sg13cmos5l_fill_1
XFILLER_158_147 VPWR VGND sg13cmos5l_fill_1
XFILLER_9_146 VPWR VGND sg13cmos5l_decap_8
XFILLER_201_265 VPWR VGND sg13cmos5l_decap_8
XFILLER_42_82 VPWR VGND sg13cmos5l_decap_8
XFILLER_173_117 VPWR VGND sg13cmos5l_decap_4
XFILLER_61_8 VPWR VGND sg13cmos5l_fill_2
XANTENNA__1792__D Tile_X0Y2_FrameData[27] VPWR VGND sg13cmos5l_antennanp
X_1410_ _1410_/Q Tile_X0Y0_FrameData[9] Tile_X0Y3_FrameStrobe[6] VPWR VGND sg13cmos5l_dlhq_1
X_2390_ Tile_X0Y0_N1BEG[0] _2390_/A VPWR VGND sg13cmos5l_buf_1
XANTENNA__0723__A1 Tile_X0Y0_W2END[5] VPWR VGND sg13cmos5l_antennanp
X_1341_ _1341_/Q Tile_X0Y0_FrameData[14] Tile_X0Y3_FrameStrobe[4] VPWR VGND sg13cmos5l_dlhq_1
XFILLER_122_294 VPWR VGND sg13cmos5l_fill_1
X_1272_ _1272_/Q Tile_X0Y0_FrameData[19] Tile_X0Y3_FrameStrobe[2] VPWR VGND sg13cmos5l_dlhq_1
XFILLER_95_167 VPWR VGND sg13cmos5l_decap_8
XANTENNA__2008__GATE Tile_X0Y3_FrameStrobe[2] VPWR VGND sg13cmos5l_antennanp
XANTENNA__2128__D Tile_X0Y3_FrameData[3] VPWR VGND sg13cmos5l_antennanp
XFILLER_36_278 VPWR VGND sg13cmos5l_decap_4
XANTENNA__2265__X Tile_X0Y1_FrameData_O[22] VPWR VGND sg13cmos5l_antennanp
XANTENNA__1264__GATE Tile_X0Y3_FrameStrobe[2] VPWR VGND sg13cmos5l_antennanp
XANTENNA__1967__D Tile_X0Y3_FrameData[4] VPWR VGND sg13cmos5l_antennanp
XANTENNA__1894__GATE Tile_X0Y3_FrameStrobe[6] VPWR VGND sg13cmos5l_antennanp
XFILLER_80_0 VPWR VGND sg13cmos5l_fill_2
XANTENNA__1279__GATE Tile_X0Y3_FrameStrobe[2] VPWR VGND sg13cmos5l_antennanp
XFILLER_164_106 VPWR VGND sg13cmos5l_fill_1
X_0987_ _0987_/Y _1627_/Q _0986_/X _0450_/Y VPWR VGND sg13cmos5l_a21oi_1
XANTENNA__2441__A Tile_X0Y0_FrameData[27] VPWR VGND sg13cmos5l_antennanp
XFILLER_157_180 VPWR VGND sg13cmos5l_decap_4
XFILLER_218_30 VPWR VGND sg13cmos5l_decap_8
XANTENNA__0962__A1 AXIL_S_SOC_WDATA31 VPWR VGND sg13cmos5l_antennanp
XANTENNA__1202__GATE Tile_X0Y3_FrameStrobe[0] VPWR VGND sg13cmos5l_antennanp
X_1608_ _1608_/Q Tile_X0Y1_FrameData[27] Tile_X0Y3_FrameStrobe[5] VPWR VGND sg13cmos5l_dlhq_1
XANTENNA__1832__GATE Tile_X0Y3_FrameStrobe[4] VPWR VGND sg13cmos5l_antennanp
X_2588_ Tile_X0Y3_S2BEGb[2] _2588_/A VPWR VGND sg13cmos5l_buf_1
XANTENNA__0714__A1 Tile_X0Y3_W2END[6] VPWR VGND sg13cmos5l_antennanp
XANTENNA__1207__D Tile_X0Y0_FrameData[20] VPWR VGND sg13cmos5l_antennanp
X_1539_ _1539_/Q Tile_X0Y1_FrameData[0] Tile_X0Y3_FrameStrobe[2] VPWR VGND sg13cmos5l_dlhq_1
XFILLER_113_294 VPWR VGND sg13cmos5l_fill_1
XANTENNA__1217__GATE Tile_X0Y3_FrameStrobe[0] VPWR VGND sg13cmos5l_antennanp
XANTENNA__0478__A0 Tile_X0Y3_N1END[2] VPWR VGND sg13cmos5l_antennanp
XANTENNA__1847__GATE Tile_X0Y3_FrameStrobe[4] VPWR VGND sg13cmos5l_antennanp
XANTENNA__2038__D Tile_X0Y3_FrameData[29] VPWR VGND sg13cmos5l_antennanp
XANTENNA__0493__A3 Tile_X0Y0_S4END[7] VPWR VGND sg13cmos5l_antennanp
XFILLER_103_77 VPWR VGND sg13cmos5l_decap_4
XFILLER_27_278 VPWR VGND sg13cmos5l_decap_4
XANTENNA__1877__D Tile_X0Y2_FrameData[6] VPWR VGND sg13cmos5l_antennanp
XFILLER_179_37 VPWR VGND sg13cmos5l_decap_4
XANTENNA__0650__A0 Tile_X0Y3_N1END[2] VPWR VGND sg13cmos5l_antennanp
XANTENNA__2351__A Tile_X0Y2_FrameData[27] VPWR VGND sg13cmos5l_antennanp
XFILLER_10_178 VPWR VGND sg13cmos5l_fill_2
XFILLER_12_74 VPWR VGND sg13cmos5l_decap_8
XANTENNA__0953__A1 AXIL_S_SOC_WDATA30 VPWR VGND sg13cmos5l_antennanp
XANTENNA__0705__A1 Tile_X0Y3_W6END[8] VPWR VGND sg13cmos5l_antennanp
XFILLER_104_294 VPWR VGND sg13cmos5l_fill_1
XFILLER_77_178 VPWR VGND sg13cmos5l_decap_8
XFILLER_92_148 VPWR VGND sg13cmos5l_decap_8
XFILLER_160_50 VPWR VGND sg13cmos5l_fill_2
XFILLER_18_245 VPWR VGND sg13cmos5l_fill_1
XFILLER_160_72 VPWR VGND sg13cmos5l_fill_1
XFILLER_160_83 VPWR VGND sg13cmos5l_fill_1
XANTENNA__1787__D Tile_X0Y2_FrameData[0] VPWR VGND sg13cmos5l_antennanp
X_0910_ _0910_/Y Tile_X0Y1_W1END[0] _1667_/Q _0909_/Y VPWR VGND sg13cmos5l_o21ai_1
XANTENNA__0641__A0 Tile_X0Y2_W2MID[7] VPWR VGND sg13cmos5l_antennanp
X_1890_ _1890_/Q Tile_X0Y2_FrameData[25] Tile_X0Y3_FrameStrobe[6] VPWR VGND sg13cmos5l_dlhq_1
X_0841_ _2475_/A AXIL_S_SOC_WSTRB0 AXIL_S_SOC_AWADDR3 _0646_/X _0751_/X _1345_/Q _1344_/Q
+ VPWR VGND sg13cmos5l_mux4_1
XFILLER_186_286 VPWR VGND sg13cmos5l_fill_1
XANTENNA__2261__A Tile_X0Y1_FrameData[18] VPWR VGND sg13cmos5l_antennanp
X_0772_ _0772_/X _0752_/X Tile_X0Y0_S1END[1] Tile_X0Y3_N4END[13] Tile_X0Y0_S4END[1]
+ _1232_/Q _1233_/Q VPWR VGND sg13cmos5l_mux4_1
XFILLER_154_150 VPWR VGND sg13cmos5l_decap_8
XFILLER_161_109 VPWR VGND sg13cmos5l_fill_1
X_2511_ Tile_X0Y3_E2BEGb[5] _2511_/A VPWR VGND sg13cmos5l_buf_1
X_2442_ Tile_X0Y0_FrameData_O[28] Tile_X0Y0_FrameData[28] VPWR VGND sg13cmos5l_buf_1
X_2373_ Tile_X0Y0_N4BEG[15] _2373_/A VPWR VGND sg13cmos5l_buf_1
XFILLER_110_242 VPWR VGND sg13cmos5l_fill_2
X_1324_ _1324_/Q Tile_X0Y0_FrameData[31] Tile_X0Y3_FrameStrobe[4] VPWR VGND sg13cmos5l_dlhq_1
XFILLER_68_134 VPWR VGND sg13cmos5l_fill_1
XFILLER_68_156 VPWR VGND sg13cmos5l_fill_2
X_1255_ _1255_/Q Tile_X0Y0_FrameData[4] Tile_X0Y3_FrameStrobe[1] VPWR VGND sg13cmos5l_dlhq_1
X_1186_ _1187_/B _0605_/X _0604_/X _2163_/Q VPWR VGND sg13cmos5l_mux2_1
XANTENNA__2436__A Tile_X0Y0_FrameData[22] VPWR VGND sg13cmos5l_antennanp
XFILLER_91_170 VPWR VGND sg13cmos5l_decap_8
XFILLER_24_215 VPWR VGND sg13cmos5l_decap_8
XANTENNA__0880__A0 AXIL_S_SOC_AWADDR0 VPWR VGND sg13cmos5l_antennanp
XANTENNA__1697__D Tile_X0Y2_FrameData[26] VPWR VGND sg13cmos5l_antennanp
XFILLER_149_29 VPWR VGND sg13cmos5l_decap_8
XFILLER_137_128 VPWR VGND sg13cmos5l_decap_8
XFILLER_145_150 VPWR VGND sg13cmos5l_decap_8
XANTENNA__1771__GATE Tile_X0Y3_FrameStrobe[2] VPWR VGND sg13cmos5l_antennanp
XFILLER_99_270 VPWR VGND sg13cmos5l_decap_8
XFILLER_59_134 VPWR VGND sg13cmos5l_decap_4
XFILLER_181_49 VPWR VGND sg13cmos5l_decap_8
XANTENNA__1786__GATE Tile_X0Y3_FrameStrobe[2] VPWR VGND sg13cmos5l_antennanp
XFILLER_101_264 VPWR VGND sg13cmos5l_decap_8
XANTENNA__2346__A Tile_X0Y2_FrameData[22] VPWR VGND sg13cmos5l_antennanp
XANTENNA__0871__A0 Tile_X0Y2_W1END[1] VPWR VGND sg13cmos5l_antennanp
XFILLER_130_53 VPWR VGND sg13cmos5l_decap_8
XFILLER_82_181 VPWR VGND sg13cmos5l_decap_8
XANTENNA__1400__D Tile_X0Y0_FrameData[19] VPWR VGND sg13cmos5l_antennanp
XANTENNA__1724__GATE Tile_X0Y3_FrameStrobe[1] VPWR VGND sg13cmos5l_antennanp
XFILLER_90_79 VPWR VGND sg13cmos5l_decap_8
XFILLER_139_40 VPWR VGND sg13cmos5l_decap_8
XFILLER_168_275 VPWR VGND sg13cmos5l_fill_2
XFILLER_23_73 VPWR VGND sg13cmos5l_decap_4
XFILLER_128_0 VPWR VGND sg13cmos5l_fill_2
XFILLER_139_51 VPWR VGND sg13cmos5l_fill_1
XFILLER_183_234 VPWR VGND sg13cmos5l_decap_8
XANTENNA__1179__A1 Tile_X0Y2_W2END[3] VPWR VGND sg13cmos5l_antennanp
XFILLER_99_55 VPWR VGND sg13cmos5l_fill_1
XANTENNA__1739__GATE Tile_X0Y3_FrameStrobe[1] VPWR VGND sg13cmos5l_antennanp
XFILLER_99_66 VPWR VGND sg13cmos5l_decap_8
XFILLER_151_142 VPWR VGND sg13cmos5l_decap_8
XFILLER_155_50 VPWR VGND sg13cmos5l_fill_1
XFILLER_2_152 VPWR VGND sg13cmos5l_decap_8
XFILLER_24_8 VPWR VGND sg13cmos5l_fill_1
XFILLER_0_11 VPWR VGND sg13cmos5l_decap_4
X_1040_ _2231_/A AXIL_S_SOC_WDATA20 AXIL_S_SOC_WDATA24 _0947_/A _0868_/X _1571_/Q
+ _1570_/Q VPWR VGND sg13cmos5l_mux4_1
XANTENNA__2256__A Tile_X0Y1_FrameData[13] VPWR VGND sg13cmos5l_antennanp
XANTENNA__1310__D Tile_X0Y0_FrameData[13] VPWR VGND sg13cmos5l_antennanp
XANTENNA__2543__X Tile_X0Y3_FrameData_O[1] VPWR VGND sg13cmos5l_antennanp
XFILLER_14_281 VPWR VGND sg13cmos5l_fill_1
XFILLER_159_253 VPWR VGND sg13cmos5l_fill_2
X_1942_ _1942_/Q Tile_X0Y3_FrameData[29] Tile_X0Y3_FrameStrobe[0] VPWR VGND sg13cmos5l_dlhq_1
XFILLER_221_157 VPWR VGND sg13cmos5l_decap_4
X_1873_ _1873_/Q Tile_X0Y2_FrameData[10] Tile_X0Y3_FrameStrobe[5] VPWR VGND sg13cmos5l_dlhq_1
XFILLER_119_128 VPWR VGND sg13cmos5l_decap_8
X_0824_ _0824_/X Tile_X0Y0_W6END[7] _0794_/B _1374_/Q VPWR VGND sg13cmos5l_mux2_1
XANTENNA__2141__D Tile_X0Y3_FrameData[22] VPWR VGND sg13cmos5l_antennanp
XFILLER_127_161 VPWR VGND sg13cmos5l_fill_1
X_0755_ _0755_/X _2381_/A _0754_/X Tile_X0Y0_S2MID[7] Tile_X0Y0_S2END[7] _1205_/Q
+ _1204_/Q VPWR VGND sg13cmos5l_mux4_1
X_0686_ _2539_/A _0655_/X _0485_/X AXIL_S_SOC_ARADDR8 _0483_/X _2048_/Q _2049_/Q VPWR
+ VGND sg13cmos5l_mux4_1
XFILLER_43_0 VPWR VGND sg13cmos5l_fill_2
XANTENNA__1980__D Tile_X0Y3_FrameData[23] VPWR VGND sg13cmos5l_antennanp
XFILLER_142_164 VPWR VGND sg13cmos5l_decap_8
X_2425_ Tile_X0Y0_FrameData_O[11] Tile_X0Y0_FrameData[11] VPWR VGND sg13cmos5l_buf_1
XFILLER_215_20 VPWR VGND sg13cmos5l_fill_2
X_2356_ Tile_X0Y2_UserCLKo Tile_X0Y2_UserCLK VPWR VGND sg13cmos5l_buf_1
XFILLER_215_75 VPWR VGND sg13cmos5l_decap_8
XFILLER_151_19 VPWR VGND sg13cmos5l_decap_8
X_1307_ _1307_/Q Tile_X0Y0_FrameData[16] Tile_X0Y3_FrameStrobe[3] VPWR VGND sg13cmos5l_dlhq_1
X_2287_ Tile_X0Y2_E2BEG[7] _2287_/A VPWR VGND sg13cmos5l_buf_1
X_1238_ _1238_/Q Tile_X0Y0_FrameData[21] Tile_X0Y3_FrameStrobe[1] VPWR VGND sg13cmos5l_dlhq_1
XANTENNA__0853__A0 AXIL_S_SOC_WSTRB1 VPWR VGND sg13cmos5l_antennanp
X_1169_ _1170_/B Tile_X0Y2_W1END[3] Tile_X0Y2_W6END[11] Tile_X0Y2_WW4END[3] _1112_/X
+ _1905_/Q _1906_/Q VPWR VGND sg13cmos5l_mux4_1
XANTENNA__1220__D Tile_X0Y0_FrameData[7] VPWR VGND sg13cmos5l_antennanp
XANTENNA__2453__X Tile_X0Y0_EE4BEG[7] VPWR VGND sg13cmos5l_antennanp
XFILLER_100_23 VPWR VGND sg13cmos5l_fill_2
XANTENNA__0605__A0 Tile_X0Y3_N1END[0] VPWR VGND sg13cmos5l_antennanp
XFILLER_109_32 VPWR VGND sg13cmos5l_decap_8
XFILLER_165_256 VPWR VGND sg13cmos5l_decap_8
XANTENNA__2051__D Tile_X0Y3_FrameData[16] VPWR VGND sg13cmos5l_antennanp
XFILLER_109_54 VPWR VGND sg13cmos5l_fill_1
XANTENNA__0701__X AXIL_S_SOC_RDATA0 VPWR VGND sg13cmos5l_antennanp
XANTENNA__1030__A0 AXIL_S_SOC_WDATA18 VPWR VGND sg13cmos5l_antennanp
XFILLER_192_15 VPWR VGND sg13cmos5l_decap_4
XANTENNA__1890__D Tile_X0Y2_FrameData[25] VPWR VGND sg13cmos5l_antennanp
XFILLER_69_58 VPWR VGND sg13cmos5l_fill_2
XFILLER_125_20 VPWR VGND sg13cmos5l_fill_1
XFILLER_87_262 VPWR VGND sg13cmos5l_decap_8
XFILLER_87_251 VPWR VGND sg13cmos5l_fill_1
XFILLER_85_35 VPWR VGND sg13cmos5l_decap_8
XFILLER_87_273 VPWR VGND sg13cmos5l_fill_2
XFILLER_18_62 VPWR VGND sg13cmos5l_decap_8
XFILLER_62_118 VPWR VGND sg13cmos5l_decap_4
XANTENNA__0844__A0 AXIL_S_SOC_AWADDR1 VPWR VGND sg13cmos5l_antennanp
XANTENNA__1663__GATE Tile_X0Y3_FrameStrobe[6] VPWR VGND sg13cmos5l_antennanp
XANTENNA__2363__X Tile_X0Y0_N4BEG[5] VPWR VGND sg13cmos5l_antennanp
XFILLER_70_184 VPWR VGND sg13cmos5l_decap_8
XFILLER_11_240 VPWR VGND sg13cmos5l_fill_2
XFILLER_34_83 VPWR VGND sg13cmos5l_decap_8
XFILLER_11_273 VPWR VGND sg13cmos5l_decap_8
XANTENNA__0611__A3 Tile_X0Y0_S4END[13] VPWR VGND sg13cmos5l_antennanp
XANTENNA__1678__GATE Tile_X0Y3_FrameStrobe[7] VPWR VGND sg13cmos5l_antennanp
XFILLER_156_256 VPWR VGND sg13cmos5l_fill_1
XFILLER_171_204 VPWR VGND sg13cmos5l_decap_8
XFILLER_109_183 VPWR VGND sg13cmos5l_decap_8
XFILLER_171_215 VPWR VGND sg13cmos5l_fill_1
XANTENNA__1021__A0 AXIL_S_SOC_WDATA23 VPWR VGND sg13cmos5l_antennanp
X_0540_ _0540_/Y _1946_/Q _0538_/Y _0539_/Y VPWR VGND sg13cmos5l_o21ai_1
XANTENNA__1601__GATE Tile_X0Y3_FrameStrobe[4] VPWR VGND sg13cmos5l_antennanp
XFILLER_124_175 VPWR VGND sg13cmos5l_decap_4
X_2210_ Tile_X0Y1_E2BEGb[3] _2210_/A VPWR VGND sg13cmos5l_buf_1
X_0471_ _0471_/X _0936_/X _0470_/X Tile_X0Y3_N4END[6] Tile_X0Y0_S4END[10] _1718_/Q
+ _1719_/Q VPWR VGND sg13cmos5l_mux4_1
XANTENNA__1305__D Tile_X0Y0_FrameData[18] VPWR VGND sg13cmos5l_antennanp
XANTENNA__2538__X Tile_X0Y3_EE4BEG[12] VPWR VGND sg13cmos5l_antennanp
X_2141_ _2141_/Q Tile_X0Y3_FrameData[22] Tile_X0Y3_FrameStrobe[6] VPWR VGND sg13cmos5l_dlhq_1
XFILLER_93_221 VPWR VGND sg13cmos5l_fill_1
XFILLER_38_104 VPWR VGND sg13cmos5l_decap_8
XANTENNA__1616__GATE Tile_X0Y3_FrameStrobe[5] VPWR VGND sg13cmos5l_antennanp
X_2072_ _2072_/Q Tile_X0Y3_FrameData[27] Tile_X0Y3_FrameStrobe[4] VPWR VGND sg13cmos5l_dlhq_1
XFILLER_93_243 VPWR VGND sg13cmos5l_decap_8
XANTENNA__1088__A0 AXIL_S_SOC_WDATA1 VPWR VGND sg13cmos5l_antennanp
X_1023_ _2238_/A AXIL_S_SOC_WDATA23 _0916_/B AXIL_S_SOC_WDATA27 _0869_/X _1556_/Q
+ _1557_/Q VPWR VGND sg13cmos5l_mux4_1
XFILLER_61_162 VPWR VGND sg13cmos5l_decap_8
XANTENNA__2136__D Tile_X0Y3_FrameData[27] VPWR VGND sg13cmos5l_antennanp
XANTENNA__2273__X Tile_X0Y1_FrameData_O[30] VPWR VGND sg13cmos5l_antennanp
X_1925_ _1925_/Q Tile_X0Y2_FrameData[22] Tile_X0Y3_FrameStrobe[7] VPWR VGND sg13cmos5l_dlhq_1
XANTENNA__1975__D Tile_X0Y3_FrameData[28] VPWR VGND sg13cmos5l_antennanp
XFILLER_162_204 VPWR VGND sg13cmos5l_decap_8
X_1856_ _1856_/Q Tile_X0Y2_FrameData[27] Tile_X0Y3_FrameStrobe[5] VPWR VGND sg13cmos5l_dlhq_1
X_1787_ _1787_/Q Tile_X0Y2_FrameData[0] Tile_X0Y3_FrameStrobe[2] VPWR VGND sg13cmos5l_dlhq_1
X_0807_ _0807_/Y _1378_/Q _0542_/X _0806_/Y VPWR VGND sg13cmos5l_a21oi_1
XANTENNA__1012__A0 Tile_X0Y1_W2MID[6] VPWR VGND sg13cmos5l_antennanp
X_0738_ _2378_/A Tile_X0Y1_W2MID[3] Tile_X0Y1_W2END[3] Tile_X0Y1_W6END[3] _0869_/X
+ _1675_/Q _1674_/Q VPWR VGND sg13cmos5l_mux4_1
XFILLER_130_134 VPWR VGND sg13cmos5l_fill_1
X_0669_ _2510_/A AXIL_S_SOC_ARVALID AXIL_S_SOC_ARADDR7 _0511_/X _0590_/X _2083_/Q
+ _2082_/Q VPWR VGND sg13cmos5l_mux4_1
XFILLER_39_39 VPWR VGND sg13cmos5l_decap_4
X_2408_ Tile_X0Y0_FrameStrobe_O[14] Tile_X0Y3_FrameStrobe[14] VPWR VGND sg13cmos5l_buf_1
XFILLER_69_240 VPWR VGND sg13cmos5l_fill_2
XANTENNA__1215__D Tile_X0Y0_FrameData[12] VPWR VGND sg13cmos5l_antennanp
XANTENNA__2448__X Tile_X0Y0_EE4BEG[2] VPWR VGND sg13cmos5l_antennanp
X_2339_ Tile_X0Y2_FrameData_O[15] Tile_X0Y2_FrameData[15] VPWR VGND sg13cmos5l_buf_1
XFILLER_84_221 VPWR VGND sg13cmos5l_decap_8
XFILLER_183_9 VPWR VGND sg13cmos5l_decap_8
XANTENNA__1079__A0 AXIL_S_SOC_WDATA5 VPWR VGND sg13cmos5l_antennanp
XFILLER_55_49 VPWR VGND sg13cmos5l_decap_8
XFILLER_52_140 VPWR VGND sg13cmos5l_decap_4
XANTENNA__2046__D Tile_X0Y3_FrameData[21] VPWR VGND sg13cmos5l_antennanp
XFILLER_52_195 VPWR VGND sg13cmos5l_decap_4
XFILLER_197_134 VPWR VGND sg13cmos5l_decap_8
XFILLER_187_15 VPWR VGND sg13cmos5l_decap_4
XANTENNA__1885__D Tile_X0Y2_FrameData[30] VPWR VGND sg13cmos5l_antennanp
XFILLER_138_278 VPWR VGND sg13cmos5l_decap_4
XFILLER_153_215 VPWR VGND sg13cmos5l_decap_8
XANTENNA__1003__A0 Tile_X0Y1_W2MID[0] VPWR VGND sg13cmos5l_antennanp
XFILLER_106_120 VPWR VGND sg13cmos5l_fill_1
XFILLER_136_41 VPWR VGND sg13cmos5l_decap_8
XFILLER_4_269 VPWR VGND sg13cmos5l_decap_4
XFILLER_96_34 VPWR VGND sg13cmos5l_fill_2
XFILLER_136_96 VPWR VGND sg13cmos5l_decap_8
XFILLER_96_67 VPWR VGND sg13cmos5l_fill_2
XANTENNA__2358__X Tile_X0Y0_N4BEG[0] VPWR VGND sg13cmos5l_antennanp
XFILLER_195_0 VPWR VGND sg13cmos5l_fill_2
XFILLER_90_213 VPWR VGND sg13cmos5l_decap_4
XFILLER_35_118 VPWR VGND sg13cmos5l_decap_8
XFILLER_35_107 VPWR VGND sg13cmos5l_fill_1
XFILLER_223_219 VPWR VGND sg13cmos5l_fill_2
XFILLER_216_271 VPWR VGND sg13cmos5l_decap_8
XANTENNA__1085__A3 AXIL_S_SOC_WDATA4 VPWR VGND sg13cmos5l_antennanp
XFILLER_90_279 VPWR VGND sg13cmos5l_fill_1
XFILLER_45_82 VPWR VGND sg13cmos5l_decap_8
XFILLER_43_140 VPWR VGND sg13cmos5l_decap_8
XFILLER_216_293 VPWR VGND sg13cmos5l_fill_2
XFILLER_91_8 VPWR VGND sg13cmos5l_decap_4
XFILLER_45_93 VPWR VGND sg13cmos5l_fill_2
XFILLER_188_145 VPWR VGND sg13cmos5l_fill_1
XANTENNA__1795__D Tile_X0Y2_FrameData[24] VPWR VGND sg13cmos5l_antennanp
X_1710_ _1710_/Q Tile_X0Y2_FrameData[13] Tile_X0Y3_FrameStrobe[0] VPWR VGND sg13cmos5l_dlhq_1
XANTENNA_3 AXIL_S_SOC_AWADDR3 VPWR VGND sg13cmos5l_antennanp
XANTENNA__0596__A2 Tile_X0Y1_W2MID[1] VPWR VGND sg13cmos5l_antennanp
X_1641_ _1641_/Q Tile_X0Y1_FrameData[26] Tile_X0Y3_FrameStrobe[6] VPWR VGND sg13cmos5l_dlhq_1
XFILLER_177_81 VPWR VGND sg13cmos5l_fill_1
XANTENNA__1540__GATE Tile_X0Y3_FrameStrobe[3] VPWR VGND sg13cmos5l_antennanp
XFILLER_144_237 VPWR VGND sg13cmos5l_decap_4
XFILLER_144_259 VPWR VGND sg13cmos5l_decap_8
X_1572_ _1572_/Q Tile_X0Y1_FrameData[31] Tile_X0Y3_FrameStrobe[4] VPWR VGND sg13cmos5l_dlhq_1
X_0523_ _0523_/Y _1451_/Q _1450_/Q VPWR VGND sg13cmos5l_nor2b_1
X_0454_ _0454_/Y _1623_/Q VPWR VGND sg13cmos5l_inv_1
XANTENNA__1555__GATE Tile_X0Y3_FrameStrobe[3] VPWR VGND sg13cmos5l_antennanp
XANTENNA__2268__X Tile_X0Y1_FrameData_O[25] VPWR VGND sg13cmos5l_antennanp
XANTENNA__1172__X AXIL_S_SOC_RDATA15 VPWR VGND sg13cmos5l_antennanp
X_2124_ _2124_/Q Tile_X0Y3_FrameData[7] Tile_X0Y3_FrameStrobe[5] VPWR VGND sg13cmos5l_dlhq_1
X_2055_ _2055_/Q Tile_X0Y3_FrameData[12] Tile_X0Y3_FrameStrobe[3] VPWR VGND sg13cmos5l_dlhq_1
XFILLER_19_181 VPWR VGND sg13cmos5l_decap_8
X_1006_ _2224_/A AXIL_S_SOC_WDATA17 _0929_/X _0933_/X _0865_/X _1529_/Q _1528_/Q VPWR
+ VGND sg13cmos5l_mux4_1
XFILLER_34_151 VPWR VGND sg13cmos5l_decap_8
XFILLER_207_293 VPWR VGND sg13cmos5l_fill_2
XFILLER_179_101 VPWR VGND sg13cmos5l_fill_2
XANTENNA__2444__A Tile_X0Y0_FrameData[30] VPWR VGND sg13cmos5l_antennanp
XFILLER_179_145 VPWR VGND sg13cmos5l_fill_1
X_1908_ _1908_/Q Tile_X0Y2_FrameData[7] Tile_X0Y3_FrameStrobe[6] VPWR VGND sg13cmos5l_dlhq_1
XANTENNA__0587__A2 Tile_X0Y3_W6END[11] VPWR VGND sg13cmos5l_antennanp
X_1839_ _1839_/Q Tile_X0Y2_FrameData[12] Tile_X0Y3_FrameStrobe[4] VPWR VGND sg13cmos5l_dlhq_1
XANTENNA__1508__GATE Tile_X0Y3_FrameStrobe[2] VPWR VGND sg13cmos5l_antennanp
XFILLER_150_207 VPWR VGND sg13cmos5l_decap_8
XFILLER_150_218 VPWR VGND sg13cmos5l_fill_2
XFILLER_103_112 VPWR VGND sg13cmos5l_fill_2
XFILLER_57_276 VPWR VGND sg13cmos5l_decap_4
XFILLER_122_65 VPWR VGND sg13cmos5l_decap_8
XFILLER_72_235 VPWR VGND sg13cmos5l_decap_8
XANTENNA__1067__A3 Tile_X0Y0_S4END[8] VPWR VGND sg13cmos5l_antennanp
XANTENNA__2354__A Tile_X0Y2_FrameData[30] VPWR VGND sg13cmos5l_antennanp
XFILLER_213_230 VPWR VGND sg13cmos5l_decap_8
XFILLER_80_290 VPWR VGND sg13cmos5l_decap_4
XFILLER_40_132 VPWR VGND sg13cmos5l_decap_4
XFILLER_40_176 VPWR VGND sg13cmos5l_decap_8
XFILLER_185_148 VPWR VGND sg13cmos5l_decap_8
XFILLER_40_187 VPWR VGND sg13cmos5l_fill_2
XANTENNA__0578__A2 Tile_X0Y2_W6END[8] VPWR VGND sg13cmos5l_antennanp
XFILLER_31_51 VPWR VGND sg13cmos5l_fill_2
XFILLER_110_0 VPWR VGND sg13cmos5l_fill_2
XFILLER_208_0 VPWR VGND sg13cmos5l_fill_2
XANTENNA__0750__A2 Tile_X0Y2_W6END[1] VPWR VGND sg13cmos5l_antennanp
XFILLER_163_72 VPWR VGND sg13cmos5l_fill_1
XFILLER_0_283 VPWR VGND sg13cmos5l_fill_1
XFILLER_48_232 VPWR VGND sg13cmos5l_decap_8
XFILLER_56_81 VPWR VGND sg13cmos5l_decap_8
XFILLER_56_70 VPWR VGND sg13cmos5l_decap_8
XFILLER_204_252 VPWR VGND sg13cmos5l_decap_8
XANTENNA__2264__A Tile_X0Y1_FrameData[21] VPWR VGND sg13cmos5l_antennanp
XFILLER_71_290 VPWR VGND sg13cmos5l_decap_4
XFILLER_31_143 VPWR VGND sg13cmos5l_decap_8
XFILLER_204_285 VPWR VGND sg13cmos5l_fill_2
XANTENNA__2551__X Tile_X0Y3_FrameData_O[9] VPWR VGND sg13cmos5l_antennanp
XFILLER_176_148 VPWR VGND sg13cmos5l_decap_8
XFILLER_184_181 VPWR VGND sg13cmos5l_decap_8
X_1624_ _1624_/Q Tile_X0Y1_FrameData[11] Tile_X0Y3_FrameStrobe[5] VPWR VGND sg13cmos5l_dlhq_1
X_1555_ _1555_/Q Tile_X0Y1_FrameData[16] Tile_X0Y3_FrameStrobe[3] VPWR VGND sg13cmos5l_dlhq_1
XANTENNA__1494__GATE Tile_X0Y3_FrameStrobe[1] VPWR VGND sg13cmos5l_antennanp
X_0506_ _0506_/X Tile_X0Y3_N1END[3] Tile_X0Y3_N4END[3] _0574_/B Tile_X0Y0_S4END[15]
+ _1981_/Q _1980_/Q VPWR VGND sg13cmos5l_mux4_1
XANTENNA__0741__A2 Tile_X0Y3_W6END[3] VPWR VGND sg13cmos5l_antennanp
X_1486_ _1486_/Q Tile_X0Y1_FrameData[21] Tile_X0Y3_FrameStrobe[1] VPWR VGND sg13cmos5l_dlhq_1
XFILLER_39_210 VPWR VGND sg13cmos5l_decap_8
XANTENNA__2439__A Tile_X0Y0_FrameData[25] VPWR VGND sg13cmos5l_antennanp
X_0437_ _0776_/S _1414_/Q VPWR VGND sg13cmos5l_inv_1
XFILLER_39_276 VPWR VGND sg13cmos5l_fill_2
X_2107_ _2107_/Q Tile_X0Y3_FrameData[24] Tile_X0Y3_FrameStrobe[5] VPWR VGND sg13cmos5l_dlhq_1
X_2038_ _2038_/Q Tile_X0Y3_FrameData[29] Tile_X0Y3_FrameStrobe[3] VPWR VGND sg13cmos5l_dlhq_1
XFILLER_54_279 VPWR VGND sg13cmos5l_decap_4
XANTENNA__1049__A3 Tile_X0Y0_S4END[9] VPWR VGND sg13cmos5l_antennanp
XANTENNA__1432__GATE Tile_X0Y3_FrameStrobe[7] VPWR VGND sg13cmos5l_antennanp
XFILLER_210_211 VPWR VGND sg13cmos5l_decap_8
XFILLER_167_115 VPWR VGND sg13cmos5l_decap_8
XANTENNA__2461__X Tile_X0Y0_EE4BEG[15] VPWR VGND sg13cmos5l_antennanp
XFILLER_139_8 VPWR VGND sg13cmos5l_decap_8
XFILLER_210_255 VPWR VGND sg13cmos5l_decap_8
XANTENNA__1447__GATE Tile_X0Y3_FrameStrobe[0] VPWR VGND sg13cmos5l_antennanp
XFILLER_190_140 VPWR VGND sg13cmos5l_decap_8
XFILLER_116_270 VPWR VGND sg13cmos5l_decap_8
XFILLER_117_43 VPWR VGND sg13cmos5l_decap_8
XFILLER_89_121 VPWR VGND sg13cmos5l_fill_1
XFILLER_89_110 VPWR VGND sg13cmos5l_decap_8
XFILLER_117_87 VPWR VGND sg13cmos5l_decap_8
XFILLER_89_143 VPWR VGND sg13cmos5l_decap_8
XANTENNA__0732__A2 Tile_X0Y3_N2MID[5] VPWR VGND sg13cmos5l_antennanp
XFILLER_77_58 VPWR VGND sg13cmos5l_decap_4
XFILLER_77_47 VPWR VGND sg13cmos5l_decap_4
XANTENNA__2349__A Tile_X0Y2_FrameData[25] VPWR VGND sg13cmos5l_antennanp
XFILLER_133_53 VPWR VGND sg13cmos5l_decap_8
XFILLER_93_13 VPWR VGND sg13cmos5l_fill_1
XANTENNA__1403__D Tile_X0Y0_FrameData[16] VPWR VGND sg13cmos5l_antennanp
XFILLER_93_46 VPWR VGND sg13cmos5l_decap_4
XFILLER_158_0 VPWR VGND sg13cmos5l_fill_2
XFILLER_198_262 VPWR VGND sg13cmos5l_decap_8
XFILLER_201_244 VPWR VGND sg13cmos5l_decap_8
XFILLER_198_273 VPWR VGND sg13cmos5l_fill_1
XANTENNA__2371__X Tile_X0Y0_N4BEG[13] VPWR VGND sg13cmos5l_antennanp
XFILLER_9_169 VPWR VGND sg13cmos5l_fill_1
XFILLER_181_162 VPWR VGND sg13cmos5l_decap_4
XFILLER_114_229 VPWR VGND sg13cmos5l_decap_4
X_1340_ _1340_/Q Tile_X0Y0_FrameData[15] Tile_X0Y3_FrameStrobe[4] VPWR VGND sg13cmos5l_dlhq_1
XANTENNA__0723__A2 Tile_X0Y0_W6END[10] VPWR VGND sg13cmos5l_antennanp
XANTENNA__2259__A Tile_X0Y1_FrameData[16] VPWR VGND sg13cmos5l_antennanp
X_1271_ _1271_/Q Tile_X0Y0_FrameData[20] Tile_X0Y3_FrameStrobe[2] VPWR VGND sg13cmos5l_dlhq_1
XFILLER_95_124 VPWR VGND sg13cmos5l_decap_8
XFILLER_3_99 VPWR VGND sg13cmos5l_fill_2
XANTENNA__1313__D Tile_X0Y0_FrameData[10] VPWR VGND sg13cmos5l_antennanp
XANTENNA__2546__X Tile_X0Y3_FrameData_O[4] VPWR VGND sg13cmos5l_antennanp
XFILLER_36_257 VPWR VGND sg13cmos5l_decap_8
XANTENNA__2162__GATE Tile_X0Y3_FrameStrobe[6] VPWR VGND sg13cmos5l_antennanp
XFILLER_149_137 VPWR VGND sg13cmos5l_decap_4
XANTENNA__2144__D Tile_X0Y3_FrameData[19] VPWR VGND sg13cmos5l_antennanp
XANTENNA__2281__X Tile_X0Y2_E2BEG[1] VPWR VGND sg13cmos5l_antennanp
XFILLER_164_129 VPWR VGND sg13cmos5l_fill_1
X_0986_ _0986_/X _0547_/X _0865_/X _1628_/Q VPWR VGND sg13cmos5l_mux2_1
XFILLER_73_0 VPWR VGND sg13cmos5l_fill_2
XANTENNA__1983__D Tile_X0Y3_FrameData[20] VPWR VGND sg13cmos5l_antennanp
XANTENNA__2177__GATE Tile_X0Y3_FrameStrobe[7] VPWR VGND sg13cmos5l_antennanp
XFILLER_8_191 VPWR VGND sg13cmos5l_decap_8
XFILLER_218_42 VPWR VGND sg13cmos5l_decap_4
XFILLER_154_19 VPWR VGND sg13cmos5l_fill_1
X_1607_ _1607_/Q Tile_X0Y1_FrameData[28] Tile_X0Y3_FrameStrobe[5] VPWR VGND sg13cmos5l_dlhq_1
XFILLER_218_97 VPWR VGND sg13cmos5l_decap_8
XFILLER_218_75 VPWR VGND sg13cmos5l_fill_2
XANTENNA__2100__GATE Tile_X0Y3_FrameStrobe[5] VPWR VGND sg13cmos5l_antennanp
X_2587_ Tile_X0Y3_S2BEGb[1] _2587_/A VPWR VGND sg13cmos5l_buf_1
XANTENNA__0714__A2 Tile_X0Y3_W6END[6] VPWR VGND sg13cmos5l_antennanp
X_1538_ _1538_/Q Tile_X0Y1_FrameData[1] Tile_X0Y3_FrameStrobe[2] VPWR VGND sg13cmos5l_dlhq_1
XFILLER_113_284 VPWR VGND sg13cmos5l_fill_2
X_1469_ _1469_/Q Tile_X0Y1_FrameData[6] Tile_X0Y3_FrameStrobe[0] VPWR VGND sg13cmos5l_dlhq_1
XFILLER_170_29 VPWR VGND sg13cmos5l_fill_2
XANTENNA__0478__A1 Tile_X0Y3_N4END[2] VPWR VGND sg13cmos5l_antennanp
XANTENNA__2115__GATE Tile_X0Y3_FrameStrobe[5] VPWR VGND sg13cmos5l_antennanp
XANTENNA__2456__X Tile_X0Y0_EE4BEG[10] VPWR VGND sg13cmos5l_antennanp
XFILLER_27_213 VPWR VGND sg13cmos5l_fill_2
XANTENNA__1223__D Tile_X0Y0_FrameData[4] VPWR VGND sg13cmos5l_antennanp
XANTENNA__1371__GATE Tile_X0Y3_FrameStrobe[5] VPWR VGND sg13cmos5l_antennanp
XFILLER_179_16 VPWR VGND sg13cmos5l_fill_1
XFILLER_42_249 VPWR VGND sg13cmos5l_fill_2
XFILLER_195_210 VPWR VGND sg13cmos5l_decap_8
XANTENNA__0704__X AXIL_S_SOC_RDATA3 VPWR VGND sg13cmos5l_antennanp
XANTENNA__1386__GATE Tile_X0Y3_FrameStrobe[5] VPWR VGND sg13cmos5l_antennanp
XANTENNA__2054__D Tile_X0Y3_FrameData[13] VPWR VGND sg13cmos5l_antennanp
XFILLER_50_282 VPWR VGND sg13cmos5l_fill_2
XFILLER_195_26 VPWR VGND sg13cmos5l_decap_8
XFILLER_195_15 VPWR VGND sg13cmos5l_decap_8
XANTENNA__1893__D Tile_X0Y2_FrameData[22] VPWR VGND sg13cmos5l_antennanp
XFILLER_148_170 VPWR VGND sg13cmos5l_decap_8
XFILLER_128_31 VPWR VGND sg13cmos5l_decap_4
XFILLER_128_86 VPWR VGND sg13cmos5l_decap_8
XANTENNA__0705__A2 Tile_X0Y3_WW4END[15] VPWR VGND sg13cmos5l_antennanp
XFILLER_104_273 VPWR VGND sg13cmos5l_fill_1
XANTENNA__1324__GATE Tile_X0Y3_FrameStrobe[4] VPWR VGND sg13cmos5l_antennanp
XFILLER_104_284 VPWR VGND sg13cmos5l_fill_2
XANTENNA__1954__GATE Tile_X0Y3_FrameStrobe[0] VPWR VGND sg13cmos5l_antennanp
XANTENNA__2366__X Tile_X0Y0_N4BEG[8] VPWR VGND sg13cmos5l_antennanp
XFILLER_92_127 VPWR VGND sg13cmos5l_fill_2
XANTENNA__1339__GATE Tile_X0Y3_FrameStrobe[4] VPWR VGND sg13cmos5l_antennanp
XANTENNA__1969__GATE Tile_X0Y3_FrameStrobe[0] VPWR VGND sg13cmos5l_antennanp
XFILLER_160_95 VPWR VGND sg13cmos5l_decap_4
XFILLER_26_290 VPWR VGND sg13cmos5l_decap_4
XFILLER_186_210 VPWR VGND sg13cmos5l_decap_8
XANTENNA__0641__A1 Tile_X0Y2_W2END[7] VPWR VGND sg13cmos5l_antennanp
XFILLER_41_293 VPWR VGND sg13cmos5l_fill_2
XANTENNA__2542__A Tile_X0Y3_FrameData[0] VPWR VGND sg13cmos5l_antennanp
X_0840_ _2476_/A AXIL_S_SOC_WSTRB1 AXIL_S_SOC_AWADDR4 _0653_/X _0736_/X _1343_/Q _1342_/Q
+ VPWR VGND sg13cmos5l_mux4_1
X_0771_ _0771_/X Tile_X0Y1_W1END[3] _0493_/X Tile_X0Y1_W6END[7] _0498_/X _1684_/Q
+ _1685_/Q VPWR VGND sg13cmos5l_mux4_1
X_2510_ Tile_X0Y3_E2BEGb[4] _2510_/A VPWR VGND sg13cmos5l_buf_1
XANTENNA__1907__GATE Tile_X0Y3_FrameStrobe[6] VPWR VGND sg13cmos5l_antennanp
X_2441_ Tile_X0Y0_FrameData_O[27] Tile_X0Y0_FrameData[27] VPWR VGND sg13cmos5l_buf_1
XANTENNA__1308__D Tile_X0Y0_FrameData[15] VPWR VGND sg13cmos5l_antennanp
X_2372_ Tile_X0Y0_N4BEG[14] _2372_/A VPWR VGND sg13cmos5l_buf_1
XFILLER_110_221 VPWR VGND sg13cmos5l_decap_8
X_1323_ _1323_/Q Tile_X0Y0_FrameData[0] Tile_X0Y3_FrameStrobe[3] VPWR VGND sg13cmos5l_dlhq_1
X_1254_ _1254_/Q Tile_X0Y0_FrameData[5] Tile_X0Y3_FrameStrobe[1] VPWR VGND sg13cmos5l_dlhq_1
XFILLER_204_22 VPWR VGND sg13cmos5l_fill_2
XANTENNA__2139__D Tile_X0Y3_FrameData[24] VPWR VGND sg13cmos5l_antennanp
XANTENNA__2276__X Tile_X0Y2_E1BEG[0] VPWR VGND sg13cmos5l_antennanp
XANTENNA__1180__X AXIL_S_SOC_RDATA10 VPWR VGND sg13cmos5l_antennanp
X_1185_ _2359_/A _1184_/X _1183_/X _2158_/Q VPWR VGND sg13cmos5l_mux2_1
XFILLER_209_185 VPWR VGND sg13cmos5l_decap_8
XANTENNA__1978__D Tile_X0Y3_FrameData[25] VPWR VGND sg13cmos5l_antennanp
XFILLER_224_133 VPWR VGND sg13cmos5l_fill_1
XANTENNA__0880__A1 AXIL_S_SOC_AWADDR4 VPWR VGND sg13cmos5l_antennanp
XFILLER_32_293 VPWR VGND sg13cmos5l_fill_2
XFILLER_192_213 VPWR VGND sg13cmos5l_decap_8
X_0969_ _0969_/Y _0451_/Y _0968_/X _1620_/Q VPWR VGND sg13cmos5l_a21oi_1
XANTENNA__1218__D Tile_X0Y0_FrameData[9] VPWR VGND sg13cmos5l_antennanp
XFILLER_99_293 VPWR VGND sg13cmos5l_fill_2
XANTENNA__2054__GATE Tile_X0Y3_FrameStrobe[3] VPWR VGND sg13cmos5l_antennanp
XFILLER_101_243 VPWR VGND sg13cmos5l_decap_8
XFILLER_59_157 VPWR VGND sg13cmos5l_fill_2
XANTENNA__2049__D Tile_X0Y3_FrameData[18] VPWR VGND sg13cmos5l_antennanp
XANTENNA__1112__A2 Tile_X0Y3_N4END[7] VPWR VGND sg13cmos5l_antennanp
XANTENNA__1888__D Tile_X0Y2_FrameData[27] VPWR VGND sg13cmos5l_antennanp
XFILLER_82_160 VPWR VGND sg13cmos5l_fill_1
XANTENNA__2069__GATE Tile_X0Y3_FrameStrobe[4] VPWR VGND sg13cmos5l_antennanp
XFILLER_130_32 VPWR VGND sg13cmos5l_decap_8
XFILLER_168_254 VPWR VGND sg13cmos5l_decap_8
XFILLER_128_107 VPWR VGND sg13cmos5l_decap_4
XANTENNA__1179__A2 Tile_X0Y2_W6END[3] VPWR VGND sg13cmos5l_antennanp
XANTENNA__0926__A2 Tile_X0Y3_N4END[9] VPWR VGND sg13cmos5l_antennanp
XANTENNA__2007__GATE Tile_X0Y3_FrameStrobe[2] VPWR VGND sg13cmos5l_antennanp
XFILLER_3_0 VPWR VGND sg13cmos5l_fill_2
XFILLER_191_290 VPWR VGND sg13cmos5l_decap_4
XANTENNA__1263__GATE Tile_X0Y3_FrameStrobe[2] VPWR VGND sg13cmos5l_antennanp
XFILLER_155_62 VPWR VGND sg13cmos5l_fill_1
XFILLER_155_73 VPWR VGND sg13cmos5l_decap_8
XFILLER_97_208 VPWR VGND sg13cmos5l_fill_1
XANTENNA__1893__GATE Tile_X0Y3_FrameStrobe[6] VPWR VGND sg13cmos5l_antennanp
XFILLER_2_186 VPWR VGND sg13cmos5l_fill_1
XFILLER_2_175 VPWR VGND sg13cmos5l_fill_2
XFILLER_17_8 VPWR VGND sg13cmos5l_fill_1
XANTENNA__1103__A2 Tile_X0Y3_N4END[7] VPWR VGND sg13cmos5l_antennanp
XANTENNA__1278__GATE Tile_X0Y3_FrameStrobe[2] VPWR VGND sg13cmos5l_antennanp
XFILLER_58_190 VPWR VGND sg13cmos5l_fill_1
XANTENNA__1798__D Tile_X0Y2_FrameData[21] VPWR VGND sg13cmos5l_antennanp
XFILLER_0_89 VPWR VGND sg13cmos5l_decap_8
XFILLER_64_81 VPWR VGND sg13cmos5l_decap_4
XFILLER_221_103 VPWR VGND sg13cmos5l_fill_2
XANTENNA__1201__GATE Tile_X0Y3_FrameStrobe[0] VPWR VGND sg13cmos5l_antennanp
XFILLER_21_208 VPWR VGND sg13cmos5l_decap_8
XANTENNA__1831__GATE Tile_X0Y3_FrameStrobe[4] VPWR VGND sg13cmos5l_antennanp
X_1941_ _1941_/Q Tile_X0Y3_FrameData[30] Tile_X0Y3_FrameStrobe[0] VPWR VGND sg13cmos5l_dlhq_1
XFILLER_9_54 VPWR VGND sg13cmos5l_decap_8
XANTENNA__2272__A Tile_X0Y1_FrameData[29] VPWR VGND sg13cmos5l_antennanp
XFILLER_14_293 VPWR VGND sg13cmos5l_fill_2
X_1872_ _1872_/Q Tile_X0Y2_FrameData[11] Tile_X0Y3_FrameStrobe[5] VPWR VGND sg13cmos5l_dlhq_1
XANTENNA__1216__GATE Tile_X0Y3_FrameStrobe[0] VPWR VGND sg13cmos5l_antennanp
X_0823_ _0823_/Y _0445_/Y _0488_/X _0822_/Y VPWR VGND sg13cmos5l_a21oi_1
XANTENNA__1846__GATE Tile_X0Y3_FrameStrobe[4] VPWR VGND sg13cmos5l_antennanp
XFILLER_142_110 VPWR VGND sg13cmos5l_decap_8
X_0754_ _0754_/X Tile_X0Y2_W2MID[0] Tile_X0Y2_W2END[0] Tile_X0Y2_W6END[0] _0758_/X
+ _1917_/Q _1916_/Q VPWR VGND sg13cmos5l_mux4_1
XANTENNA__1175__X AXIL_S_SOC_RDATA12 VPWR VGND sg13cmos5l_antennanp
XFILLER_142_143 VPWR VGND sg13cmos5l_decap_8
X_0685_ _2538_/A _0649_/X _0513_/X AXIL_S_SOC_ARADDR7 _0511_/X _2050_/Q _2051_/Q VPWR
+ VGND sg13cmos5l_mux4_1
X_2424_ Tile_X0Y0_FrameData_O[10] Tile_X0Y0_FrameData[10] VPWR VGND sg13cmos5l_buf_1
XFILLER_142_198 VPWR VGND sg13cmos5l_decap_8
X_2355_ Tile_X0Y2_FrameData_O[31] Tile_X0Y2_FrameData[31] VPWR VGND sg13cmos5l_buf_1
XFILLER_36_0 VPWR VGND sg13cmos5l_fill_2
XFILLER_215_32 VPWR VGND sg13cmos5l_decap_4
X_1306_ _1306_/Q Tile_X0Y0_FrameData[17] Tile_X0Y3_FrameStrobe[3] VPWR VGND sg13cmos5l_dlhq_1
X_2286_ Tile_X0Y2_E2BEG[6] _2286_/A VPWR VGND sg13cmos5l_buf_1
XFILLER_96_285 VPWR VGND sg13cmos5l_fill_2
XFILLER_56_116 VPWR VGND sg13cmos5l_fill_2
X_1237_ _1237_/Q Tile_X0Y0_FrameData[22] Tile_X0Y3_FrameStrobe[1] VPWR VGND sg13cmos5l_dlhq_1
X_1168_ _1168_/X _1904_/Q _1168_/B VPWR VGND sg13cmos5l_and2_1
XANTENNA__0853__A1 AXIL_S_SOC_AWADDR8 VPWR VGND sg13cmos5l_antennanp
XFILLER_64_171 VPWR VGND sg13cmos5l_decap_8
XANTENNA__1501__D Tile_X0Y1_FrameData[6] VPWR VGND sg13cmos5l_antennanp
X_1099_ _2311_/A AXIL_S_SOC_WDATA3 AXIL_S_SOC_WDATA15 _0529_/X _0742_/X _1821_/Q _1820_/Q
+ VPWR VGND sg13cmos5l_mux4_1
XFILLER_100_46 VPWR VGND sg13cmos5l_fill_2
XANTENNA__0605__A1 Tile_X0Y3_N4END[0] VPWR VGND sg13cmos5l_antennanp
XFILLER_165_246 VPWR VGND sg13cmos5l_decap_8
XFILLER_219_8 VPWR VGND sg13cmos5l_fill_1
XFILLER_20_285 VPWR VGND sg13cmos5l_fill_1
XFILLER_133_110 VPWR VGND sg13cmos5l_decap_4
XFILLER_180_216 VPWR VGND sg13cmos5l_decap_8
XANTENNA__1030__A1 AXIL_S_SOC_WDATA26 VPWR VGND sg13cmos5l_antennanp
XFILLER_109_88 VPWR VGND sg13cmos5l_fill_1
XANTENNA__0430__A Tile_X0Y0_W6END[2] VPWR VGND sg13cmos5l_antennanp
XFILLER_133_187 VPWR VGND sg13cmos5l_fill_2
XFILLER_125_65 VPWR VGND sg13cmos5l_decap_8
XANTENNA__0541__A0 Tile_X0Y3_W1END[0] VPWR VGND sg13cmos5l_antennanp
XANTENNA__2357__A Tile_X0Y0_UserCLK VPWR VGND sg13cmos5l_antennanp
XANTENNA__0844__A1 AXIL_S_SOC_AWADDR9 VPWR VGND sg13cmos5l_antennanp
XANTENNA__1411__D Tile_X0Y0_FrameData[8] VPWR VGND sg13cmos5l_antennanp
XFILLER_34_62 VPWR VGND sg13cmos5l_decap_8
XFILLER_156_235 VPWR VGND sg13cmos5l_fill_2
XFILLER_109_151 VPWR VGND sg13cmos5l_decap_8
XFILLER_109_162 VPWR VGND sg13cmos5l_decap_8
X_0470_ _0470_/X Tile_X0Y1_W1END[2] Tile_X0Y1_W6END[10] _0465_/X _0469_/Y _1651_/Q
+ _1650_/Q VPWR VGND sg13cmos5l_mux4_1
X_2140_ _2140_/Q Tile_X0Y3_FrameData[23] Tile_X0Y3_FrameStrobe[6] VPWR VGND sg13cmos5l_dlhq_1
XANTENNA__2267__A Tile_X0Y1_FrameData[24] VPWR VGND sg13cmos5l_antennanp
X_2071_ _2071_/Q Tile_X0Y3_FrameData[28] Tile_X0Y3_FrameStrobe[4] VPWR VGND sg13cmos5l_dlhq_1
X_1022_ _2237_/A AXIL_S_SOC_WDATA22 AXIL_S_SOC_WDATA26 _0926_/X _0865_/X _1559_/Q
+ _1558_/Q VPWR VGND sg13cmos5l_mux4_1
XANTENNA__1321__D Tile_X0Y0_FrameData[2] VPWR VGND sg13cmos5l_antennanp
XANTENNA__1770__GATE Tile_X0Y3_FrameStrobe[2] VPWR VGND sg13cmos5l_antennanp
XANTENNA__2554__X Tile_X0Y3_FrameData_O[12] VPWR VGND sg13cmos5l_antennanp
XFILLER_201_34 VPWR VGND sg13cmos5l_decap_8
XFILLER_201_78 VPWR VGND sg13cmos5l_fill_2
XANTENNA__0599__A0 Tile_X0Y3_W1END[2] VPWR VGND sg13cmos5l_antennanp
X_1924_ _1924_/Q Tile_X0Y2_FrameData[23] Tile_X0Y3_FrameStrobe[7] VPWR VGND sg13cmos5l_dlhq_1
XANTENNA__1785__GATE Tile_X0Y3_FrameStrobe[2] VPWR VGND sg13cmos5l_antennanp
XFILLER_147_235 VPWR VGND sg13cmos5l_fill_2
XANTENNA__2152__D Tile_X0Y3_FrameData[11] VPWR VGND sg13cmos5l_antennanp
XFILLER_147_268 VPWR VGND sg13cmos5l_decap_8
X_1855_ _1855_/Q Tile_X0Y2_FrameData[28] Tile_X0Y3_FrameStrobe[5] VPWR VGND sg13cmos5l_dlhq_1
X_1786_ _1786_/Q Tile_X0Y2_FrameData[1] Tile_X0Y3_FrameStrobe[2] VPWR VGND sg13cmos5l_dlhq_1
X_0806_ _0806_/Y _1378_/Q Tile_X0Y0_W6END[5] VPWR VGND sg13cmos5l_nor2b_1
XANTENNA__1012__A1 Tile_X0Y1_W2END[6] VPWR VGND sg13cmos5l_antennanp
XANTENNA__1991__D Tile_X0Y3_FrameData[12] VPWR VGND sg13cmos5l_antennanp
XFILLER_115_110 VPWR VGND sg13cmos5l_decap_4
XFILLER_162_249 VPWR VGND sg13cmos5l_decap_8
X_0737_ _0737_/X Tile_X0Y2_W2MID[3] Tile_X0Y2_W2END[3] Tile_X0Y2_W6END[3] _0742_/X
+ _1923_/Q _1922_/Q VPWR VGND sg13cmos5l_mux4_1
XANTENNA__0771__A0 Tile_X0Y1_W1END[3] VPWR VGND sg13cmos5l_antennanp
XFILLER_170_282 VPWR VGND sg13cmos5l_fill_2
XFILLER_170_293 VPWR VGND sg13cmos5l_fill_2
X_0668_ _2509_/A AXIL_S_SOC_RREADY AXIL_S_SOC_ARADDR6 _0511_/X _0590_/X _2085_/Q _2084_/Q
+ VPWR VGND sg13cmos5l_mux4_1
XFILLER_130_146 VPWR VGND sg13cmos5l_decap_8
X_2407_ Tile_X0Y0_FrameStrobe_O[13] Tile_X0Y3_FrameStrobe[13] VPWR VGND sg13cmos5l_buf_1
X_0599_ _2584_/A Tile_X0Y3_W1END[2] Tile_X0Y3_W2MID[1] Tile_X0Y3_W2END[1] _0598_/X
+ _2131_/Q _2130_/Q VPWR VGND sg13cmos5l_mux4_1
XANTENNA__1723__GATE Tile_X0Y3_FrameStrobe[0] VPWR VGND sg13cmos5l_antennanp
X_2338_ Tile_X0Y2_FrameData_O[14] Tile_X0Y2_FrameData[14] VPWR VGND sg13cmos5l_buf_1
XFILLER_84_211 VPWR VGND sg13cmos5l_decap_4
XFILLER_29_127 VPWR VGND sg13cmos5l_fill_2
X_2269_ Tile_X0Y1_FrameData_O[26] Tile_X0Y1_FrameData[26] VPWR VGND sg13cmos5l_buf_1
XANTENNA__1079__A1 AXIL_S_SOC_WDATA13 VPWR VGND sg13cmos5l_antennanp
XFILLER_169_8 VPWR VGND sg13cmos5l_decap_8
XANTENNA__0806__B_N Tile_X0Y0_W6END[5] VPWR VGND sg13cmos5l_antennanp
XANTENNA__1231__D Tile_X0Y0_FrameData[28] VPWR VGND sg13cmos5l_antennanp
XANTENNA__1738__GATE Tile_X0Y3_FrameStrobe[1] VPWR VGND sg13cmos5l_antennanp
XANTENNA__2464__X Tile_X0Y0_E6BEG[2] VPWR VGND sg13cmos5l_antennanp
XFILLER_111_34 VPWR VGND sg13cmos5l_fill_1
XFILLER_225_294 VPWR VGND sg13cmos5l_fill_1
XFILLER_225_283 VPWR VGND sg13cmos5l_fill_1
XFILLER_225_272 VPWR VGND sg13cmos5l_decap_8
XFILLER_197_113 VPWR VGND sg13cmos5l_decap_8
XFILLER_71_38 VPWR VGND sg13cmos5l_decap_8
XFILLER_197_179 VPWR VGND sg13cmos5l_decap_8
XANTENNA__2062__D Tile_X0Y3_FrameData[5] VPWR VGND sg13cmos5l_antennanp
XFILLER_138_257 VPWR VGND sg13cmos5l_decap_8
XANTENNA__1003__A1 Tile_X0Y1_W2END[0] VPWR VGND sg13cmos5l_antennanp
XFILLER_20_20 VPWR VGND sg13cmos5l_fill_2
XFILLER_106_176 VPWR VGND sg13cmos5l_decap_8
XANTENNA__1406__D Tile_X0Y0_FrameData[13] VPWR VGND sg13cmos5l_antennanp
XFILLER_121_146 VPWR VGND sg13cmos5l_fill_1
XFILLER_121_168 VPWR VGND sg13cmos5l_fill_2
XFILLER_96_46 VPWR VGND sg13cmos5l_decap_8
XANTENNA__0514__A0 Tile_X0Y3_W1END[3] VPWR VGND sg13cmos5l_antennanp
XFILLER_152_30 VPWR VGND sg13cmos5l_fill_1
XFILLER_208_217 VPWR VGND sg13cmos5l_decap_4
XFILLER_188_0 VPWR VGND sg13cmos5l_fill_2
XFILLER_90_236 VPWR VGND sg13cmos5l_decap_8
XANTENNA__0817__A1 AXIL_S_SOC_WVALID VPWR VGND sg13cmos5l_antennanp
XANTENNA__2374__X Tile_X0Y0_N2BEGb[0] VPWR VGND sg13cmos5l_antennanp
XFILLER_188_102 VPWR VGND sg13cmos5l_fill_1
XFILLER_188_168 VPWR VGND sg13cmos5l_fill_1
XFILLER_129_213 VPWR VGND sg13cmos5l_decap_8
XFILLER_129_224 VPWR VGND sg13cmos5l_fill_2
XFILLER_61_71 VPWR VGND sg13cmos5l_decap_8
XFILLER_196_190 VPWR VGND sg13cmos5l_decap_4
XANTENNA__2550__A Tile_X0Y3_FrameData[8] VPWR VGND sg13cmos5l_antennanp
X_1640_ _1640_/Q Tile_X0Y1_FrameData[27] Tile_X0Y3_FrameStrobe[6] VPWR VGND sg13cmos5l_dlhq_1
XFILLER_6_33 VPWR VGND sg13cmos5l_decap_4
XFILLER_6_11 VPWR VGND sg13cmos5l_fill_1
XANTENNA_4 AXIL_S_SOC_AWADDR3 VPWR VGND sg13cmos5l_antennanp
X_1571_ _1571_/Q Tile_X0Y1_FrameData[0] Tile_X0Y3_FrameStrobe[3] VPWR VGND sg13cmos5l_dlhq_1
XFILLER_6_66 VPWR VGND sg13cmos5l_decap_8
X_0522_ _0522_/X _0870_/X _0521_/X Tile_X0Y3_N4END[8] Tile_X0Y0_S4END[4] _1474_/Q
+ _1475_/Q VPWR VGND sg13cmos5l_mux4_1
XANTENNA__0753__A0 Tile_X0Y1_W2MID[0] VPWR VGND sg13cmos5l_antennanp
XANTENNA__1316__D Tile_X0Y0_FrameData[7] VPWR VGND sg13cmos5l_antennanp
XANTENNA__2549__X Tile_X0Y3_FrameData_O[7] VPWR VGND sg13cmos5l_antennanp
X_0453_ _0453_/Y _1620_/Q VPWR VGND sg13cmos5l_inv_1
XANTENNA__0505__A0 Tile_X0Y2_W1END[3] VPWR VGND sg13cmos5l_antennanp
X_2123_ _2123_/Q Tile_X0Y3_FrameData[8] Tile_X0Y3_FrameStrobe[5] VPWR VGND sg13cmos5l_dlhq_1
X_2054_ _2054_/Q Tile_X0Y3_FrameData[13] Tile_X0Y3_FrameStrobe[3] VPWR VGND sg13cmos5l_dlhq_1
XFILLER_212_66 VPWR VGND sg13cmos5l_decap_8
XFILLER_207_261 VPWR VGND sg13cmos5l_decap_8
XANTENNA__2147__D Tile_X0Y3_FrameData[16] VPWR VGND sg13cmos5l_antennanp
XANTENNA__2284__X Tile_X0Y2_E2BEG[4] VPWR VGND sg13cmos5l_antennanp
X_1005_ _2225_/A AXIL_S_SOC_WDATA18 _0923_/A _0926_/X _0866_/X _1527_/Q _1526_/Q VPWR
+ VGND sg13cmos5l_mux4_1
XFILLER_222_220 VPWR VGND sg13cmos5l_decap_4
XANTENNA__1986__D Tile_X0Y3_FrameData[17] VPWR VGND sg13cmos5l_antennanp
XFILLER_222_286 VPWR VGND sg13cmos5l_fill_1
XFILLER_194_105 VPWR VGND sg13cmos5l_decap_8
XFILLER_179_179 VPWR VGND sg13cmos5l_decap_8
X_1907_ _1907_/Q Tile_X0Y2_FrameData[8] Tile_X0Y3_FrameStrobe[6] VPWR VGND sg13cmos5l_dlhq_1
XFILLER_194_149 VPWR VGND sg13cmos5l_fill_1
X_1838_ _1838_/Q Tile_X0Y2_FrameData[13] Tile_X0Y3_FrameStrobe[4] VPWR VGND sg13cmos5l_dlhq_1
X_1769_ _1769_/Q Tile_X0Y2_FrameData[18] Tile_X0Y3_FrameStrobe[2] VPWR VGND sg13cmos5l_dlhq_1
XANTENNA__0744__A0 Tile_X0Y0_W2MID[4] VPWR VGND sg13cmos5l_antennanp
XFILLER_143_293 VPWR VGND sg13cmos5l_fill_2
XANTENNA__1226__D Tile_X0Y0_FrameData[1] VPWR VGND sg13cmos5l_antennanp
XANTENNA__1662__GATE Tile_X0Y3_FrameStrobe[6] VPWR VGND sg13cmos5l_antennanp
XANTENNA__2459__X Tile_X0Y0_EE4BEG[13] VPWR VGND sg13cmos5l_antennanp
XFILLER_103_146 VPWR VGND sg13cmos5l_decap_8
XFILLER_103_157 VPWR VGND sg13cmos5l_fill_2
XFILLER_106_67 VPWR VGND sg13cmos5l_fill_2
XFILLER_122_11 VPWR VGND sg13cmos5l_decap_8
XANTENNA__1677__GATE Tile_X0Y3_FrameStrobe[7] VPWR VGND sg13cmos5l_antennanp
XFILLER_122_44 VPWR VGND sg13cmos5l_decap_8
XANTENNA__0707__X AXIL_S_SOC_RDATA6 VPWR VGND sg13cmos5l_antennanp
XANTENNA__2057__D Tile_X0Y3_FrameData[10] VPWR VGND sg13cmos5l_antennanp
XFILLER_25_152 VPWR VGND sg13cmos5l_fill_1
XFILLER_198_15 VPWR VGND sg13cmos5l_fill_2
XANTENNA__1600__GATE Tile_X0Y3_FrameStrobe[4] VPWR VGND sg13cmos5l_antennanp
XANTENNA__1896__D Tile_X0Y2_FrameData[19] VPWR VGND sg13cmos5l_antennanp
XFILLER_15_53 VPWR VGND sg13cmos5l_decap_8
XFILLER_213_275 VPWR VGND sg13cmos5l_fill_1
XANTENNA__1615__GATE Tile_X0Y3_FrameStrobe[5] VPWR VGND sg13cmos5l_antennanp
XFILLER_119_290 VPWR VGND sg13cmos5l_decap_4
XFILLER_103_0 VPWR VGND sg13cmos5l_fill_2
XFILLER_147_85 VPWR VGND sg13cmos5l_decap_4
XANTENNA__0735__A0 Tile_X0Y1_W2MID[2] VPWR VGND sg13cmos5l_antennanp
XFILLER_134_293 VPWR VGND sg13cmos5l_fill_2
XANTENNA__2369__X Tile_X0Y0_N4BEG[11] VPWR VGND sg13cmos5l_antennanp
XFILLER_0_251 VPWR VGND sg13cmos5l_decap_8
XFILLER_48_200 VPWR VGND sg13cmos5l_decap_4
XANTENNA__1160__A0 Tile_X0Y2_W1END[2] VPWR VGND sg13cmos5l_antennanp
XANTENNA__2545__A Tile_X0Y3_FrameData[3] VPWR VGND sg13cmos5l_antennanp
XFILLER_204_231 VPWR VGND sg13cmos5l_decap_8
XFILLER_31_122 VPWR VGND sg13cmos5l_decap_8
XFILLER_169_190 VPWR VGND sg13cmos5l_decap_8
XFILLER_75_4 VPWR VGND sg13cmos5l_fill_1
X_1623_ _1623_/Q Tile_X0Y1_FrameData[12] Tile_X0Y3_FrameStrobe[5] VPWR VGND sg13cmos5l_dlhq_1
XANTENNA__0726__A0 Tile_X0Y0_W2MID[5] VPWR VGND sg13cmos5l_antennanp
X_1554_ _1554_/Q Tile_X0Y1_FrameData[17] Tile_X0Y3_FrameStrobe[3] VPWR VGND sg13cmos5l_dlhq_1
XANTENNA__2279__X Tile_X0Y2_E1BEG[3] VPWR VGND sg13cmos5l_antennanp
XFILLER_125_293 VPWR VGND sg13cmos5l_fill_2
X_1485_ _1485_/Q Tile_X0Y1_FrameData[22] Tile_X0Y3_FrameStrobe[1] VPWR VGND sg13cmos5l_dlhq_1
X_0505_ _0574_/B Tile_X0Y2_W1END[3] Tile_X0Y2_W6END[11] _0500_/X _0504_/Y _1897_/Q
+ _1896_/Q VPWR VGND sg13cmos5l_mux4_1
XFILLER_140_274 VPWR VGND sg13cmos5l_decap_8
X_0436_ _0436_/Y _1417_/Q VPWR VGND sg13cmos5l_inv_1
.ends
