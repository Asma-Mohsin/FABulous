* NGSPICE file created from NPU_PSUM_PORT.ext - technology: ihp-sg13cmos5l

* Black-box entry subcircuit for sg13cmos5l_antennanp abstract view
.subckt sg13cmos5l_antennanp A VDD VSS
.ends

* Black-box entry subcircuit for sg13cmos5l_decap_8 abstract view
.subckt sg13cmos5l_decap_8 VDD VSS
.ends

* Black-box entry subcircuit for sg13cmos5l_fill_2 abstract view
.subckt sg13cmos5l_fill_2 VDD VSS
.ends

* Black-box entry subcircuit for sg13cmos5l_fill_1 abstract view
.subckt sg13cmos5l_fill_1 VDD VSS
.ends

* Black-box entry subcircuit for sg13cmos5l_buf_1 abstract view
.subckt sg13cmos5l_buf_1 X A VDD VSS
.ends

* Black-box entry subcircuit for sg13cmos5l_decap_4 abstract view
.subckt sg13cmos5l_decap_4 VDD VSS
.ends

.subckt NPU_PSUM_PORT NPU_ADDR0 NPU_ADDR1 NPU_ADDR2 NPU_ADDR3 NPU_ADDR4 NPU_ADDR5
+ NPU_ADDR6 NPU_ADDR7 NPU_RDATA0 NPU_RDATA1 NPU_RDATA10 NPU_RDATA11 NPU_RDATA12 NPU_RDATA13
+ NPU_RDATA14 NPU_RDATA15 NPU_RDATA16 NPU_RDATA17 NPU_RDATA18 NPU_RDATA19 NPU_RDATA2
+ NPU_RDATA20 NPU_RDATA21 NPU_RDATA22 NPU_RDATA23 NPU_RDATA24 NPU_RDATA25 NPU_RDATA26
+ NPU_RDATA27 NPU_RDATA28 NPU_RDATA29 NPU_RDATA3 NPU_RDATA30 NPU_RDATA31 NPU_RDATA4
+ NPU_RDATA5 NPU_RDATA6 NPU_RDATA7 NPU_RDATA8 NPU_RDATA9 NPU_READ_BANK_SEL0 NPU_READ_BANK_SEL1
+ NPU_READ_BANK_SEL2 NPU_WDATA0 NPU_WDATA1 NPU_WDATA10 NPU_WDATA11 NPU_WDATA12 NPU_WDATA13
+ NPU_WDATA14 NPU_WDATA15 NPU_WDATA16 NPU_WDATA17 NPU_WDATA18 NPU_WDATA19 NPU_WDATA2
+ NPU_WDATA20 NPU_WDATA21 NPU_WDATA22 NPU_WDATA23 NPU_WDATA24 NPU_WDATA25 NPU_WDATA26
+ NPU_WDATA27 NPU_WDATA28 NPU_WDATA29 NPU_WDATA3 NPU_WDATA30 NPU_WDATA31 NPU_WDATA4
+ NPU_WDATA5 NPU_WDATA6 NPU_WDATA7 NPU_WDATA8 NPU_WDATA9 NPU_WE0 NPU_WE1 NPU_WE2 NPU_WE3
+ NPU_WE4 NPU_WE5 NPU_WE6 NPU_WE7 Tile_X0Y0_Ci Tile_X0Y0_FrameData[0] Tile_X0Y0_FrameData[10]
+ Tile_X0Y0_FrameData[11] Tile_X0Y0_FrameData[12] Tile_X0Y0_FrameData[13] Tile_X0Y0_FrameData[14]
+ Tile_X0Y0_FrameData[15] Tile_X0Y0_FrameData[16] Tile_X0Y0_FrameData[17] Tile_X0Y0_FrameData[18]
+ Tile_X0Y0_FrameData[19] Tile_X0Y0_FrameData[1] Tile_X0Y0_FrameData[20] Tile_X0Y0_FrameData[21]
+ Tile_X0Y0_FrameData[22] Tile_X0Y0_FrameData[23] Tile_X0Y0_FrameData[24] Tile_X0Y0_FrameData[25]
+ Tile_X0Y0_FrameData[26] Tile_X0Y0_FrameData[27] Tile_X0Y0_FrameData[28] Tile_X0Y0_FrameData[29]
+ Tile_X0Y0_FrameData[2] Tile_X0Y0_FrameData[30] Tile_X0Y0_FrameData[31] Tile_X0Y0_FrameData[3]
+ Tile_X0Y0_FrameData[4] Tile_X0Y0_FrameData[5] Tile_X0Y0_FrameData[6] Tile_X0Y0_FrameData[7]
+ Tile_X0Y0_FrameData[8] Tile_X0Y0_FrameData[9] Tile_X0Y0_FrameStrobe[0] Tile_X0Y0_FrameStrobe[10]
+ Tile_X0Y0_FrameStrobe[11] Tile_X0Y0_FrameStrobe[12] Tile_X0Y0_FrameStrobe[13] Tile_X0Y0_FrameStrobe[14]
+ Tile_X0Y0_FrameStrobe[15] Tile_X0Y0_FrameStrobe[16] Tile_X0Y0_FrameStrobe[17] Tile_X0Y0_FrameStrobe[18]
+ Tile_X0Y0_FrameStrobe[19] Tile_X0Y0_FrameStrobe[1] Tile_X0Y0_FrameStrobe[2] Tile_X0Y0_FrameStrobe[3]
+ Tile_X0Y0_FrameStrobe[4] Tile_X0Y0_FrameStrobe[5] Tile_X0Y0_FrameStrobe[6] Tile_X0Y0_FrameStrobe[7]
+ Tile_X0Y0_FrameStrobe[8] Tile_X0Y0_FrameStrobe[9] Tile_X0Y0_FrameStrobe_O[0] Tile_X0Y0_FrameStrobe_O[10]
+ Tile_X0Y0_FrameStrobe_O[11] Tile_X0Y0_FrameStrobe_O[12] Tile_X0Y0_FrameStrobe_O[13]
+ Tile_X0Y0_FrameStrobe_O[14] Tile_X0Y0_FrameStrobe_O[15] Tile_X0Y0_FrameStrobe_O[16]
+ Tile_X0Y0_FrameStrobe_O[17] Tile_X0Y0_FrameStrobe_O[18] Tile_X0Y0_FrameStrobe_O[19]
+ Tile_X0Y0_FrameStrobe_O[1] Tile_X0Y0_FrameStrobe_O[2] Tile_X0Y0_FrameStrobe_O[3]
+ Tile_X0Y0_FrameStrobe_O[4] Tile_X0Y0_FrameStrobe_O[5] Tile_X0Y0_FrameStrobe_O[6]
+ Tile_X0Y0_FrameStrobe_O[7] Tile_X0Y0_FrameStrobe_O[8] Tile_X0Y0_FrameStrobe_O[9]
+ Tile_X0Y0_N1END[0] Tile_X0Y0_N1END[1] Tile_X0Y0_N1END[2] Tile_X0Y0_N1END[3] Tile_X0Y0_N2END[0]
+ Tile_X0Y0_N2END[1] Tile_X0Y0_N2END[2] Tile_X0Y0_N2END[3] Tile_X0Y0_N2END[4] Tile_X0Y0_N2END[5]
+ Tile_X0Y0_N2END[6] Tile_X0Y0_N2END[7] Tile_X0Y0_N2MID[0] Tile_X0Y0_N2MID[1] Tile_X0Y0_N2MID[2]
+ Tile_X0Y0_N2MID[3] Tile_X0Y0_N2MID[4] Tile_X0Y0_N2MID[5] Tile_X0Y0_N2MID[6] Tile_X0Y0_N2MID[7]
+ Tile_X0Y0_N4END[0] Tile_X0Y0_N4END[10] Tile_X0Y0_N4END[11] Tile_X0Y0_N4END[12] Tile_X0Y0_N4END[13]
+ Tile_X0Y0_N4END[14] Tile_X0Y0_N4END[15] Tile_X0Y0_N4END[1] Tile_X0Y0_N4END[2] Tile_X0Y0_N4END[3]
+ Tile_X0Y0_N4END[4] Tile_X0Y0_N4END[5] Tile_X0Y0_N4END[6] Tile_X0Y0_N4END[7] Tile_X0Y0_N4END[8]
+ Tile_X0Y0_N4END[9] Tile_X0Y0_NN4END[0] Tile_X0Y0_NN4END[10] Tile_X0Y0_NN4END[11]
+ Tile_X0Y0_NN4END[12] Tile_X0Y0_NN4END[13] Tile_X0Y0_NN4END[14] Tile_X0Y0_NN4END[15]
+ Tile_X0Y0_NN4END[1] Tile_X0Y0_NN4END[2] Tile_X0Y0_NN4END[3] Tile_X0Y0_NN4END[4]
+ Tile_X0Y0_NN4END[5] Tile_X0Y0_NN4END[6] Tile_X0Y0_NN4END[7] Tile_X0Y0_NN4END[8]
+ Tile_X0Y0_NN4END[9] Tile_X0Y0_S1BEG[0] Tile_X0Y0_S1BEG[1] Tile_X0Y0_S1BEG[2] Tile_X0Y0_S1BEG[3]
+ Tile_X0Y0_S2BEG[0] Tile_X0Y0_S2BEG[1] Tile_X0Y0_S2BEG[2] Tile_X0Y0_S2BEG[3] Tile_X0Y0_S2BEG[4]
+ Tile_X0Y0_S2BEG[5] Tile_X0Y0_S2BEG[6] Tile_X0Y0_S2BEG[7] Tile_X0Y0_S2BEGb[0] Tile_X0Y0_S2BEGb[1]
+ Tile_X0Y0_S2BEGb[2] Tile_X0Y0_S2BEGb[3] Tile_X0Y0_S2BEGb[4] Tile_X0Y0_S2BEGb[5]
+ Tile_X0Y0_S2BEGb[6] Tile_X0Y0_S2BEGb[7] Tile_X0Y0_S4BEG[0] Tile_X0Y0_S4BEG[10] Tile_X0Y0_S4BEG[11]
+ Tile_X0Y0_S4BEG[12] Tile_X0Y0_S4BEG[13] Tile_X0Y0_S4BEG[14] Tile_X0Y0_S4BEG[15]
+ Tile_X0Y0_S4BEG[1] Tile_X0Y0_S4BEG[2] Tile_X0Y0_S4BEG[3] Tile_X0Y0_S4BEG[4] Tile_X0Y0_S4BEG[5]
+ Tile_X0Y0_S4BEG[6] Tile_X0Y0_S4BEG[7] Tile_X0Y0_S4BEG[8] Tile_X0Y0_S4BEG[9] Tile_X0Y0_SS4BEG[0]
+ Tile_X0Y0_SS4BEG[10] Tile_X0Y0_SS4BEG[11] Tile_X0Y0_SS4BEG[12] Tile_X0Y0_SS4BEG[13]
+ Tile_X0Y0_SS4BEG[14] Tile_X0Y0_SS4BEG[15] Tile_X0Y0_SS4BEG[1] Tile_X0Y0_SS4BEG[2]
+ Tile_X0Y0_SS4BEG[3] Tile_X0Y0_SS4BEG[4] Tile_X0Y0_SS4BEG[5] Tile_X0Y0_SS4BEG[6]
+ Tile_X0Y0_SS4BEG[7] Tile_X0Y0_SS4BEG[8] Tile_X0Y0_SS4BEG[9] Tile_X0Y0_UserCLK Tile_X1Y0_Ci
+ Tile_X1Y0_FrameData_O[0] Tile_X1Y0_FrameData_O[10] Tile_X1Y0_FrameData_O[11] Tile_X1Y0_FrameData_O[12]
+ Tile_X1Y0_FrameData_O[13] Tile_X1Y0_FrameData_O[14] Tile_X1Y0_FrameData_O[15] Tile_X1Y0_FrameData_O[16]
+ Tile_X1Y0_FrameData_O[17] Tile_X1Y0_FrameData_O[18] Tile_X1Y0_FrameData_O[19] Tile_X1Y0_FrameData_O[1]
+ Tile_X1Y0_FrameData_O[20] Tile_X1Y0_FrameData_O[21] Tile_X1Y0_FrameData_O[22] Tile_X1Y0_FrameData_O[23]
+ Tile_X1Y0_FrameData_O[24] Tile_X1Y0_FrameData_O[25] Tile_X1Y0_FrameData_O[26] Tile_X1Y0_FrameData_O[27]
+ Tile_X1Y0_FrameData_O[28] Tile_X1Y0_FrameData_O[29] Tile_X1Y0_FrameData_O[2] Tile_X1Y0_FrameData_O[30]
+ Tile_X1Y0_FrameData_O[31] Tile_X1Y0_FrameData_O[3] Tile_X1Y0_FrameData_O[4] Tile_X1Y0_FrameData_O[5]
+ Tile_X1Y0_FrameData_O[6] Tile_X1Y0_FrameData_O[7] Tile_X1Y0_FrameData_O[8] Tile_X1Y0_FrameData_O[9]
+ Tile_X1Y0_FrameStrobe[0] Tile_X1Y0_FrameStrobe[10] Tile_X1Y0_FrameStrobe[11] Tile_X1Y0_FrameStrobe[12]
+ Tile_X1Y0_FrameStrobe[13] Tile_X1Y0_FrameStrobe[14] Tile_X1Y0_FrameStrobe[15] Tile_X1Y0_FrameStrobe[16]
+ Tile_X1Y0_FrameStrobe[17] Tile_X1Y0_FrameStrobe[18] Tile_X1Y0_FrameStrobe[19] Tile_X1Y0_FrameStrobe[1]
+ Tile_X1Y0_FrameStrobe[2] Tile_X1Y0_FrameStrobe[3] Tile_X1Y0_FrameStrobe[4] Tile_X1Y0_FrameStrobe[5]
+ Tile_X1Y0_FrameStrobe[6] Tile_X1Y0_FrameStrobe[7] Tile_X1Y0_FrameStrobe[8] Tile_X1Y0_FrameStrobe[9]
+ Tile_X1Y0_FrameStrobe_O[0] Tile_X1Y0_FrameStrobe_O[10] Tile_X1Y0_FrameStrobe_O[11]
+ Tile_X1Y0_FrameStrobe_O[12] Tile_X1Y0_FrameStrobe_O[13] Tile_X1Y0_FrameStrobe_O[14]
+ Tile_X1Y0_FrameStrobe_O[15] Tile_X1Y0_FrameStrobe_O[16] Tile_X1Y0_FrameStrobe_O[17]
+ Tile_X1Y0_FrameStrobe_O[18] Tile_X1Y0_FrameStrobe_O[19] Tile_X1Y0_FrameStrobe_O[1]
+ Tile_X1Y0_FrameStrobe_O[2] Tile_X1Y0_FrameStrobe_O[3] Tile_X1Y0_FrameStrobe_O[4]
+ Tile_X1Y0_FrameStrobe_O[5] Tile_X1Y0_FrameStrobe_O[6] Tile_X1Y0_FrameStrobe_O[7]
+ Tile_X1Y0_FrameStrobe_O[8] Tile_X1Y0_FrameStrobe_O[9] Tile_X1Y0_N1END[0] Tile_X1Y0_N1END[1]
+ Tile_X1Y0_N1END[2] Tile_X1Y0_N1END[3] Tile_X1Y0_N2END[0] Tile_X1Y0_N2END[1] Tile_X1Y0_N2END[2]
+ Tile_X1Y0_N2END[3] Tile_X1Y0_N2END[4] Tile_X1Y0_N2END[5] Tile_X1Y0_N2END[6] Tile_X1Y0_N2END[7]
+ Tile_X1Y0_N2MID[0] Tile_X1Y0_N2MID[1] Tile_X1Y0_N2MID[2] Tile_X1Y0_N2MID[3] Tile_X1Y0_N2MID[4]
+ Tile_X1Y0_N2MID[5] Tile_X1Y0_N2MID[6] Tile_X1Y0_N2MID[7] Tile_X1Y0_N4END[0] Tile_X1Y0_N4END[10]
+ Tile_X1Y0_N4END[11] Tile_X1Y0_N4END[12] Tile_X1Y0_N4END[13] Tile_X1Y0_N4END[14]
+ Tile_X1Y0_N4END[15] Tile_X1Y0_N4END[1] Tile_X1Y0_N4END[2] Tile_X1Y0_N4END[3] Tile_X1Y0_N4END[4]
+ Tile_X1Y0_N4END[5] Tile_X1Y0_N4END[6] Tile_X1Y0_N4END[7] Tile_X1Y0_N4END[8] Tile_X1Y0_N4END[9]
+ Tile_X1Y0_NN4END[0] Tile_X1Y0_NN4END[10] Tile_X1Y0_NN4END[11] Tile_X1Y0_NN4END[12]
+ Tile_X1Y0_NN4END[13] Tile_X1Y0_NN4END[14] Tile_X1Y0_NN4END[15] Tile_X1Y0_NN4END[1]
+ Tile_X1Y0_NN4END[2] Tile_X1Y0_NN4END[3] Tile_X1Y0_NN4END[4] Tile_X1Y0_NN4END[5]
+ Tile_X1Y0_NN4END[6] Tile_X1Y0_NN4END[7] Tile_X1Y0_NN4END[8] Tile_X1Y0_NN4END[9]
+ Tile_X1Y0_S1BEG[0] Tile_X1Y0_S1BEG[1] Tile_X1Y0_S1BEG[2] Tile_X1Y0_S1BEG[3] Tile_X1Y0_S2BEG[0]
+ Tile_X1Y0_S2BEG[1] Tile_X1Y0_S2BEG[2] Tile_X1Y0_S2BEG[3] Tile_X1Y0_S2BEG[4] Tile_X1Y0_S2BEG[5]
+ Tile_X1Y0_S2BEG[6] Tile_X1Y0_S2BEG[7] Tile_X1Y0_S2BEGb[0] Tile_X1Y0_S2BEGb[1] Tile_X1Y0_S2BEGb[2]
+ Tile_X1Y0_S2BEGb[3] Tile_X1Y0_S2BEGb[4] Tile_X1Y0_S2BEGb[5] Tile_X1Y0_S2BEGb[6]
+ Tile_X1Y0_S2BEGb[7] Tile_X1Y0_S4BEG[0] Tile_X1Y0_S4BEG[10] Tile_X1Y0_S4BEG[11] Tile_X1Y0_S4BEG[12]
+ Tile_X1Y0_S4BEG[13] Tile_X1Y0_S4BEG[14] Tile_X1Y0_S4BEG[15] Tile_X1Y0_S4BEG[1] Tile_X1Y0_S4BEG[2]
+ Tile_X1Y0_S4BEG[3] Tile_X1Y0_S4BEG[4] Tile_X1Y0_S4BEG[5] Tile_X1Y0_S4BEG[6] Tile_X1Y0_S4BEG[7]
+ Tile_X1Y0_S4BEG[8] Tile_X1Y0_S4BEG[9] Tile_X1Y0_SS4BEG[0] Tile_X1Y0_SS4BEG[10] Tile_X1Y0_SS4BEG[11]
+ Tile_X1Y0_SS4BEG[12] Tile_X1Y0_SS4BEG[13] Tile_X1Y0_SS4BEG[14] Tile_X1Y0_SS4BEG[15]
+ Tile_X1Y0_SS4BEG[1] Tile_X1Y0_SS4BEG[2] Tile_X1Y0_SS4BEG[3] Tile_X1Y0_SS4BEG[4]
+ Tile_X1Y0_SS4BEG[5] Tile_X1Y0_SS4BEG[6] Tile_X1Y0_SS4BEG[7] Tile_X1Y0_SS4BEG[8]
+ Tile_X1Y0_SS4BEG[9] Tile_X1Y0_UserCLKo VGND VPWR
XANTENNA__043__X NPU_ADDR2 VPWR VGND sg13cmos5l_antennanp
XFILLER_2_538 VPWR VGND sg13cmos5l_decap_8
XANTENNA__218__X Tile_X1Y0_SS4BEG[7] VPWR VGND sg13cmos5l_antennanp
XFILLER_9_115 VPWR VGND sg13cmos5l_decap_8
XFILLER_6_811 VPWR VGND sg13cmos5l_decap_8
XFILLER_5_321 VPWR VGND sg13cmos5l_decap_8
XFILLER_10_873 VPWR VGND sg13cmos5l_decap_8
XFILLER_1_593 VPWR VGND sg13cmos5l_fill_2
XANTENNA__128__X Tile_X0Y0_FrameStrobe_O[14] VPWR VGND sg13cmos5l_antennanp
XFILLER_9_693 VPWR VGND sg13cmos5l_decap_8
XANTENNA__038__X NPU_ADDR7 VPWR VGND sg13cmos5l_antennanp
XFILLER_10_147 VPWR VGND sg13cmos5l_fill_1
XFILLER_10_158 VPWR VGND sg13cmos5l_decap_8
XFILLER_10_169 VPWR VGND sg13cmos5l_fill_1
XFILLER_7_608 VPWR VGND sg13cmos5l_decap_8
XFILLER_6_129 VPWR VGND sg13cmos5l_decap_8
XFILLER_11_615 VPWR VGND sg13cmos5l_decap_8
XANTENNA__214__A Tile_X1Y0_NN4END[12] VPWR VGND sg13cmos5l_antennanp
XFILLER_3_814 VPWR VGND sg13cmos5l_decap_8
XFILLER_2_368 VPWR VGND sg13cmos5l_fill_2
XFILLER_2_335 VPWR VGND sg13cmos5l_fill_2
XANTENNA__124__A Tile_X0Y0_FrameStrobe[10] VPWR VGND sg13cmos5l_antennanp
XFILLER_6_696 VPWR VGND sg13cmos5l_decap_8
XFILLER_6_685 VPWR VGND sg13cmos5l_fill_1
XFILLER_6_641 VPWR VGND sg13cmos5l_decap_8
XFILLER_5_140 VPWR VGND sg13cmos5l_decap_8
XANTENNA__034__A Tile_X0Y0_N1END[3] VPWR VGND sg13cmos5l_antennanp
XFILLER_0_806 VPWR VGND sg13cmos5l_decap_8
XANTENNA__209__A NPU_RDATA17 VPWR VGND sg13cmos5l_antennanp
X_200_ Tile_X1Y0_S4BEG[5] NPU_RDATA26 VPWR VGND sg13cmos5l_buf_1
XFILLER_11_423 VPWR VGND sg13cmos5l_decap_8
X_062_ Tile_X1Y0_FrameData_O[16] Tile_X0Y0_FrameData[16] VPWR VGND sg13cmos5l_buf_1
X_131_ Tile_X0Y0_FrameStrobe_O[17] Tile_X0Y0_FrameStrobe[17] VPWR VGND sg13cmos5l_buf_1
XFILLER_7_449 VPWR VGND sg13cmos5l_decap_8
XFILLER_3_688 VPWR VGND sg13cmos5l_decap_8
XFILLER_3_633 VPWR VGND sg13cmos5l_fill_2
XFILLER_2_121 VPWR VGND sg13cmos5l_decap_4
XFILLER_0_46 VPWR VGND sg13cmos5l_decap_8
XANTENNA__119__A Tile_X0Y0_FrameStrobe[5] VPWR VGND sg13cmos5l_antennanp
XFILLER_9_66 VPWR VGND sg13cmos5l_decap_8
XANTENNA__141__X Tile_X0Y0_S4BEG[7] VPWR VGND sg13cmos5l_antennanp
XANTENNA__029__A Tile_X0Y0_NN4END[4] VPWR VGND sg13cmos5l_antennanp
XANTENNA__051__X Tile_X1Y0_FrameData_O[5] VPWR VGND sg13cmos5l_antennanp
XFILLER_0_614 VPWR VGND sg13cmos5l_fill_2
XANTENNA__226__X Tile_X1Y0_SS4BEG[15] VPWR VGND sg13cmos5l_antennanp
XFILLER_8_736 VPWR VGND sg13cmos5l_decap_8
XFILLER_8_703 VPWR VGND sg13cmos5l_decap_8
XFILLER_11_231 VPWR VGND sg13cmos5l_decap_8
X_045_ NPU_ADDR0 Tile_X1Y0_N4END[15] VPWR VGND sg13cmos5l_buf_1
X_114_ Tile_X0Y0_FrameStrobe_O[0] Tile_X0Y0_FrameStrobe[0] VPWR VGND sg13cmos5l_buf_1
XFILLER_7_268 VPWR VGND sg13cmos5l_decap_8
XFILLER_3_452 VPWR VGND sg13cmos5l_decap_8
XANTENNA__136__X Tile_X0Y0_S4BEG[2] VPWR VGND sg13cmos5l_antennanp
XANTENNA__046__X Tile_X1Y0_FrameData_O[0] VPWR VGND sg13cmos5l_antennanp
XANTENNA__222__A Tile_X1Y0_NN4END[4] VPWR VGND sg13cmos5l_antennanp
XFILLER_0_444 VPWR VGND sg13cmos5l_decap_8
XANTENNA__132__A Tile_X0Y0_FrameStrobe[18] VPWR VGND sg13cmos5l_antennanp
X_028_ Tile_X0Y0_SS4BEG[10] Tile_X0Y0_NN4END[5] VPWR VGND sg13cmos5l_buf_1
XFILLER_6_45 VPWR VGND sg13cmos5l_decap_8
XFILLER_2_709 VPWR VGND sg13cmos5l_fill_2
XANTENNA__042__A Tile_X1Y0_N4END[12] VPWR VGND sg13cmos5l_antennanp
XANTENNA__217__A Tile_X1Y0_NN4END[9] VPWR VGND sg13cmos5l_antennanp
XFILLER_0_230 VPWR VGND sg13cmos5l_fill_2
XFILLER_5_536 VPWR VGND sg13cmos5l_fill_2
XFILLER_5_525 VPWR VGND sg13cmos5l_decap_8
XFILLER_0_285 VPWR VGND sg13cmos5l_decap_8
XANTENNA__127__A Tile_X0Y0_FrameStrobe[13] VPWR VGND sg13cmos5l_antennanp
XFILLER_9_853 VPWR VGND sg13cmos5l_decap_8
XFILLER_8_374 VPWR VGND sg13cmos5l_decap_8
XFILLER_11_0 VPWR VGND sg13cmos5l_decap_8
XANTENNA__037__A Tile_X0Y0_N1END[0] VPWR VGND sg13cmos5l_antennanp
XFILLER_10_318 VPWR VGND sg13cmos5l_fill_1
XFILLER_11_819 VPWR VGND sg13cmos5l_decap_8
XFILLER_2_517 VPWR VGND sg13cmos5l_decap_8
XFILLER_2_506 VPWR VGND sg13cmos5l_decap_8
XFILLER_6_867 VPWR VGND sg13cmos5l_decap_8
XFILLER_10_841 VPWR VGND sg13cmos5l_decap_8
XFILLER_5_399 VPWR VGND sg13cmos5l_decap_8
XFILLER_3_24 VPWR VGND sg13cmos5l_decap_8
XANTENNA__144__X Tile_X0Y0_S4BEG[10] VPWR VGND sg13cmos5l_antennanp
XFILLER_9_672 VPWR VGND sg13cmos5l_fill_2
XFILLER_8_182 VPWR VGND sg13cmos5l_decap_8
XANTENNA__054__X Tile_X1Y0_FrameData_O[8] VPWR VGND sg13cmos5l_antennanp
XFILLER_10_126 VPWR VGND sg13cmos5l_decap_8
XFILLER_6_108 VPWR VGND sg13cmos5l_decap_8
XFILLER_6_620 VPWR VGND sg13cmos5l_decap_8
XFILLER_10_693 VPWR VGND sg13cmos5l_fill_2
XANTENNA__140__A NPU_RDATA9 VPWR VGND sg13cmos5l_antennanp
XANTENNA__139__X Tile_X0Y0_S4BEG[5] VPWR VGND sg13cmos5l_antennanp
XFILLER_9_491 VPWR VGND sg13cmos5l_fill_2
XANTENNA__050__A Tile_X0Y0_FrameData[4] VPWR VGND sg13cmos5l_antennanp
XANTENNA__049__X Tile_X1Y0_FrameData_O[3] VPWR VGND sg13cmos5l_antennanp
X_130_ Tile_X0Y0_FrameStrobe_O[16] Tile_X0Y0_FrameStrobe[16] VPWR VGND sg13cmos5l_buf_1
XFILLER_11_402 VPWR VGND sg13cmos5l_decap_8
XANTENNA__225__A Tile_X1Y0_NN4END[1] VPWR VGND sg13cmos5l_antennanp
X_061_ Tile_X1Y0_FrameData_O[15] Tile_X0Y0_FrameData[15] VPWR VGND sg13cmos5l_buf_1
XFILLER_7_428 VPWR VGND sg13cmos5l_decap_8
XFILLER_3_612 VPWR VGND sg13cmos5l_decap_8
XFILLER_3_667 VPWR VGND sg13cmos5l_decap_8
XFILLER_2_199 VPWR VGND sg13cmos5l_fill_2
XFILLER_0_25 VPWR VGND sg13cmos5l_decap_8
XANTENNA__135__A NPU_RDATA14 VPWR VGND sg13cmos5l_antennanp
XFILLER_9_45 VPWR VGND sg13cmos5l_decap_8
XANTENNA__045__A Tile_X1Y0_N4END[15] VPWR VGND sg13cmos5l_antennanp
XFILLER_4_409 VPWR VGND sg13cmos5l_decap_8
XFILLER_0_659 VPWR VGND sg13cmos5l_fill_2
X_113_ Tile_X0Y0_S2BEGb[7] Tile_X0Y0_N2END[0] VPWR VGND sg13cmos5l_buf_1
XFILLER_7_236 VPWR VGND sg13cmos5l_decap_4
XFILLER_7_203 VPWR VGND sg13cmos5l_decap_8
XFILLER_11_287 VPWR VGND sg13cmos5l_decap_8
XFILLER_11_210 VPWR VGND sg13cmos5l_decap_8
X_044_ NPU_ADDR1 Tile_X1Y0_N4END[14] VPWR VGND sg13cmos5l_buf_1
XFILLER_3_431 VPWR VGND sg13cmos5l_fill_1
XANTENNA__152__X NPU_WE5 VPWR VGND sg13cmos5l_antennanp
XFILLER_7_781 VPWR VGND sg13cmos5l_decap_8
XANTENNA__062__X Tile_X1Y0_FrameData_O[16] VPWR VGND sg13cmos5l_antennanp
XFILLER_4_228 VPWR VGND sg13cmos5l_fill_1
XFILLER_0_423 VPWR VGND sg13cmos5l_decap_8
XFILLER_0_456 VPWR VGND sg13cmos5l_fill_2
XFILLER_8_556 VPWR VGND sg13cmos5l_fill_2
XFILLER_8_545 VPWR VGND sg13cmos5l_decap_8
XFILLER_8_534 VPWR VGND sg13cmos5l_decap_8
XFILLER_6_24 VPWR VGND sg13cmos5l_decap_8
X_027_ Tile_X0Y0_SS4BEG[9] Tile_X0Y0_NN4END[6] VPWR VGND sg13cmos5l_buf_1
XFILLER_4_795 VPWR VGND sg13cmos5l_decap_8
XFILLER_3_294 VPWR VGND sg13cmos5l_decap_4
XFILLER_3_283 VPWR VGND sg13cmos5l_fill_1
XANTENNA__147__X Tile_X0Y0_S4BEG[13] VPWR VGND sg13cmos5l_antennanp
XANTENNA__057__X Tile_X1Y0_FrameData_O[11] VPWR VGND sg13cmos5l_antennanp
XFILLER_5_504 VPWR VGND sg13cmos5l_fill_2
XFILLER_5_559 VPWR VGND sg13cmos5l_fill_1
XFILLER_5_548 VPWR VGND sg13cmos5l_fill_2
XFILLER_1_787 VPWR VGND sg13cmos5l_decap_8
XFILLER_9_832 VPWR VGND sg13cmos5l_decap_8
XANTENNA__143__A NPU_RDATA6 VPWR VGND sg13cmos5l_antennanp
XFILLER_9_887 VPWR VGND sg13cmos5l_fill_1
XFILLER_8_353 VPWR VGND sg13cmos5l_decap_8
XANTENNA__053__A Tile_X0Y0_FrameData[7] VPWR VGND sg13cmos5l_antennanp
XFILLER_10_820 VPWR VGND sg13cmos5l_decap_8
XFILLER_6_846 VPWR VGND sg13cmos5l_decap_8
XFILLER_5_378 VPWR VGND sg13cmos5l_decap_8
XFILLER_5_301 VPWR VGND sg13cmos5l_decap_4
XFILLER_3_69 VPWR VGND sg13cmos5l_decap_8
XFILLER_1_584 VPWR VGND sg13cmos5l_fill_2
XANTENNA__138__A NPU_RDATA11 VPWR VGND sg13cmos5l_antennanp
XFILLER_9_651 VPWR VGND sg13cmos5l_decap_8
XFILLER_8_161 VPWR VGND sg13cmos5l_decap_8
XANTENNA__160__X NPU_WDATA7 VPWR VGND sg13cmos5l_antennanp
XANTENNA__048__A Tile_X0Y0_FrameData[2] VPWR VGND sg13cmos5l_antennanp
XFILLER_10_105 VPWR VGND sg13cmos5l_decap_8
XFILLER_2_304 VPWR VGND sg13cmos5l_decap_8
XANTENNA__070__X Tile_X1Y0_FrameData_O[24] VPWR VGND sg13cmos5l_antennanp
XFILLER_3_849 VPWR VGND sg13cmos5l_decap_8
XFILLER_2_348 VPWR VGND sg13cmos5l_fill_2
XFILLER_6_676 VPWR VGND sg13cmos5l_decap_8
XFILLER_5_186 VPWR VGND sg13cmos5l_fill_2
XFILLER_2_871 VPWR VGND sg13cmos5l_decap_8
XANTENNA__155__X NPU_WE2 VPWR VGND sg13cmos5l_antennanp
XANTENNA__065__X Tile_X1Y0_FrameData_O[19] VPWR VGND sg13cmos5l_antennanp
XFILLER_7_407 VPWR VGND sg13cmos5l_decap_8
XFILLER_11_469 VPWR VGND sg13cmos5l_decap_4
XFILLER_11_458 VPWR VGND sg13cmos5l_decap_8
X_060_ Tile_X1Y0_FrameData_O[14] Tile_X0Y0_FrameData[14] VPWR VGND sg13cmos5l_buf_1
XFILLER_3_646 VPWR VGND sg13cmos5l_decap_8
XFILLER_3_635 VPWR VGND sg13cmos5l_fill_1
XFILLER_2_178 VPWR VGND sg13cmos5l_decap_8
XFILLER_2_167 VPWR VGND sg13cmos5l_decap_4
XFILLER_9_24 VPWR VGND sg13cmos5l_decap_8
X_189_ Tile_X1Y0_S2BEGb[2] Tile_X1Y0_N2END[5] VPWR VGND sg13cmos5l_buf_1
XANTENNA__151__A Tile_X1Y0_N4END[1] VPWR VGND sg13cmos5l_antennanp
XFILLER_6_484 VPWR VGND sg13cmos5l_decap_8
XANTENNA__061__A Tile_X0Y0_FrameData[15] VPWR VGND sg13cmos5l_antennanp
XFILLER_0_638 VPWR VGND sg13cmos5l_decap_8
X_043_ NPU_ADDR2 Tile_X1Y0_N4END[13] VPWR VGND sg13cmos5l_buf_1
X_112_ Tile_X0Y0_S2BEGb[6] Tile_X0Y0_N2END[1] VPWR VGND sg13cmos5l_buf_1
XFILLER_7_215 VPWR VGND sg13cmos5l_decap_8
XFILLER_11_266 VPWR VGND sg13cmos5l_decap_8
XFILLER_3_487 VPWR VGND sg13cmos5l_decap_8
XFILLER_1_0 VPWR VGND sg13cmos5l_fill_1
XANTENNA__146__A NPU_RDATA3 VPWR VGND sg13cmos5l_antennanp
XFILLER_7_760 VPWR VGND sg13cmos5l_decap_8
XANTENNA__056__A Tile_X0Y0_FrameData[10] VPWR VGND sg13cmos5l_antennanp
XFILLER_4_207 VPWR VGND sg13cmos5l_decap_8
XFILLER_8_513 VPWR VGND sg13cmos5l_decap_8
XFILLER_8_502 VPWR VGND sg13cmos5l_fill_1
X_026_ Tile_X0Y0_SS4BEG[8] Tile_X0Y0_NN4END[7] VPWR VGND sg13cmos5l_buf_1
XFILLER_4_774 VPWR VGND sg13cmos5l_decap_8
XFILLER_3_240 VPWR VGND sg13cmos5l_fill_2
XANTENNA__163__X NPU_WDATA4 VPWR VGND sg13cmos5l_antennanp
XANTENNA__073__X Tile_X1Y0_FrameData_O[27] VPWR VGND sg13cmos5l_antennanp
XFILLER_0_254 VPWR VGND sg13cmos5l_decap_8
XFILLER_1_755 VPWR VGND sg13cmos5l_fill_1
XFILLER_1_744 VPWR VGND sg13cmos5l_decap_8
XFILLER_1_711 VPWR VGND sg13cmos5l_fill_1
XFILLER_9_811 VPWR VGND sg13cmos5l_decap_8
XFILLER_9_866 VPWR VGND sg13cmos5l_decap_8
XFILLER_8_332 VPWR VGND sg13cmos5l_decap_8
X_009_ NPU_WDATA13 Tile_X0Y0_N4END[2] VPWR VGND sg13cmos5l_buf_1
XANTENNA__158__X NPU_WDATA9 VPWR VGND sg13cmos5l_antennanp
XANTENNA__068__X Tile_X1Y0_FrameData_O[22] VPWR VGND sg13cmos5l_antennanp
XFILLER_9_129 VPWR VGND sg13cmos5l_decap_8
XFILLER_6_825 VPWR VGND sg13cmos5l_decap_8
XFILLER_5_357 VPWR VGND sg13cmos5l_decap_8
XFILLER_5_335 VPWR VGND sg13cmos5l_decap_8
XFILLER_10_887 VPWR VGND sg13cmos5l_fill_1
XFILLER_10_865 VPWR VGND sg13cmos5l_fill_1
XFILLER_3_48 VPWR VGND sg13cmos5l_decap_8
XANTENNA__154__A Tile_X1Y0_N4END[4] VPWR VGND sg13cmos5l_antennanp
XFILLER_9_630 VPWR VGND sg13cmos5l_fill_2
XFILLER_9_674 VPWR VGND sg13cmos5l_fill_1
XFILLER_8_140 VPWR VGND sg13cmos5l_decap_8
XFILLER_4_390 VPWR VGND sg13cmos5l_decap_8
XFILLER_11_629 VPWR VGND sg13cmos5l_decap_8
XANTENNA__064__A Tile_X0Y0_FrameData[18] VPWR VGND sg13cmos5l_antennanp
XFILLER_3_828 VPWR VGND sg13cmos5l_decap_8
XFILLER_2_327 VPWR VGND sg13cmos5l_fill_2
XFILLER_10_651 VPWR VGND sg13cmos5l_fill_1
XFILLER_6_655 VPWR VGND sg13cmos5l_decap_8
XFILLER_5_165 VPWR VGND sg13cmos5l_decap_8
XFILLER_5_154 VPWR VGND sg13cmos5l_fill_1
XANTENNA__149__A NPU_RDATA0 VPWR VGND sg13cmos5l_antennanp
XANTENNA__171__X NPU_WDATA25 VPWR VGND sg13cmos5l_antennanp
XFILLER_9_482 VPWR VGND sg13cmos5l_fill_1
XFILLER_9_493 VPWR VGND sg13cmos5l_fill_1
XFILLER_4_80 VPWR VGND sg13cmos5l_decap_8
XANTENNA__059__A Tile_X0Y0_FrameData[13] VPWR VGND sg13cmos5l_antennanp
XFILLER_11_437 VPWR VGND sg13cmos5l_decap_8
XANTENNA__081__X Tile_X1Y0_FrameStrobe_O[3] VPWR VGND sg13cmos5l_antennanp
XFILLER_2_146 VPWR VGND sg13cmos5l_decap_8
XFILLER_10_470 VPWR VGND sg13cmos5l_fill_1
X_188_ Tile_X1Y0_S2BEGb[1] Tile_X1Y0_N2END[6] VPWR VGND sg13cmos5l_buf_1
XFILLER_6_463 VPWR VGND sg13cmos5l_decap_8
XANTENNA__166__X NPU_WDATA3 VPWR VGND sg13cmos5l_antennanp
XFILLER_0_628 VPWR VGND sg13cmos5l_decap_8
XANTENNA__076__X Tile_X1Y0_FrameData_O[30] VPWR VGND sg13cmos5l_antennanp
X_042_ NPU_ADDR3 Tile_X1Y0_N4END[12] VPWR VGND sg13cmos5l_buf_1
X_111_ Tile_X0Y0_S2BEGb[5] Tile_X0Y0_N2END[2] VPWR VGND sg13cmos5l_buf_1
XFILLER_8_717 VPWR VGND sg13cmos5l_decap_8
XFILLER_11_245 VPWR VGND sg13cmos5l_decap_8
XFILLER_3_466 VPWR VGND sg13cmos5l_decap_8
XANTENNA__162__A Tile_X0Y0_N4END[10] VPWR VGND sg13cmos5l_antennanp
XFILLER_6_293 VPWR VGND sg13cmos5l_decap_8
XANTENNA__072__A Tile_X0Y0_FrameData[26] VPWR VGND sg13cmos5l_antennanp
X_025_ Tile_X0Y0_SS4BEG[7] Tile_X0Y0_NN4END[8] VPWR VGND sg13cmos5l_buf_1
XFILLER_6_59 VPWR VGND sg13cmos5l_decap_8
XFILLER_4_753 VPWR VGND sg13cmos5l_decap_8
XANTENNA__157__A Tile_X1Y0_N4END[7] VPWR VGND sg13cmos5l_antennanp
XFILLER_7_580 VPWR VGND sg13cmos5l_decap_8
XANTENNA__067__A Tile_X0Y0_FrameData[21] VPWR VGND sg13cmos5l_antennanp
XFILLER_5_506 VPWR VGND sg13cmos5l_fill_1
XFILLER_0_299 VPWR VGND sg13cmos5l_decap_8
XFILLER_8_388 VPWR VGND sg13cmos5l_decap_8
X_008_ NPU_WDATA14 Tile_X0Y0_N4END[1] VPWR VGND sg13cmos5l_buf_1
XFILLER_4_583 VPWR VGND sg13cmos5l_decap_8
XANTENNA__174__X NPU_WDATA22 VPWR VGND sg13cmos5l_antennanp
XFILLER_7_91 VPWR VGND sg13cmos5l_decap_8
XANTENNA__084__X Tile_X1Y0_FrameStrobe_O[6] VPWR VGND sg13cmos5l_antennanp
XFILLER_9_108 VPWR VGND sg13cmos5l_decap_8
XFILLER_6_804 VPWR VGND sg13cmos5l_decap_8
XFILLER_10_855 VPWR VGND sg13cmos5l_decap_8
XFILLER_5_314 VPWR VGND sg13cmos5l_decap_8
XFILLER_1_531 VPWR VGND sg13cmos5l_fill_1
XFILLER_1_586 VPWR VGND sg13cmos5l_fill_1
XFILLER_9_686 VPWR VGND sg13cmos5l_decap_8
XFILLER_8_196 VPWR VGND sg13cmos5l_decap_8
XANTENNA__170__A Tile_X0Y0_NN4END[5] VPWR VGND sg13cmos5l_antennanp
XANTENNA__169__X NPU_WDATA27 VPWR VGND sg13cmos5l_antennanp
XFILLER_11_608 VPWR VGND sg13cmos5l_decap_8
XANTENNA__080__A Tile_X1Y0_FrameStrobe[2] VPWR VGND sg13cmos5l_antennanp
XFILLER_3_807 VPWR VGND sg13cmos5l_decap_8
XANTENNA__079__X Tile_X1Y0_FrameStrobe_O[1] VPWR VGND sg13cmos5l_antennanp
XFILLER_6_634 VPWR VGND sg13cmos5l_decap_8
XFILLER_5_133 VPWR VGND sg13cmos5l_decap_8
XFILLER_10_685 VPWR VGND sg13cmos5l_fill_2
XFILLER_10_641 VPWR VGND sg13cmos5l_fill_2
XFILLER_6_689 VPWR VGND sg13cmos5l_decap_8
XFILLER_5_188 VPWR VGND sg13cmos5l_fill_1
XFILLER_1_361 VPWR VGND sg13cmos5l_decap_8
XANTENNA__165__A Tile_X0Y0_NN4END[1] VPWR VGND sg13cmos5l_antennanp
XANTENNA__075__A Tile_X0Y0_FrameData[29] VPWR VGND sg13cmos5l_antennanp
XFILLER_11_416 VPWR VGND sg13cmos5l_decap_8
XFILLER_3_626 VPWR VGND sg13cmos5l_fill_2
XFILLER_2_136 VPWR VGND sg13cmos5l_decap_8
XFILLER_2_125 VPWR VGND sg13cmos5l_fill_1
XFILLER_2_114 VPWR VGND sg13cmos5l_decap_8
XFILLER_2_103 VPWR VGND sg13cmos5l_fill_1
XFILLER_0_39 VPWR VGND sg13cmos5l_decap_8
XFILLER_9_59 VPWR VGND sg13cmos5l_decap_8
X_187_ Tile_X1Y0_S2BEGb[0] Tile_X1Y0_N2END[7] VPWR VGND sg13cmos5l_buf_1
XFILLER_6_442 VPWR VGND sg13cmos5l_decap_8
XANTENNA__182__X Tile_X1Y0_S2BEG[3] VPWR VGND sg13cmos5l_antennanp
XFILLER_0_607 VPWR VGND sg13cmos5l_fill_1
X_110_ Tile_X0Y0_S2BEGb[4] Tile_X0Y0_N2END[3] VPWR VGND sg13cmos5l_buf_1
XFILLER_11_224 VPWR VGND sg13cmos5l_decap_8
XANTENNA__092__X Tile_X1Y0_FrameStrobe_O[14] VPWR VGND sg13cmos5l_antennanp
X_041_ NPU_ADDR4 Tile_X1Y0_N4END[11] VPWR VGND sg13cmos5l_buf_1
XFILLER_11_791 VPWR VGND sg13cmos5l_decap_8
XFILLER_10_290 VPWR VGND sg13cmos5l_decap_8
XFILLER_7_795 VPWR VGND sg13cmos5l_decap_8
XFILLER_6_272 VPWR VGND sg13cmos5l_decap_8
XANTENNA__177__X Tile_X1Y0_S1BEG[2] VPWR VGND sg13cmos5l_antennanp
XFILLER_0_415 VPWR VGND sg13cmos5l_decap_4
XFILLER_0_437 VPWR VGND sg13cmos5l_decap_8
XANTENNA__087__X Tile_X1Y0_FrameStrobe_O[9] VPWR VGND sg13cmos5l_antennanp
X_024_ Tile_X0Y0_SS4BEG[6] Tile_X0Y0_NN4END[9] VPWR VGND sg13cmos5l_buf_1
XFILLER_6_38 VPWR VGND sg13cmos5l_decap_8
XFILLER_4_732 VPWR VGND sg13cmos5l_decap_8
XFILLER_3_253 VPWR VGND sg13cmos5l_fill_2
XFILLER_3_242 VPWR VGND sg13cmos5l_fill_1
XFILLER_3_231 VPWR VGND sg13cmos5l_decap_4
XFILLER_10_91 VPWR VGND sg13cmos5l_decap_8
XANTENNA__173__A Tile_X0Y0_NN4END[8] VPWR VGND sg13cmos5l_antennanp
XANTENNA__083__A Tile_X1Y0_FrameStrobe[5] VPWR VGND sg13cmos5l_antennanp
XFILLER_5_518 VPWR VGND sg13cmos5l_decap_8
XFILLER_0_278 VPWR VGND sg13cmos5l_decap_8
XFILLER_9_846 VPWR VGND sg13cmos5l_decap_8
XFILLER_8_367 VPWR VGND sg13cmos5l_decap_8
XFILLER_8_301 VPWR VGND sg13cmos5l_decap_8
X_007_ NPU_WDATA15 Tile_X0Y0_N4END[0] VPWR VGND sg13cmos5l_buf_1
XANTENNA__168__A Tile_X0Y0_NN4END[3] VPWR VGND sg13cmos5l_antennanp
XANTENNA__190__X Tile_X1Y0_S2BEGb[3] VPWR VGND sg13cmos5l_antennanp
XFILLER_7_70 VPWR VGND sg13cmos5l_decap_8
XANTENNA__078__A Tile_X1Y0_FrameStrobe[0] VPWR VGND sg13cmos5l_antennanp
XFILLER_10_834 VPWR VGND sg13cmos5l_decap_8
XFILLER_3_17 VPWR VGND sg13cmos5l_decap_8
XFILLER_9_665 VPWR VGND sg13cmos5l_decap_8
XFILLER_8_175 VPWR VGND sg13cmos5l_decap_8
XFILLER_5_882 VPWR VGND sg13cmos5l_decap_4
XANTENNA__185__X Tile_X1Y0_S2BEG[6] VPWR VGND sg13cmos5l_antennanp
XFILLER_10_119 VPWR VGND sg13cmos5l_decap_8
XANTENNA__095__X Tile_X1Y0_FrameStrobe_O[17] VPWR VGND sg13cmos5l_antennanp
XFILLER_6_613 VPWR VGND sg13cmos5l_decap_8
XFILLER_5_112 VPWR VGND sg13cmos5l_decap_8
XFILLER_10_664 VPWR VGND sg13cmos5l_fill_2
XFILLER_2_885 VPWR VGND sg13cmos5l_fill_2
XFILLER_2_841 VPWR VGND sg13cmos5l_decap_8
XFILLER_9_440 VPWR VGND sg13cmos5l_decap_8
XANTENNA__181__A Tile_X1Y0_N2MID[5] VPWR VGND sg13cmos5l_antennanp
XFILLER_5_690 VPWR VGND sg13cmos5l_decap_8
XANTENNA__091__A Tile_X1Y0_FrameStrobe[13] VPWR VGND sg13cmos5l_antennanp
XFILLER_3_605 VPWR VGND sg13cmos5l_decap_8
XFILLER_0_18 VPWR VGND sg13cmos5l_decap_8
XFILLER_9_38 VPWR VGND sg13cmos5l_decap_8
X_186_ Tile_X1Y0_S2BEG[7] Tile_X1Y0_N2MID[0] VPWR VGND sg13cmos5l_buf_1
XFILLER_6_498 VPWR VGND sg13cmos5l_decap_8
XFILLER_6_421 VPWR VGND sg13cmos5l_decap_8
XFILLER_2_671 VPWR VGND sg13cmos5l_fill_2
XANTENNA__176__A Tile_X1Y0_N1END[2] VPWR VGND sg13cmos5l_antennanp
XFILLER_0_619 VPWR VGND sg13cmos5l_decap_4
XANTENNA__086__A Tile_X1Y0_FrameStrobe[8] VPWR VGND sg13cmos5l_antennanp
XFILLER_7_229 VPWR VGND sg13cmos5l_decap_8
XFILLER_11_203 VPWR VGND sg13cmos5l_decap_8
X_040_ NPU_ADDR5 Tile_X1Y0_N4END[10] VPWR VGND sg13cmos5l_buf_1
XFILLER_3_424 VPWR VGND sg13cmos5l_fill_2
XFILLER_3_413 VPWR VGND sg13cmos5l_fill_1
XFILLER_3_402 VPWR VGND sg13cmos5l_decap_8
X_169_ NPU_WDATA27 Tile_X0Y0_NN4END[4] VPWR VGND sg13cmos5l_buf_1
XFILLER_7_774 VPWR VGND sg13cmos5l_decap_8
XFILLER_7_730 VPWR VGND sg13cmos5l_decap_4
XFILLER_6_251 VPWR VGND sg13cmos5l_decap_8
XFILLER_6_240 VPWR VGND sg13cmos5l_decap_8
XFILLER_11_770 VPWR VGND sg13cmos5l_decap_8
XANTENNA__193__X Tile_X1Y0_S2BEGb[6] VPWR VGND sg13cmos5l_antennanp
X_023_ Tile_X0Y0_SS4BEG[5] Tile_X0Y0_NN4END[10] VPWR VGND sg13cmos5l_buf_1
XFILLER_8_527 VPWR VGND sg13cmos5l_decap_4
XFILLER_6_17 VPWR VGND sg13cmos5l_decap_8
XFILLER_4_788 VPWR VGND sg13cmos5l_decap_8
XFILLER_4_711 VPWR VGND sg13cmos5l_decap_8
XFILLER_3_298 VPWR VGND sg13cmos5l_fill_2
XFILLER_3_287 VPWR VGND sg13cmos5l_decap_8
XFILLER_10_70 VPWR VGND sg13cmos5l_decap_8
XANTENNA__188__X Tile_X1Y0_S2BEGb[1] VPWR VGND sg13cmos5l_antennanp
XFILLER_0_235 VPWR VGND sg13cmos5l_fill_2
XANTENNA__098__X Tile_X0Y0_S2BEG[0] VPWR VGND sg13cmos5l_antennanp
XFILLER_9_825 VPWR VGND sg13cmos5l_decap_8
X_006_ NPU_WDATA16 Tile_X0Y0_NN4END[15] VPWR VGND sg13cmos5l_buf_1
XFILLER_8_346 VPWR VGND sg13cmos5l_decap_8
XFILLER_4_552 VPWR VGND sg13cmos5l_fill_2
XFILLER_4_530 VPWR VGND sg13cmos5l_fill_2
XANTENNA__184__A Tile_X1Y0_N2MID[2] VPWR VGND sg13cmos5l_antennanp
XANTENNA__094__A Tile_X1Y0_FrameStrobe[16] VPWR VGND sg13cmos5l_antennanp
XFILLER_6_839 VPWR VGND sg13cmos5l_decap_8
XFILLER_5_305 VPWR VGND sg13cmos5l_fill_1
XFILLER_10_813 VPWR VGND sg13cmos5l_decap_8
XFILLER_8_154 VPWR VGND sg13cmos5l_decap_8
XANTENNA__179__A Tile_X1Y0_N2MID[7] VPWR VGND sg13cmos5l_antennanp
XANTENNA__089__A Tile_X1Y0_FrameStrobe[11] VPWR VGND sg13cmos5l_antennanp
XFILLER_10_643 VPWR VGND sg13cmos5l_fill_1
XFILLER_6_669 VPWR VGND sg13cmos5l_decap_8
XFILLER_5_179 VPWR VGND sg13cmos5l_decap_8
XFILLER_2_820 VPWR VGND sg13cmos5l_decap_8
XFILLER_2_864 VPWR VGND sg13cmos5l_decap_8
XANTENNA__196__X Tile_X1Y0_S4BEG[1] VPWR VGND sg13cmos5l_antennanp
XFILLER_3_639 VPWR VGND sg13cmos5l_decap_8
XFILLER_3_628 VPWR VGND sg13cmos5l_fill_1
XFILLER_9_17 VPWR VGND sg13cmos5l_decap_8
XFILLER_10_484 VPWR VGND sg13cmos5l_fill_1
X_185_ Tile_X1Y0_S2BEG[6] Tile_X1Y0_N2MID[1] VPWR VGND sg13cmos5l_buf_1
XFILLER_6_400 VPWR VGND sg13cmos5l_decap_8
XFILLER_6_477 VPWR VGND sg13cmos5l_decap_8
XANTENNA__192__A Tile_X1Y0_N2END[2] VPWR VGND sg13cmos5l_antennanp
XFILLER_11_259 VPWR VGND sg13cmos5l_decap_8
X_168_ NPU_WDATA28 Tile_X0Y0_NN4END[3] VPWR VGND sg13cmos5l_buf_1
XFILLER_7_753 VPWR VGND sg13cmos5l_decap_8
X_099_ Tile_X0Y0_S2BEG[1] Tile_X0Y0_N2MID[6] VPWR VGND sg13cmos5l_buf_1
XANTENNA__187__A Tile_X1Y0_N2END[7] VPWR VGND sg13cmos5l_antennanp
XANTENNA__097__A Tile_X1Y0_FrameStrobe[19] VPWR VGND sg13cmos5l_antennanp
X_022_ Tile_X0Y0_SS4BEG[4] Tile_X0Y0_NN4END[11] VPWR VGND sg13cmos5l_buf_1
XFILLER_8_506 VPWR VGND sg13cmos5l_decap_8
XFILLER_4_767 VPWR VGND sg13cmos5l_decap_4
XFILLER_3_266 VPWR VGND sg13cmos5l_fill_2
XFILLER_7_594 VPWR VGND sg13cmos5l_decap_8
XFILLER_0_203 VPWR VGND sg13cmos5l_fill_1
XFILLER_0_214 VPWR VGND sg13cmos5l_decap_8
XFILLER_0_225 VPWR VGND sg13cmos5l_fill_2
XFILLER_0_247 VPWR VGND sg13cmos5l_decap_8
XFILLER_1_704 VPWR VGND sg13cmos5l_fill_1
XFILLER_9_804 VPWR VGND sg13cmos5l_decap_8
XFILLER_8_325 VPWR VGND sg13cmos5l_decap_8
X_005_ NPU_WDATA17 Tile_X0Y0_NN4END[14] VPWR VGND sg13cmos5l_buf_1
XFILLER_4_564 VPWR VGND sg13cmos5l_fill_2
XFILLER_0_792 VPWR VGND sg13cmos5l_decap_8
XFILLER_4_597 VPWR VGND sg13cmos5l_decap_8
XANTENNA__199__X Tile_X1Y0_S4BEG[4] VPWR VGND sg13cmos5l_antennanp
XFILLER_6_818 VPWR VGND sg13cmos5l_decap_8
XFILLER_5_328 VPWR VGND sg13cmos5l_decap_8
XFILLER_10_869 VPWR VGND sg13cmos5l_fill_1
XFILLER_9_612 VPWR VGND sg13cmos5l_decap_8
XFILLER_9_678 VPWR VGND sg13cmos5l_fill_2
XFILLER_8_133 VPWR VGND sg13cmos5l_decap_8
XFILLER_5_862 VPWR VGND sg13cmos5l_fill_2
XFILLER_4_383 VPWR VGND sg13cmos5l_decap_8
XANTENNA__195__A NPU_RDATA31 VPWR VGND sg13cmos5l_antennanp
XFILLER_6_648 VPWR VGND sg13cmos5l_decap_8
XFILLER_5_158 VPWR VGND sg13cmos5l_decap_8
XFILLER_5_147 VPWR VGND sg13cmos5l_decap_8
XFILLER_2_887 VPWR VGND sg13cmos5l_fill_1
XFILLER_1_375 VPWR VGND sg13cmos5l_fill_1
XFILLER_9_464 VPWR VGND sg13cmos5l_fill_1
XFILLER_9_486 VPWR VGND sg13cmos5l_fill_2
XFILLER_9_497 VPWR VGND sg13cmos5l_fill_2
XFILLER_4_73 VPWR VGND sg13cmos5l_decap_8
X_184_ Tile_X1Y0_S2BEG[5] Tile_X1Y0_N2MID[2] VPWR VGND sg13cmos5l_buf_1
XFILLER_6_456 VPWR VGND sg13cmos5l_decap_8
XFILLER_2_684 VPWR VGND sg13cmos5l_fill_1
XFILLER_2_673 VPWR VGND sg13cmos5l_fill_1
XFILLER_1_172 VPWR VGND sg13cmos5l_fill_2
XFILLER_9_250 VPWR VGND sg13cmos5l_decap_8
XANTENNA__000__X NPU_WDATA21 VPWR VGND sg13cmos5l_antennanp
XFILLER_11_238 VPWR VGND sg13cmos5l_decap_8
XFILLER_3_459 VPWR VGND sg13cmos5l_decap_8
XFILLER_10_271 VPWR VGND sg13cmos5l_decap_8
X_098_ Tile_X0Y0_S2BEG[0] Tile_X0Y0_N2MID[7] VPWR VGND sg13cmos5l_buf_1
X_167_ NPU_WDATA29 Tile_X0Y0_NN4END[2] VPWR VGND sg13cmos5l_buf_1
XFILLER_6_286 VPWR VGND sg13cmos5l_decap_8
XFILLER_2_492 VPWR VGND sg13cmos5l_decap_8
XFILLER_2_470 VPWR VGND sg13cmos5l_decap_8
XFILLER_1_74 VPWR VGND sg13cmos5l_decap_4
X_021_ Tile_X0Y0_SS4BEG[3] Tile_X0Y0_NN4END[12] VPWR VGND sg13cmos5l_buf_1
XFILLER_4_746 VPWR VGND sg13cmos5l_decap_8
XFILLER_3_212 VPWR VGND sg13cmos5l_fill_2
X_219_ Tile_X1Y0_SS4BEG[8] Tile_X1Y0_NN4END[7] VPWR VGND sg13cmos5l_buf_1
XFILLER_11_580 VPWR VGND sg13cmos5l_decap_8
XFILLER_7_573 VPWR VGND sg13cmos5l_decap_8
XANTENNA__198__A NPU_RDATA28 VPWR VGND sg13cmos5l_antennanp
XFILLER_1_727 VPWR VGND sg13cmos5l_fill_1
XFILLER_8_315 VPWR VGND sg13cmos5l_decap_4
X_004_ NPU_WDATA18 Tile_X0Y0_NN4END[13] VPWR VGND sg13cmos5l_buf_1
XFILLER_4_576 VPWR VGND sg13cmos5l_decap_8
XFILLER_4_543 VPWR VGND sg13cmos5l_fill_1
XFILLER_4_521 VPWR VGND sg13cmos5l_decap_4
XFILLER_11_7 VPWR VGND sg13cmos5l_decap_8
XFILLER_7_84 VPWR VGND sg13cmos5l_decap_8
XFILLER_10_848 VPWR VGND sg13cmos5l_decap_8
XFILLER_1_557 VPWR VGND sg13cmos5l_fill_2
XFILLER_9_635 VPWR VGND sg13cmos5l_fill_1
XFILLER_9_646 VPWR VGND sg13cmos5l_fill_2
XFILLER_8_189 VPWR VGND sg13cmos5l_decap_8
XFILLER_8_112 VPWR VGND sg13cmos5l_decap_8
XFILLER_5_841 VPWR VGND sg13cmos5l_decap_8
XFILLER_4_362 VPWR VGND sg13cmos5l_decap_8
XANTENNA__003__X NPU_WDATA19 VPWR VGND sg13cmos5l_antennanp
XFILLER_6_627 VPWR VGND sg13cmos5l_decap_8
XFILLER_5_126 VPWR VGND sg13cmos5l_decap_8
XFILLER_10_634 VPWR VGND sg13cmos5l_decap_8
XFILLER_2_855 VPWR VGND sg13cmos5l_fill_1
XFILLER_1_387 VPWR VGND sg13cmos5l_fill_1
XFILLER_9_454 VPWR VGND sg13cmos5l_decap_8
XFILLER_4_52 VPWR VGND sg13cmos5l_decap_8
XFILLER_11_409 VPWR VGND sg13cmos5l_decap_8
XFILLER_3_619 VPWR VGND sg13cmos5l_decap_8
XFILLER_2_129 VPWR VGND sg13cmos5l_decap_8
XFILLER_2_107 VPWR VGND sg13cmos5l_decap_8
X_183_ Tile_X1Y0_S2BEG[4] Tile_X1Y0_N2MID[3] VPWR VGND sg13cmos5l_buf_1
XFILLER_6_435 VPWR VGND sg13cmos5l_decap_8
XFILLER_2_696 VPWR VGND sg13cmos5l_decap_8
XFILLER_2_663 VPWR VGND sg13cmos5l_decap_4
XFILLER_5_490 VPWR VGND sg13cmos5l_decap_8
XFILLER_11_217 VPWR VGND sg13cmos5l_decap_8
XFILLER_3_438 VPWR VGND sg13cmos5l_decap_4
XFILLER_11_784 VPWR VGND sg13cmos5l_decap_8
XFILLER_10_283 VPWR VGND sg13cmos5l_decap_4
X_097_ Tile_X1Y0_FrameStrobe_O[19] Tile_X1Y0_FrameStrobe[19] VPWR VGND sg13cmos5l_buf_1
X_166_ NPU_WDATA3 Tile_X0Y0_N4END[12] VPWR VGND sg13cmos5l_buf_1
XFILLER_7_788 VPWR VGND sg13cmos5l_decap_8
XFILLER_6_265 VPWR VGND sg13cmos5l_decap_8
XANTENNA__101__X Tile_X0Y0_S2BEG[3] VPWR VGND sg13cmos5l_antennanp
XFILLER_0_408 VPWR VGND sg13cmos5l_decap_8
XFILLER_0_419 VPWR VGND sg13cmos5l_fill_1
XANTENNA__011__X NPU_WDATA11 VPWR VGND sg13cmos5l_antennanp
X_020_ Tile_X0Y0_SS4BEG[2] Tile_X0Y0_NN4END[13] VPWR VGND sg13cmos5l_buf_1
XFILLER_4_725 VPWR VGND sg13cmos5l_decap_8
XFILLER_3_268 VPWR VGND sg13cmos5l_fill_1
XFILLER_3_235 VPWR VGND sg13cmos5l_fill_2
XFILLER_3_224 VPWR VGND sg13cmos5l_decap_8
XFILLER_3_279 VPWR VGND sg13cmos5l_decap_4
XFILLER_10_84 VPWR VGND sg13cmos5l_decap_8
X_218_ Tile_X1Y0_SS4BEG[7] Tile_X1Y0_NN4END[8] VPWR VGND sg13cmos5l_buf_1
X_149_ Tile_X0Y0_S4BEG[15] NPU_RDATA0 VPWR VGND sg13cmos5l_buf_1
XFILLER_2_290 VPWR VGND sg13cmos5l_decap_8
XANTENNA__006__X NPU_WDATA16 VPWR VGND sg13cmos5l_antennanp
XFILLER_9_839 VPWR VGND sg13cmos5l_decap_8
X_003_ NPU_WDATA19 Tile_X0Y0_NN4END[12] VPWR VGND sg13cmos5l_buf_1
XFILLER_8_883 VPWR VGND sg13cmos5l_decap_4
XFILLER_7_63 VPWR VGND sg13cmos5l_decap_8
XFILLER_7_393 VPWR VGND sg13cmos5l_decap_8
XANTENNA__002__A Tile_X0Y0_N4END[13] VPWR VGND sg13cmos5l_antennanp
XFILLER_10_827 VPWR VGND sg13cmos5l_decap_8
XFILLER_1_569 VPWR VGND sg13cmos5l_fill_1
XFILLER_9_658 VPWR VGND sg13cmos5l_decap_8
XFILLER_8_168 VPWR VGND sg13cmos5l_decap_8
XFILLER_5_875 VPWR VGND sg13cmos5l_decap_8
XFILLER_5_820 VPWR VGND sg13cmos5l_decap_8
XFILLER_4_330 VPWR VGND sg13cmos5l_fill_2
XFILLER_5_886 VPWR VGND sg13cmos5l_fill_2
XFILLER_6_606 VPWR VGND sg13cmos5l_decap_8
XFILLER_5_105 VPWR VGND sg13cmos5l_decap_8
XFILLER_10_679 VPWR VGND sg13cmos5l_fill_2
XFILLER_10_613 VPWR VGND sg13cmos5l_decap_4
XFILLER_2_878 VPWR VGND sg13cmos5l_decap_8
XFILLER_2_834 VPWR VGND sg13cmos5l_decap_8
XFILLER_1_300 VPWR VGND sg13cmos5l_decap_4
XFILLER_9_433 VPWR VGND sg13cmos5l_decap_8
XANTENNA__104__X Tile_X0Y0_S2BEG[6] VPWR VGND sg13cmos5l_antennanp
XFILLER_5_683 VPWR VGND sg13cmos5l_decap_8
XFILLER_4_31 VPWR VGND sg13cmos5l_decap_8
XFILLER_4_193 VPWR VGND sg13cmos5l_decap_8
XFILLER_4_97 VPWR VGND sg13cmos5l_decap_8
XANTENNA__014__X NPU_WDATA0 VPWR VGND sg13cmos5l_antennanp
XFILLER_10_410 VPWR VGND sg13cmos5l_decap_8
XFILLER_10_421 VPWR VGND sg13cmos5l_fill_1
XFILLER_10_443 VPWR VGND sg13cmos5l_decap_8
X_182_ Tile_X1Y0_S2BEG[3] Tile_X1Y0_N2MID[4] VPWR VGND sg13cmos5l_buf_1
XFILLER_8_0 VPWR VGND sg13cmos5l_fill_2
XFILLER_6_414 VPWR VGND sg13cmos5l_decap_8
XFILLER_2_642 VPWR VGND sg13cmos5l_fill_2
XFILLER_2_631 VPWR VGND sg13cmos5l_decap_8
XANTENNA__100__A Tile_X0Y0_N2MID[5] VPWR VGND sg13cmos5l_antennanp
XANTENNA__010__A Tile_X0Y0_N4END[3] VPWR VGND sg13cmos5l_antennanp
XANTENNA__009__X NPU_WDATA13 VPWR VGND sg13cmos5l_antennanp
XFILLER_3_417 VPWR VGND sg13cmos5l_decap_8
X_165_ NPU_WDATA30 Tile_X0Y0_NN4END[1] VPWR VGND sg13cmos5l_buf_1
XFILLER_7_767 VPWR VGND sg13cmos5l_decap_8
XFILLER_7_734 VPWR VGND sg13cmos5l_fill_2
XFILLER_7_723 VPWR VGND sg13cmos5l_decap_8
XFILLER_6_233 VPWR VGND sg13cmos5l_decap_8
XFILLER_6_211 VPWR VGND sg13cmos5l_decap_8
XFILLER_11_763 VPWR VGND sg13cmos5l_decap_8
X_096_ Tile_X1Y0_FrameStrobe_O[18] Tile_X1Y0_FrameStrobe[18] VPWR VGND sg13cmos5l_buf_1
XANTENNA__005__A Tile_X0Y0_NN4END[14] VPWR VGND sg13cmos5l_antennanp
XFILLER_4_704 VPWR VGND sg13cmos5l_decap_8
XFILLER_10_63 VPWR VGND sg13cmos5l_decap_8
XANTENNA__202__X Tile_X1Y0_S4BEG[7] VPWR VGND sg13cmos5l_antennanp
X_217_ Tile_X1Y0_SS4BEG[6] Tile_X1Y0_NN4END[9] VPWR VGND sg13cmos5l_buf_1
X_148_ Tile_X0Y0_S4BEG[14] NPU_RDATA1 VPWR VGND sg13cmos5l_buf_1
XANTENNA__112__X Tile_X0Y0_S2BEGb[6] VPWR VGND sg13cmos5l_antennanp
X_079_ Tile_X1Y0_FrameStrobe_O[1] Tile_X1Y0_FrameStrobe[1] VPWR VGND sg13cmos5l_buf_1
XANTENNA__022__X Tile_X0Y0_SS4BEG[4] VPWR VGND sg13cmos5l_antennanp
XFILLER_9_818 VPWR VGND sg13cmos5l_decap_8
X_002_ NPU_WDATA2 Tile_X0Y0_N4END[13] VPWR VGND sg13cmos5l_buf_1
XFILLER_8_339 VPWR VGND sg13cmos5l_decap_8
XFILLER_0_751 VPWR VGND sg13cmos5l_decap_8
XANTENNA__107__X Tile_X0Y0_S2BEGb[1] VPWR VGND sg13cmos5l_antennanp
XFILLER_8_862 VPWR VGND sg13cmos5l_decap_8
XFILLER_7_42 VPWR VGND sg13cmos5l_decap_8
XFILLER_7_372 VPWR VGND sg13cmos5l_decap_8
XANTENNA__017__X NPU_READ_BANK_SEL0 VPWR VGND sg13cmos5l_antennanp
XFILLER_10_806 VPWR VGND sg13cmos5l_decap_8
XFILLER_9_626 VPWR VGND sg13cmos5l_decap_4
XFILLER_8_147 VPWR VGND sg13cmos5l_decap_8
XANTENNA__103__A Tile_X0Y0_N2MID[2] VPWR VGND sg13cmos5l_antennanp
XFILLER_0_581 VPWR VGND sg13cmos5l_decap_8
XFILLER_4_397 VPWR VGND sg13cmos5l_decap_8
XANTENNA__013__A Tile_X0Y0_N4END[14] VPWR VGND sg13cmos5l_antennanp
XFILLER_2_813 VPWR VGND sg13cmos5l_decap_8
XFILLER_10_669 VPWR VGND sg13cmos5l_fill_1
XFILLER_10_647 VPWR VGND sg13cmos5l_decap_4
XANTENNA__210__X Tile_X1Y0_S4BEG[15] VPWR VGND sg13cmos5l_antennanp
XFILLER_9_401 VPWR VGND sg13cmos5l_decap_4
XFILLER_5_662 VPWR VGND sg13cmos5l_decap_8
XFILLER_4_172 VPWR VGND sg13cmos5l_decap_8
XANTENNA__120__X Tile_X0Y0_FrameStrobe_O[6] VPWR VGND sg13cmos5l_antennanp
XFILLER_4_87 VPWR VGND sg13cmos5l_decap_8
XANTENNA__008__A Tile_X0Y0_N4END[1] VPWR VGND sg13cmos5l_antennanp
XANTENNA__030__X Tile_X0Y0_SS4BEG[12] VPWR VGND sg13cmos5l_antennanp
X_181_ Tile_X1Y0_S2BEG[2] Tile_X1Y0_N2MID[5] VPWR VGND sg13cmos5l_buf_1
XANTENNA__205__X Tile_X1Y0_S4BEG[10] VPWR VGND sg13cmos5l_antennanp
XFILLER_2_654 VPWR VGND sg13cmos5l_decap_4
XANTENNA__115__X Tile_X0Y0_FrameStrobe_O[1] VPWR VGND sg13cmos5l_antennanp
XFILLER_9_264 VPWR VGND sg13cmos5l_decap_8
XANTENNA__025__X Tile_X0Y0_SS4BEG[7] VPWR VGND sg13cmos5l_antennanp
XFILLER_3_429 VPWR VGND sg13cmos5l_fill_2
XANTENNA__201__A NPU_RDATA25 VPWR VGND sg13cmos5l_antennanp
XFILLER_10_230 VPWR VGND sg13cmos5l_decap_8
X_095_ Tile_X1Y0_FrameStrobe_O[17] Tile_X1Y0_FrameStrobe[17] VPWR VGND sg13cmos5l_buf_1
X_164_ NPU_WDATA31 Tile_X0Y0_NN4END[0] VPWR VGND sg13cmos5l_buf_1
XFILLER_7_746 VPWR VGND sg13cmos5l_decap_8
XFILLER_11_742 VPWR VGND sg13cmos5l_decap_8
XANTENNA__111__A Tile_X0Y0_N2END[2] VPWR VGND sg13cmos5l_antennanp
XFILLER_6_790 VPWR VGND sg13cmos5l_decap_8
XANTENNA__021__A Tile_X0Y0_NN4END[12] VPWR VGND sg13cmos5l_antennanp
XFILLER_10_42 VPWR VGND sg13cmos5l_decap_8
XFILLER_3_259 VPWR VGND sg13cmos5l_decap_8
XFILLER_3_204 VPWR VGND sg13cmos5l_decap_4
XANTENNA__106__A Tile_X0Y0_N2END[7] VPWR VGND sg13cmos5l_antennanp
X_078_ Tile_X1Y0_FrameStrobe_O[0] Tile_X1Y0_FrameStrobe[0] VPWR VGND sg13cmos5l_buf_1
X_216_ Tile_X1Y0_SS4BEG[5] Tile_X1Y0_NN4END[10] VPWR VGND sg13cmos5l_buf_1
X_147_ Tile_X0Y0_S4BEG[13] NPU_RDATA2 VPWR VGND sg13cmos5l_buf_1
XFILLER_7_587 VPWR VGND sg13cmos5l_decap_8
XFILLER_7_565 VPWR VGND sg13cmos5l_decap_4
XFILLER_11_594 VPWR VGND sg13cmos5l_decap_8
XFILLER_3_793 VPWR VGND sg13cmos5l_decap_8
XANTENNA__016__A Tile_X1Y0_NN4END[14] VPWR VGND sg13cmos5l_antennanp
XFILLER_0_207 VPWR VGND sg13cmos5l_decap_8
XANTENNA__213__X Tile_X1Y0_SS4BEG[2] VPWR VGND sg13cmos5l_antennanp
X_001_ NPU_WDATA20 Tile_X0Y0_NN4END[11] VPWR VGND sg13cmos5l_buf_1
XFILLER_4_557 VPWR VGND sg13cmos5l_decap_8
XFILLER_0_730 VPWR VGND sg13cmos5l_decap_8
XFILLER_0_785 VPWR VGND sg13cmos5l_decap_8
XFILLER_8_841 VPWR VGND sg13cmos5l_decap_8
XFILLER_7_351 VPWR VGND sg13cmos5l_decap_8
XFILLER_7_21 VPWR VGND sg13cmos5l_decap_8
XANTENNA__123__X Tile_X0Y0_FrameStrobe_O[9] VPWR VGND sg13cmos5l_antennanp
XFILLER_7_98 VPWR VGND sg13cmos5l_decap_8
XANTENNA__033__X Tile_X0Y0_SS4BEG[15] VPWR VGND sg13cmos5l_antennanp
XFILLER_1_549 VPWR VGND sg13cmos5l_fill_1
XANTENNA__208__X Tile_X1Y0_S4BEG[13] VPWR VGND sg13cmos5l_antennanp
XFILLER_9_605 VPWR VGND sg13cmos5l_decap_8
XFILLER_8_126 VPWR VGND sg13cmos5l_decap_8
XFILLER_5_855 VPWR VGND sg13cmos5l_decap_8
XFILLER_4_376 VPWR VGND sg13cmos5l_decap_8
XFILLER_4_332 VPWR VGND sg13cmos5l_fill_1
XANTENNA__118__X Tile_X0Y0_FrameStrobe_O[4] VPWR VGND sg13cmos5l_antennanp
XFILLER_8_682 VPWR VGND sg13cmos5l_decap_8
XANTENNA__028__X Tile_X0Y0_SS4BEG[10] VPWR VGND sg13cmos5l_antennanp
XANTENNA__204__A NPU_RDATA22 VPWR VGND sg13cmos5l_antennanp
XFILLER_1_368 VPWR VGND sg13cmos5l_decap_8
XFILLER_9_468 VPWR VGND sg13cmos5l_fill_1
XFILLER_5_641 VPWR VGND sg13cmos5l_decap_8
XANTENNA__114__A Tile_X0Y0_FrameStrobe[0] VPWR VGND sg13cmos5l_antennanp
XFILLER_4_66 VPWR VGND sg13cmos5l_decap_8
XFILLER_1_880 VPWR VGND sg13cmos5l_decap_8
XANTENNA__024__A Tile_X0Y0_NN4END[9] VPWR VGND sg13cmos5l_antennanp
XFILLER_10_456 VPWR VGND sg13cmos5l_fill_2
XFILLER_10_478 VPWR VGND sg13cmos5l_fill_2
XFILLER_10_489 VPWR VGND sg13cmos5l_fill_1
X_180_ Tile_X1Y0_S2BEG[1] Tile_X1Y0_N2MID[6] VPWR VGND sg13cmos5l_buf_1
XFILLER_6_449 VPWR VGND sg13cmos5l_decap_8
XANTENNA__221__X Tile_X1Y0_SS4BEG[10] VPWR VGND sg13cmos5l_antennanp
XFILLER_2_677 VPWR VGND sg13cmos5l_decap_8
XFILLER_2_622 VPWR VGND sg13cmos5l_decap_4
XFILLER_1_132 VPWR VGND sg13cmos5l_decap_4
XANTENNA__109__A Tile_X0Y0_N2END[4] VPWR VGND sg13cmos5l_antennanp
XFILLER_9_210 VPWR VGND sg13cmos5l_decap_8
XANTENNA__131__X Tile_X0Y0_FrameStrobe_O[17] VPWR VGND sg13cmos5l_antennanp
XANTENNA__019__A Tile_X0Y0_NN4END[14] VPWR VGND sg13cmos5l_antennanp
XANTENNA__041__X NPU_ADDR4 VPWR VGND sg13cmos5l_antennanp
XFILLER_11_721 VPWR VGND sg13cmos5l_decap_8
XANTENNA__216__X Tile_X1Y0_SS4BEG[5] VPWR VGND sg13cmos5l_antennanp
XFILLER_10_264 VPWR VGND sg13cmos5l_decap_4
XFILLER_10_297 VPWR VGND sg13cmos5l_decap_4
X_094_ Tile_X1Y0_FrameStrobe_O[16] Tile_X1Y0_FrameStrobe[16] VPWR VGND sg13cmos5l_buf_1
X_163_ NPU_WDATA4 Tile_X0Y0_N4END[11] VPWR VGND sg13cmos5l_buf_1
XFILLER_6_279 VPWR VGND sg13cmos5l_decap_8
XFILLER_11_798 VPWR VGND sg13cmos5l_decap_8
XFILLER_2_463 VPWR VGND sg13cmos5l_decap_8
XFILLER_2_441 VPWR VGND sg13cmos5l_decap_8
XFILLER_1_78 VPWR VGND sg13cmos5l_fill_1
XFILLER_1_67 VPWR VGND sg13cmos5l_decap_8
XANTENNA__126__X Tile_X0Y0_FrameStrobe_O[12] VPWR VGND sg13cmos5l_antennanp
XANTENNA__036__X Tile_X0Y0_S1BEG[2] VPWR VGND sg13cmos5l_antennanp
XFILLER_10_21 VPWR VGND sg13cmos5l_decap_8
XFILLER_4_739 VPWR VGND sg13cmos5l_decap_8
XANTENNA__212__A Tile_X1Y0_NN4END[14] VPWR VGND sg13cmos5l_antennanp
XFILLER_3_249 VPWR VGND sg13cmos5l_decap_4
XFILLER_10_98 VPWR VGND sg13cmos5l_decap_8
X_215_ Tile_X1Y0_SS4BEG[4] Tile_X1Y0_NN4END[11] VPWR VGND sg13cmos5l_buf_1
XFILLER_7_533 VPWR VGND sg13cmos5l_fill_2
XFILLER_11_573 VPWR VGND sg13cmos5l_decap_8
XANTENNA__122__A Tile_X0Y0_FrameStrobe[8] VPWR VGND sg13cmos5l_antennanp
X_077_ Tile_X1Y0_FrameData_O[31] Tile_X0Y0_FrameData[31] VPWR VGND sg13cmos5l_buf_1
X_146_ Tile_X0Y0_S4BEG[12] NPU_RDATA3 VPWR VGND sg13cmos5l_buf_1
XFILLER_3_772 VPWR VGND sg13cmos5l_decap_8
XANTENNA__032__A Tile_X0Y0_NN4END[1] VPWR VGND sg13cmos5l_antennanp
XFILLER_1_709 VPWR VGND sg13cmos5l_fill_2
XANTENNA__207__A NPU_RDATA19 VPWR VGND sg13cmos5l_antennanp
XFILLER_8_319 VPWR VGND sg13cmos5l_fill_2
XFILLER_8_308 VPWR VGND sg13cmos5l_decap_8
X_000_ NPU_WDATA21 Tile_X0Y0_NN4END[10] VPWR VGND sg13cmos5l_buf_1
XFILLER_4_525 VPWR VGND sg13cmos5l_fill_2
XFILLER_4_514 VPWR VGND sg13cmos5l_decap_8
XANTENNA__117__A Tile_X0Y0_FrameStrobe[3] VPWR VGND sg13cmos5l_antennanp
XFILLER_8_820 VPWR VGND sg13cmos5l_decap_8
XFILLER_7_77 VPWR VGND sg13cmos5l_decap_8
XFILLER_7_330 VPWR VGND sg13cmos5l_decap_8
X_129_ Tile_X0Y0_FrameStrobe_O[15] Tile_X0Y0_FrameStrobe[15] VPWR VGND sg13cmos5l_buf_1
XFILLER_3_591 VPWR VGND sg13cmos5l_decap_8
XANTENNA__027__A Tile_X0Y0_NN4END[6] VPWR VGND sg13cmos5l_antennanp
XANTENNA__224__X Tile_X1Y0_SS4BEG[13] VPWR VGND sg13cmos5l_antennanp
XFILLER_9_639 VPWR VGND sg13cmos5l_decap_8
XFILLER_8_105 VPWR VGND sg13cmos5l_decap_8
XFILLER_5_834 VPWR VGND sg13cmos5l_decap_8
XFILLER_4_355 VPWR VGND sg13cmos5l_decap_8
XFILLER_4_344 VPWR VGND sg13cmos5l_decap_8
XFILLER_4_311 VPWR VGND sg13cmos5l_decap_8
XFILLER_0_550 VPWR VGND sg13cmos5l_fill_1
XANTENNA__134__X Tile_X0Y0_S4BEG[0] VPWR VGND sg13cmos5l_antennanp
XFILLER_8_650 VPWR VGND sg13cmos5l_decap_8
XFILLER_7_182 VPWR VGND sg13cmos5l_decap_8
XFILLER_5_119 VPWR VGND sg13cmos5l_decap_8
XANTENNA__044__X NPU_ADDR1 VPWR VGND sg13cmos5l_antennanp
XFILLER_2_848 VPWR VGND sg13cmos5l_decap_8
XANTENNA__220__A Tile_X1Y0_NN4END[6] VPWR VGND sg13cmos5l_antennanp
XANTENNA__219__X Tile_X1Y0_SS4BEG[8] VPWR VGND sg13cmos5l_antennanp
XFILLER_9_447 VPWR VGND sg13cmos5l_decap_8
XFILLER_5_620 VPWR VGND sg13cmos5l_decap_8
XANTENNA__130__A Tile_X0Y0_FrameStrobe[16] VPWR VGND sg13cmos5l_antennanp
XFILLER_0_391 VPWR VGND sg13cmos5l_decap_8
XFILLER_5_697 VPWR VGND sg13cmos5l_decap_8
XFILLER_4_45 VPWR VGND sg13cmos5l_decap_8
XANTENNA__129__X Tile_X0Y0_FrameStrobe_O[15] VPWR VGND sg13cmos5l_antennanp
XFILLER_8_491 VPWR VGND sg13cmos5l_decap_8
XANTENNA__040__A Tile_X1Y0_N4END[10] VPWR VGND sg13cmos5l_antennanp
XANTENNA__039__X NPU_ADDR6 VPWR VGND sg13cmos5l_antennanp
XANTENNA__215__A Tile_X1Y0_NN4END[11] VPWR VGND sg13cmos5l_antennanp
XFILLER_6_428 VPWR VGND sg13cmos5l_decap_8
XFILLER_2_689 VPWR VGND sg13cmos5l_decap_8
XFILLER_2_667 VPWR VGND sg13cmos5l_fill_1
XFILLER_1_155 VPWR VGND sg13cmos5l_decap_4
XFILLER_9_233 VPWR VGND sg13cmos5l_fill_1
XFILLER_9_277 VPWR VGND sg13cmos5l_fill_2
XANTENNA__125__A Tile_X0Y0_FrameStrobe[11] VPWR VGND sg13cmos5l_antennanp
XFILLER_5_483 VPWR VGND sg13cmos5l_decap_8
XANTENNA__035__A Tile_X0Y0_N1END[2] VPWR VGND sg13cmos5l_antennanp
XFILLER_3_409 VPWR VGND sg13cmos5l_fill_1
X_162_ NPU_WDATA5 Tile_X0Y0_N4END[10] VPWR VGND sg13cmos5l_buf_1
XFILLER_11_700 VPWR VGND sg13cmos5l_decap_8
X_093_ Tile_X1Y0_FrameStrobe_O[15] Tile_X1Y0_FrameStrobe[15] VPWR VGND sg13cmos5l_buf_1
XFILLER_6_258 VPWR VGND sg13cmos5l_decap_8
XFILLER_6_225 VPWR VGND sg13cmos5l_decap_4
XFILLER_6_0 VPWR VGND sg13cmos5l_fill_2
XFILLER_11_777 VPWR VGND sg13cmos5l_decap_8
XFILLER_1_13 VPWR VGND sg13cmos5l_fill_2
XANTENNA__142__X Tile_X0Y0_S4BEG[8] VPWR VGND sg13cmos5l_antennanp
XFILLER_5_280 VPWR VGND sg13cmos5l_decap_8
XANTENNA__052__X Tile_X1Y0_FrameData_O[6] VPWR VGND sg13cmos5l_antennanp
XFILLER_4_718 VPWR VGND sg13cmos5l_decap_8
XFILLER_3_217 VPWR VGND sg13cmos5l_decap_8
XFILLER_10_77 VPWR VGND sg13cmos5l_decap_8
XANTENNA__227__X Tile_X1Y0_UserCLKo VPWR VGND sg13cmos5l_antennanp
X_214_ Tile_X1Y0_SS4BEG[3] Tile_X1Y0_NN4END[12] VPWR VGND sg13cmos5l_buf_1
X_145_ Tile_X0Y0_S4BEG[11] NPU_RDATA4 VPWR VGND sg13cmos5l_buf_1
XFILLER_7_556 VPWR VGND sg13cmos5l_fill_1
XFILLER_7_545 VPWR VGND sg13cmos5l_fill_2
XFILLER_7_512 VPWR VGND sg13cmos5l_decap_8
XFILLER_11_552 VPWR VGND sg13cmos5l_decap_8
X_076_ Tile_X1Y0_FrameData_O[30] Tile_X0Y0_FrameData[30] VPWR VGND sg13cmos5l_buf_1
XFILLER_3_751 VPWR VGND sg13cmos5l_decap_8
XFILLER_2_283 VPWR VGND sg13cmos5l_decap_8
XANTENNA__137__X Tile_X0Y0_S4BEG[3] VPWR VGND sg13cmos5l_antennanp
XANTENNA__047__X Tile_X1Y0_FrameData_O[1] VPWR VGND sg13cmos5l_antennanp
XANTENNA__223__A Tile_X1Y0_NN4END[3] VPWR VGND sg13cmos5l_antennanp
XFILLER_4_548 VPWR VGND sg13cmos5l_decap_4
XFILLER_0_765 VPWR VGND sg13cmos5l_decap_8
XANTENNA__133__A Tile_X0Y0_FrameStrobe[19] VPWR VGND sg13cmos5l_antennanp
XFILLER_8_876 VPWR VGND sg13cmos5l_decap_8
XFILLER_8_887 VPWR VGND sg13cmos5l_fill_1
X_128_ Tile_X0Y0_FrameStrobe_O[14] Tile_X0Y0_FrameStrobe[14] VPWR VGND sg13cmos5l_buf_1
XFILLER_7_56 VPWR VGND sg13cmos5l_decap_8
XFILLER_7_386 VPWR VGND sg13cmos5l_decap_8
XFILLER_11_371 VPWR VGND sg13cmos5l_decap_8
X_059_ Tile_X1Y0_FrameData_O[13] Tile_X0Y0_FrameData[13] VPWR VGND sg13cmos5l_buf_1
XFILLER_3_570 VPWR VGND sg13cmos5l_fill_2
XANTENNA__043__A Tile_X1Y0_N4END[13] VPWR VGND sg13cmos5l_antennanp
XANTENNA__218__A Tile_X1Y0_NN4END[8] VPWR VGND sg13cmos5l_antennanp
XFILLER_5_813 VPWR VGND sg13cmos5l_decap_8
XFILLER_5_868 VPWR VGND sg13cmos5l_decap_8
XANTENNA__128__A Tile_X0Y0_FrameStrobe[14] VPWR VGND sg13cmos5l_antennanp
XFILLER_7_161 VPWR VGND sg13cmos5l_decap_8
XANTENNA__150__X NPU_WE7 VPWR VGND sg13cmos5l_antennanp
XANTENNA__038__A Tile_X1Y0_N4END[8] VPWR VGND sg13cmos5l_antennanp
XFILLER_10_606 VPWR VGND sg13cmos5l_decap_8
XANTENNA__060__X Tile_X1Y0_FrameData_O[14] VPWR VGND sg13cmos5l_antennanp
XFILLER_2_827 VPWR VGND sg13cmos5l_decap_8
XFILLER_1_304 VPWR VGND sg13cmos5l_fill_2
XFILLER_9_426 VPWR VGND sg13cmos5l_decap_8
XFILLER_5_676 VPWR VGND sg13cmos5l_decap_8
XFILLER_4_24 VPWR VGND sg13cmos5l_decap_8
XFILLER_4_153 VPWR VGND sg13cmos5l_fill_2
XFILLER_0_370 VPWR VGND sg13cmos5l_decap_8
XFILLER_0_381 VPWR VGND sg13cmos5l_fill_1
XFILLER_4_186 VPWR VGND sg13cmos5l_decap_8
XFILLER_1_871 VPWR VGND sg13cmos5l_decap_4
XANTENNA__145__X Tile_X0Y0_S4BEG[11] VPWR VGND sg13cmos5l_antennanp
XANTENNA__055__X Tile_X1Y0_FrameData_O[9] VPWR VGND sg13cmos5l_antennanp
XFILLER_6_407 VPWR VGND sg13cmos5l_decap_8
XFILLER_9_245 VPWR VGND sg13cmos5l_fill_1
XANTENNA__141__A NPU_RDATA8 VPWR VGND sg13cmos5l_antennanp
XFILLER_5_462 VPWR VGND sg13cmos5l_decap_8
XFILLER_9_790 VPWR VGND sg13cmos5l_decap_8
XANTENNA__051__A Tile_X0Y0_FrameData[5] VPWR VGND sg13cmos5l_antennanp
XANTENNA__226__A Tile_X1Y0_NN4END[0] VPWR VGND sg13cmos5l_antennanp
XFILLER_10_244 VPWR VGND sg13cmos5l_decap_8
XFILLER_10_255 VPWR VGND sg13cmos5l_decap_4
X_161_ NPU_WDATA6 Tile_X0Y0_N4END[9] VPWR VGND sg13cmos5l_buf_1
XFILLER_7_716 VPWR VGND sg13cmos5l_decap_8
XFILLER_6_204 VPWR VGND sg13cmos5l_decap_8
XFILLER_11_756 VPWR VGND sg13cmos5l_decap_8
X_092_ Tile_X1Y0_FrameStrobe_O[14] Tile_X1Y0_FrameStrobe[14] VPWR VGND sg13cmos5l_buf_1
XFILLER_2_410 VPWR VGND sg13cmos5l_decap_8
XFILLER_2_487 VPWR VGND sg13cmos5l_fill_2
XANTENNA__136__A NPU_RDATA13 VPWR VGND sg13cmos5l_antennanp
XANTENNA__046__A Tile_X0Y0_FrameData[0] VPWR VGND sg13cmos5l_antennanp
XFILLER_10_56 VPWR VGND sg13cmos5l_decap_8
X_075_ Tile_X1Y0_FrameData_O[29] Tile_X0Y0_FrameData[29] VPWR VGND sg13cmos5l_buf_1
X_213_ Tile_X1Y0_SS4BEG[2] Tile_X1Y0_NN4END[13] VPWR VGND sg13cmos5l_buf_1
X_144_ Tile_X0Y0_S4BEG[10] NPU_RDATA5 VPWR VGND sg13cmos5l_buf_1
XFILLER_11_542 VPWR VGND sg13cmos5l_fill_2
XFILLER_11_531 VPWR VGND sg13cmos5l_decap_8
XFILLER_3_730 VPWR VGND sg13cmos5l_decap_8
XFILLER_2_262 VPWR VGND sg13cmos5l_decap_8
XANTENNA__153__X NPU_WE4 VPWR VGND sg13cmos5l_antennanp
XANTENNA__063__X Tile_X1Y0_FrameData_O[17] VPWR VGND sg13cmos5l_antennanp
XFILLER_0_744 VPWR VGND sg13cmos5l_decap_8
XFILLER_0_799 VPWR VGND sg13cmos5l_decap_8
XFILLER_11_350 VPWR VGND sg13cmos5l_decap_8
XFILLER_8_855 VPWR VGND sg13cmos5l_decap_8
X_058_ Tile_X1Y0_FrameData_O[12] Tile_X0Y0_FrameData[12] VPWR VGND sg13cmos5l_buf_1
X_127_ Tile_X0Y0_FrameStrobe_O[13] Tile_X0Y0_FrameStrobe[13] VPWR VGND sg13cmos5l_buf_1
XFILLER_7_365 VPWR VGND sg13cmos5l_decap_8
XFILLER_7_35 VPWR VGND sg13cmos5l_decap_8
XANTENNA__148__X Tile_X0Y0_S4BEG[14] VPWR VGND sg13cmos5l_antennanp
XANTENNA__058__X Tile_X1Y0_FrameData_O[12] VPWR VGND sg13cmos5l_antennanp
XFILLER_9_619 VPWR VGND sg13cmos5l_decap_8
XFILLER_0_574 VPWR VGND sg13cmos5l_decap_8
XANTENNA__144__A NPU_RDATA5 VPWR VGND sg13cmos5l_antennanp
XFILLER_7_140 VPWR VGND sg13cmos5l_decap_8
XFILLER_8_696 VPWR VGND sg13cmos5l_decap_8
XANTENNA__054__A Tile_X0Y0_FrameData[8] VPWR VGND sg13cmos5l_antennanp
XFILLER_2_806 VPWR VGND sg13cmos5l_decap_8
XFILLER_9_405 VPWR VGND sg13cmos5l_fill_2
XFILLER_5_655 VPWR VGND sg13cmos5l_decap_8
XFILLER_4_165 VPWR VGND sg13cmos5l_decap_8
XFILLER_4_132 VPWR VGND sg13cmos5l_decap_8
XFILLER_1_850 VPWR VGND sg13cmos5l_fill_2
XANTENNA__139__A NPU_RDATA10 VPWR VGND sg13cmos5l_antennanp
XFILLER_8_482 VPWR VGND sg13cmos5l_fill_2
XANTENNA__161__X NPU_WDATA6 VPWR VGND sg13cmos5l_antennanp
XANTENNA__049__A Tile_X0Y0_FrameData[3] VPWR VGND sg13cmos5l_antennanp
XFILLER_10_426 VPWR VGND sg13cmos5l_fill_2
XANTENNA__071__X Tile_X1Y0_FrameData_O[25] VPWR VGND sg13cmos5l_antennanp
XFILLER_2_658 VPWR VGND sg13cmos5l_fill_2
XFILLER_2_647 VPWR VGND sg13cmos5l_fill_1
XFILLER_2_603 VPWR VGND sg13cmos5l_fill_2
XFILLER_9_224 VPWR VGND sg13cmos5l_fill_1
XFILLER_9_257 VPWR VGND sg13cmos5l_decap_8
XFILLER_5_441 VPWR VGND sg13cmos5l_decap_8
XFILLER_1_691 VPWR VGND sg13cmos5l_fill_1
XANTENNA__156__X NPU_WE1 VPWR VGND sg13cmos5l_antennanp
XANTENNA__066__X Tile_X1Y0_FrameData_O[20] VPWR VGND sg13cmos5l_antennanp
XFILLER_10_223 VPWR VGND sg13cmos5l_decap_8
XFILLER_10_278 VPWR VGND sg13cmos5l_fill_1
X_091_ Tile_X1Y0_FrameStrobe_O[13] Tile_X1Y0_FrameStrobe[13] VPWR VGND sg13cmos5l_buf_1
X_160_ NPU_WDATA7 Tile_X0Y0_N4END[8] VPWR VGND sg13cmos5l_buf_1
XFILLER_7_739 VPWR VGND sg13cmos5l_decap_8
XFILLER_11_735 VPWR VGND sg13cmos5l_decap_8
XFILLER_2_499 VPWR VGND sg13cmos5l_decap_8
XFILLER_2_477 VPWR VGND sg13cmos5l_decap_4
XANTENNA__152__A Tile_X1Y0_N4END[2] VPWR VGND sg13cmos5l_antennanp
XFILLER_6_783 VPWR VGND sg13cmos5l_decap_8
XANTENNA__062__A Tile_X0Y0_FrameData[16] VPWR VGND sg13cmos5l_antennanp
XFILLER_10_35 VPWR VGND sg13cmos5l_decap_8
X_212_ Tile_X1Y0_SS4BEG[1] Tile_X1Y0_NN4END[14] VPWR VGND sg13cmos5l_buf_1
X_074_ Tile_X1Y0_FrameData_O[28] Tile_X0Y0_FrameData[28] VPWR VGND sg13cmos5l_buf_1
X_143_ Tile_X0Y0_S4BEG[9] NPU_RDATA6 VPWR VGND sg13cmos5l_buf_1
XFILLER_7_569 VPWR VGND sg13cmos5l_fill_1
XFILLER_11_587 VPWR VGND sg13cmos5l_decap_8
XFILLER_3_786 VPWR VGND sg13cmos5l_decap_8
XFILLER_2_252 VPWR VGND sg13cmos5l_decap_8
XANTENNA__147__A NPU_RDATA2 VPWR VGND sg13cmos5l_antennanp
XANTENNA__057__A Tile_X0Y0_FrameData[11] VPWR VGND sg13cmos5l_antennanp
XFILLER_4_539 VPWR VGND sg13cmos5l_decap_4
XFILLER_0_723 VPWR VGND sg13cmos5l_decap_8
XFILLER_0_778 VPWR VGND sg13cmos5l_decap_8
XFILLER_8_834 VPWR VGND sg13cmos5l_decap_8
XFILLER_7_14 VPWR VGND sg13cmos5l_decap_8
X_057_ Tile_X1Y0_FrameData_O[11] Tile_X0Y0_FrameData[11] VPWR VGND sg13cmos5l_buf_1
X_126_ Tile_X0Y0_FrameStrobe_O[12] Tile_X0Y0_FrameStrobe[12] VPWR VGND sg13cmos5l_buf_1
XFILLER_7_344 VPWR VGND sg13cmos5l_decap_8
XFILLER_3_550 VPWR VGND sg13cmos5l_decap_4
XFILLER_11_395 VPWR VGND sg13cmos5l_decap_8
XANTENNA__164__X NPU_WDATA31 VPWR VGND sg13cmos5l_antennanp
XANTENNA__074__X Tile_X1Y0_FrameData_O[28] VPWR VGND sg13cmos5l_antennanp
XFILLER_8_119 VPWR VGND sg13cmos5l_decap_8
XFILLER_5_848 VPWR VGND sg13cmos5l_decap_8
XFILLER_4_369 VPWR VGND sg13cmos5l_decap_8
XFILLER_4_325 VPWR VGND sg13cmos5l_fill_1
XFILLER_8_675 VPWR VGND sg13cmos5l_decap_8
XFILLER_8_664 VPWR VGND sg13cmos5l_decap_4
XANTENNA__160__A Tile_X0Y0_N4END[8] VPWR VGND sg13cmos5l_antennanp
X_109_ Tile_X0Y0_S2BEGb[3] Tile_X0Y0_N2END[4] VPWR VGND sg13cmos5l_buf_1
XFILLER_7_196 VPWR VGND sg13cmos5l_decap_8
XANTENNA__159__X NPU_WDATA8 VPWR VGND sg13cmos5l_antennanp
XANTENNA__070__A Tile_X0Y0_FrameData[24] VPWR VGND sg13cmos5l_antennanp
XANTENNA__069__X Tile_X1Y0_FrameData_O[23] VPWR VGND sg13cmos5l_antennanp
XFILLER_5_634 VPWR VGND sg13cmos5l_decap_8
XFILLER_4_59 VPWR VGND sg13cmos5l_decap_8
XFILLER_4_111 VPWR VGND sg13cmos5l_decap_8
XANTENNA__155__A Tile_X1Y0_N4END[5] VPWR VGND sg13cmos5l_antennanp
XFILLER_8_472 VPWR VGND sg13cmos5l_decap_8
XANTENNA__065__A Tile_X0Y0_FrameData[19] VPWR VGND sg13cmos5l_antennanp
XFILLER_2_626 VPWR VGND sg13cmos5l_fill_2
XFILLER_2_615 VPWR VGND sg13cmos5l_decap_8
XFILLER_1_136 VPWR VGND sg13cmos5l_fill_1
XFILLER_1_125 VPWR VGND sg13cmos5l_decap_8
XFILLER_9_203 VPWR VGND sg13cmos5l_decap_8
XFILLER_5_420 VPWR VGND sg13cmos5l_decap_8
XFILLER_5_497 VPWR VGND sg13cmos5l_decap_8
XANTENNA__172__X NPU_WDATA24 VPWR VGND sg13cmos5l_antennanp
XFILLER_8_280 VPWR VGND sg13cmos5l_decap_8
XFILLER_5_91 VPWR VGND sg13cmos5l_decap_8
XFILLER_11_714 VPWR VGND sg13cmos5l_decap_8
XANTENNA__082__X Tile_X1Y0_FrameStrobe_O[4] VPWR VGND sg13cmos5l_antennanp
XFILLER_10_202 VPWR VGND sg13cmos5l_decap_8
X_090_ Tile_X1Y0_FrameStrobe_O[12] Tile_X1Y0_FrameStrobe[12] VPWR VGND sg13cmos5l_buf_1
XFILLER_6_762 VPWR VGND sg13cmos5l_decap_8
XFILLER_6_751 VPWR VGND sg13cmos5l_fill_1
XFILLER_6_740 VPWR VGND sg13cmos5l_decap_8
XFILLER_5_294 VPWR VGND sg13cmos5l_decap_8
XANTENNA__167__X NPU_WDATA29 VPWR VGND sg13cmos5l_antennanp
XFILLER_10_14 VPWR VGND sg13cmos5l_decap_8
XANTENNA__077__X Tile_X1Y0_FrameData_O[31] VPWR VGND sg13cmos5l_antennanp
X_211_ Tile_X1Y0_SS4BEG[0] Tile_X1Y0_NN4END[15] VPWR VGND sg13cmos5l_buf_1
X_142_ Tile_X0Y0_S4BEG[8] NPU_RDATA7 VPWR VGND sg13cmos5l_buf_1
XFILLER_11_566 VPWR VGND sg13cmos5l_decap_8
X_073_ Tile_X1Y0_FrameData_O[27] Tile_X0Y0_FrameData[27] VPWR VGND sg13cmos5l_buf_1
XFILLER_7_526 VPWR VGND sg13cmos5l_decap_8
XFILLER_4_0 VPWR VGND sg13cmos5l_fill_2
XFILLER_3_710 VPWR VGND sg13cmos5l_decap_4
XFILLER_3_765 VPWR VGND sg13cmos5l_decap_8
XFILLER_2_297 VPWR VGND sg13cmos5l_decap_8
XANTENNA__163__A Tile_X0Y0_N4END[11] VPWR VGND sg13cmos5l_antennanp
XFILLER_6_592 VPWR VGND sg13cmos5l_decap_8
XFILLER_2_92 VPWR VGND sg13cmos5l_decap_8
XFILLER_2_81 VPWR VGND sg13cmos5l_fill_1
XFILLER_2_70 VPWR VGND sg13cmos5l_decap_8
XANTENNA__073__A Tile_X0Y0_FrameData[27] VPWR VGND sg13cmos5l_antennanp
XFILLER_0_713 VPWR VGND sg13cmos5l_decap_8
XFILLER_8_813 VPWR VGND sg13cmos5l_decap_8
X_125_ Tile_X0Y0_FrameStrobe_O[11] Tile_X0Y0_FrameStrobe[11] VPWR VGND sg13cmos5l_buf_1
XFILLER_7_323 VPWR VGND sg13cmos5l_decap_8
XFILLER_11_385 VPWR VGND sg13cmos5l_decap_8
X_056_ Tile_X1Y0_FrameData_O[10] Tile_X0Y0_FrameData[10] VPWR VGND sg13cmos5l_buf_1
XANTENNA__158__A Tile_X0Y0_N4END[6] VPWR VGND sg13cmos5l_antennanp
XANTENNA__180__X Tile_X1Y0_S2BEG[1] VPWR VGND sg13cmos5l_antennanp
XANTENNA__068__A Tile_X0Y0_FrameData[22] VPWR VGND sg13cmos5l_antennanp
XANTENNA__090__X Tile_X1Y0_FrameStrobe_O[12] VPWR VGND sg13cmos5l_antennanp
XFILLER_5_827 VPWR VGND sg13cmos5l_decap_8
XFILLER_4_337 VPWR VGND sg13cmos5l_decap_8
XFILLER_4_304 VPWR VGND sg13cmos5l_decap_8
XFILLER_0_554 VPWR VGND sg13cmos5l_decap_4
X_108_ Tile_X0Y0_S2BEGb[2] Tile_X0Y0_N2END[5] VPWR VGND sg13cmos5l_buf_1
XFILLER_8_643 VPWR VGND sg13cmos5l_decap_8
XFILLER_7_175 VPWR VGND sg13cmos5l_decap_8
XFILLER_11_182 VPWR VGND sg13cmos5l_decap_8
X_039_ NPU_ADDR6 Tile_X1Y0_N4END[9] VPWR VGND sg13cmos5l_buf_1
XFILLER_3_381 VPWR VGND sg13cmos5l_decap_8
XANTENNA__175__X Tile_X1Y0_S1BEG[0] VPWR VGND sg13cmos5l_antennanp
XFILLER_8_91 VPWR VGND sg13cmos5l_decap_8
XANTENNA__085__X Tile_X1Y0_FrameStrobe_O[7] VPWR VGND sg13cmos5l_antennanp
XFILLER_5_613 VPWR VGND sg13cmos5l_decap_8
XFILLER_0_351 VPWR VGND sg13cmos5l_fill_2
XFILLER_4_38 VPWR VGND sg13cmos5l_decap_8
XFILLER_1_852 VPWR VGND sg13cmos5l_fill_1
XANTENNA__171__A Tile_X0Y0_NN4END[6] VPWR VGND sg13cmos5l_antennanp
XFILLER_8_451 VPWR VGND sg13cmos5l_decap_8
XFILLER_4_690 VPWR VGND sg13cmos5l_decap_8
XFILLER_10_417 VPWR VGND sg13cmos5l_decap_4
XFILLER_10_428 VPWR VGND sg13cmos5l_fill_1
XFILLER_10_439 VPWR VGND sg13cmos5l_fill_1
XANTENNA__081__A Tile_X1Y0_FrameStrobe[3] VPWR VGND sg13cmos5l_antennanp
XFILLER_2_638 VPWR VGND sg13cmos5l_decap_4
XFILLER_1_159 VPWR VGND sg13cmos5l_fill_1
XFILLER_5_476 VPWR VGND sg13cmos5l_decap_8
XANTENNA__166__A Tile_X0Y0_N4END[12] VPWR VGND sg13cmos5l_antennanp
XFILLER_5_70 VPWR VGND sg13cmos5l_decap_8
XANTENNA__076__A Tile_X0Y0_FrameData[30] VPWR VGND sg13cmos5l_antennanp
XFILLER_6_218 VPWR VGND sg13cmos5l_decap_8
XFILLER_2_402 VPWR VGND sg13cmos5l_fill_1
XFILLER_1_39 VPWR VGND sg13cmos5l_decap_4
XFILLER_5_273 VPWR VGND sg13cmos5l_decap_8
XFILLER_10_792 VPWR VGND sg13cmos5l_decap_8
XANTENNA__183__X Tile_X1Y0_S2BEG[4] VPWR VGND sg13cmos5l_antennanp
XANTENNA__093__X Tile_X1Y0_FrameStrobe_O[15] VPWR VGND sg13cmos5l_antennanp
X_210_ Tile_X1Y0_S4BEG[15] NPU_RDATA16 VPWR VGND sg13cmos5l_buf_1
X_141_ Tile_X0Y0_S4BEG[7] NPU_RDATA8 VPWR VGND sg13cmos5l_buf_1
XFILLER_7_538 VPWR VGND sg13cmos5l_decap_8
XFILLER_7_505 VPWR VGND sg13cmos5l_decap_8
X_072_ Tile_X1Y0_FrameData_O[26] Tile_X0Y0_FrameData[26] VPWR VGND sg13cmos5l_buf_1
XFILLER_3_744 VPWR VGND sg13cmos5l_decap_8
XFILLER_2_276 VPWR VGND sg13cmos5l_decap_4
XFILLER_6_571 VPWR VGND sg13cmos5l_decap_8
XFILLER_6_560 VPWR VGND sg13cmos5l_fill_1
XANTENNA__178__X Tile_X1Y0_S1BEG[3] VPWR VGND sg13cmos5l_antennanp
XANTENNA__088__X Tile_X1Y0_FrameStrobe_O[10] VPWR VGND sg13cmos5l_antennanp
XFILLER_0_758 VPWR VGND sg13cmos5l_decap_8
XFILLER_8_869 VPWR VGND sg13cmos5l_decap_8
X_055_ Tile_X1Y0_FrameData_O[9] Tile_X0Y0_FrameData[9] VPWR VGND sg13cmos5l_buf_1
X_124_ Tile_X0Y0_FrameStrobe_O[10] Tile_X0Y0_FrameStrobe[10] VPWR VGND sg13cmos5l_buf_1
XFILLER_7_49 VPWR VGND sg13cmos5l_decap_8
XFILLER_7_379 VPWR VGND sg13cmos5l_decap_8
XFILLER_7_302 VPWR VGND sg13cmos5l_decap_8
XFILLER_11_364 VPWR VGND sg13cmos5l_decap_8
XFILLER_3_563 VPWR VGND sg13cmos5l_decap_8
XFILLER_11_91 VPWR VGND sg13cmos5l_decap_8
XANTENNA__174__A Tile_X0Y0_NN4END[9] VPWR VGND sg13cmos5l_antennanp
XANTENNA__084__A Tile_X1Y0_FrameStrobe[6] VPWR VGND sg13cmos5l_antennanp
XFILLER_5_806 VPWR VGND sg13cmos5l_decap_8
XFILLER_0_588 VPWR VGND sg13cmos5l_decap_8
XFILLER_8_622 VPWR VGND sg13cmos5l_decap_8
X_038_ NPU_ADDR7 Tile_X1Y0_N4END[8] VPWR VGND sg13cmos5l_buf_1
X_107_ Tile_X0Y0_S2BEGb[1] Tile_X0Y0_N2END[6] VPWR VGND sg13cmos5l_buf_1
XFILLER_7_154 VPWR VGND sg13cmos5l_decap_8
XFILLER_11_161 VPWR VGND sg13cmos5l_decap_8
XFILLER_4_883 VPWR VGND sg13cmos5l_decap_4
XFILLER_3_360 VPWR VGND sg13cmos5l_decap_8
XANTENNA__169__A Tile_X0Y0_NN4END[4] VPWR VGND sg13cmos5l_antennanp
XANTENNA__191__X Tile_X1Y0_S2BEGb[4] VPWR VGND sg13cmos5l_antennanp
XFILLER_8_70 VPWR VGND sg13cmos5l_decap_8
XANTENNA__079__A Tile_X1Y0_FrameStrobe[1] VPWR VGND sg13cmos5l_antennanp
XFILLER_9_419 VPWR VGND sg13cmos5l_decap_8
XFILLER_5_669 VPWR VGND sg13cmos5l_decap_8
XFILLER_4_146 VPWR VGND sg13cmos5l_decap_8
XFILLER_0_363 VPWR VGND sg13cmos5l_decap_8
XFILLER_4_179 VPWR VGND sg13cmos5l_decap_8
XFILLER_4_17 VPWR VGND sg13cmos5l_decap_8
XFILLER_1_875 VPWR VGND sg13cmos5l_fill_2
XFILLER_1_864 VPWR VGND sg13cmos5l_fill_1
XFILLER_8_430 VPWR VGND sg13cmos5l_decap_8
XFILLER_3_190 VPWR VGND sg13cmos5l_decap_8
XANTENNA__186__X Tile_X1Y0_S2BEG[7] VPWR VGND sg13cmos5l_antennanp
XANTENNA__096__X Tile_X1Y0_FrameStrobe_O[18] VPWR VGND sg13cmos5l_antennanp
XFILLER_9_238 VPWR VGND sg13cmos5l_decap_8
XFILLER_5_455 VPWR VGND sg13cmos5l_decap_8
XFILLER_0_193 VPWR VGND sg13cmos5l_fill_1
XANTENNA__182__A Tile_X1Y0_N2MID[4] VPWR VGND sg13cmos5l_antennanp
XFILLER_9_783 VPWR VGND sg13cmos5l_decap_8
XFILLER_10_237 VPWR VGND sg13cmos5l_decap_8
XFILLER_10_259 VPWR VGND sg13cmos5l_fill_1
XFILLER_7_709 VPWR VGND sg13cmos5l_decap_8
XFILLER_11_749 VPWR VGND sg13cmos5l_decap_8
XANTENNA__092__A Tile_X1Y0_FrameStrobe[14] VPWR VGND sg13cmos5l_antennanp
XFILLER_2_458 VPWR VGND sg13cmos5l_fill_2
XFILLER_10_771 VPWR VGND sg13cmos5l_decap_8
XFILLER_6_797 VPWR VGND sg13cmos5l_decap_8
XFILLER_5_252 VPWR VGND sg13cmos5l_decap_8
XANTENNA__177__A Tile_X1Y0_N1END[1] VPWR VGND sg13cmos5l_antennanp
XFILLER_10_49 VPWR VGND sg13cmos5l_decap_8
XFILLER_9_591 VPWR VGND sg13cmos5l_decap_8
XANTENNA__087__A Tile_X1Y0_FrameStrobe[9] VPWR VGND sg13cmos5l_antennanp
X_071_ Tile_X1Y0_FrameData_O[25] Tile_X0Y0_FrameData[25] VPWR VGND sg13cmos5l_buf_1
X_140_ Tile_X0Y0_S4BEG[6] NPU_RDATA9 VPWR VGND sg13cmos5l_buf_1
XFILLER_11_524 VPWR VGND sg13cmos5l_decap_8
XFILLER_11_513 VPWR VGND sg13cmos5l_decap_4
XFILLER_3_723 VPWR VGND sg13cmos5l_decap_8
XFILLER_3_701 VPWR VGND sg13cmos5l_fill_2
XFILLER_2_233 VPWR VGND sg13cmos5l_fill_2
XANTENNA__194__X Tile_X1Y0_S2BEGb[7] VPWR VGND sg13cmos5l_antennanp
XFILLER_0_737 VPWR VGND sg13cmos5l_decap_8
XFILLER_4_509 VPWR VGND sg13cmos5l_fill_2
XFILLER_8_848 VPWR VGND sg13cmos5l_decap_8
X_054_ Tile_X1Y0_FrameData_O[8] Tile_X0Y0_FrameData[8] VPWR VGND sg13cmos5l_buf_1
X_123_ Tile_X0Y0_FrameStrobe_O[9] Tile_X0Y0_FrameStrobe[9] VPWR VGND sg13cmos5l_buf_1
XFILLER_7_358 VPWR VGND sg13cmos5l_decap_8
XFILLER_7_28 VPWR VGND sg13cmos5l_decap_8
XFILLER_11_343 VPWR VGND sg13cmos5l_decap_8
XFILLER_3_575 VPWR VGND sg13cmos5l_fill_1
XFILLER_11_70 VPWR VGND sg13cmos5l_decap_8
XANTENNA__190__A Tile_X1Y0_N2END[4] VPWR VGND sg13cmos5l_antennanp
XANTENNA__189__X Tile_X1Y0_S2BEGb[2] VPWR VGND sg13cmos5l_antennanp
XANTENNA__099__X Tile_X0Y0_S2BEG[1] VPWR VGND sg13cmos5l_antennanp
XFILLER_0_567 VPWR VGND sg13cmos5l_decap_8
XFILLER_8_601 VPWR VGND sg13cmos5l_decap_8
XFILLER_11_140 VPWR VGND sg13cmos5l_decap_8
X_037_ Tile_X0Y0_S1BEG[3] Tile_X0Y0_N1END[0] VPWR VGND sg13cmos5l_buf_1
X_106_ Tile_X0Y0_S2BEGb[0] Tile_X0Y0_N2END[7] VPWR VGND sg13cmos5l_buf_1
XFILLER_8_689 VPWR VGND sg13cmos5l_decap_8
XFILLER_7_133 VPWR VGND sg13cmos5l_decap_8
XFILLER_4_873 VPWR VGND sg13cmos5l_fill_1
XFILLER_4_862 VPWR VGND sg13cmos5l_decap_8
XANTENNA__185__A Tile_X1Y0_N2MID[1] VPWR VGND sg13cmos5l_antennanp
XANTENNA__095__A Tile_X1Y0_FrameStrobe[17] VPWR VGND sg13cmos5l_antennanp
XFILLER_5_648 VPWR VGND sg13cmos5l_decap_8
XFILLER_4_158 VPWR VGND sg13cmos5l_decap_8
XFILLER_4_125 VPWR VGND sg13cmos5l_decap_8
XFILLER_1_887 VPWR VGND sg13cmos5l_fill_1
XFILLER_1_843 VPWR VGND sg13cmos5l_decap_8
XFILLER_9_217 VPWR VGND sg13cmos5l_decap_8
XFILLER_5_434 VPWR VGND sg13cmos5l_decap_8
XFILLER_1_640 VPWR VGND sg13cmos5l_fill_2
XFILLER_0_172 VPWR VGND sg13cmos5l_fill_1
XFILLER_1_673 VPWR VGND sg13cmos5l_fill_1
XFILLER_9_762 VPWR VGND sg13cmos5l_decap_8
XFILLER_8_294 VPWR VGND sg13cmos5l_decap_8
XFILLER_8_250 VPWR VGND sg13cmos5l_fill_2
XANTENNA__197__X Tile_X1Y0_S4BEG[2] VPWR VGND sg13cmos5l_antennanp
XFILLER_10_216 VPWR VGND sg13cmos5l_decap_8
XFILLER_11_728 VPWR VGND sg13cmos5l_decap_8
XFILLER_2_448 VPWR VGND sg13cmos5l_decap_8
XFILLER_6_776 VPWR VGND sg13cmos5l_decap_8
XFILLER_6_710 VPWR VGND sg13cmos5l_decap_8
XFILLER_5_231 VPWR VGND sg13cmos5l_decap_8
XFILLER_10_750 VPWR VGND sg13cmos5l_decap_8
XANTENNA__193__A Tile_X1Y0_N2END[1] VPWR VGND sg13cmos5l_antennanp
XFILLER_10_28 VPWR VGND sg13cmos5l_decap_8
X_070_ Tile_X1Y0_FrameData_O[24] Tile_X0Y0_FrameData[24] VPWR VGND sg13cmos5l_buf_1
XFILLER_11_547 VPWR VGND sg13cmos5l_fill_2
XFILLER_3_779 VPWR VGND sg13cmos5l_decap_8
XFILLER_2_245 VPWR VGND sg13cmos5l_decap_8
XFILLER_2_223 VPWR VGND sg13cmos5l_fill_2
XFILLER_2_212 VPWR VGND sg13cmos5l_decap_8
XFILLER_2_201 VPWR VGND sg13cmos5l_fill_1
X_199_ Tile_X1Y0_S4BEG[4] NPU_RDATA27 VPWR VGND sg13cmos5l_buf_1
XFILLER_10_580 VPWR VGND sg13cmos5l_fill_1
XANTENNA__188__A Tile_X1Y0_N2END[6] VPWR VGND sg13cmos5l_antennanp
XFILLER_2_40 VPWR VGND sg13cmos5l_decap_8
XANTENNA__098__A Tile_X0Y0_N2MID[7] VPWR VGND sg13cmos5l_antennanp
XFILLER_8_827 VPWR VGND sg13cmos5l_decap_8
XFILLER_11_322 VPWR VGND sg13cmos5l_decap_8
X_053_ Tile_X1Y0_FrameData_O[7] Tile_X0Y0_FrameData[7] VPWR VGND sg13cmos5l_buf_1
X_122_ Tile_X0Y0_FrameStrobe_O[8] Tile_X0Y0_FrameStrobe[8] VPWR VGND sg13cmos5l_buf_1
XFILLER_7_337 VPWR VGND sg13cmos5l_fill_2
XFILLER_3_554 VPWR VGND sg13cmos5l_fill_1
XFILLER_3_543 VPWR VGND sg13cmos5l_decap_8
XFILLER_2_0 VPWR VGND sg13cmos5l_decap_8
XFILLER_3_598 VPWR VGND sg13cmos5l_decap_8
XFILLER_4_318 VPWR VGND sg13cmos5l_decap_8
XFILLER_0_502 VPWR VGND sg13cmos5l_decap_8
XFILLER_0_513 VPWR VGND sg13cmos5l_fill_1
XFILLER_0_524 VPWR VGND sg13cmos5l_fill_2
XFILLER_0_546 VPWR VGND sg13cmos5l_decap_4
X_105_ Tile_X0Y0_S2BEG[7] Tile_X0Y0_N2MID[0] VPWR VGND sg13cmos5l_buf_1
XFILLER_8_668 VPWR VGND sg13cmos5l_fill_1
XFILLER_8_657 VPWR VGND sg13cmos5l_decap_4
XFILLER_7_112 VPWR VGND sg13cmos5l_decap_8
XFILLER_11_196 VPWR VGND sg13cmos5l_decap_8
X_036_ Tile_X0Y0_S1BEG[2] Tile_X0Y0_N1END[1] VPWR VGND sg13cmos5l_buf_1
XFILLER_7_189 VPWR VGND sg13cmos5l_decap_8
XFILLER_4_841 VPWR VGND sg13cmos5l_decap_8
XFILLER_4_830 VPWR VGND sg13cmos5l_decap_8
XFILLER_3_395 VPWR VGND sg13cmos5l_fill_2
XFILLER_5_627 VPWR VGND sg13cmos5l_decap_8
XFILLER_4_104 VPWR VGND sg13cmos5l_decap_8
XFILLER_1_822 VPWR VGND sg13cmos5l_decap_8
XFILLER_0_398 VPWR VGND sg13cmos5l_decap_8
XFILLER_8_498 VPWR VGND sg13cmos5l_decap_4
XFILLER_8_487 VPWR VGND sg13cmos5l_fill_1
XFILLER_8_465 VPWR VGND sg13cmos5l_decap_8
X_019_ Tile_X0Y0_SS4BEG[1] Tile_X0Y0_NN4END[14] VPWR VGND sg13cmos5l_buf_1
XANTENNA__196__A NPU_RDATA30 VPWR VGND sg13cmos5l_antennanp
XFILLER_2_608 VPWR VGND sg13cmos5l_decap_8
XFILLER_1_118 VPWR VGND sg13cmos5l_decap_8
XFILLER_9_229 VPWR VGND sg13cmos5l_decap_4
XFILLER_5_413 VPWR VGND sg13cmos5l_decap_8
XFILLER_0_162 VPWR VGND sg13cmos5l_fill_2
XFILLER_9_741 VPWR VGND sg13cmos5l_decap_8
XFILLER_8_273 VPWR VGND sg13cmos5l_decap_8
XFILLER_5_84 VPWR VGND sg13cmos5l_decap_8
XFILLER_11_707 VPWR VGND sg13cmos5l_decap_8
XFILLER_6_755 VPWR VGND sg13cmos5l_decap_8
XFILLER_6_733 VPWR VGND sg13cmos5l_decap_8
XFILLER_5_287 VPWR VGND sg13cmos5l_decap_8
XFILLER_5_210 VPWR VGND sg13cmos5l_decap_8
XFILLER_1_471 VPWR VGND sg13cmos5l_fill_2
XANTENNA__001__X NPU_WDATA20 VPWR VGND sg13cmos5l_antennanp
XFILLER_7_519 VPWR VGND sg13cmos5l_decap_8
XFILLER_3_703 VPWR VGND sg13cmos5l_fill_1
XFILLER_11_559 VPWR VGND sg13cmos5l_decap_8
XFILLER_3_758 VPWR VGND sg13cmos5l_decap_8
X_198_ Tile_X1Y0_S4BEG[3] NPU_RDATA28 VPWR VGND sg13cmos5l_buf_1
XFILLER_6_585 VPWR VGND sg13cmos5l_decap_8
XFILLER_6_552 VPWR VGND sg13cmos5l_fill_1
XFILLER_10_592 VPWR VGND sg13cmos5l_decap_8
XFILLER_2_85 VPWR VGND sg13cmos5l_decap_8
XFILLER_2_63 VPWR VGND sg13cmos5l_decap_8
XFILLER_9_390 VPWR VGND sg13cmos5l_fill_2
XFILLER_0_706 VPWR VGND sg13cmos5l_decap_8
XFILLER_8_806 VPWR VGND sg13cmos5l_decap_8
X_121_ Tile_X0Y0_FrameStrobe_O[7] Tile_X0Y0_FrameStrobe[7] VPWR VGND sg13cmos5l_buf_1
XFILLER_7_316 VPWR VGND sg13cmos5l_decap_8
XFILLER_11_378 VPWR VGND sg13cmos5l_decap_8
XFILLER_11_301 VPWR VGND sg13cmos5l_decap_8
X_052_ Tile_X1Y0_FrameData_O[6] Tile_X0Y0_FrameData[6] VPWR VGND sg13cmos5l_buf_1
XFILLER_3_522 VPWR VGND sg13cmos5l_decap_8
XFILLER_7_872 VPWR VGND sg13cmos5l_decap_8
XANTENNA__199__A NPU_RDATA27 VPWR VGND sg13cmos5l_antennanp
XFILLER_6_393 VPWR VGND sg13cmos5l_decap_8
XFILLER_0_536 VPWR VGND sg13cmos5l_decap_8
X_035_ Tile_X0Y0_S1BEG[1] Tile_X0Y0_N1END[2] VPWR VGND sg13cmos5l_buf_1
X_104_ Tile_X0Y0_S2BEG[6] Tile_X0Y0_N2MID[1] VPWR VGND sg13cmos5l_buf_1
XFILLER_8_636 VPWR VGND sg13cmos5l_decap_8
XFILLER_7_168 VPWR VGND sg13cmos5l_decap_8
XFILLER_11_175 VPWR VGND sg13cmos5l_decap_8
XFILLER_3_374 VPWR VGND sg13cmos5l_decap_8
XFILLER_8_84 VPWR VGND sg13cmos5l_decap_8
XFILLER_6_190 VPWR VGND sg13cmos5l_decap_8
XFILLER_5_606 VPWR VGND sg13cmos5l_decap_8
XFILLER_1_801 VPWR VGND sg13cmos5l_decap_8
XFILLER_0_377 VPWR VGND sg13cmos5l_decap_4
X_018_ Tile_X0Y0_SS4BEG[0] Tile_X0Y0_NN4END[15] VPWR VGND sg13cmos5l_buf_1
XFILLER_8_444 VPWR VGND sg13cmos5l_decap_8
XFILLER_4_683 VPWR VGND sg13cmos5l_decap_8
XANTENNA__004__X NPU_WDATA18 VPWR VGND sg13cmos5l_antennanp
XFILLER_5_469 VPWR VGND sg13cmos5l_decap_8
XFILLER_1_631 VPWR VGND sg13cmos5l_fill_2
XFILLER_9_720 VPWR VGND sg13cmos5l_decap_8
XFILLER_8_263 VPWR VGND sg13cmos5l_fill_2
XFILLER_9_797 VPWR VGND sg13cmos5l_decap_8
XFILLER_5_63 VPWR VGND sg13cmos5l_decap_8
XANTENNA__000__A Tile_X0Y0_NN4END[10] VPWR VGND sg13cmos5l_antennanp
XFILLER_10_0 VPWR VGND sg13cmos5l_decap_8
XFILLER_2_417 VPWR VGND sg13cmos5l_fill_1
XFILLER_5_266 VPWR VGND sg13cmos5l_decap_8
XFILLER_5_200 VPWR VGND sg13cmos5l_decap_4
XFILLER_10_785 VPWR VGND sg13cmos5l_decap_8
XFILLER_11_538 VPWR VGND sg13cmos5l_decap_4
XFILLER_3_737 VPWR VGND sg13cmos5l_decap_8
XFILLER_2_269 VPWR VGND sg13cmos5l_decap_8
X_197_ Tile_X1Y0_S4BEG[2] NPU_RDATA29 VPWR VGND sg13cmos5l_buf_1
XANTENNA__102__X Tile_X0Y0_S2BEG[4] VPWR VGND sg13cmos5l_antennanp
XFILLER_2_792 VPWR VGND sg13cmos5l_decap_8
XANTENNA__012__X NPU_WDATA10 VPWR VGND sg13cmos5l_antennanp
X_051_ Tile_X1Y0_FrameData_O[5] Tile_X0Y0_FrameData[5] VPWR VGND sg13cmos5l_buf_1
X_120_ Tile_X0Y0_FrameStrobe_O[6] Tile_X0Y0_FrameStrobe[6] VPWR VGND sg13cmos5l_buf_1
XFILLER_7_339 VPWR VGND sg13cmos5l_fill_1
XFILLER_11_357 VPWR VGND sg13cmos5l_decap_8
XFILLER_3_501 VPWR VGND sg13cmos5l_decap_8
XFILLER_11_84 VPWR VGND sg13cmos5l_decap_8
XFILLER_7_851 VPWR VGND sg13cmos5l_decap_8
XFILLER_6_372 VPWR VGND sg13cmos5l_decap_8
XANTENNA__007__X NPU_WDATA15 VPWR VGND sg13cmos5l_antennanp
X_034_ Tile_X0Y0_S1BEG[0] Tile_X0Y0_N1END[3] VPWR VGND sg13cmos5l_buf_1
X_103_ Tile_X0Y0_S2BEG[5] Tile_X0Y0_N2MID[2] VPWR VGND sg13cmos5l_buf_1
XFILLER_8_615 VPWR VGND sg13cmos5l_decap_8
XFILLER_7_147 VPWR VGND sg13cmos5l_decap_8
XFILLER_11_154 VPWR VGND sg13cmos5l_decap_8
XFILLER_4_887 VPWR VGND sg13cmos5l_fill_1
XFILLER_3_397 VPWR VGND sg13cmos5l_fill_1
XFILLER_3_353 VPWR VGND sg13cmos5l_fill_2
XFILLER_8_63 VPWR VGND sg13cmos5l_decap_8
XFILLER_7_692 VPWR VGND sg13cmos5l_decap_8
XANTENNA__003__A Tile_X0Y0_NN4END[12] VPWR VGND sg13cmos5l_antennanp
XFILLER_4_139 VPWR VGND sg13cmos5l_decap_8
XFILLER_0_334 VPWR VGND sg13cmos5l_fill_1
XFILLER_0_356 VPWR VGND sg13cmos5l_decap_8
XANTENNA__200__X Tile_X1Y0_S4BEG[5] VPWR VGND sg13cmos5l_antennanp
XFILLER_8_423 VPWR VGND sg13cmos5l_decap_8
X_017_ NPU_READ_BANK_SEL0 Tile_X1Y0_NN4END[15] VPWR VGND sg13cmos5l_buf_1
XFILLER_4_662 VPWR VGND sg13cmos5l_decap_8
XANTENNA__110__X Tile_X0Y0_S2BEGb[4] VPWR VGND sg13cmos5l_antennanp
XFILLER_3_183 VPWR VGND sg13cmos5l_decap_8
XANTENNA__020__X Tile_X0Y0_SS4BEG[2] VPWR VGND sg13cmos5l_antennanp
XFILLER_5_448 VPWR VGND sg13cmos5l_decap_8
XFILLER_0_131 VPWR VGND sg13cmos5l_decap_8
XFILLER_0_186 VPWR VGND sg13cmos5l_decap_4
XFILLER_1_665 VPWR VGND sg13cmos5l_fill_1
XFILLER_9_776 VPWR VGND sg13cmos5l_decap_8
XANTENNA__105__X Tile_X0Y0_S2BEG[7] VPWR VGND sg13cmos5l_antennanp
XFILLER_5_42 VPWR VGND sg13cmos5l_decap_8
XANTENNA__015__X NPU_READ_BANK_SEL2 VPWR VGND sg13cmos5l_antennanp
XFILLER_10_764 VPWR VGND sg13cmos5l_decap_8
XFILLER_5_245 VPWR VGND sg13cmos5l_decap_8
XANTENNA__101__A Tile_X0Y0_N2MID[4] VPWR VGND sg13cmos5l_antennanp
XFILLER_9_562 VPWR VGND sg13cmos5l_decap_8
XFILLER_9_573 VPWR VGND sg13cmos5l_fill_1
XFILLER_9_584 VPWR VGND sg13cmos5l_decap_8
XANTENNA__011__A Tile_X0Y0_N4END[4] VPWR VGND sg13cmos5l_antennanp
XFILLER_11_517 VPWR VGND sg13cmos5l_fill_1
XFILLER_11_506 VPWR VGND sg13cmos5l_decap_8
X_196_ Tile_X1Y0_S4BEG[1] NPU_RDATA30 VPWR VGND sg13cmos5l_buf_1
XFILLER_6_565 VPWR VGND sg13cmos5l_fill_2
XFILLER_2_54 VPWR VGND sg13cmos5l_decap_4
XANTENNA__006__A Tile_X0Y0_NN4END[15] VPWR VGND sg13cmos5l_antennanp
X_050_ Tile_X1Y0_FrameData_O[4] Tile_X0Y0_FrameData[4] VPWR VGND sg13cmos5l_buf_1
XFILLER_11_336 VPWR VGND sg13cmos5l_decap_8
XANTENNA__203__X Tile_X1Y0_S4BEG[8] VPWR VGND sg13cmos5l_antennanp
XFILLER_3_513 VPWR VGND sg13cmos5l_decap_4
XFILLER_11_63 VPWR VGND sg13cmos5l_decap_8
XANTENNA__113__X Tile_X0Y0_S2BEGb[7] VPWR VGND sg13cmos5l_antennanp
X_179_ Tile_X1Y0_S2BEG[0] Tile_X1Y0_N2MID[7] VPWR VGND sg13cmos5l_buf_1
XFILLER_7_830 VPWR VGND sg13cmos5l_decap_8
XFILLER_6_351 VPWR VGND sg13cmos5l_decap_8
XANTENNA__023__X Tile_X0Y0_SS4BEG[5] VPWR VGND sg13cmos5l_antennanp
XFILLER_11_133 VPWR VGND sg13cmos5l_decap_8
X_033_ Tile_X0Y0_SS4BEG[15] Tile_X0Y0_NN4END[0] VPWR VGND sg13cmos5l_buf_1
X_102_ Tile_X0Y0_S2BEG[4] Tile_X0Y0_N2MID[3] VPWR VGND sg13cmos5l_buf_1
XFILLER_7_126 VPWR VGND sg13cmos5l_decap_8
XFILLER_4_855 VPWR VGND sg13cmos5l_decap_8
XFILLER_3_332 VPWR VGND sg13cmos5l_decap_8
XFILLER_0_0 VPWR VGND sg13cmos5l_decap_8
XANTENNA__108__X Tile_X0Y0_S2BEGb[2] VPWR VGND sg13cmos5l_antennanp
XFILLER_8_42 VPWR VGND sg13cmos5l_decap_8
XFILLER_7_671 VPWR VGND sg13cmos5l_decap_8
XANTENNA__018__X Tile_X0Y0_SS4BEG[0] VPWR VGND sg13cmos5l_antennanp
XFILLER_4_118 VPWR VGND sg13cmos5l_decap_8
XFILLER_0_346 VPWR VGND sg13cmos5l_fill_2
XFILLER_1_836 VPWR VGND sg13cmos5l_decap_8
XFILLER_8_402 VPWR VGND sg13cmos5l_decap_8
XANTENNA__104__A Tile_X0Y0_N2MID[1] VPWR VGND sg13cmos5l_antennanp
X_016_ NPU_READ_BANK_SEL1 Tile_X1Y0_NN4END[14] VPWR VGND sg13cmos5l_buf_1
XFILLER_4_641 VPWR VGND sg13cmos5l_decap_8
XFILLER_3_162 VPWR VGND sg13cmos5l_decap_8
XANTENNA__014__A Tile_X0Y0_N4END[15] VPWR VGND sg13cmos5l_antennanp
XFILLER_0_110 VPWR VGND sg13cmos5l_decap_8
XFILLER_5_427 VPWR VGND sg13cmos5l_decap_8
XFILLER_1_622 VPWR VGND sg13cmos5l_fill_2
XANTENNA__211__X Tile_X1Y0_SS4BEG[0] VPWR VGND sg13cmos5l_antennanp
XFILLER_9_755 VPWR VGND sg13cmos5l_decap_8
XFILLER_8_287 VPWR VGND sg13cmos5l_decap_8
XFILLER_8_243 VPWR VGND sg13cmos5l_decap_8
XFILLER_8_221 VPWR VGND sg13cmos5l_decap_4
XFILLER_8_210 VPWR VGND sg13cmos5l_decap_8
XFILLER_5_21 VPWR VGND sg13cmos5l_decap_8
XANTENNA__121__X Tile_X0Y0_FrameStrobe_O[7] VPWR VGND sg13cmos5l_antennanp
XFILLER_5_98 VPWR VGND sg13cmos5l_decap_8
XFILLER_4_482 VPWR VGND sg13cmos5l_decap_8
XANTENNA__009__A Tile_X0Y0_N4END[2] VPWR VGND sg13cmos5l_antennanp
XFILLER_10_209 VPWR VGND sg13cmos5l_decap_8
XANTENNA__031__X Tile_X0Y0_SS4BEG[13] VPWR VGND sg13cmos5l_antennanp
XANTENNA__206__X Tile_X1Y0_S4BEG[11] VPWR VGND sg13cmos5l_antennanp
XFILLER_6_769 VPWR VGND sg13cmos5l_decap_4
XFILLER_6_747 VPWR VGND sg13cmos5l_decap_4
XFILLER_6_703 VPWR VGND sg13cmos5l_decap_8
XFILLER_5_224 VPWR VGND sg13cmos5l_decap_8
XFILLER_10_743 VPWR VGND sg13cmos5l_decap_8
XFILLER_9_530 VPWR VGND sg13cmos5l_fill_2
XFILLER_9_552 VPWR VGND sg13cmos5l_fill_2
XANTENNA__116__X Tile_X0Y0_FrameStrobe_O[2] VPWR VGND sg13cmos5l_antennanp
XANTENNA__026__X Tile_X0Y0_SS4BEG[8] VPWR VGND sg13cmos5l_antennanp
XANTENNA__202__A NPU_RDATA24 VPWR VGND sg13cmos5l_antennanp
XFILLER_2_238 VPWR VGND sg13cmos5l_decap_8
XFILLER_2_205 VPWR VGND sg13cmos5l_decap_8
X_195_ Tile_X1Y0_S4BEG[0] NPU_RDATA31 VPWR VGND sg13cmos5l_buf_1
XFILLER_6_599 VPWR VGND sg13cmos5l_decap_8
XFILLER_6_533 VPWR VGND sg13cmos5l_fill_2
XANTENNA__112__A Tile_X0Y0_N2END[1] VPWR VGND sg13cmos5l_antennanp
XFILLER_2_77 VPWR VGND sg13cmos5l_decap_4
XFILLER_2_761 VPWR VGND sg13cmos5l_decap_8
XFILLER_2_33 VPWR VGND sg13cmos5l_decap_8
XFILLER_1_293 VPWR VGND sg13cmos5l_decap_8
XFILLER_1_282 VPWR VGND sg13cmos5l_fill_1
XFILLER_2_99 VPWR VGND sg13cmos5l_decap_4
XANTENNA__022__A Tile_X0Y0_NN4END[11] VPWR VGND sg13cmos5l_antennanp
XFILLER_11_315 VPWR VGND sg13cmos5l_decap_8
XFILLER_11_42 VPWR VGND sg13cmos5l_decap_8
XFILLER_3_558 VPWR VGND sg13cmos5l_fill_1
XANTENNA__107__A Tile_X0Y0_N2END[6] VPWR VGND sg13cmos5l_antennanp
XFILLER_11_882 VPWR VGND sg13cmos5l_decap_4
XFILLER_10_381 VPWR VGND sg13cmos5l_fill_1
X_178_ Tile_X1Y0_S1BEG[3] Tile_X1Y0_N1END[0] VPWR VGND sg13cmos5l_buf_1
XFILLER_7_886 VPWR VGND sg13cmos5l_fill_2
XFILLER_6_330 VPWR VGND sg13cmos5l_decap_8
XFILLER_2_580 VPWR VGND sg13cmos5l_fill_1
XANTENNA__017__A Tile_X1Y0_NN4END[15] VPWR VGND sg13cmos5l_antennanp
XFILLER_0_517 VPWR VGND sg13cmos5l_decap_8
X_101_ Tile_X0Y0_S2BEG[3] Tile_X0Y0_N2MID[4] VPWR VGND sg13cmos5l_buf_1
XFILLER_7_105 VPWR VGND sg13cmos5l_decap_8
XFILLER_11_189 VPWR VGND sg13cmos5l_decap_8
XFILLER_11_112 VPWR VGND sg13cmos5l_decap_8
XANTENNA__214__X Tile_X1Y0_SS4BEG[3] VPWR VGND sg13cmos5l_antennanp
X_032_ Tile_X0Y0_SS4BEG[14] Tile_X0Y0_NN4END[1] VPWR VGND sg13cmos5l_buf_1
XFILLER_4_823 VPWR VGND sg13cmos5l_decap_8
XFILLER_3_388 VPWR VGND sg13cmos5l_decap_8
XFILLER_3_355 VPWR VGND sg13cmos5l_fill_1
XFILLER_3_311 VPWR VGND sg13cmos5l_decap_8
XANTENNA__124__X Tile_X0Y0_FrameStrobe_O[10] VPWR VGND sg13cmos5l_antennanp
XFILLER_8_98 VPWR VGND sg13cmos5l_decap_8
XFILLER_8_21 VPWR VGND sg13cmos5l_decap_8
XFILLER_7_650 VPWR VGND sg13cmos5l_decap_8
XANTENNA__034__X Tile_X0Y0_S1BEG[0] VPWR VGND sg13cmos5l_antennanp
XFILLER_1_815 VPWR VGND sg13cmos5l_fill_1
XANTENNA__210__A NPU_RDATA16 VPWR VGND sg13cmos5l_antennanp
XFILLER_1_859 VPWR VGND sg13cmos5l_fill_2
XANTENNA__209__X Tile_X1Y0_S4BEG[14] VPWR VGND sg13cmos5l_antennanp
X_015_ NPU_READ_BANK_SEL2 Tile_X1Y0_NN4END[13] VPWR VGND sg13cmos5l_buf_1
XFILLER_8_458 VPWR VGND sg13cmos5l_decap_8
XFILLER_4_697 VPWR VGND sg13cmos5l_decap_8
XANTENNA__120__A Tile_X0Y0_FrameStrobe[6] VPWR VGND sg13cmos5l_antennanp
XANTENNA__119__X Tile_X0Y0_FrameStrobe_O[5] VPWR VGND sg13cmos5l_antennanp
XFILLER_7_491 VPWR VGND sg13cmos5l_decap_8
XANTENNA__030__A Tile_X0Y0_NN4END[3] VPWR VGND sg13cmos5l_antennanp
XANTENNA__029__X Tile_X0Y0_SS4BEG[11] VPWR VGND sg13cmos5l_antennanp
XFILLER_5_406 VPWR VGND sg13cmos5l_decap_8
XANTENNA__205__A NPU_RDATA21 VPWR VGND sg13cmos5l_antennanp
XFILLER_1_678 VPWR VGND sg13cmos5l_fill_1
XFILLER_0_155 VPWR VGND sg13cmos5l_decap_8
XFILLER_1_689 VPWR VGND sg13cmos5l_fill_2
XFILLER_9_734 VPWR VGND sg13cmos5l_decap_8
XANTENNA__115__A Tile_X0Y0_FrameStrobe[1] VPWR VGND sg13cmos5l_antennanp
XFILLER_4_461 VPWR VGND sg13cmos5l_decap_8
XFILLER_5_77 VPWR VGND sg13cmos5l_decap_8
XANTENNA__025__A Tile_X0Y0_NN4END[8] VPWR VGND sg13cmos5l_antennanp
XFILLER_10_799 VPWR VGND sg13cmos5l_decap_8
XFILLER_10_722 VPWR VGND sg13cmos5l_decap_8
XANTENNA__222__X Tile_X1Y0_SS4BEG[11] VPWR VGND sg13cmos5l_antennanp
XFILLER_1_497 VPWR VGND sg13cmos5l_fill_2
XFILLER_1_431 VPWR VGND sg13cmos5l_decap_8
XANTENNA__132__X Tile_X0Y0_FrameStrobe_O[18] VPWR VGND sg13cmos5l_antennanp
XFILLER_5_792 VPWR VGND sg13cmos5l_decap_8
XANTENNA__042__X NPU_ADDR3 VPWR VGND sg13cmos5l_antennanp
XFILLER_2_228 VPWR VGND sg13cmos5l_fill_2
XANTENNA__217__X Tile_X1Y0_SS4BEG[6] VPWR VGND sg13cmos5l_antennanp
X_194_ Tile_X1Y0_S2BEGb[7] Tile_X1Y0_N2END[0] VPWR VGND sg13cmos5l_buf_1
XFILLER_6_578 VPWR VGND sg13cmos5l_decap_8
XFILLER_6_567 VPWR VGND sg13cmos5l_fill_1
XFILLER_6_556 VPWR VGND sg13cmos5l_decap_4
XFILLER_6_512 VPWR VGND sg13cmos5l_decap_4
XFILLER_2_740 VPWR VGND sg13cmos5l_decap_8
XFILLER_10_585 VPWR VGND sg13cmos5l_decap_4
XFILLER_1_261 VPWR VGND sg13cmos5l_fill_2
XANTENNA__127__X Tile_X0Y0_FrameStrobe_O[13] VPWR VGND sg13cmos5l_antennanp
XFILLER_9_383 VPWR VGND sg13cmos5l_decap_8
XANTENNA__037__X Tile_X0Y0_S1BEG[3] VPWR VGND sg13cmos5l_antennanp
XFILLER_7_309 VPWR VGND sg13cmos5l_decap_8
XANTENNA__213__A Tile_X1Y0_NN4END[13] VPWR VGND sg13cmos5l_antennanp
XFILLER_11_98 VPWR VGND sg13cmos5l_decap_8
XFILLER_11_21 VPWR VGND sg13cmos5l_decap_8
XFILLER_10_360 VPWR VGND sg13cmos5l_fill_1
X_177_ Tile_X1Y0_S1BEG[2] Tile_X1Y0_N1END[1] VPWR VGND sg13cmos5l_buf_1
XFILLER_7_865 VPWR VGND sg13cmos5l_decap_8
XFILLER_11_861 VPWR VGND sg13cmos5l_decap_8
XANTENNA__123__A Tile_X0Y0_FrameStrobe[9] VPWR VGND sg13cmos5l_antennanp
XFILLER_6_386 VPWR VGND sg13cmos5l_decap_8
XFILLER_2_592 VPWR VGND sg13cmos5l_decap_8
XANTENNA__033__A Tile_X0Y0_NN4END[0] VPWR VGND sg13cmos5l_antennanp
XFILLER_0_529 VPWR VGND sg13cmos5l_decap_8
XANTENNA__208__A NPU_RDATA18 VPWR VGND sg13cmos5l_antennanp
X_031_ Tile_X0Y0_SS4BEG[13] Tile_X0Y0_NN4END[2] VPWR VGND sg13cmos5l_buf_1
X_100_ Tile_X0Y0_S2BEG[2] Tile_X0Y0_N2MID[5] VPWR VGND sg13cmos5l_buf_1
XFILLER_8_629 VPWR VGND sg13cmos5l_decap_8
XFILLER_4_802 VPWR VGND sg13cmos5l_decap_8
XFILLER_11_168 VPWR VGND sg13cmos5l_decap_8
XFILLER_3_367 VPWR VGND sg13cmos5l_decap_8
XANTENNA__118__A Tile_X0Y0_FrameStrobe[4] VPWR VGND sg13cmos5l_antennanp
XFILLER_8_77 VPWR VGND sg13cmos5l_decap_8
XFILLER_6_183 VPWR VGND sg13cmos5l_decap_8
XFILLER_6_150 VPWR VGND sg13cmos5l_decap_4
XANTENNA__140__X Tile_X0Y0_S4BEG[6] VPWR VGND sg13cmos5l_antennanp
XANTENNA__028__A Tile_X0Y0_NN4END[5] VPWR VGND sg13cmos5l_antennanp
XFILLER_0_326 VPWR VGND sg13cmos5l_fill_1
XANTENNA__050__X Tile_X1Y0_FrameData_O[4] VPWR VGND sg13cmos5l_antennanp
XANTENNA__225__X Tile_X1Y0_SS4BEG[14] VPWR VGND sg13cmos5l_antennanp
X_014_ NPU_WDATA0 Tile_X0Y0_N4END[15] VPWR VGND sg13cmos5l_buf_1
XFILLER_8_437 VPWR VGND sg13cmos5l_decap_8
XFILLER_4_676 VPWR VGND sg13cmos5l_decap_8
XFILLER_3_197 VPWR VGND sg13cmos5l_decap_8
XANTENNA__135__X Tile_X0Y0_S4BEG[1] VPWR VGND sg13cmos5l_antennanp
XFILLER_7_470 VPWR VGND sg13cmos5l_decap_8
XANTENNA__045__X NPU_ADDR0 VPWR VGND sg13cmos5l_antennanp
XANTENNA__221__A Tile_X1Y0_NN4END[5] VPWR VGND sg13cmos5l_antennanp
XFILLER_9_713 VPWR VGND sg13cmos5l_decap_8
XFILLER_8_256 VPWR VGND sg13cmos5l_decap_8
XFILLER_5_56 VPWR VGND sg13cmos5l_decap_8
XANTENNA__131__A Tile_X0Y0_FrameStrobe[17] VPWR VGND sg13cmos5l_antennanp
XANTENNA__041__A Tile_X1Y0_N4END[11] VPWR VGND sg13cmos5l_antennanp
XFILLER_10_701 VPWR VGND sg13cmos5l_decap_8
XANTENNA__216__A Tile_X1Y0_NN4END[10] VPWR VGND sg13cmos5l_antennanp
XFILLER_6_727 VPWR VGND sg13cmos5l_fill_2
XFILLER_5_259 VPWR VGND sg13cmos5l_decap_8
XFILLER_5_204 VPWR VGND sg13cmos5l_fill_2
XFILLER_1_410 VPWR VGND sg13cmos5l_fill_2
XFILLER_10_778 VPWR VGND sg13cmos5l_decap_8
XANTENNA__126__A Tile_X0Y0_FrameStrobe[12] VPWR VGND sg13cmos5l_antennanp
XFILLER_9_510 VPWR VGND sg13cmos5l_fill_1
XFILLER_9_532 VPWR VGND sg13cmos5l_fill_1
XFILLER_9_554 VPWR VGND sg13cmos5l_fill_1
XFILLER_9_598 VPWR VGND sg13cmos5l_decap_8
XANTENNA__036__A Tile_X0Y0_N1END[1] VPWR VGND sg13cmos5l_antennanp
XFILLER_10_531 VPWR VGND sg13cmos5l_fill_1
X_193_ Tile_X1Y0_S2BEGb[6] Tile_X1Y0_N2END[1] VPWR VGND sg13cmos5l_buf_1
XFILLER_6_535 VPWR VGND sg13cmos5l_fill_1
XFILLER_1_240 VPWR VGND sg13cmos5l_fill_2
XANTENNA__143__X Tile_X0Y0_S4BEG[9] VPWR VGND sg13cmos5l_antennanp
XANTENNA__053__X Tile_X1Y0_FrameData_O[7] VPWR VGND sg13cmos5l_antennanp
XFILLER_11_77 VPWR VGND sg13cmos5l_decap_8
XFILLER_10_394 VPWR VGND sg13cmos5l_fill_1
X_176_ Tile_X1Y0_S1BEG[1] Tile_X1Y0_N1END[2] VPWR VGND sg13cmos5l_buf_1
XFILLER_7_844 VPWR VGND sg13cmos5l_decap_8
XFILLER_6_365 VPWR VGND sg13cmos5l_decap_8
XFILLER_11_840 VPWR VGND sg13cmos5l_decap_8
XANTENNA__138__X Tile_X0Y0_S4BEG[4] VPWR VGND sg13cmos5l_antennanp
XANTENNA__048__X Tile_X1Y0_FrameData_O[2] VPWR VGND sg13cmos5l_antennanp
XANTENNA__224__A Tile_X1Y0_NN4END[2] VPWR VGND sg13cmos5l_antennanp
X_030_ Tile_X0Y0_SS4BEG[12] Tile_X0Y0_NN4END[3] VPWR VGND sg13cmos5l_buf_1
XFILLER_8_608 VPWR VGND sg13cmos5l_decap_8
XFILLER_11_147 VPWR VGND sg13cmos5l_decap_8
XFILLER_4_869 VPWR VGND sg13cmos5l_decap_4
XFILLER_3_346 VPWR VGND sg13cmos5l_decap_8
XFILLER_8_56 VPWR VGND sg13cmos5l_decap_8
XANTENNA__134__A NPU_RDATA15 VPWR VGND sg13cmos5l_antennanp
XFILLER_10_180 VPWR VGND sg13cmos5l_decap_8
XFILLER_10_191 VPWR VGND sg13cmos5l_fill_1
X_159_ NPU_WDATA8 Tile_X0Y0_N4END[7] VPWR VGND sg13cmos5l_buf_1
XFILLER_7_685 VPWR VGND sg13cmos5l_decap_8
XFILLER_6_162 VPWR VGND sg13cmos5l_decap_8
XFILLER_2_390 VPWR VGND sg13cmos5l_decap_4
XANTENNA__044__A Tile_X1Y0_N4END[14] VPWR VGND sg13cmos5l_antennanp
XFILLER_0_338 VPWR VGND sg13cmos5l_fill_1
XANTENNA__219__A Tile_X1Y0_NN4END[7] VPWR VGND sg13cmos5l_antennanp
XFILLER_8_416 VPWR VGND sg13cmos5l_decap_8
X_013_ NPU_WDATA1 Tile_X0Y0_N4END[14] VPWR VGND sg13cmos5l_buf_1
XFILLER_4_655 VPWR VGND sg13cmos5l_decap_8
XFILLER_4_622 VPWR VGND sg13cmos5l_fill_2
XFILLER_4_611 VPWR VGND sg13cmos5l_decap_4
XFILLER_3_132 VPWR VGND sg13cmos5l_decap_8
XFILLER_0_883 VPWR VGND sg13cmos5l_decap_4
XFILLER_3_176 VPWR VGND sg13cmos5l_decap_8
XANTENNA__129__A Tile_X0Y0_FrameStrobe[15] VPWR VGND sg13cmos5l_antennanp
XANTENNA__151__X NPU_WE6 VPWR VGND sg13cmos5l_antennanp
XANTENNA__039__A Tile_X1Y0_N4END[9] VPWR VGND sg13cmos5l_antennanp
XANTENNA__061__X Tile_X1Y0_FrameData_O[15] VPWR VGND sg13cmos5l_antennanp
XFILLER_0_124 VPWR VGND sg13cmos5l_decap_8
XFILLER_0_168 VPWR VGND sg13cmos5l_decap_4
XFILLER_0_179 VPWR VGND sg13cmos5l_decap_8
XFILLER_9_769 VPWR VGND sg13cmos5l_decap_8
XFILLER_5_35 VPWR VGND sg13cmos5l_decap_8
XFILLER_4_496 VPWR VGND sg13cmos5l_fill_2
XFILLER_4_430 VPWR VGND sg13cmos5l_decap_8
XANTENNA__146__X Tile_X0Y0_S4BEG[12] VPWR VGND sg13cmos5l_antennanp
XANTENNA__056__X Tile_X1Y0_FrameData_O[10] VPWR VGND sg13cmos5l_antennanp
XFILLER_6_717 VPWR VGND sg13cmos5l_decap_8
XFILLER_10_757 VPWR VGND sg13cmos5l_decap_8
XFILLER_5_238 VPWR VGND sg13cmos5l_decap_8
XFILLER_9_577 VPWR VGND sg13cmos5l_decap_8
XANTENNA__142__A NPU_RDATA7 VPWR VGND sg13cmos5l_antennanp
XFILLER_4_282 VPWR VGND sg13cmos5l_decap_8
XANTENNA__052__A Tile_X0Y0_FrameData[6] VPWR VGND sg13cmos5l_antennanp
XFILLER_2_219 VPWR VGND sg13cmos5l_decap_4
XANTENNA__227__A Tile_X0Y0_UserCLK VPWR VGND sg13cmos5l_antennanp
XFILLER_10_510 VPWR VGND sg13cmos5l_fill_2
X_192_ Tile_X1Y0_S2BEGb[5] Tile_X1Y0_N2END[2] VPWR VGND sg13cmos5l_buf_1
XFILLER_9_0 VPWR VGND sg13cmos5l_fill_2
XFILLER_2_14 VPWR VGND sg13cmos5l_fill_2
XFILLER_2_58 VPWR VGND sg13cmos5l_fill_2
XFILLER_2_47 VPWR VGND sg13cmos5l_decap_8
XANTENNA__137__A NPU_RDATA12 VPWR VGND sg13cmos5l_antennanp
XFILLER_9_352 VPWR VGND sg13cmos5l_decap_8
XANTENNA__047__A Tile_X0Y0_FrameData[1] VPWR VGND sg13cmos5l_antennanp
XFILLER_11_329 VPWR VGND sg13cmos5l_decap_8
XFILLER_3_517 VPWR VGND sg13cmos5l_fill_1
XFILLER_2_7 VPWR VGND sg13cmos5l_decap_8
XFILLER_11_56 VPWR VGND sg13cmos5l_decap_8
X_175_ Tile_X1Y0_S1BEG[0] Tile_X1Y0_N1END[3] VPWR VGND sg13cmos5l_buf_1
XFILLER_7_823 VPWR VGND sg13cmos5l_decap_8
XFILLER_6_344 VPWR VGND sg13cmos5l_decap_8
XFILLER_6_300 VPWR VGND sg13cmos5l_fill_1
XANTENNA__154__X NPU_WE3 VPWR VGND sg13cmos5l_antennanp
XFILLER_9_182 VPWR VGND sg13cmos5l_decap_8
XFILLER_0_509 VPWR VGND sg13cmos5l_fill_1
XFILLER_3_90 VPWR VGND sg13cmos5l_decap_8
XFILLER_11_126 VPWR VGND sg13cmos5l_decap_8
XANTENNA__064__X Tile_X1Y0_FrameData_O[18] VPWR VGND sg13cmos5l_antennanp
XFILLER_7_119 VPWR VGND sg13cmos5l_decap_8
XFILLER_4_848 VPWR VGND sg13cmos5l_decap_8
XFILLER_4_837 VPWR VGND sg13cmos5l_fill_1
XFILLER_3_325 VPWR VGND sg13cmos5l_fill_2
X_227_ Tile_X1Y0_UserCLKo Tile_X0Y0_UserCLK VPWR VGND sg13cmos5l_buf_1
XFILLER_8_35 VPWR VGND sg13cmos5l_decap_8
XFILLER_11_693 VPWR VGND sg13cmos5l_decap_8
XFILLER_11_671 VPWR VGND sg13cmos5l_decap_4
X_089_ Tile_X1Y0_FrameStrobe_O[11] Tile_X1Y0_FrameStrobe[11] VPWR VGND sg13cmos5l_buf_1
X_158_ NPU_WDATA9 Tile_X0Y0_N4END[6] VPWR VGND sg13cmos5l_buf_1
XFILLER_7_664 VPWR VGND sg13cmos5l_decap_4
XFILLER_3_870 VPWR VGND sg13cmos5l_fill_1
XANTENNA__150__A Tile_X1Y0_N4END[0] VPWR VGND sg13cmos5l_antennanp
XANTENNA__149__X Tile_X0Y0_S4BEG[15] VPWR VGND sg13cmos5l_antennanp
XANTENNA__060__A Tile_X0Y0_FrameData[14] VPWR VGND sg13cmos5l_antennanp
XFILLER_0_306 VPWR VGND sg13cmos5l_decap_8
XFILLER_1_829 VPWR VGND sg13cmos5l_decap_8
XANTENNA__059__X Tile_X1Y0_FrameData_O[13] VPWR VGND sg13cmos5l_antennanp
X_012_ NPU_WDATA10 Tile_X0Y0_N4END[5] VPWR VGND sg13cmos5l_buf_1
XFILLER_4_634 VPWR VGND sg13cmos5l_decap_8
XFILLER_3_155 VPWR VGND sg13cmos5l_decap_8
XFILLER_3_111 VPWR VGND sg13cmos5l_decap_8
XFILLER_0_862 VPWR VGND sg13cmos5l_decap_8
XANTENNA__145__A NPU_RDATA4 VPWR VGND sg13cmos5l_antennanp
XANTENNA__055__A Tile_X0Y0_FrameData[9] VPWR VGND sg13cmos5l_antennanp
XFILLER_0_103 VPWR VGND sg13cmos5l_decap_8
XFILLER_9_748 VPWR VGND sg13cmos5l_decap_8
XFILLER_8_236 VPWR VGND sg13cmos5l_decap_8
XFILLER_8_203 VPWR VGND sg13cmos5l_decap_8
XFILLER_5_14 VPWR VGND sg13cmos5l_decap_8
XFILLER_4_475 VPWR VGND sg13cmos5l_decap_8
XFILLER_0_692 VPWR VGND sg13cmos5l_decap_8
XANTENNA__162__X NPU_WDATA5 VPWR VGND sg13cmos5l_antennanp
XFILLER_8_792 VPWR VGND sg13cmos5l_decap_8
XFILLER_6_729 VPWR VGND sg13cmos5l_fill_1
XFILLER_5_217 VPWR VGND sg13cmos5l_decap_8
XFILLER_10_736 VPWR VGND sg13cmos5l_decap_8
XANTENNA__072__X Tile_X1Y0_FrameData_O[26] VPWR VGND sg13cmos5l_antennanp
XFILLER_1_445 VPWR VGND sg13cmos5l_fill_1
XFILLER_9_523 VPWR VGND sg13cmos5l_decap_8
XFILLER_5_762 VPWR VGND sg13cmos5l_decap_8
XANTENNA__157__X NPU_WE0 VPWR VGND sg13cmos5l_antennanp
XANTENNA__067__X Tile_X1Y0_FrameData_O[21] VPWR VGND sg13cmos5l_antennanp
X_191_ Tile_X1Y0_S2BEGb[4] Tile_X1Y0_N2END[3] VPWR VGND sg13cmos5l_buf_1
XFILLER_6_526 VPWR VGND sg13cmos5l_decap_8
XFILLER_10_599 VPWR VGND sg13cmos5l_decap_8
XFILLER_2_754 VPWR VGND sg13cmos5l_decap_8
XFILLER_2_26 VPWR VGND sg13cmos5l_decap_8
XFILLER_1_286 VPWR VGND sg13cmos5l_fill_1
XANTENNA__153__A Tile_X1Y0_N4END[3] VPWR VGND sg13cmos5l_antennanp
XFILLER_5_592 VPWR VGND sg13cmos5l_decap_8
XFILLER_11_308 VPWR VGND sg13cmos5l_decap_8
XANTENNA__063__A Tile_X0Y0_FrameData[17] VPWR VGND sg13cmos5l_antennanp
XFILLER_11_35 VPWR VGND sg13cmos5l_decap_8
XFILLER_3_529 VPWR VGND sg13cmos5l_decap_8
XFILLER_7_802 VPWR VGND sg13cmos5l_decap_8
XFILLER_11_886 VPWR VGND sg13cmos5l_fill_2
XFILLER_11_875 VPWR VGND sg13cmos5l_decap_8
X_174_ NPU_WDATA22 Tile_X0Y0_NN4END[9] VPWR VGND sg13cmos5l_buf_1
XFILLER_7_879 VPWR VGND sg13cmos5l_decap_8
XFILLER_6_323 VPWR VGND sg13cmos5l_decap_8
XANTENNA__148__A NPU_RDATA1 VPWR VGND sg13cmos5l_antennanp
XANTENNA__170__X NPU_WDATA26 VPWR VGND sg13cmos5l_antennanp
XANTENNA__058__A Tile_X0Y0_FrameData[12] VPWR VGND sg13cmos5l_antennanp
XFILLER_11_105 VPWR VGND sg13cmos5l_decap_8
XANTENNA__080__X Tile_X1Y0_FrameStrobe_O[2] VPWR VGND sg13cmos5l_antennanp
XFILLER_4_816 VPWR VGND sg13cmos5l_decap_8
XFILLER_3_304 VPWR VGND sg13cmos5l_decap_8
X_226_ Tile_X1Y0_SS4BEG[15] Tile_X1Y0_NN4END[0] VPWR VGND sg13cmos5l_buf_1
X_157_ NPU_WE0 Tile_X1Y0_N4END[7] VPWR VGND sg13cmos5l_buf_1
XFILLER_8_14 VPWR VGND sg13cmos5l_decap_8
XFILLER_7_643 VPWR VGND sg13cmos5l_decap_8
XFILLER_11_650 VPWR VGND sg13cmos5l_decap_8
X_088_ Tile_X1Y0_FrameStrobe_O[10] Tile_X1Y0_FrameStrobe[10] VPWR VGND sg13cmos5l_buf_1
XFILLER_6_197 VPWR VGND sg13cmos5l_decap_8
XFILLER_2_370 VPWR VGND sg13cmos5l_fill_1
XANTENNA__165__X NPU_WDATA30 VPWR VGND sg13cmos5l_antennanp
XFILLER_1_808 VPWR VGND sg13cmos5l_decap_8
XANTENNA__075__X Tile_X1Y0_FrameData_O[29] VPWR VGND sg13cmos5l_antennanp
X_011_ NPU_WDATA11 Tile_X0Y0_N4END[4] VPWR VGND sg13cmos5l_buf_1
XFILLER_0_841 VPWR VGND sg13cmos5l_decap_8
XANTENNA__161__A Tile_X0Y0_N4END[9] VPWR VGND sg13cmos5l_antennanp
X_209_ Tile_X1Y0_S4BEG[14] NPU_RDATA17 VPWR VGND sg13cmos5l_buf_1
XFILLER_7_484 VPWR VGND sg13cmos5l_decap_8
XFILLER_11_491 VPWR VGND sg13cmos5l_fill_1
XFILLER_0_81 VPWR VGND sg13cmos5l_fill_2
XANTENNA__071__A Tile_X0Y0_FrameData[25] VPWR VGND sg13cmos5l_antennanp
XFILLER_1_649 VPWR VGND sg13cmos5l_fill_1
XFILLER_0_148 VPWR VGND sg13cmos5l_decap_8
XFILLER_9_727 VPWR VGND sg13cmos5l_decap_8
XFILLER_0_671 VPWR VGND sg13cmos5l_decap_8
XFILLER_4_498 VPWR VGND sg13cmos5l_fill_1
XFILLER_4_454 VPWR VGND sg13cmos5l_decap_8
XFILLER_10_7 VPWR VGND sg13cmos5l_decap_8
XANTENNA__156__A Tile_X1Y0_N4END[6] VPWR VGND sg13cmos5l_antennanp
XFILLER_8_771 VPWR VGND sg13cmos5l_decap_8
XFILLER_7_281 VPWR VGND sg13cmos5l_decap_8
XANTENNA__066__A Tile_X0Y0_FrameData[20] VPWR VGND sg13cmos5l_antennanp
XFILLER_10_715 VPWR VGND sg13cmos5l_decap_8
XFILLER_9_502 VPWR VGND sg13cmos5l_decap_4
XFILLER_5_741 VPWR VGND sg13cmos5l_decap_8
XFILLER_4_273 VPWR VGND sg13cmos5l_decap_4
XFILLER_4_240 VPWR VGND sg13cmos5l_fill_1
XANTENNA__173__X NPU_WDATA23 VPWR VGND sg13cmos5l_antennanp
XFILLER_6_80 VPWR VGND sg13cmos5l_decap_8
X_190_ Tile_X1Y0_S2BEGb[3] Tile_X1Y0_N2END[4] VPWR VGND sg13cmos5l_buf_1
XANTENNA__083__X Tile_X1Y0_FrameStrobe_O[5] VPWR VGND sg13cmos5l_antennanp
XFILLER_10_578 VPWR VGND sg13cmos5l_fill_2
XFILLER_6_505 VPWR VGND sg13cmos5l_decap_8
XFILLER_2_733 VPWR VGND sg13cmos5l_decap_8
XFILLER_2_799 VPWR VGND sg13cmos5l_decap_8
XFILLER_2_788 VPWR VGND sg13cmos5l_fill_1
XFILLER_9_321 VPWR VGND sg13cmos5l_decap_4
XFILLER_9_376 VPWR VGND sg13cmos5l_decap_8
XFILLER_5_571 VPWR VGND sg13cmos5l_decap_8
XANTENNA__168__X NPU_WDATA28 VPWR VGND sg13cmos5l_antennanp
XFILLER_3_508 VPWR VGND sg13cmos5l_fill_1
XFILLER_11_14 VPWR VGND sg13cmos5l_decap_8
XANTENNA__078__X Tile_X1Y0_FrameStrobe_O[0] VPWR VGND sg13cmos5l_antennanp
XFILLER_10_353 VPWR VGND sg13cmos5l_decap_8
X_173_ NPU_WDATA23 Tile_X0Y0_NN4END[8] VPWR VGND sg13cmos5l_buf_1
XFILLER_7_858 VPWR VGND sg13cmos5l_decap_8
XFILLER_11_854 VPWR VGND sg13cmos5l_decap_8
XFILLER_6_379 VPWR VGND sg13cmos5l_decap_8
XFILLER_2_563 VPWR VGND sg13cmos5l_fill_1
XFILLER_2_552 VPWR VGND sg13cmos5l_decap_8
XFILLER_2_585 VPWR VGND sg13cmos5l_decap_8
XANTENNA__164__A Tile_X0Y0_NN4END[0] VPWR VGND sg13cmos5l_antennanp
XANTENNA__074__A Tile_X0Y0_FrameData[28] VPWR VGND sg13cmos5l_antennanp
XFILLER_3_327 VPWR VGND sg13cmos5l_fill_1
X_087_ Tile_X1Y0_FrameStrobe_O[9] Tile_X1Y0_FrameStrobe[9] VPWR VGND sg13cmos5l_buf_1
X_225_ Tile_X1Y0_SS4BEG[14] Tile_X1Y0_NN4END[1] VPWR VGND sg13cmos5l_buf_1
X_156_ NPU_WE1 Tile_X1Y0_N4END[6] VPWR VGND sg13cmos5l_buf_1
XFILLER_7_699 VPWR VGND sg13cmos5l_decap_4
XFILLER_7_622 VPWR VGND sg13cmos5l_decap_8
XFILLER_6_176 VPWR VGND sg13cmos5l_decap_8
XFILLER_6_154 VPWR VGND sg13cmos5l_fill_2
XFILLER_6_143 VPWR VGND sg13cmos5l_decap_8
XFILLER_3_883 VPWR VGND sg13cmos5l_decap_4
XANTENNA__159__A Tile_X0Y0_N4END[7] VPWR VGND sg13cmos5l_antennanp
XANTENNA__181__X Tile_X1Y0_S2BEG[2] VPWR VGND sg13cmos5l_antennanp
XANTENNA__069__A Tile_X0Y0_FrameData[23] VPWR VGND sg13cmos5l_antennanp
XANTENNA__091__X Tile_X1Y0_FrameStrobe_O[13] VPWR VGND sg13cmos5l_antennanp
X_010_ NPU_WDATA12 Tile_X0Y0_N4END[3] VPWR VGND sg13cmos5l_buf_1
XFILLER_0_820 VPWR VGND sg13cmos5l_decap_8
XFILLER_4_669 VPWR VGND sg13cmos5l_decap_8
XFILLER_3_146 VPWR VGND sg13cmos5l_fill_2
X_208_ Tile_X1Y0_S4BEG[13] NPU_RDATA18 VPWR VGND sg13cmos5l_buf_1
X_139_ Tile_X0Y0_S4BEG[5] NPU_RDATA10 VPWR VGND sg13cmos5l_buf_1
XFILLER_7_463 VPWR VGND sg13cmos5l_decap_8
XANTENNA__176__X Tile_X1Y0_S1BEG[1] VPWR VGND sg13cmos5l_antennanp
XFILLER_0_60 VPWR VGND sg13cmos5l_decap_8
XFILLER_9_80 VPWR VGND sg13cmos5l_decap_8
XFILLER_0_138 VPWR VGND sg13cmos5l_decap_8
XANTENNA__086__X Tile_X1Y0_FrameStrobe_O[8] VPWR VGND sg13cmos5l_antennanp
XFILLER_9_706 VPWR VGND sg13cmos5l_decap_8
XFILLER_5_49 VPWR VGND sg13cmos5l_decap_8
XFILLER_4_444 VPWR VGND sg13cmos5l_decap_8
XFILLER_0_661 VPWR VGND sg13cmos5l_fill_1
XANTENNA__172__A Tile_X0Y0_NN4END[7] VPWR VGND sg13cmos5l_antennanp
XFILLER_8_750 VPWR VGND sg13cmos5l_decap_8
XANTENNA__082__A Tile_X1Y0_FrameStrobe[4] VPWR VGND sg13cmos5l_antennanp
XFILLER_9_514 VPWR VGND sg13cmos5l_decap_4
XFILLER_9_558 VPWR VGND sg13cmos5l_fill_1
XFILLER_9_569 VPWR VGND sg13cmos5l_decap_4
XFILLER_5_786 VPWR VGND sg13cmos5l_fill_2
XFILLER_5_720 VPWR VGND sg13cmos5l_decap_8
XFILLER_4_296 VPWR VGND sg13cmos5l_decap_4
XFILLER_4_252 VPWR VGND sg13cmos5l_decap_8
XFILLER_0_491 VPWR VGND sg13cmos5l_fill_1
XANTENNA__167__A Tile_X0Y0_NN4END[2] VPWR VGND sg13cmos5l_antennanp
XFILLER_8_580 VPWR VGND sg13cmos5l_decap_8
XANTENNA__077__A Tile_X0Y0_FrameData[31] VPWR VGND sg13cmos5l_antennanp
XFILLER_6_539 VPWR VGND sg13cmos5l_fill_2
XFILLER_2_778 VPWR VGND sg13cmos5l_decap_8
XFILLER_9_333 VPWR VGND sg13cmos5l_fill_2
XFILLER_9_366 VPWR VGND sg13cmos5l_decap_8
XANTENNA__184__X Tile_X1Y0_S2BEG[5] VPWR VGND sg13cmos5l_antennanp
XANTENNA__094__X Tile_X1Y0_FrameStrobe_O[16] VPWR VGND sg13cmos5l_antennanp
XFILLER_10_376 VPWR VGND sg13cmos5l_fill_2
X_172_ NPU_WDATA24 Tile_X0Y0_NN4END[7] VPWR VGND sg13cmos5l_buf_1
XFILLER_7_837 VPWR VGND sg13cmos5l_decap_8
XFILLER_6_358 VPWR VGND sg13cmos5l_decap_8
XFILLER_11_833 VPWR VGND sg13cmos5l_decap_8
XFILLER_7_0 VPWR VGND sg13cmos5l_fill_2
XFILLER_2_531 VPWR VGND sg13cmos5l_decap_8
XANTENNA__180__A Tile_X1Y0_N2MID[6] VPWR VGND sg13cmos5l_antennanp
XFILLER_9_196 VPWR VGND sg13cmos5l_decap_8
XFILLER_6_881 VPWR VGND sg13cmos5l_decap_8
XANTENNA__179__X Tile_X1Y0_S2BEG[0] VPWR VGND sg13cmos5l_antennanp
XANTENNA__090__A Tile_X1Y0_FrameStrobe[12] VPWR VGND sg13cmos5l_antennanp
XFILLER_0_7 VPWR VGND sg13cmos5l_fill_1
XFILLER_3_339 VPWR VGND sg13cmos5l_decap_8
XANTENNA__089__X Tile_X1Y0_FrameStrobe_O[11] VPWR VGND sg13cmos5l_antennanp
X_224_ Tile_X1Y0_SS4BEG[13] Tile_X1Y0_NN4END[2] VPWR VGND sg13cmos5l_buf_1
XFILLER_8_49 VPWR VGND sg13cmos5l_decap_8
XFILLER_10_140 VPWR VGND sg13cmos5l_decap_8
XFILLER_10_151 VPWR VGND sg13cmos5l_decap_8
XFILLER_10_173 VPWR VGND sg13cmos5l_decap_8
XFILLER_10_195 VPWR VGND sg13cmos5l_decap_8
X_086_ Tile_X1Y0_FrameStrobe_O[8] Tile_X1Y0_FrameStrobe[8] VPWR VGND sg13cmos5l_buf_1
X_155_ NPU_WE2 Tile_X1Y0_N4END[5] VPWR VGND sg13cmos5l_buf_1
XFILLER_7_678 VPWR VGND sg13cmos5l_decap_8
XFILLER_7_601 VPWR VGND sg13cmos5l_decap_8
XFILLER_6_122 VPWR VGND sg13cmos5l_decap_8
XFILLER_2_383 VPWR VGND sg13cmos5l_fill_2
XFILLER_2_350 VPWR VGND sg13cmos5l_fill_1
XANTENNA__175__A Tile_X1Y0_N1END[3] VPWR VGND sg13cmos5l_antennanp
XANTENNA__085__A Tile_X1Y0_FrameStrobe[7] VPWR VGND sg13cmos5l_antennanp
XFILLER_8_409 VPWR VGND sg13cmos5l_decap_8
XFILLER_4_648 VPWR VGND sg13cmos5l_decap_8
XFILLER_4_615 VPWR VGND sg13cmos5l_fill_1
XFILLER_4_604 VPWR VGND sg13cmos5l_decap_8
XFILLER_3_125 VPWR VGND sg13cmos5l_fill_2
XFILLER_0_876 VPWR VGND sg13cmos5l_decap_8
XFILLER_0_887 VPWR VGND sg13cmos5l_fill_1
XFILLER_3_169 VPWR VGND sg13cmos5l_decap_8
X_207_ Tile_X1Y0_S4BEG[12] NPU_RDATA19 VPWR VGND sg13cmos5l_buf_1
XFILLER_7_442 VPWR VGND sg13cmos5l_decap_8
X_069_ Tile_X1Y0_FrameData_O[23] Tile_X0Y0_FrameData[23] VPWR VGND sg13cmos5l_buf_1
X_138_ Tile_X0Y0_S4BEG[4] NPU_RDATA11 VPWR VGND sg13cmos5l_buf_1
XFILLER_3_681 VPWR VGND sg13cmos5l_decap_8
XFILLER_0_83 VPWR VGND sg13cmos5l_fill_1
XFILLER_0_94 VPWR VGND sg13cmos5l_decap_4
XANTENNA__192__X Tile_X1Y0_S2BEGb[5] VPWR VGND sg13cmos5l_antennanp
XFILLER_0_117 VPWR VGND sg13cmos5l_decap_8
XFILLER_5_28 VPWR VGND sg13cmos5l_decap_8
XFILLER_4_489 VPWR VGND sg13cmos5l_decap_8
XFILLER_4_423 VPWR VGND sg13cmos5l_decap_8
XFILLER_7_261 VPWR VGND sg13cmos5l_decap_8
XANTENNA__187__X Tile_X1Y0_S2BEGb[0] VPWR VGND sg13cmos5l_antennanp
XANTENNA__097__X Tile_X1Y0_FrameStrobe_O[19] VPWR VGND sg13cmos5l_antennanp
XANTENNA__183__A Tile_X1Y0_N2MID[3] VPWR VGND sg13cmos5l_antennanp
XANTENNA__093__A Tile_X1Y0_FrameStrobe[15] VPWR VGND sg13cmos5l_antennanp
XFILLER_10_536 VPWR VGND sg13cmos5l_fill_1
XFILLER_2_768 VPWR VGND sg13cmos5l_decap_4
XFILLER_9_345 VPWR VGND sg13cmos5l_decap_8
XANTENNA__178__A Tile_X1Y0_N1END[0] VPWR VGND sg13cmos5l_antennanp
XFILLER_11_49 VPWR VGND sg13cmos5l_decap_8
XANTENNA__088__A Tile_X1Y0_FrameStrobe[10] VPWR VGND sg13cmos5l_antennanp
XFILLER_11_812 VPWR VGND sg13cmos5l_decap_8
X_171_ NPU_WDATA25 Tile_X0Y0_NN4END[6] VPWR VGND sg13cmos5l_buf_1
XFILLER_7_816 VPWR VGND sg13cmos5l_decap_8
XFILLER_6_337 VPWR VGND sg13cmos5l_decap_8
XFILLER_9_175 VPWR VGND sg13cmos5l_decap_8
XFILLER_6_860 VPWR VGND sg13cmos5l_decap_8
XFILLER_5_392 VPWR VGND sg13cmos5l_decap_8
XFILLER_3_83 VPWR VGND sg13cmos5l_decap_8
XANTENNA__195__X Tile_X1Y0_S4BEG[0] VPWR VGND sg13cmos5l_antennanp
XFILLER_11_119 VPWR VGND sg13cmos5l_decap_8
XFILLER_3_318 VPWR VGND sg13cmos5l_decap_8
X_223_ Tile_X1Y0_SS4BEG[12] Tile_X1Y0_NN4END[3] VPWR VGND sg13cmos5l_buf_1
XFILLER_8_28 VPWR VGND sg13cmos5l_decap_8
XFILLER_6_101 VPWR VGND sg13cmos5l_decap_8
XFILLER_11_675 VPWR VGND sg13cmos5l_fill_1
XFILLER_11_664 VPWR VGND sg13cmos5l_decap_8
X_085_ Tile_X1Y0_FrameStrobe_O[7] Tile_X1Y0_FrameStrobe[7] VPWR VGND sg13cmos5l_buf_1
X_154_ NPU_WE3 Tile_X1Y0_N4END[4] VPWR VGND sg13cmos5l_buf_1
XFILLER_7_657 VPWR VGND sg13cmos5l_decap_8
XFILLER_3_863 VPWR VGND sg13cmos5l_decap_8
XFILLER_2_340 VPWR VGND sg13cmos5l_fill_2
XFILLER_11_686 VPWR VGND sg13cmos5l_decap_8
XANTENNA__191__A Tile_X1Y0_N2END[3] VPWR VGND sg13cmos5l_antennanp
XFILLER_4_627 VPWR VGND sg13cmos5l_decap_8
XFILLER_3_148 VPWR VGND sg13cmos5l_fill_1
XFILLER_3_104 VPWR VGND sg13cmos5l_decap_8
XFILLER_0_855 VPWR VGND sg13cmos5l_decap_8
X_206_ Tile_X1Y0_S4BEG[11] NPU_RDATA20 VPWR VGND sg13cmos5l_buf_1
X_137_ Tile_X0Y0_S4BEG[3] NPU_RDATA12 VPWR VGND sg13cmos5l_buf_1
XFILLER_7_421 VPWR VGND sg13cmos5l_decap_8
X_068_ Tile_X1Y0_FrameData_O[22] Tile_X0Y0_FrameData[22] VPWR VGND sg13cmos5l_buf_1
XFILLER_7_498 VPWR VGND sg13cmos5l_decap_8
XFILLER_3_660 VPWR VGND sg13cmos5l_decap_8
XFILLER_2_192 VPWR VGND sg13cmos5l_decap_8
XANTENNA__186__A Tile_X1Y0_N2MID[0] VPWR VGND sg13cmos5l_antennanp
XANTENNA__096__A Tile_X1Y0_FrameStrobe[18] VPWR VGND sg13cmos5l_antennanp
XFILLER_8_229 VPWR VGND sg13cmos5l_decap_8
XFILLER_4_468 VPWR VGND sg13cmos5l_decap_8
XFILLER_0_652 VPWR VGND sg13cmos5l_decap_8
XFILLER_0_685 VPWR VGND sg13cmos5l_decap_8
XFILLER_8_785 VPWR VGND sg13cmos5l_decap_8
XFILLER_7_295 VPWR VGND sg13cmos5l_decap_8
XFILLER_7_251 VPWR VGND sg13cmos5l_decap_4
XFILLER_11_280 VPWR VGND sg13cmos5l_decap_8
XFILLER_10_729 VPWR VGND sg13cmos5l_decap_8
XFILLER_1_438 VPWR VGND sg13cmos5l_decap_8
XFILLER_1_405 VPWR VGND sg13cmos5l_fill_2
XFILLER_5_755 VPWR VGND sg13cmos5l_decap_8
XFILLER_5_711 VPWR VGND sg13cmos5l_fill_1
XFILLER_4_221 VPWR VGND sg13cmos5l_decap_8
XFILLER_5_799 VPWR VGND sg13cmos5l_decap_8
XFILLER_5_788 VPWR VGND sg13cmos5l_fill_1
XFILLER_6_94 VPWR VGND sg13cmos5l_decap_8
XANTENNA__198__X Tile_X1Y0_S4BEG[3] VPWR VGND sg13cmos5l_antennanp
XFILLER_6_519 VPWR VGND sg13cmos5l_decap_8
XFILLER_2_747 VPWR VGND sg13cmos5l_decap_8
XFILLER_2_703 VPWR VGND sg13cmos5l_fill_2
XFILLER_2_19 VPWR VGND sg13cmos5l_decap_8
XFILLER_5_585 VPWR VGND sg13cmos5l_decap_8
XFILLER_5_541 VPWR VGND sg13cmos5l_decap_8
XANTENNA__194__A Tile_X1Y0_N2END[0] VPWR VGND sg13cmos5l_antennanp
XFILLER_9_880 VPWR VGND sg13cmos5l_decap_8
XFILLER_11_28 VPWR VGND sg13cmos5l_decap_8
XFILLER_10_301 VPWR VGND sg13cmos5l_fill_1
XFILLER_10_312 VPWR VGND sg13cmos5l_fill_2
X_170_ NPU_WDATA26 Tile_X0Y0_NN4END[5] VPWR VGND sg13cmos5l_buf_1
XFILLER_6_316 VPWR VGND sg13cmos5l_decap_8
XFILLER_11_868 VPWR VGND sg13cmos5l_decap_8
XFILLER_2_599 VPWR VGND sg13cmos5l_decap_4
XFILLER_9_143 VPWR VGND sg13cmos5l_decap_4
XFILLER_5_371 VPWR VGND sg13cmos5l_decap_8
XANTENNA__189__A Tile_X1Y0_N2END[5] VPWR VGND sg13cmos5l_antennanp
XFILLER_3_62 VPWR VGND sg13cmos5l_decap_8
XFILLER_4_809 VPWR VGND sg13cmos5l_decap_8
XANTENNA__099__A Tile_X0Y0_N2MID[6] VPWR VGND sg13cmos5l_antennanp
X_222_ Tile_X1Y0_SS4BEG[11] Tile_X1Y0_NN4END[4] VPWR VGND sg13cmos5l_buf_1
X_153_ NPU_WE4 Tile_X1Y0_N4END[3] VPWR VGND sg13cmos5l_buf_1
XFILLER_7_636 VPWR VGND sg13cmos5l_decap_8
XFILLER_11_643 VPWR VGND sg13cmos5l_decap_8
X_084_ Tile_X1Y0_FrameStrobe_O[6] Tile_X1Y0_FrameStrobe[6] VPWR VGND sg13cmos5l_buf_1
XFILLER_3_842 VPWR VGND sg13cmos5l_decap_8
XFILLER_2_385 VPWR VGND sg13cmos5l_fill_1
XFILLER_3_127 VPWR VGND sg13cmos5l_fill_1
XFILLER_0_834 VPWR VGND sg13cmos5l_decap_8
X_205_ Tile_X1Y0_S4BEG[10] NPU_RDATA21 VPWR VGND sg13cmos5l_buf_1
X_136_ Tile_X0Y0_S4BEG[2] NPU_RDATA13 VPWR VGND sg13cmos5l_buf_1
XFILLER_7_477 VPWR VGND sg13cmos5l_decap_8
XFILLER_7_400 VPWR VGND sg13cmos5l_decap_8
XFILLER_11_495 VPWR VGND sg13cmos5l_fill_1
XFILLER_11_484 VPWR VGND sg13cmos5l_decap_8
XFILLER_11_473 VPWR VGND sg13cmos5l_fill_1
XFILLER_11_451 VPWR VGND sg13cmos5l_decap_8
X_067_ Tile_X1Y0_FrameData_O[21] Tile_X0Y0_FrameData[21] VPWR VGND sg13cmos5l_buf_1
XFILLER_2_171 VPWR VGND sg13cmos5l_fill_1
XFILLER_2_160 VPWR VGND sg13cmos5l_decap_8
XFILLER_0_74 VPWR VGND sg13cmos5l_decap_8
XFILLER_9_94 VPWR VGND sg13cmos5l_decap_8
XFILLER_8_731 VPWR VGND sg13cmos5l_fill_2
XFILLER_8_764 VPWR VGND sg13cmos5l_decap_8
X_119_ Tile_X0Y0_FrameStrobe_O[5] Tile_X0Y0_FrameStrobe[5] VPWR VGND sg13cmos5l_buf_1
XFILLER_3_480 VPWR VGND sg13cmos5l_decap_8
XANTENNA__197__A NPU_RDATA29 VPWR VGND sg13cmos5l_antennanp
XFILLER_10_708 VPWR VGND sg13cmos5l_decap_8
XFILLER_9_506 VPWR VGND sg13cmos5l_fill_1
XFILLER_5_734 VPWR VGND sg13cmos5l_decap_8
XFILLER_4_266 VPWR VGND sg13cmos5l_decap_8
XFILLER_4_233 VPWR VGND sg13cmos5l_decap_8
XFILLER_4_200 VPWR VGND sg13cmos5l_decap_8
XFILLER_0_461 VPWR VGND sg13cmos5l_decap_4
XFILLER_0_483 VPWR VGND sg13cmos5l_fill_1
XFILLER_4_277 VPWR VGND sg13cmos5l_fill_1
XFILLER_8_594 VPWR VGND sg13cmos5l_decap_8
XFILLER_6_73 VPWR VGND sg13cmos5l_decap_8
XFILLER_9_314 VPWR VGND sg13cmos5l_decap_8
XFILLER_9_325 VPWR VGND sg13cmos5l_fill_1
XFILLER_5_564 VPWR VGND sg13cmos5l_decap_8
XFILLER_5_553 VPWR VGND sg13cmos5l_fill_1
XANTENNA__002__X NPU_WDATA2 VPWR VGND sg13cmos5l_antennanp
XFILLER_11_847 VPWR VGND sg13cmos5l_decap_8
XFILLER_2_545 VPWR VGND sg13cmos5l_decap_8
XFILLER_9_122 VPWR VGND sg13cmos5l_decap_8
XFILLER_10_880 VPWR VGND sg13cmos5l_decap_8
XFILLER_5_350 VPWR VGND sg13cmos5l_decap_8
XFILLER_3_41 VPWR VGND sg13cmos5l_decap_8
XFILLER_10_165 VPWR VGND sg13cmos5l_decap_4
XFILLER_10_187 VPWR VGND sg13cmos5l_decap_4
X_083_ Tile_X1Y0_FrameStrobe_O[5] Tile_X1Y0_FrameStrobe[5] VPWR VGND sg13cmos5l_buf_1
X_221_ Tile_X1Y0_SS4BEG[10] Tile_X1Y0_NN4END[5] VPWR VGND sg13cmos5l_buf_1
X_152_ NPU_WE5 Tile_X1Y0_N4END[2] VPWR VGND sg13cmos5l_buf_1
XFILLER_7_615 VPWR VGND sg13cmos5l_decap_8
XFILLER_6_136 VPWR VGND sg13cmos5l_decap_8
XFILLER_11_622 VPWR VGND sg13cmos5l_decap_8
XFILLER_6_169 VPWR VGND sg13cmos5l_decap_8
XFILLER_5_0 VPWR VGND sg13cmos5l_fill_2
XFILLER_3_887 VPWR VGND sg13cmos5l_fill_1
XFILLER_3_821 VPWR VGND sg13cmos5l_decap_8
XFILLER_0_813 VPWR VGND sg13cmos5l_decap_8
XFILLER_3_139 VPWR VGND sg13cmos5l_decap_8
X_204_ Tile_X1Y0_S4BEG[9] NPU_RDATA22 VPWR VGND sg13cmos5l_buf_1
XFILLER_11_430 VPWR VGND sg13cmos5l_decap_8
X_066_ Tile_X1Y0_FrameData_O[20] Tile_X0Y0_FrameData[20] VPWR VGND sg13cmos5l_buf_1
X_135_ Tile_X0Y0_S4BEG[1] NPU_RDATA14 VPWR VGND sg13cmos5l_buf_1
XFILLER_7_456 VPWR VGND sg13cmos5l_decap_8
XFILLER_3_695 VPWR VGND sg13cmos5l_fill_2
XANTENNA__100__X Tile_X0Y0_S2BEG[2] VPWR VGND sg13cmos5l_antennanp
XFILLER_0_53 VPWR VGND sg13cmos5l_decap_8
XFILLER_9_73 VPWR VGND sg13cmos5l_decap_8
XANTENNA__010__X NPU_WDATA12 VPWR VGND sg13cmos5l_antennanp
XFILLER_4_437 VPWR VGND sg13cmos5l_decap_8
XFILLER_4_404 VPWR VGND sg13cmos5l_fill_2
XFILLER_8_743 VPWR VGND sg13cmos5l_decap_8
XFILLER_8_710 VPWR VGND sg13cmos5l_decap_8
X_049_ Tile_X1Y0_FrameData_O[3] Tile_X0Y0_FrameData[3] VPWR VGND sg13cmos5l_buf_1
X_118_ Tile_X0Y0_FrameStrobe_O[4] Tile_X0Y0_FrameStrobe[4] VPWR VGND sg13cmos5l_buf_1
XFILLER_7_275 VPWR VGND sg13cmos5l_fill_2
XANTENNA__005__X NPU_WDATA17 VPWR VGND sg13cmos5l_antennanp
XFILLER_9_518 VPWR VGND sg13cmos5l_fill_2
XFILLER_5_779 VPWR VGND sg13cmos5l_decap_8
XFILLER_4_289 VPWR VGND sg13cmos5l_decap_8
XFILLER_4_245 VPWR VGND sg13cmos5l_decap_8
XFILLER_0_451 VPWR VGND sg13cmos5l_fill_2
XFILLER_8_573 VPWR VGND sg13cmos5l_decap_8
XFILLER_8_562 VPWR VGND sg13cmos5l_fill_2
XFILLER_6_52 VPWR VGND sg13cmos5l_decap_8
XANTENNA__001__A Tile_X0Y0_NN4END[11] VPWR VGND sg13cmos5l_antennanp
XFILLER_10_506 VPWR VGND sg13cmos5l_fill_1
XFILLER_1_248 VPWR VGND sg13cmos5l_decap_8
XFILLER_9_359 VPWR VGND sg13cmos5l_decap_8
XFILLER_5_532 VPWR VGND sg13cmos5l_decap_4
XFILLER_0_292 VPWR VGND sg13cmos5l_decap_8
XFILLER_9_860 VPWR VGND sg13cmos5l_fill_2
XFILLER_8_381 VPWR VGND sg13cmos5l_decap_8
XFILLER_10_325 VPWR VGND sg13cmos5l_fill_1
XFILLER_11_826 VPWR VGND sg13cmos5l_decap_8
XFILLER_2_524 VPWR VGND sg13cmos5l_decap_4
XFILLER_2_513 VPWR VGND sg13cmos5l_fill_1
XFILLER_9_101 VPWR VGND sg13cmos5l_decap_8
XFILLER_9_189 VPWR VGND sg13cmos5l_decap_8
XFILLER_6_874 VPWR VGND sg13cmos5l_decap_8
XANTENNA__103__X Tile_X0Y0_S2BEG[5] VPWR VGND sg13cmos5l_antennanp
XFILLER_3_97 VPWR VGND sg13cmos5l_decap_8
XFILLER_3_31 VPWR VGND sg13cmos5l_decap_8
XANTENNA__013__X NPU_WDATA1 VPWR VGND sg13cmos5l_antennanp
X_220_ Tile_X1Y0_SS4BEG[9] Tile_X1Y0_NN4END[6] VPWR VGND sg13cmos5l_buf_1
XFILLER_11_601 VPWR VGND sg13cmos5l_decap_8
XFILLER_10_133 VPWR VGND sg13cmos5l_decap_8
X_082_ Tile_X1Y0_FrameStrobe_O[4] Tile_X1Y0_FrameStrobe[4] VPWR VGND sg13cmos5l_buf_1
X_151_ NPU_WE6 Tile_X1Y0_N4END[1] VPWR VGND sg13cmos5l_buf_1
XFILLER_6_115 VPWR VGND sg13cmos5l_decap_8
XFILLER_3_800 VPWR VGND sg13cmos5l_decap_8
XFILLER_2_354 VPWR VGND sg13cmos5l_fill_2
XANTENNA__008__X NPU_WDATA14 VPWR VGND sg13cmos5l_antennanp
XFILLER_0_869 VPWR VGND sg13cmos5l_decap_8
XFILLER_3_118 VPWR VGND sg13cmos5l_decap_8
X_203_ Tile_X1Y0_S4BEG[8] NPU_RDATA23 VPWR VGND sg13cmos5l_buf_1
X_065_ Tile_X1Y0_FrameData_O[19] Tile_X0Y0_FrameData[19] VPWR VGND sg13cmos5l_buf_1
X_134_ Tile_X0Y0_S4BEG[0] NPU_RDATA15 VPWR VGND sg13cmos5l_buf_1
XFILLER_7_435 VPWR VGND sg13cmos5l_decap_8
XFILLER_3_674 VPWR VGND sg13cmos5l_decap_4
XFILLER_0_32 VPWR VGND sg13cmos5l_decap_8
XFILLER_0_87 VPWR VGND sg13cmos5l_decap_8
XFILLER_0_98 VPWR VGND sg13cmos5l_fill_2
XFILLER_9_52 VPWR VGND sg13cmos5l_decap_8
XANTENNA__004__A Tile_X0Y0_NN4END[13] VPWR VGND sg13cmos5l_antennanp
XFILLER_4_416 VPWR VGND sg13cmos5l_decap_8
XANTENNA__201__X Tile_X1Y0_S4BEG[6] VPWR VGND sg13cmos5l_antennanp
XFILLER_0_699 VPWR VGND sg13cmos5l_decap_8
XFILLER_8_799 VPWR VGND sg13cmos5l_decap_8
X_117_ Tile_X0Y0_FrameStrobe_O[3] Tile_X0Y0_FrameStrobe[3] VPWR VGND sg13cmos5l_buf_1
XFILLER_7_210 VPWR VGND sg13cmos5l_fill_1
XFILLER_11_294 VPWR VGND sg13cmos5l_decap_8
X_048_ Tile_X1Y0_FrameData_O[2] Tile_X0Y0_FrameData[2] VPWR VGND sg13cmos5l_buf_1
XANTENNA__111__X Tile_X0Y0_S2BEGb[5] VPWR VGND sg13cmos5l_antennanp
XANTENNA__021__X Tile_X0Y0_SS4BEG[3] VPWR VGND sg13cmos5l_antennanp
XFILLER_0_430 VPWR VGND sg13cmos5l_decap_8
XFILLER_5_769 VPWR VGND sg13cmos5l_decap_8
XANTENNA__106__X Tile_X0Y0_S2BEGb[0] VPWR VGND sg13cmos5l_antennanp
XFILLER_8_552 VPWR VGND sg13cmos5l_decap_4
XFILLER_6_31 VPWR VGND sg13cmos5l_decap_8
XANTENNA__016__X NPU_READ_BANK_SEL1 VPWR VGND sg13cmos5l_antennanp
XFILLER_9_338 VPWR VGND sg13cmos5l_decap_8
XFILLER_5_511 VPWR VGND sg13cmos5l_decap_8
XANTENNA__102__A Tile_X0Y0_N2MID[3] VPWR VGND sg13cmos5l_antennanp
XFILLER_0_271 VPWR VGND sg13cmos5l_decap_8
XFILLER_5_599 VPWR VGND sg13cmos5l_decap_8
XFILLER_1_794 VPWR VGND sg13cmos5l_decap_8
XFILLER_8_360 VPWR VGND sg13cmos5l_decap_8
XANTENNA__012__A Tile_X0Y0_N4END[5] VPWR VGND sg13cmos5l_antennanp
XFILLER_11_805 VPWR VGND sg13cmos5l_decap_8
XFILLER_7_809 VPWR VGND sg13cmos5l_decap_8
XFILLER_9_168 VPWR VGND sg13cmos5l_decap_8
XFILLER_6_853 VPWR VGND sg13cmos5l_decap_8
XFILLER_5_385 VPWR VGND sg13cmos5l_decap_8
XFILLER_3_76 VPWR VGND sg13cmos5l_decap_8
XANTENNA__007__A Tile_X0Y0_N4END[0] VPWR VGND sg13cmos5l_antennanp
XFILLER_10_112 VPWR VGND sg13cmos5l_decap_8
X_150_ NPU_WE7 Tile_X1Y0_N4END[0] VPWR VGND sg13cmos5l_buf_1
XFILLER_11_657 VPWR VGND sg13cmos5l_decap_8
XANTENNA__204__X Tile_X1Y0_S4BEG[9] VPWR VGND sg13cmos5l_antennanp
X_081_ Tile_X1Y0_FrameStrobe_O[3] Tile_X1Y0_FrameStrobe[3] VPWR VGND sg13cmos5l_buf_1
XFILLER_3_856 VPWR VGND sg13cmos5l_decap_8
XFILLER_2_311 VPWR VGND sg13cmos5l_decap_4
XFILLER_11_679 VPWR VGND sg13cmos5l_decap_8
XANTENNA__114__X Tile_X0Y0_FrameStrobe_O[0] VPWR VGND sg13cmos5l_antennanp
XFILLER_6_683 VPWR VGND sg13cmos5l_fill_2
XFILLER_5_193 VPWR VGND sg13cmos5l_decap_8
XANTENNA__024__X Tile_X0Y0_SS4BEG[6] VPWR VGND sg13cmos5l_antennanp
XFILLER_0_848 VPWR VGND sg13cmos5l_decap_8
XANTENNA__200__A NPU_RDATA26 VPWR VGND sg13cmos5l_antennanp
X_202_ Tile_X1Y0_S4BEG[7] NPU_RDATA24 VPWR VGND sg13cmos5l_buf_1
X_133_ Tile_X0Y0_FrameStrobe_O[19] Tile_X0Y0_FrameStrobe[19] VPWR VGND sg13cmos5l_buf_1
XFILLER_7_414 VPWR VGND sg13cmos5l_decap_8
XFILLER_11_465 VPWR VGND sg13cmos5l_fill_1
X_064_ Tile_X1Y0_FrameData_O[18] Tile_X0Y0_FrameData[18] VPWR VGND sg13cmos5l_buf_1
XFILLER_3_697 VPWR VGND sg13cmos5l_fill_1
XFILLER_3_653 VPWR VGND sg13cmos5l_decap_8
XANTENNA__110__A Tile_X0Y0_N2END[3] VPWR VGND sg13cmos5l_antennanp
XFILLER_0_11 VPWR VGND sg13cmos5l_decap_8
XFILLER_2_185 VPWR VGND sg13cmos5l_decap_8
XANTENNA__109__X Tile_X0Y0_S2BEGb[3] VPWR VGND sg13cmos5l_antennanp
XFILLER_9_31 VPWR VGND sg13cmos5l_decap_8
XFILLER_6_491 VPWR VGND sg13cmos5l_decap_8
XANTENNA__020__A Tile_X0Y0_NN4END[13] VPWR VGND sg13cmos5l_antennanp
XANTENNA__019__X Tile_X0Y0_SS4BEG[1] VPWR VGND sg13cmos5l_antennanp
XFILLER_0_623 VPWR VGND sg13cmos5l_fill_2
XFILLER_0_645 VPWR VGND sg13cmos5l_decap_4
XFILLER_0_678 VPWR VGND sg13cmos5l_decap_8
XANTENNA__105__A Tile_X0Y0_N2MID[0] VPWR VGND sg13cmos5l_antennanp
XFILLER_8_778 VPWR VGND sg13cmos5l_decap_8
X_116_ Tile_X0Y0_FrameStrobe_O[2] Tile_X0Y0_FrameStrobe[2] VPWR VGND sg13cmos5l_buf_1
XFILLER_7_288 VPWR VGND sg13cmos5l_decap_8
XFILLER_7_255 VPWR VGND sg13cmos5l_fill_2
XFILLER_7_244 VPWR VGND sg13cmos5l_decap_8
XFILLER_7_222 VPWR VGND sg13cmos5l_decap_8
XFILLER_11_273 VPWR VGND sg13cmos5l_decap_8
X_047_ Tile_X1Y0_FrameData_O[1] Tile_X0Y0_FrameData[1] VPWR VGND sg13cmos5l_buf_1
XFILLER_3_494 VPWR VGND sg13cmos5l_decap_8
XANTENNA__015__A Tile_X1Y0_NN4END[13] VPWR VGND sg13cmos5l_antennanp
XFILLER_5_748 VPWR VGND sg13cmos5l_decap_8
XFILLER_5_715 VPWR VGND sg13cmos5l_fill_2
XFILLER_5_704 VPWR VGND sg13cmos5l_decap_4
XFILLER_4_214 VPWR VGND sg13cmos5l_decap_8
XANTENNA__212__X Tile_X1Y0_SS4BEG[1] VPWR VGND sg13cmos5l_antennanp
XFILLER_8_520 VPWR VGND sg13cmos5l_decap_8
XFILLER_6_87 VPWR VGND sg13cmos5l_decap_8
XANTENNA__122__X Tile_X0Y0_FrameStrobe_O[8] VPWR VGND sg13cmos5l_antennanp
XFILLER_4_781 VPWR VGND sg13cmos5l_decap_8
XANTENNA__032__X Tile_X0Y0_SS4BEG[14] VPWR VGND sg13cmos5l_antennanp
XANTENNA__207__X Tile_X1Y0_S4BEG[12] VPWR VGND sg13cmos5l_antennanp
XFILLER_5_578 VPWR VGND sg13cmos5l_decap_8
XFILLER_0_261 VPWR VGND sg13cmos5l_decap_8
XFILLER_1_762 VPWR VGND sg13cmos5l_fill_2
XFILLER_1_751 VPWR VGND sg13cmos5l_decap_4
XANTENNA__117__X Tile_X0Y0_FrameStrobe_O[3] VPWR VGND sg13cmos5l_antennanp
XFILLER_9_862 VPWR VGND sg13cmos5l_fill_1
XFILLER_9_873 VPWR VGND sg13cmos5l_decap_8
XANTENNA__027__X Tile_X0Y0_SS4BEG[9] VPWR VGND sg13cmos5l_antennanp
XFILLER_10_305 VPWR VGND sg13cmos5l_decap_8
XFILLER_6_309 VPWR VGND sg13cmos5l_decap_8
XANTENNA__203__A NPU_RDATA23 VPWR VGND sg13cmos5l_antennanp
XFILLER_2_559 VPWR VGND sg13cmos5l_decap_4
XFILLER_9_136 VPWR VGND sg13cmos5l_decap_8
XANTENNA__113__A Tile_X0Y0_N2END[0] VPWR VGND sg13cmos5l_antennanp
XFILLER_6_832 VPWR VGND sg13cmos5l_decap_8
XFILLER_5_364 VPWR VGND sg13cmos5l_decap_8
XFILLER_5_342 VPWR VGND sg13cmos5l_decap_4
XFILLER_3_55 VPWR VGND sg13cmos5l_decap_8
XANTENNA__023__A Tile_X0Y0_NN4END[10] VPWR VGND sg13cmos5l_antennanp
X_080_ Tile_X1Y0_FrameStrobe_O[2] Tile_X1Y0_FrameStrobe[2] VPWR VGND sg13cmos5l_buf_1
XFILLER_7_629 VPWR VGND sg13cmos5l_decap_8
XFILLER_11_636 VPWR VGND sg13cmos5l_decap_8
XFILLER_3_835 VPWR VGND sg13cmos5l_decap_8
XFILLER_2_323 VPWR VGND sg13cmos5l_fill_1
XANTENNA__220__X Tile_X1Y0_SS4BEG[9] VPWR VGND sg13cmos5l_antennanp
XANTENNA__108__A Tile_X0Y0_N2END[5] VPWR VGND sg13cmos5l_antennanp
XFILLER_6_662 VPWR VGND sg13cmos5l_decap_8
XANTENNA__130__X Tile_X0Y0_FrameStrobe_O[16] VPWR VGND sg13cmos5l_antennanp
XFILLER_5_172 VPWR VGND sg13cmos5l_decap_8
XANTENNA__018__A Tile_X0Y0_NN4END[15] VPWR VGND sg13cmos5l_antennanp
XANTENNA__040__X NPU_ADDR5 VPWR VGND sg13cmos5l_antennanp
XFILLER_0_827 VPWR VGND sg13cmos5l_decap_8
XANTENNA__215__X Tile_X1Y0_SS4BEG[4] VPWR VGND sg13cmos5l_antennanp
X_063_ Tile_X1Y0_FrameData_O[17] Tile_X0Y0_FrameData[17] VPWR VGND sg13cmos5l_buf_1
X_201_ Tile_X1Y0_S4BEG[6] NPU_RDATA25 VPWR VGND sg13cmos5l_buf_1
X_132_ Tile_X0Y0_FrameStrobe_O[18] Tile_X0Y0_FrameStrobe[18] VPWR VGND sg13cmos5l_buf_1
XFILLER_11_499 VPWR VGND sg13cmos5l_decap_8
XFILLER_11_477 VPWR VGND sg13cmos5l_decap_8
XFILLER_11_444 VPWR VGND sg13cmos5l_decap_8
XFILLER_3_0 VPWR VGND sg13cmos5l_fill_2
XFILLER_2_153 VPWR VGND sg13cmos5l_decap_8
XFILLER_0_67 VPWR VGND sg13cmos5l_decap_8
XFILLER_9_87 VPWR VGND sg13cmos5l_decap_8
XANTENNA__125__X Tile_X0Y0_FrameStrobe_O[11] VPWR VGND sg13cmos5l_antennanp
XFILLER_6_470 VPWR VGND sg13cmos5l_decap_8
XANTENNA__035__X Tile_X0Y0_S1BEG[1] VPWR VGND sg13cmos5l_antennanp
XANTENNA__211__A Tile_X1Y0_NN4END[15] VPWR VGND sg13cmos5l_antennanp
XFILLER_8_757 VPWR VGND sg13cmos5l_decap_8
X_046_ Tile_X1Y0_FrameData_O[0] Tile_X0Y0_FrameData[0] VPWR VGND sg13cmos5l_buf_1
X_115_ Tile_X0Y0_FrameStrobe_O[1] Tile_X0Y0_FrameStrobe[1] VPWR VGND sg13cmos5l_buf_1
XFILLER_8_724 VPWR VGND sg13cmos5l_decap_8
XFILLER_11_252 VPWR VGND sg13cmos5l_decap_8
XANTENNA__121__A Tile_X0Y0_FrameStrobe[7] VPWR VGND sg13cmos5l_antennanp
XFILLER_3_473 VPWR VGND sg13cmos5l_decap_8
XANTENNA__031__A Tile_X0Y0_NN4END[2] VPWR VGND sg13cmos5l_antennanp
XANTENNA__206__A NPU_RDATA20 VPWR VGND sg13cmos5l_antennanp
XFILLER_5_727 VPWR VGND sg13cmos5l_decap_8
XFILLER_0_487 VPWR VGND sg13cmos5l_fill_1
XFILLER_0_498 VPWR VGND sg13cmos5l_fill_1
XFILLER_4_259 VPWR VGND sg13cmos5l_decap_8
XANTENNA__116__A Tile_X0Y0_FrameStrobe[2] VPWR VGND sg13cmos5l_antennanp
X_029_ Tile_X0Y0_SS4BEG[11] Tile_X0Y0_NN4END[4] VPWR VGND sg13cmos5l_buf_1
XFILLER_8_587 VPWR VGND sg13cmos5l_decap_8
XFILLER_6_66 VPWR VGND sg13cmos5l_decap_8
XFILLER_4_760 VPWR VGND sg13cmos5l_decap_8
XANTENNA__026__A Tile_X0Y0_NN4END[7] VPWR VGND sg13cmos5l_antennanp
XFILLER_2_719 VPWR VGND sg13cmos5l_fill_2
XFILLER_9_307 VPWR VGND sg13cmos5l_decap_8
XFILLER_9_329 VPWR VGND sg13cmos5l_decap_4
XANTENNA__223__X Tile_X1Y0_SS4BEG[12] VPWR VGND sg13cmos5l_antennanp
XFILLER_5_557 VPWR VGND sg13cmos5l_fill_2
XFILLER_0_240 VPWR VGND sg13cmos5l_decap_8
XFILLER_8_395 VPWR VGND sg13cmos5l_decap_8
XANTENNA__133__X Tile_X0Y0_FrameStrobe_O[19] VPWR VGND sg13cmos5l_antennanp
XFILLER_4_590 VPWR VGND sg13cmos5l_decap_8
.ends
