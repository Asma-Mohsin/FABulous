* NGSPICE file created from RegFile.ext - technology: ihp-sg13cmos5l

* Black-box entry subcircuit for sg13cmos5l_fill_2 abstract view
.subckt sg13cmos5l_fill_2 VDD VSS
.ends

* Black-box entry subcircuit for sg13cmos5l_decap_4 abstract view
.subckt sg13cmos5l_decap_4 VDD VSS
.ends

* Black-box entry subcircuit for sg13cmos5l_mux2_1 abstract view
.subckt sg13cmos5l_mux2_1 X A0 A1 S VDD VSS
.ends

* Black-box entry subcircuit for sg13cmos5l_o21ai_1 abstract view
.subckt sg13cmos5l_o21ai_1 Y A1 A2 B1 VDD VSS
.ends

* Black-box entry subcircuit for sg13cmos5l_dlhq_1 abstract view
.subckt sg13cmos5l_dlhq_1 Q D GATE VDD VSS
.ends

* Black-box entry subcircuit for sg13cmos5l_dfrbpq_1 abstract view
.subckt sg13cmos5l_dfrbpq_1 Q CLK D RESET_B VDD VSS
.ends

* Black-box entry subcircuit for sg13cmos5l_antennanp abstract view
.subckt sg13cmos5l_antennanp A VDD VSS
.ends

* Black-box entry subcircuit for sg13cmos5l_fill_1 abstract view
.subckt sg13cmos5l_fill_1 VDD VSS
.ends

* Black-box entry subcircuit for sg13cmos5l_buf_8 abstract view
.subckt sg13cmos5l_buf_8 X A VDD VSS
.ends

* Black-box entry subcircuit for sg13cmos5l_nand2_1 abstract view
.subckt sg13cmos5l_nand2_1 Y A B VDD VSS
.ends

* Black-box entry subcircuit for sg13cmos5l_buf_1 abstract view
.subckt sg13cmos5l_buf_1 X A VDD VSS
.ends

* Black-box entry subcircuit for sg13cmos5l_inv_1 abstract view
.subckt sg13cmos5l_inv_1 Y A VDD VSS
.ends

* Black-box entry subcircuit for sg13cmos5l_mux4_1 abstract view
.subckt sg13cmos5l_mux4_1 X A0 A1 A2 A3 S0 S1 VDD VSS
.ends

* Black-box entry subcircuit for sg13cmos5l_a21oi_1 abstract view
.subckt sg13cmos5l_a21oi_1 Y A1 A2 B1 VDD VSS
.ends

* Black-box entry subcircuit for sg13cmos5l_nor2b_1 abstract view
.subckt sg13cmos5l_nor2b_1 Y A B_N VDD VSS
.ends

* Black-box entry subcircuit for sg13cmos5l_tiehi abstract view
.subckt sg13cmos5l_tiehi L_HI VDD VSS
.ends

* Black-box entry subcircuit for sg13cmos5l_nand2b_1 abstract view
.subckt sg13cmos5l_nand2b_1 Y A_N B VDD VSS
.ends

* Black-box entry subcircuit for sg13cmos5l_decap_8 abstract view
.subckt sg13cmos5l_decap_8 VDD VSS
.ends

* Black-box entry subcircuit for sg13cmos5l_a22oi_1 abstract view
.subckt sg13cmos5l_a22oi_1 Y A1 A2 B1 B2 VDD VSS
.ends

* Black-box entry subcircuit for sg13cmos5l_a21o_1 abstract view
.subckt sg13cmos5l_a21o_1 X A1 A2 B1 VDD VSS
.ends

* Black-box entry subcircuit for sg13cmos5l_nor2_1 abstract view
.subckt sg13cmos5l_nor2_1 Y A B VDD VSS
.ends

* Black-box entry subcircuit for sg13cmos5l_a221oi_1 abstract view
.subckt sg13cmos5l_a221oi_1 Y A1 A2 B1 B2 C1 VDD VSS
.ends

* Black-box entry subcircuit for sg13cmos5l_nor3_1 abstract view
.subckt sg13cmos5l_nor3_1 Y A B C VDD VSS
.ends

* Black-box entry subcircuit for sg13cmos5l_nand3_1 abstract view
.subckt sg13cmos5l_nand3_1 Y A B C VDD VSS
.ends

* Black-box entry subcircuit for sg13cmos5l_and2_1 abstract view
.subckt sg13cmos5l_and2_1 X A B VDD VSS
.ends

* Black-box entry subcircuit for sg13cmos5l_or2_1 abstract view
.subckt sg13cmos5l_or2_1 X A B VDD VSS
.ends

* Black-box entry subcircuit for sg13cmos5l_or3_1 abstract view
.subckt sg13cmos5l_or3_1 X A B C VDD VSS
.ends

.subckt RegFile E1BEG[0] E1BEG[1] E1BEG[2] E1BEG[3] E1END[0] E1END[1] E1END[2] E1END[3]
+ E2BEG[0] E2BEG[1] E2BEG[2] E2BEG[3] E2BEG[4] E2BEG[5] E2BEG[6] E2BEG[7] E2BEGb[0]
+ E2BEGb[1] E2BEGb[2] E2BEGb[3] E2BEGb[4] E2BEGb[5] E2BEGb[6] E2BEGb[7] E2END[0] E2END[1]
+ E2END[2] E2END[3] E2END[4] E2END[5] E2END[6] E2END[7] E2MID[0] E2MID[1] E2MID[2]
+ E2MID[3] E2MID[4] E2MID[5] E2MID[6] E2MID[7] E6BEG[0] E6BEG[10] E6BEG[11] E6BEG[1]
+ E6BEG[2] E6BEG[3] E6BEG[4] E6BEG[5] E6BEG[6] E6BEG[7] E6BEG[8] E6BEG[9] E6END[0]
+ E6END[10] E6END[11] E6END[1] E6END[2] E6END[3] E6END[4] E6END[5] E6END[6] E6END[7]
+ E6END[8] E6END[9] EE4BEG[0] EE4BEG[10] EE4BEG[11] EE4BEG[12] EE4BEG[13] EE4BEG[14]
+ EE4BEG[15] EE4BEG[1] EE4BEG[2] EE4BEG[3] EE4BEG[4] EE4BEG[5] EE4BEG[6] EE4BEG[7]
+ EE4BEG[8] EE4BEG[9] EE4END[0] EE4END[10] EE4END[11] EE4END[12] EE4END[13] EE4END[14]
+ EE4END[15] EE4END[1] EE4END[2] EE4END[3] EE4END[4] EE4END[5] EE4END[6] EE4END[7]
+ EE4END[8] EE4END[9] FrameData[0] FrameData[10] FrameData[11] FrameData[12] FrameData[13]
+ FrameData[14] FrameData[15] FrameData[16] FrameData[17] FrameData[18] FrameData[19]
+ FrameData[1] FrameData[20] FrameData[21] FrameData[22] FrameData[23] FrameData[24]
+ FrameData[25] FrameData[26] FrameData[27] FrameData[28] FrameData[29] FrameData[2]
+ FrameData[30] FrameData[31] FrameData[3] FrameData[4] FrameData[5] FrameData[6]
+ FrameData[7] FrameData[8] FrameData[9] FrameData_O[0] FrameData_O[10] FrameData_O[11]
+ FrameData_O[12] FrameData_O[13] FrameData_O[14] FrameData_O[15] FrameData_O[16]
+ FrameData_O[17] FrameData_O[18] FrameData_O[19] FrameData_O[1] FrameData_O[20] FrameData_O[21]
+ FrameData_O[22] FrameData_O[23] FrameData_O[24] FrameData_O[25] FrameData_O[26]
+ FrameData_O[27] FrameData_O[28] FrameData_O[29] FrameData_O[2] FrameData_O[30] FrameData_O[31]
+ FrameData_O[3] FrameData_O[4] FrameData_O[5] FrameData_O[6] FrameData_O[7] FrameData_O[8]
+ FrameData_O[9] FrameStrobe[0] FrameStrobe[10] FrameStrobe[11] FrameStrobe[12] FrameStrobe[13]
+ FrameStrobe[14] FrameStrobe[15] FrameStrobe[16] FrameStrobe[17] FrameStrobe[18]
+ FrameStrobe[19] FrameStrobe[1] FrameStrobe[2] FrameStrobe[3] FrameStrobe[4] FrameStrobe[5]
+ FrameStrobe[6] FrameStrobe[7] FrameStrobe[8] FrameStrobe[9] FrameStrobe_O[0] FrameStrobe_O[10]
+ FrameStrobe_O[11] FrameStrobe_O[12] FrameStrobe_O[13] FrameStrobe_O[14] FrameStrobe_O[15]
+ FrameStrobe_O[16] FrameStrobe_O[17] FrameStrobe_O[18] FrameStrobe_O[19] FrameStrobe_O[1]
+ FrameStrobe_O[2] FrameStrobe_O[3] FrameStrobe_O[4] FrameStrobe_O[5] FrameStrobe_O[6]
+ FrameStrobe_O[7] FrameStrobe_O[8] FrameStrobe_O[9] N1BEG[0] N1BEG[1] N1BEG[2] N1BEG[3]
+ N1END[0] N1END[1] N1END[2] N1END[3] N2BEG[0] N2BEG[1] N2BEG[2] N2BEG[3] N2BEG[4]
+ N2BEG[5] N2BEG[6] N2BEG[7] N2BEGb[0] N2BEGb[1] N2BEGb[2] N2BEGb[3] N2BEGb[4] N2BEGb[5]
+ N2BEGb[6] N2BEGb[7] N2END[0] N2END[1] N2END[2] N2END[3] N2END[4] N2END[5] N2END[6]
+ N2END[7] N2MID[0] N2MID[1] N2MID[2] N2MID[3] N2MID[4] N2MID[5] N2MID[6] N2MID[7]
+ N4BEG[0] N4BEG[10] N4BEG[11] N4BEG[12] N4BEG[13] N4BEG[14] N4BEG[15] N4BEG[1] N4BEG[2]
+ N4BEG[3] N4BEG[4] N4BEG[5] N4BEG[6] N4BEG[7] N4BEG[8] N4BEG[9] N4END[0] N4END[10]
+ N4END[11] N4END[12] N4END[13] N4END[14] N4END[15] N4END[1] N4END[2] N4END[3] N4END[4]
+ N4END[5] N4END[6] N4END[7] N4END[8] N4END[9] NN4BEG[0] NN4BEG[10] NN4BEG[11] NN4BEG[12]
+ NN4BEG[13] NN4BEG[14] NN4BEG[15] NN4BEG[1] NN4BEG[2] NN4BEG[3] NN4BEG[4] NN4BEG[5]
+ NN4BEG[6] NN4BEG[7] NN4BEG[8] NN4BEG[9] NN4END[0] NN4END[10] NN4END[11] NN4END[12]
+ NN4END[13] NN4END[14] NN4END[15] NN4END[1] NN4END[2] NN4END[3] NN4END[4] NN4END[5]
+ NN4END[6] NN4END[7] NN4END[8] NN4END[9] S1BEG[0] S1BEG[1] S1BEG[2] S1BEG[3] S1END[0]
+ S1END[1] S1END[2] S1END[3] S2BEG[0] S2BEG[1] S2BEG[2] S2BEG[3] S2BEG[4] S2BEG[5]
+ S2BEG[6] S2BEG[7] S2BEGb[0] S2BEGb[1] S2BEGb[2] S2BEGb[3] S2BEGb[4] S2BEGb[5] S2BEGb[6]
+ S2BEGb[7] S2END[0] S2END[1] S2END[2] S2END[3] S2END[4] S2END[5] S2END[6] S2END[7]
+ S2MID[0] S2MID[1] S2MID[2] S2MID[3] S2MID[4] S2MID[5] S2MID[6] S2MID[7] S4BEG[0]
+ S4BEG[10] S4BEG[11] S4BEG[12] S4BEG[13] S4BEG[14] S4BEG[15] S4BEG[1] S4BEG[2] S4BEG[3]
+ S4BEG[4] S4BEG[5] S4BEG[6] S4BEG[7] S4BEG[8] S4BEG[9] S4END[0] S4END[10] S4END[11]
+ S4END[12] S4END[13] S4END[14] S4END[15] S4END[1] S4END[2] S4END[3] S4END[4] S4END[5]
+ S4END[6] S4END[7] S4END[8] S4END[9] SS4BEG[0] SS4BEG[10] SS4BEG[11] SS4BEG[12] SS4BEG[13]
+ SS4BEG[14] SS4BEG[15] SS4BEG[1] SS4BEG[2] SS4BEG[3] SS4BEG[4] SS4BEG[5] SS4BEG[6]
+ SS4BEG[7] SS4BEG[8] SS4BEG[9] SS4END[0] SS4END[10] SS4END[11] SS4END[12] SS4END[13]
+ SS4END[14] SS4END[15] SS4END[1] SS4END[2] SS4END[3] SS4END[4] SS4END[5] SS4END[6]
+ SS4END[7] SS4END[8] SS4END[9] UserCLK UserCLKo VGND VPWR W1BEG[0] W1BEG[1] W1BEG[2]
+ W1BEG[3] W1END[0] W1END[1] W1END[2] W1END[3] W2BEG[0] W2BEG[1] W2BEG[2] W2BEG[3]
+ W2BEG[4] W2BEG[5] W2BEG[6] W2BEG[7] W2BEGb[0] W2BEGb[1] W2BEGb[2] W2BEGb[3] W2BEGb[4]
+ W2BEGb[5] W2BEGb[6] W2BEGb[7] W2END[0] W2END[1] W2END[2] W2END[3] W2END[4] W2END[5]
+ W2END[6] W2END[7] W2MID[0] W2MID[1] W2MID[2] W2MID[3] W2MID[4] W2MID[5] W2MID[6]
+ W2MID[7] W6BEG[0] W6BEG[10] W6BEG[11] W6BEG[1] W6BEG[2] W6BEG[3] W6BEG[4] W6BEG[5]
+ W6BEG[6] W6BEG[7] W6BEG[8] W6BEG[9] W6END[0] W6END[10] W6END[11] W6END[1] W6END[2]
+ W6END[3] W6END[4] W6END[5] W6END[6] W6END[7] W6END[8] W6END[9] WW4BEG[0] WW4BEG[10]
+ WW4BEG[11] WW4BEG[12] WW4BEG[13] WW4BEG[14] WW4BEG[15] WW4BEG[1] WW4BEG[2] WW4BEG[3]
+ WW4BEG[4] WW4BEG[5] WW4BEG[6] WW4BEG[7] WW4BEG[8] WW4BEG[9] WW4END[0] WW4END[10]
+ WW4END[11] WW4END[12] WW4END[13] WW4END[14] WW4END[15] WW4END[1] WW4END[2] WW4END[3]
+ WW4END[4] WW4END[5] WW4END[6] WW4END[7] WW4END[8] WW4END[9]
XFILLER_27_439 VPWR VGND sg13cmos5l_fill_2
XFILLER_39_244 VPWR VGND sg13cmos5l_decap_4
XFILLER_54_258 VPWR VGND sg13cmos5l_fill_2
X_2037_ _2037_/X _2864_/Q _2860_/Q _2052_/A VPWR VGND sg13cmos5l_mux2_1
X_2106_ _2106_/Y _3395_/Q _2105_/Y _3135_/Q VPWR VGND sg13cmos5l_o21ai_1
X_3155_ _3155_/Q FrameData[9] FrameStrobe[7] VPWR VGND sg13cmos5l_dlhq_1
X_3086_ _3086_/Q FrameData[4] FrameStrobe[9] VPWR VGND sg13cmos5l_dlhq_1
XFILLER_50_497 VPWR VGND sg13cmos5l_fill_2
X_2939_ _2939_/Q clkload1/A _2939_/D _3467_/L_HI VPWR VGND sg13cmos5l_dfrbpq_1
XANTENNA__3573__X N4BEG[7] VPWR VGND sg13cmos5l_antennanp
XANTENNA__3748__X E1BEG[2] VPWR VGND sg13cmos5l_antennanp
XFILLER_26_96 VPWR VGND sg13cmos5l_fill_1
XFILLER_13_177 VPWR VGND sg13cmos5l_fill_2
XFILLER_9_159 VPWR VGND sg13cmos5l_fill_1
Xclkbuf_5_29__f_UserCLK_regs _2914_/CLK clkbuf_3_7_0_UserCLK_regs/X VPWR VGND sg13cmos5l_buf_8
XFILLER_5_354 VPWR VGND sg13cmos5l_fill_1
XFILLER_5_376 VPWR VGND sg13cmos5l_fill_1
XFILLER_36_225 VPWR VGND sg13cmos5l_fill_1
XFILLER_3_67 VPWR VGND sg13cmos5l_fill_2
XANTENNA__3658__X S2BEG[4] VPWR VGND sg13cmos5l_antennanp
X_1606_ _1606_/Y _1606_/A _1606_/B VPWR VGND sg13cmos5l_nand2_1
X_3773_ W6BEG[2] W6END[4] VPWR VGND sg13cmos5l_buf_1
X_2724_ _2886_/D _2886_/Q _2675_/X _2725_/S VPWR VGND sg13cmos5l_mux2_1
X_2655_ _2839_/A _2818_/A VPWR VGND sg13cmos5l_inv_1
X_1468_ _1468_/Y N2MID[2] VPWR VGND sg13cmos5l_inv_1
X_1537_ _1537_/Y _3553_/A VPWR VGND sg13cmos5l_inv_1
X_3207_ _3207_/Q FrameData[29] FrameStrobe[6] VPWR VGND sg13cmos5l_dlhq_1
X_2586_ _2587_/B W1END[2] _1912_/B _2058_/X _2029_/X _3336_/Q _3334_/Q VPWR VGND sg13cmos5l_mux4_1
XFILLER_42_228 VPWR VGND sg13cmos5l_fill_1
X_3138_ _3138_/Q FrameData[24] FrameStrobe[8] VPWR VGND sg13cmos5l_dlhq_1
X_3069_ _3069_/Q FrameData[19] FrameStrobe[10] VPWR VGND sg13cmos5l_dlhq_1
XANTENNA__3568__X N4BEG[2] VPWR VGND sg13cmos5l_antennanp
XFILLER_23_497 VPWR VGND sg13cmos5l_fill_2
XFILLER_2_313 VPWR VGND sg13cmos5l_fill_1
XFILLER_18_247 VPWR VGND sg13cmos5l_fill_2
X_2440_ _3749_/A _2620_/B _1963_/A _3552_/A _2292_/X _3024_/Q _3025_/Q VPWR VGND sg13cmos5l_mux4_1
X_2371_ _2371_/Y _3043_/Q _2370_/Y _3045_/Q VPWR VGND sg13cmos5l_a21oi_1
X_3756_ W2BEG[1] _3756_/A VPWR VGND sg13cmos5l_buf_1
X_3687_ EE4BEG[1] EE4END[5] VPWR VGND sg13cmos5l_buf_1
X_2707_ _2873_/D _2663_/X _2873_/Q _2709_/S VPWR VGND sg13cmos5l_mux2_1
X_2638_ _2638_/Y _3385_/Q _2637_/X _3116_/Q VPWR VGND sg13cmos5l_o21ai_1
X_2569_ _2575_/B _3110_/Q _2568_/X VPWR VGND sg13cmos5l_nor2b_1
XANTENNA__3761__X W2BEG[6] VPWR VGND sg13cmos5l_antennanp
XFILLER_2_121 VPWR VGND sg13cmos5l_fill_2
XFILLER_14_261 VPWR VGND sg13cmos5l_fill_2
X_1871_ _1873_/B N2END[3] SS4END[0] E2END[3] W2END[3] _3237_/Q _3236_/Q VPWR VGND
+ sg13cmos5l_mux4_1
X_1940_ _1941_/A _2426_/B _2139_/B _2087_/X _1980_/X _3266_/Q _3268_/Q VPWR VGND sg13cmos5l_mux4_1
X_3610_ FrameStrobe_O[12] FrameStrobe[12] VPWR VGND sg13cmos5l_buf_1
XANTENNA__3671__X S4BEG[1] VPWR VGND sg13cmos5l_antennanp
X_3541_ _3541_/L_HI VPWR VGND sg13cmos5l_tiehi
X_3472_ _3472_/L_HI VPWR VGND sg13cmos5l_tiehi
X_2423_ _2423_/X W6END[1] _2029_/X _2058_/X _2087_/X _3252_/Q _3250_/Q VPWR VGND sg13cmos5l_mux4_1
X_2285_ _2285_/Y S4END[3] _3316_/Q VPWR VGND sg13cmos5l_nand2b_1
X_2354_ _2354_/Y _3062_/Q _2350_/X _2353_/Y VPWR VGND sg13cmos5l_a21oi_1
X_3739_ E2BEG[1] _3739_/A VPWR VGND sg13cmos5l_buf_1
XANTENNA__3581__X N4BEG[15] VPWR VGND sg13cmos5l_antennanp
XANTENNA__3756__X W2BEG[1] VPWR VGND sg13cmos5l_antennanp
XFILLER_43_345 VPWR VGND sg13cmos5l_fill_2
XFILLER_3_485 VPWR VGND sg13cmos5l_fill_2
X_2070_ _2071_/B _2893_/Q _2116_/Y _2069_/Y VPWR VGND sg13cmos5l_a21oi_1
XFILLER_19_364 VPWR VGND sg13cmos5l_fill_1
XFILLER_19_386 VPWR VGND sg13cmos5l_decap_8
XFILLER_19_397 VPWR VGND sg13cmos5l_fill_1
X_2972_ _2972_/Q _2976_/CLK _2972_/D _3434_/L_HI VPWR VGND sg13cmos5l_dfrbpq_1
XANTENNA__3666__X S2BEGb[4] VPWR VGND sg13cmos5l_antennanp
X_1785_ _3408_/D _1785_/A VPWR VGND sg13cmos5l_inv_1
X_1854_ _1854_/X S1END[3] S2END[5] _3290_/Q VPWR VGND sg13cmos5l_mux2_1
X_1923_ _1923_/Y _2116_/Y _2891_/Q VPWR VGND sg13cmos5l_nor2b_1
X_3524_ _3524_/L_HI VPWR VGND sg13cmos5l_tiehi
X_3455_ _3455_/L_HI VPWR VGND sg13cmos5l_tiehi
X_3386_ _3386_/Q FrameData[16] FrameStrobe[0] VPWR VGND sg13cmos5l_dlhq_1
X_2406_ _3700_/A _2399_/Y _2403_/Y _2405_/Y VPWR VGND sg13cmos5l_a21oi_1
X_2199_ _3745_/A _2186_/Y _2189_/X _2191_/Y _2198_/Y VPWR VGND sg13cmos5l_a22oi_1
X_2268_ _2272_/A _3083_/Q _1894_/Y _2267_/Y VPWR VGND sg13cmos5l_a21oi_1
X_2337_ _2337_/Y _3069_/Q _1980_/X VPWR VGND sg13cmos5l_nor2b_1
XANTENNA__3576__X N4BEG[10] VPWR VGND sg13cmos5l_antennanp
XFILLER_0_422 VPWR VGND sg13cmos5l_fill_1
XFILLER_16_378 VPWR VGND sg13cmos5l_fill_2
XFILLER_31_348 VPWR VGND sg13cmos5l_decap_4
XANTENNA_5 E2MID[0] VPWR VGND sg13cmos5l_antennanp
X_1570_ _1571_/B N1END[2] N2END[6] _3358_/Q VPWR VGND sg13cmos5l_mux2_1
X_3240_ _3240_/Q FrameData[30] FrameStrobe[5] VPWR VGND sg13cmos5l_dlhq_1
XFILLER_54_429 VPWR VGND sg13cmos5l_fill_1
X_2053_ _2053_/Y _2956_/Q _2052_/A _2052_/Y VPWR VGND sg13cmos5l_a21oi_1
X_2122_ _2122_/Y _3344_/Q _1512_/Y _2121_/Y VPWR VGND sg13cmos5l_a21oi_1
X_3171_ _3171_/Q FrameData[25] FrameStrobe[7] VPWR VGND sg13cmos5l_dlhq_1
XFILLER_34_142 VPWR VGND sg13cmos5l_fill_2
X_2955_ _2955_/Q clkload7/A _2955_/D _3451_/L_HI VPWR VGND sg13cmos5l_dfrbpq_1
X_1768_ _1768_/X _2898_/Q _2894_/Q _2866_/Q _2862_/Q _2052_/A _2051_/A VPWR VGND sg13cmos5l_mux4_1
X_1837_ _1837_/X N1END[1] S1END[1] _3356_/Q VPWR VGND sg13cmos5l_mux2_1
X_1906_ _1906_/Y S1END[3] _3332_/Q VPWR VGND sg13cmos5l_nand2b_1
X_3507_ _3507_/L_HI VPWR VGND sg13cmos5l_tiehi
X_2886_ _2886_/Q _2922_/CLK _2886_/D _3520_/L_HI VPWR VGND sg13cmos5l_dfrbpq_1
X_1699_ _1699_/Y _3326_/Q _1697_/Y _1698_/Y VPWR VGND sg13cmos5l_o21ai_1
X_3438_ _3438_/L_HI VPWR VGND sg13cmos5l_tiehi
X_3369_ _3369_/Q FrameData[31] FrameStrobe[1] VPWR VGND sg13cmos5l_dlhq_1
XFILLER_45_407 VPWR VGND sg13cmos5l_fill_2
Xclkbuf_5_1__f_UserCLK_regs clkload0/A clkbuf_3_0_0_UserCLK_regs/X VPWR VGND sg13cmos5l_buf_8
XFILLER_40_123 VPWR VGND sg13cmos5l_fill_2
X_1622_ _1624_/B _1615_/X _1618_/X _1620_/Y VPWR VGND sg13cmos5l_a21o_1
X_2740_ _2897_/D _2663_/X _2897_/Q _2742_/S VPWR VGND sg13cmos5l_mux2_1
X_2671_ _2672_/C _2207_/B _3374_/Q _2670_/Y VPWR VGND sg13cmos5l_o21ai_1
X_1484_ _1484_/Y _3365_/Q VPWR VGND sg13cmos5l_inv_1
X_1553_ _1553_/X N1END[2] N2END[6] _3262_/Q VPWR VGND sg13cmos5l_mux2_1
X_3223_ _3223_/Q FrameData[13] FrameStrobe[5] VPWR VGND sg13cmos5l_dlhq_1
X_2036_ _2036_/X _2896_/Q _2892_/Q _2052_/A VPWR VGND sg13cmos5l_mux2_1
X_2105_ _2105_/Y EE4END[0] _3394_/Q _2104_/Y VPWR VGND sg13cmos5l_a21oi_1
X_3154_ _3154_/Q FrameData[8] FrameStrobe[7] VPWR VGND sg13cmos5l_dlhq_1
X_3085_ _3085_/Q FrameData[3] FrameStrobe[9] VPWR VGND sg13cmos5l_dlhq_1
X_2938_ _2938_/Q _2970_/CLK _2938_/D _3468_/L_HI VPWR VGND sg13cmos5l_dfrbpq_1
Xclkbuf_5_16__f_UserCLK_regs _3408_/CLK clkbuf_3_4_0_UserCLK_regs/X VPWR VGND sg13cmos5l_buf_8
X_2869_ _2869_/Q _3409_/CLK _2869_/D _3537_/L_HI VPWR VGND sg13cmos5l_dfrbpq_1
XFILLER_13_101 VPWR VGND sg13cmos5l_fill_2
XFILLER_26_495 VPWR VGND sg13cmos5l_fill_1
XANTENNA__3764__X W2BEGb[1] VPWR VGND sg13cmos5l_antennanp
XFILLER_41_498 VPWR VGND sg13cmos5l_fill_1
XFILLER_42_41 VPWR VGND sg13cmos5l_fill_1
XFILLER_32_498 VPWR VGND sg13cmos5l_fill_1
XFILLER_44_281 VPWR VGND sg13cmos5l_fill_1
X_3772_ W6BEG[1] W6END[3] VPWR VGND sg13cmos5l_buf_1
X_2723_ _2885_/D _2885_/Q _2663_/X _2725_/S VPWR VGND sg13cmos5l_mux2_1
XANTENNA__3674__X S4BEG[4] VPWR VGND sg13cmos5l_antennanp
X_1536_ _3553_/A _1521_/Y _1527_/Y _1535_/Y VPWR VGND sg13cmos5l_o21ai_1
X_1605_ _1606_/B N1END[2] E6END[0] N2END[4] S2END[4] _3352_/Q _3350_/Q VPWR VGND sg13cmos5l_mux4_1
X_2654_ _2818_/A _2646_/X _2647_/Y _2653_/Y _3115_/Q VPWR VGND sg13cmos5l_a22oi_1
X_2585_ _2585_/Y _2583_/Y _2584_/Y _3337_/Q VPWR VGND sg13cmos5l_a21oi_1
X_1467_ _1467_/Y _3032_/Q VPWR VGND sg13cmos5l_inv_1
X_3206_ _3206_/Q FrameData[28] FrameStrobe[6] VPWR VGND sg13cmos5l_dlhq_1
X_3137_ _3137_/Q FrameData[23] FrameStrobe[8] VPWR VGND sg13cmos5l_dlhq_1
XFILLER_27_237 VPWR VGND sg13cmos5l_fill_1
X_2019_ _2019_/Y _2116_/Y _2864_/Q VPWR VGND sg13cmos5l_nor2b_1
X_3068_ _3068_/Q FrameData[18] FrameStrobe[10] VPWR VGND sg13cmos5l_dlhq_1
XANTENNA__3584__X NN4BEG[2] VPWR VGND sg13cmos5l_antennanp
XANTENNA__3759__X W2BEG[4] VPWR VGND sg13cmos5l_antennanp
XFILLER_37_85 VPWR VGND sg13cmos5l_fill_1
XFILLER_14_498 VPWR VGND sg13cmos5l_fill_1
X_2370_ _2370_/Y _2370_/A VPWR VGND sg13cmos5l_inv_1
XANTENNA__3669__X S2BEGb[7] VPWR VGND sg13cmos5l_antennanp
XFILLER_17_292 VPWR VGND sg13cmos5l_fill_1
XFILLER_24_207 VPWR VGND sg13cmos5l_fill_1
X_3686_ EE4BEG[0] EE4END[4] VPWR VGND sg13cmos5l_buf_1
X_3755_ W2BEG[0] _3755_/A VPWR VGND sg13cmos5l_buf_1
X_2706_ _2872_/D _2660_/X _2872_/Q _2709_/S VPWR VGND sg13cmos5l_mux2_1
X_1519_ _1519_/Y _3256_/Q _2620_/B _1518_/Y VPWR VGND sg13cmos5l_a21oi_1
X_2637_ _2637_/X N4END[0] SS4END[0] _3384_/Q VPWR VGND sg13cmos5l_mux2_1
X_2568_ _2568_/X E2MID[6] W2MID[6] S2MID[6] _3554_/A _3155_/Q _3154_/Q VPWR VGND sg13cmos5l_mux4_1
X_2499_ _2500_/B _3010_/Q _2497_/X _2498_/Y VPWR VGND sg13cmos5l_a21oi_1
XANTENNA__3579__X N4BEG[13] VPWR VGND sg13cmos5l_antennanp
XFILLER_2_144 VPWR VGND sg13cmos5l_fill_1
XFILLER_14_295 VPWR VGND sg13cmos5l_fill_2
X_1870_ _1870_/Y _3397_/Q _1869_/X _3137_/Q VPWR VGND sg13cmos5l_o21ai_1
X_3540_ _3540_/L_HI VPWR VGND sg13cmos5l_tiehi
X_3471_ _3471_/L_HI VPWR VGND sg13cmos5l_tiehi
X_2422_ _3698_/A _2422_/A _2422_/B VPWR VGND sg13cmos5l_nor2_1
X_2353_ _2353_/Y _3062_/Q _2352_/Y _3064_/Q VPWR VGND sg13cmos5l_o21ai_1
XFILLER_37_321 VPWR VGND sg13cmos5l_fill_1
X_2284_ _2284_/Y _3315_/Q _2284_/B VPWR VGND sg13cmos5l_nand2b_1
XFILLER_20_265 VPWR VGND sg13cmos5l_fill_1
XFILLER_20_276 VPWR VGND sg13cmos5l_decap_8
X_1999_ _1999_/Y _1993_/Y _1994_/Y _1997_/Y _1998_/Y _2075_/A VPWR VGND sg13cmos5l_a221oi_1
X_3669_ S2BEGb[7] S2MID[7] VPWR VGND sg13cmos5l_buf_1
X_3738_ E2BEG[0] _3738_/A VPWR VGND sg13cmos5l_buf_1
XFILLER_43_368 VPWR VGND sg13cmos5l_fill_2
XFILLER_50_30 VPWR VGND sg13cmos5l_fill_1
XANTENNA__3772__X W6BEG[1] VPWR VGND sg13cmos5l_antennanp
XFILLER_34_346 VPWR VGND sg13cmos5l_fill_1
X_1922_ _2080_/A _1919_/Y _1920_/Y _1896_/Y VPWR VGND sg13cmos5l_a21o_1
X_2971_ _2971_/Q clkload1/A _2971_/D _3435_/L_HI VPWR VGND sg13cmos5l_dfrbpq_1
XANTENNA__3682__X S4BEG[12] VPWR VGND sg13cmos5l_antennanp
X_1784_ _1785_/A _2056_/A _1770_/X _1782_/X _1783_/Y VPWR VGND sg13cmos5l_a22oi_1
X_1853_ _1853_/Y _1853_/A VPWR VGND sg13cmos5l_inv_1
X_3523_ _3523_/L_HI VPWR VGND sg13cmos5l_tiehi
X_3454_ _3454_/L_HI VPWR VGND sg13cmos5l_tiehi
X_3385_ _3385_/Q FrameData[15] FrameStrobe[0] VPWR VGND sg13cmos5l_dlhq_1
X_2405_ _2405_/Y _3034_/Q _2405_/B VPWR VGND sg13cmos5l_nor2_1
X_2336_ _2340_/A _3069_/Q _1712_/Y _2335_/Y VPWR VGND sg13cmos5l_a21oi_1
X_2198_ _2198_/Y _3305_/Q _2198_/B VPWR VGND sg13cmos5l_nor2_1
X_2267_ _2267_/Y _3083_/Q _2237_/X _3082_/Q VPWR VGND sg13cmos5l_o21ai_1
XFILLER_52_154 VPWR VGND sg13cmos5l_fill_1
XANTENNA__3592__X NN4BEG[10] VPWR VGND sg13cmos5l_antennanp
XFILLER_29_53 VPWR VGND sg13cmos5l_fill_1
XFILLER_48_438 VPWR VGND sg13cmos5l_fill_1
XANTENNA__3767__X W2BEGb[4] VPWR VGND sg13cmos5l_antennanp
XFILLER_43_143 VPWR VGND sg13cmos5l_fill_1
XANTENNA_6 E2MID[0] VPWR VGND sg13cmos5l_antennanp
X_3170_ _3170_/Q FrameData[24] FrameStrobe[7] VPWR VGND sg13cmos5l_dlhq_1
XFILLER_47_493 VPWR VGND sg13cmos5l_fill_1
X_2052_ _2052_/Y _2052_/A _2960_/Q VPWR VGND sg13cmos5l_nor2b_1
X_2121_ _2121_/Y _3344_/Q _2139_/B VPWR VGND sg13cmos5l_nor2_1
XANTENNA__3677__X S4BEG[7] VPWR VGND sg13cmos5l_antennanp
XFILLER_22_316 VPWR VGND sg13cmos5l_fill_1
X_1905_ _1905_/X N2END[7] S2END[7] _3332_/Q VPWR VGND sg13cmos5l_mux2_1
Xclkbuf_5_24__f_UserCLK_regs _2922_/CLK clkbuf_3_6_0_UserCLK_regs/X VPWR VGND sg13cmos5l_buf_8
X_2954_ _2954_/Q _2986_/CLK _2954_/D _3452_/L_HI VPWR VGND sg13cmos5l_dfrbpq_1
X_2885_ _2885_/Q _2913_/CLK _2885_/D _3521_/L_HI VPWR VGND sg13cmos5l_dfrbpq_1
X_1698_ _1698_/Y _3326_/Q _1695_/X _1487_/Y VPWR VGND sg13cmos5l_a21oi_1
X_1767_ _1767_/Y _1793_/S _1767_/B _1767_/C VPWR VGND sg13cmos5l_nor3_1
X_1836_ _1836_/X N2END[5] S1END[3] _3356_/Q VPWR VGND sg13cmos5l_mux2_1
X_3506_ _3506_/L_HI VPWR VGND sg13cmos5l_tiehi
X_2319_ _2319_/X W6END[1] _2029_/X _2058_/X _2087_/X _3284_/Q _3282_/Q VPWR VGND sg13cmos5l_mux4_1
X_3437_ _3437_/L_HI VPWR VGND sg13cmos5l_tiehi
X_3368_ _3368_/Q FrameData[30] FrameStrobe[1] VPWR VGND sg13cmos5l_dlhq_1
X_3299_ _3299_/Q FrameData[25] FrameStrobe[3] VPWR VGND sg13cmos5l_dlhq_1
XANTENNA__3587__X NN4BEG[5] VPWR VGND sg13cmos5l_antennanp
XFILLER_13_327 VPWR VGND sg13cmos5l_fill_1
XFILLER_53_485 VPWR VGND sg13cmos5l_fill_1
XFILLER_31_32 VPWR VGND sg13cmos5l_fill_1
XFILLER_31_54 VPWR VGND sg13cmos5l_fill_1
XFILLER_8_320 VPWR VGND sg13cmos5l_fill_2
X_1552_ _1552_/X E2END[6] S1END[2] _3262_/Q VPWR VGND sg13cmos5l_mux2_1
X_1621_ _1766_/B _1615_/X _1618_/X _1620_/Y VPWR VGND sg13cmos5l_a21oi_1
X_2670_ _2670_/Y E6END[1] _3374_/Q _3375_/Q VPWR VGND sg13cmos5l_a21oi_1
X_1483_ _1483_/Y _3364_/Q VPWR VGND sg13cmos5l_inv_1
X_2104_ _2104_/Y _3394_/Q N4END[3] VPWR VGND sg13cmos5l_nor2b_1
X_3222_ _3222_/Q FrameData[12] FrameStrobe[5] VPWR VGND sg13cmos5l_dlhq_1
X_3153_ _3153_/Q FrameData[7] FrameStrobe[7] VPWR VGND sg13cmos5l_dlhq_1
XFILLER_54_205 VPWR VGND sg13cmos5l_fill_2
XFILLER_54_238 VPWR VGND sg13cmos5l_fill_2
X_2035_ _2035_/X _2904_/Q _2900_/Q _2052_/A VPWR VGND sg13cmos5l_mux2_1
X_3084_ _3084_/Q FrameData[2] FrameStrobe[9] VPWR VGND sg13cmos5l_dlhq_1
X_2937_ _2937_/Q clkload0/A _2937_/D _3469_/L_HI VPWR VGND sg13cmos5l_dfrbpq_1
X_2868_ _2868_/Q _3409_/CLK _2868_/D _3538_/L_HI VPWR VGND sg13cmos5l_dfrbpq_1
X_1819_ _1819_/Y _1816_/Y _1818_/Y _1484_/Y VPWR VGND sg13cmos5l_o21ai_1
X_2799_ _2941_/D _2663_/X _2941_/Q _2801_/S VPWR VGND sg13cmos5l_mux2_1
XFILLER_26_43 VPWR VGND sg13cmos5l_fill_2
XANTENNA__3780__X W6BEG[9] VPWR VGND sg13cmos5l_antennanp
XFILLER_3_47 VPWR VGND sg13cmos5l_fill_2
XFILLER_32_433 VPWR VGND sg13cmos5l_fill_2
XFILLER_32_444 VPWR VGND sg13cmos5l_fill_2
X_3771_ W6BEG[0] W6END[2] VPWR VGND sg13cmos5l_buf_1
X_2722_ _2884_/D _2884_/Q _2660_/X _2725_/S VPWR VGND sg13cmos5l_mux2_1
XANTENNA__3690__X EE4BEG[4] VPWR VGND sg13cmos5l_antennanp
X_1535_ _1535_/Y _3255_/Q _1528_/X _1534_/Y VPWR VGND sg13cmos5l_o21ai_1
X_1604_ _1604_/Y _1600_/Y _1602_/Y _1603_/Y VPWR VGND sg13cmos5l_o21ai_1
X_2653_ _2653_/Y _2649_/Y _2651_/Y _2652_/Y VPWR VGND sg13cmos5l_o21ai_1
X_2584_ _2584_/Y _3336_/Q _2580_/X _2579_/B VPWR VGND sg13cmos5l_a21oi_1
X_1466_ _1466_/Y S4END[1] VPWR VGND sg13cmos5l_inv_1
X_3205_ _3205_/Q FrameData[27] FrameStrobe[6] VPWR VGND sg13cmos5l_dlhq_1
X_3136_ _3136_/Q FrameData[22] FrameStrobe[8] VPWR VGND sg13cmos5l_dlhq_1
X_3067_ _3067_/Q FrameData[17] FrameStrobe[10] VPWR VGND sg13cmos5l_dlhq_1
XFILLER_23_433 VPWR VGND sg13cmos5l_fill_2
XFILLER_23_455 VPWR VGND sg13cmos5l_decap_4
XFILLER_35_293 VPWR VGND sg13cmos5l_fill_1
XFILLER_42_208 VPWR VGND sg13cmos5l_fill_1
X_2018_ _2027_/B _2077_/A _2011_/X _2014_/Y _2017_/Y _1973_/A VPWR VGND sg13cmos5l_a221oi_1
XFILLER_18_205 VPWR VGND sg13cmos5l_decap_4
XFILLER_37_31 VPWR VGND sg13cmos5l_fill_1
XANTENNA__3775__X W6BEG[4] VPWR VGND sg13cmos5l_antennanp
XFILLER_14_444 VPWR VGND sg13cmos5l_fill_2
XANTENNA__3685__X S4BEG[15] VPWR VGND sg13cmos5l_antennanp
X_3685_ S4BEG[15] _3685_/A VPWR VGND sg13cmos5l_buf_1
X_3754_ W1BEG[3] _3754_/A VPWR VGND sg13cmos5l_buf_1
X_2705_ _2709_/S _2705_/A _2855_/A VPWR VGND sg13cmos5l_nand2_1
X_2636_ _2636_/Y _3384_/Q _3757_/A _2635_/Y VPWR VGND sg13cmos5l_a21oi_1
X_1518_ _1518_/Y _3256_/Q _2426_/B VPWR VGND sg13cmos5l_nor2b_1
X_2567_ _2567_/Y _2563_/Y _2565_/Y _3111_/Q VPWR VGND sg13cmos5l_o21ai_1
X_2498_ _2498_/Y _3010_/Q _2496_/Y _3011_/Q VPWR VGND sg13cmos5l_o21ai_1
X_3119_ _3119_/Q FrameData[5] FrameStrobe[8] VPWR VGND sg13cmos5l_dlhq_1
XANTENNA__3595__X NN4BEG[13] VPWR VGND sg13cmos5l_antennanp
XFILLER_11_403 VPWR VGND sg13cmos5l_fill_2
XFILLER_23_252 VPWR VGND sg13cmos5l_fill_2
XFILLER_23_274 VPWR VGND sg13cmos5l_fill_2
XFILLER_14_263 VPWR VGND sg13cmos5l_fill_1
X_2283_ _2284_/B N2END[3] E1END[1] E6END[1] S2END[3] _3314_/Q _3316_/Q VPWR VGND sg13cmos5l_mux4_1
X_3470_ _3470_/L_HI VPWR VGND sg13cmos5l_tiehi
X_2421_ _2422_/B _3028_/Q _2421_/B VPWR VGND sg13cmos5l_nor2_1
X_2352_ _2352_/Y _3063_/Q _2238_/X _2351_/Y VPWR VGND sg13cmos5l_a21oi_1
X_1998_ _1998_/Y _2077_/A _1995_/X _2080_/A VPWR VGND sg13cmos5l_a21oi_1
X_3599_ FrameStrobe_O[1] FrameStrobe[1] VPWR VGND sg13cmos5l_buf_1
X_3668_ S2BEGb[6] S2MID[6] VPWR VGND sg13cmos5l_buf_1
X_3737_ E2BEGb[7] E2MID[7] VPWR VGND sg13cmos5l_buf_1
X_2619_ _2619_/X W1END[2] _1912_/B _2058_/X _2029_/X _3272_/Q _3270_/Q VPWR VGND sg13cmos5l_mux4_1
XFILLER_18_99 VPWR VGND sg13cmos5l_decap_8
XFILLER_11_277 VPWR VGND sg13cmos5l_fill_1
XFILLER_3_498 VPWR VGND sg13cmos5l_fill_1
X_1852_ _1853_/A N1END[1] N2END[5] EE4END[3] S1END[1] _3290_/Q _3292_/Q VPWR VGND
+ sg13cmos5l_mux4_1
X_1921_ _1973_/A _1919_/Y _1920_/Y _1896_/Y VPWR VGND sg13cmos5l_a21oi_1
X_2970_ _2970_/Q _2970_/CLK _2970_/D _3436_/L_HI VPWR VGND sg13cmos5l_dfrbpq_1
X_1783_ _1783_/Y _2056_/A _1783_/B VPWR VGND sg13cmos5l_nor2_1
X_3522_ _3522_/L_HI VPWR VGND sg13cmos5l_tiehi
X_3453_ _3453_/L_HI VPWR VGND sg13cmos5l_tiehi
X_2266_ _3796_/A _3087_/Q _2264_/Y _2265_/Y VPWR VGND sg13cmos5l_o21ai_1
X_3384_ _3384_/Q FrameData[14] FrameStrobe[0] VPWR VGND sg13cmos5l_dlhq_1
X_2404_ _2405_/B N1END[0] E1END[0] S1END[0] _1912_/B _3032_/Q _3033_/Q VPWR VGND sg13cmos5l_mux4_1
X_2335_ _2335_/Y _3069_/Q _1643_/A _3068_/Q VPWR VGND sg13cmos5l_o21ai_1
XFILLER_37_141 VPWR VGND sg13cmos5l_fill_2
X_2197_ _2198_/B _3302_/Q _2195_/Y _2196_/Y VPWR VGND sg13cmos5l_a21oi_1
XFILLER_4_229 VPWR VGND sg13cmos5l_fill_2
XFILLER_29_76 VPWR VGND sg13cmos5l_fill_1
XFILLER_28_196 VPWR VGND sg13cmos5l_decap_4
XANTENNA_7 E2MID[6] VPWR VGND sg13cmos5l_antennanp
XANTENNA__3783__X WW4BEG[0] VPWR VGND sg13cmos5l_antennanp
Xclkbuf_5_11__f_UserCLK_regs clkload8/A clkbuf_3_2_0_UserCLK_regs/X VPWR VGND sg13cmos5l_buf_8
XFILLER_20_6 VPWR VGND sg13cmos5l_fill_1
XFILLER_3_251 VPWR VGND sg13cmos5l_decap_8
X_2120_ _2120_/Y _3344_/Q _1912_/B _2119_/Y VPWR VGND sg13cmos5l_o21ai_1
XFILLER_19_185 VPWR VGND sg13cmos5l_fill_1
X_2051_ _2051_/Y _2051_/A _2051_/B VPWR VGND sg13cmos5l_nand2_1
XANTENNA__3693__X EE4BEG[7] VPWR VGND sg13cmos5l_antennanp
X_1835_ _1835_/X _1834_/X _1833_/X _1832_/X _1831_/X _3354_/Q _3355_/Q VPWR VGND sg13cmos5l_mux4_1
X_1904_ _1904_/Y _3331_/Q _1904_/B _1904_/C VPWR VGND sg13cmos5l_nand3_1
X_2953_ _2953_/Q clkload6/A _2953_/D _3453_/L_HI VPWR VGND sg13cmos5l_dfrbpq_1
X_2884_ _2884_/Q _2920_/CLK _2884_/D _3522_/L_HI VPWR VGND sg13cmos5l_dfrbpq_1
X_1697_ _1697_/Y _3328_/Q _1912_/B _1696_/Y VPWR VGND sg13cmos5l_a21oi_1
X_1766_ _1767_/C _1766_/A _1766_/B _1766_/C VPWR VGND sg13cmos5l_nor3_1
X_3505_ _3505_/L_HI VPWR VGND sg13cmos5l_tiehi
X_3436_ _3436_/L_HI VPWR VGND sg13cmos5l_tiehi
X_2249_ _2249_/Y _1464_/Y _2652_/B _3088_/Q VPWR VGND sg13cmos5l_o21ai_1
X_2318_ _2318_/Y _3285_/Q _2318_/B VPWR VGND sg13cmos5l_nand2b_1
X_3367_ _3367_/Q FrameData[29] FrameStrobe[1] VPWR VGND sg13cmos5l_dlhq_1
X_3298_ _3298_/Q FrameData[24] FrameStrobe[3] VPWR VGND sg13cmos5l_dlhq_1
XANTENNA__3778__X W6BEG[7] VPWR VGND sg13cmos5l_antennanp
XFILLER_16_166 VPWR VGND sg13cmos5l_decap_4
X_1482_ _1898_/B _3333_/Q VPWR VGND sg13cmos5l_inv_1
X_1551_ _1551_/Y _1549_/Y _1550_/X _3265_/Q VPWR VGND sg13cmos5l_o21ai_1
X_1620_ _1620_/Y _3130_/Q _1957_/B _3131_/Q VPWR VGND sg13cmos5l_o21ai_1
XFILLER_39_203 VPWR VGND sg13cmos5l_fill_2
X_2103_ _2103_/Y _3394_/Q _2101_/Y _2102_/Y VPWR VGND sg13cmos5l_a21oi_1
X_3221_ _3221_/Q FrameData[11] FrameStrobe[5] VPWR VGND sg13cmos5l_dlhq_1
X_3152_ _3152_/Q FrameData[6] FrameStrobe[7] VPWR VGND sg13cmos5l_dlhq_1
X_3083_ _3083_/Q FrameData[1] FrameStrobe[9] VPWR VGND sg13cmos5l_dlhq_1
XANTENNA__3688__X EE4BEG[2] VPWR VGND sg13cmos5l_antennanp
X_2034_ _2034_/X _2872_/Q _2868_/Q _2052_/A VPWR VGND sg13cmos5l_mux2_1
X_1818_ _1818_/Y _3362_/Q _1817_/X _3363_/Q VPWR VGND sg13cmos5l_o21ai_1
X_2936_ _2936_/Q clkload2/A _2936_/D _3470_/L_HI VPWR VGND sg13cmos5l_dfrbpq_1
X_2867_ _2867_/Q _2899_/CLK _2867_/D _3539_/L_HI VPWR VGND sg13cmos5l_dfrbpq_1
X_2798_ _2940_/D _2660_/X _2940_/Q _2801_/S VPWR VGND sg13cmos5l_mux2_1
X_1749_ _1749_/X _2953_/Q _2949_/Q _2985_/Q _2981_/Q _2052_/A _1623_/Y VPWR VGND sg13cmos5l_mux4_1
X_3419_ _3419_/L_HI VPWR VGND sg13cmos5l_tiehi
XANTENNA__3598__X FrameStrobe_O[0] VPWR VGND sg13cmos5l_antennanp
XFILLER_13_169 VPWR VGND sg13cmos5l_fill_2
XFILLER_9_118 VPWR VGND sg13cmos5l_fill_2
XFILLER_17_464 VPWR VGND sg13cmos5l_fill_1
XFILLER_44_272 VPWR VGND sg13cmos5l_decap_8
X_3770_ W2BEGb[7] W2MID[7] VPWR VGND sg13cmos5l_buf_1
X_2721_ _2725_/S _2850_/A _2726_/B VPWR VGND sg13cmos5l_and2_1
X_2652_ _2652_/Y _3114_/Q _2652_/B VPWR VGND sg13cmos5l_nand2b_1
X_1465_ _1465_/Y _3085_/Q VPWR VGND sg13cmos5l_inv_1
X_1534_ _1534_/Y _3257_/Q _1534_/B VPWR VGND sg13cmos5l_nor2_1
X_1603_ _1603_/Y _1606_/A _1598_/X _1499_/Y VPWR VGND sg13cmos5l_a21oi_1
X_3204_ _3204_/Q FrameData[26] FrameStrobe[6] VPWR VGND sg13cmos5l_dlhq_1
X_2583_ _2583_/Y _3336_/Q _2583_/B VPWR VGND sg13cmos5l_nand2b_1
XFILLER_27_217 VPWR VGND sg13cmos5l_fill_2
X_2017_ _2017_/Y _2071_/A _2016_/Y _2077_/A VPWR VGND sg13cmos5l_a21oi_1
X_3135_ _3135_/Q FrameData[21] FrameStrobe[8] VPWR VGND sg13cmos5l_dlhq_1
X_3066_ _3066_/Q FrameData[16] FrameStrobe[10] VPWR VGND sg13cmos5l_dlhq_1
X_2919_ _2919_/Q _2923_/CLK _2919_/D _3487_/L_HI VPWR VGND sg13cmos5l_dfrbpq_1
XFILLER_41_220 VPWR VGND sg13cmos5l_fill_2
XANTENNA__3791__X WW4BEG[8] VPWR VGND sg13cmos5l_antennanp
XFILLER_49_375 VPWR VGND sg13cmos5l_fill_2
XFILLER_17_283 VPWR VGND sg13cmos5l_decap_8
XFILLER_20_415 VPWR VGND sg13cmos5l_fill_2
XFILLER_9_493 VPWR VGND sg13cmos5l_fill_1
X_3684_ S4BEG[14] _3684_/A VPWR VGND sg13cmos5l_buf_1
X_3753_ W1BEG[2] _3753_/A VPWR VGND sg13cmos5l_buf_1
X_2704_ _2855_/A _2704_/A _2698_/A VPWR VGND sg13cmos5l_nor2b_1
X_2635_ _2635_/Y _3384_/Q W6END[0] VPWR VGND sg13cmos5l_nor2b_1
X_1517_ _1517_/Y _3256_/Q _1513_/Y _1516_/Y VPWR VGND sg13cmos5l_o21ai_1
X_2566_ _2566_/Y _3110_/Q _2566_/B VPWR VGND sg13cmos5l_nor2_1
X_2497_ _2497_/X _2646_/B _1668_/X _3009_/Q VPWR VGND sg13cmos5l_mux2_1
X_3118_ _3118_/Q FrameData[4] FrameStrobe[8] VPWR VGND sg13cmos5l_dlhq_1
X_3049_ _3049_/Q FrameData[31] FrameStrobe[11] VPWR VGND sg13cmos5l_dlhq_1
XFILLER_7_419 VPWR VGND sg13cmos5l_fill_2
XANTENNA__3786__X WW4BEG[3] VPWR VGND sg13cmos5l_antennanp
XFILLER_6_441 VPWR VGND sg13cmos5l_fill_1
X_2420_ _2421_/B N1END[2] S1END[2] E1END[2] _2426_/B _3027_/Q _3026_/Q VPWR VGND sg13cmos5l_mux4_1
X_2282_ _2282_/Y _1508_/Y _2281_/X _2280_/Y VPWR VGND sg13cmos5l_a21oi_1
X_2351_ _2351_/Y _3063_/Q _2087_/X VPWR VGND sg13cmos5l_nor2b_1
XFILLER_37_389 VPWR VGND sg13cmos5l_fill_2
XANTENNA__3696__X EE4BEG[10] VPWR VGND sg13cmos5l_antennanp
X_1997_ _1997_/Y _2083_/A _1997_/B VPWR VGND sg13cmos5l_nand2_1
X_3736_ E2BEGb[6] E2MID[6] VPWR VGND sg13cmos5l_buf_1
X_3598_ FrameStrobe_O[0] FrameStrobe[0] VPWR VGND sg13cmos5l_buf_1
X_3667_ S2BEGb[5] S2MID[5] VPWR VGND sg13cmos5l_buf_1
X_2618_ _2618_/Y _3271_/Q _2611_/X _2617_/Y VPWR VGND sg13cmos5l_o21ai_1
X_2549_ _2550_/A _2548_/X _2481_/A _2238_/X _2328_/X _3113_/Q _3112_/Q VPWR VGND sg13cmos5l_mux4_1
XFILLER_46_164 VPWR VGND sg13cmos5l_fill_2
X_1851_ _1877_/A _3137_/Q _1732_/X _1850_/Y VPWR VGND sg13cmos5l_o21ai_1
X_1920_ _1920_/Y _3139_/Q _1733_/X _3140_/Q VPWR VGND sg13cmos5l_a21oi_1
X_1782_ _1782_/X _1800_/A _1779_/X _1781_/X VPWR VGND sg13cmos5l_a21o_1
X_3521_ _3521_/L_HI VPWR VGND sg13cmos5l_tiehi
X_3452_ _3452_/L_HI VPWR VGND sg13cmos5l_tiehi
X_3383_ _3383_/Q FrameData[13] FrameStrobe[0] VPWR VGND sg13cmos5l_dlhq_1
X_2403_ _2403_/Y _2403_/A VPWR VGND sg13cmos5l_inv_1
X_2196_ _2196_/Y _3302_/Q _2193_/Y _3303_/Q VPWR VGND sg13cmos5l_o21ai_1
X_2265_ _2265_/Y _2259_/Y _2262_/Y _3087_/Q VPWR VGND sg13cmos5l_o21ai_1
X_2334_ _3717_/A _2332_/X _2333_/X _3073_/Q VPWR VGND sg13cmos5l_mux2_1
XFILLER_25_348 VPWR VGND sg13cmos5l_fill_2
X_3719_ E6BEG[1] E6END[3] VPWR VGND sg13cmos5l_buf_1
XFILLER_0_414 VPWR VGND sg13cmos5l_fill_2
XFILLER_28_131 VPWR VGND sg13cmos5l_fill_1
XANTENNA_8 E2MID[6] VPWR VGND sg13cmos5l_antennanp
X_2050_ _2051_/B _2924_/Q _2052_/A _2049_/Y VPWR VGND sg13cmos5l_a21oi_1
X_2952_ _2952_/Q clkload8/A _2952_/D _3454_/L_HI VPWR VGND sg13cmos5l_dfrbpq_1
XFILLER_30_362 VPWR VGND sg13cmos5l_fill_2
X_1765_ _1766_/C _2906_/Q _2902_/Q _2052_/A VPWR VGND sg13cmos5l_mux2_1
X_1834_ _1834_/X WW4END[3] _1912_/B _3356_/Q VPWR VGND sg13cmos5l_mux2_1
X_1903_ _1904_/C _3330_/Q _1900_/Y _1902_/Y VPWR VGND sg13cmos5l_o21ai_1
X_2883_ _2883_/Q _2915_/CLK _2883_/D _3523_/L_HI VPWR VGND sg13cmos5l_dfrbpq_1
X_1696_ _1696_/Y _3328_/Q W1END[2] VPWR VGND sg13cmos5l_nor2b_1
X_3504_ _3504_/L_HI VPWR VGND sg13cmos5l_tiehi
X_3435_ _3435_/L_HI VPWR VGND sg13cmos5l_tiehi
X_3366_ _3366_/Q FrameData[28] FrameStrobe[1] VPWR VGND sg13cmos5l_dlhq_1
X_2179_ _2179_/X N2END[2] N4END[2] EE4END[1] E6END[0] _3246_/Q _3248_/Q VPWR VGND
+ sg13cmos5l_mux4_1
X_2248_ _2652_/B N2END[4] SS4END[2] E2END[4] W2END[4] _3223_/Q _3222_/Q VPWR VGND
+ sg13cmos5l_mux4_1
X_2317_ _2317_/Y _3283_/Q _2317_/B VPWR VGND sg13cmos5l_nor2_1
X_3297_ _3297_/Q FrameData[23] FrameStrobe[3] VPWR VGND sg13cmos5l_dlhq_1
XFILLER_40_159 VPWR VGND sg13cmos5l_fill_2
XFILLER_53_498 VPWR VGND sg13cmos5l_fill_1
XFILLER_16_189 VPWR VGND sg13cmos5l_fill_2
XFILLER_44_498 VPWR VGND sg13cmos5l_fill_1
XANTENNA__3794__X WW4BEG[11] VPWR VGND sg13cmos5l_antennanp
XFILLER_8_322 VPWR VGND sg13cmos5l_fill_1
X_1481_ _1481_/Y _3266_/Q VPWR VGND sg13cmos5l_inv_1
X_1550_ _1550_/X _3262_/Q _1546_/X _1493_/Y VPWR VGND sg13cmos5l_a21o_1
X_3220_ _3220_/Q FrameData[10] FrameStrobe[5] VPWR VGND sg13cmos5l_dlhq_1
XFILLER_35_410 VPWR VGND sg13cmos5l_fill_1
XFILLER_39_248 VPWR VGND sg13cmos5l_fill_2
X_2033_ _2033_/Y _1800_/A _2030_/X _2032_/X VPWR VGND sg13cmos5l_a21oi_1
X_2102_ _2102_/Y _3394_/Q S4END[3] _3395_/Q VPWR VGND sg13cmos5l_o21ai_1
X_3151_ _3151_/Q FrameData[5] FrameStrobe[7] VPWR VGND sg13cmos5l_dlhq_1
X_3082_ _3082_/Q FrameData[0] FrameStrobe[9] VPWR VGND sg13cmos5l_dlhq_1
XFILLER_22_126 VPWR VGND sg13cmos5l_decap_8
XFILLER_35_498 VPWR VGND sg13cmos5l_fill_1
X_2935_ _2935_/Q clkload1/A _2935_/D _3471_/L_HI VPWR VGND sg13cmos5l_dfrbpq_1
XFILLER_30_170 VPWR VGND sg13cmos5l_fill_2
X_1748_ _1748_/Y _1794_/S _1747_/Y _1804_/S VPWR VGND sg13cmos5l_a21oi_1
X_1817_ _1817_/X E1END[3] S2END[7] _3364_/Q VPWR VGND sg13cmos5l_mux2_1
X_2866_ _2866_/Q _2866_/CLK _2866_/D _3540_/L_HI VPWR VGND sg13cmos5l_dfrbpq_1
X_2797_ _2801_/S _2840_/A _2812_/B VPWR VGND sg13cmos5l_nand2_1
X_1679_ _1679_/Y _1681_/A _1678_/X _1677_/Y VPWR VGND sg13cmos5l_o21ai_1
X_3418_ _3418_/L_HI VPWR VGND sg13cmos5l_tiehi
X_3349_ _3349_/Q FrameData[11] FrameStrobe[1] VPWR VGND sg13cmos5l_dlhq_1
XFILLER_45_218 VPWR VGND sg13cmos5l_fill_1
XANTENNA__3789__X WW4BEG[6] VPWR VGND sg13cmos5l_antennanp
XFILLER_36_218 VPWR VGND sg13cmos5l_decap_8
X_1602_ _1602_/Y _3350_/Q _1601_/X _3353_/Q VPWR VGND sg13cmos5l_o21ai_1
X_2720_ _2883_/D _2689_/Y _2883_/Q _2720_/S VPWR VGND sg13cmos5l_mux2_1
X_2651_ _2651_/Y _3383_/Q _2650_/X _3114_/Q VPWR VGND sg13cmos5l_o21ai_1
X_2582_ _2583_/B _1453_/Y _3334_/Q _2581_/Y VPWR VGND sg13cmos5l_o21ai_1
X_1464_ _1464_/Y _3089_/Q VPWR VGND sg13cmos5l_inv_1
X_1533_ _1534_/B _3254_/Q _1529_/X _1532_/Y VPWR VGND sg13cmos5l_a21oi_1
X_3203_ _3203_/Q FrameData[25] FrameStrobe[6] VPWR VGND sg13cmos5l_dlhq_1
XANTENNA__3699__X EE4BEG[13] VPWR VGND sg13cmos5l_antennanp
X_2016_ _2016_/Y _2916_/Q _2116_/Y _2015_/Y VPWR VGND sg13cmos5l_a21oi_1
X_3134_ _3134_/Q FrameData[20] FrameStrobe[8] VPWR VGND sg13cmos5l_dlhq_1
X_3065_ _3065_/Q FrameData[15] FrameStrobe[10] VPWR VGND sg13cmos5l_dlhq_1
XFILLER_23_435 VPWR VGND sg13cmos5l_fill_1
XFILLER_23_446 VPWR VGND sg13cmos5l_fill_2
X_2918_ _2918_/Q _2922_/CLK _2918_/D _3488_/L_HI VPWR VGND sg13cmos5l_dfrbpq_1
X_2849_ _2979_/D _2689_/Y _2979_/Q _2849_/S VPWR VGND sg13cmos5l_mux2_1
XFILLER_17_251 VPWR VGND sg13cmos5l_decap_4
X_3752_ W1BEG[1] _3752_/A VPWR VGND sg13cmos5l_buf_1
X_1516_ _1516_/Y _3256_/Q _1980_/X VPWR VGND sg13cmos5l_nand2_1
X_3683_ S4BEG[13] _3683_/A VPWR VGND sg13cmos5l_buf_1
X_2703_ _2871_/D _2871_/Q _2689_/Y _2703_/S VPWR VGND sg13cmos5l_mux2_1
X_2634_ _2817_/A _2633_/Y _2631_/Y _2629_/Y _2610_/Y _3119_/Q _3120_/Q VPWR VGND sg13cmos5l_mux4_1
X_2565_ _2565_/Y _3379_/Q _2564_/X _3110_/Q VPWR VGND sg13cmos5l_o21ai_1
X_3117_ _3117_/Q FrameData[3] FrameStrobe[8] VPWR VGND sg13cmos5l_dlhq_1
X_2496_ _2496_/Y _3009_/Q _2620_/B _2495_/Y VPWR VGND sg13cmos5l_o21ai_1
X_3048_ _3048_/Q FrameData[30] FrameStrobe[11] VPWR VGND sg13cmos5l_dlhq_1
XFILLER_11_427 VPWR VGND sg13cmos5l_fill_1
XFILLER_14_254 VPWR VGND sg13cmos5l_decap_4
XFILLER_6_497 VPWR VGND sg13cmos5l_fill_2
X_2281_ _2281_/X W6END[1] _2029_/X _2058_/X _2087_/X _3316_/Q _3314_/Q VPWR VGND sg13cmos5l_mux4_1
X_2350_ _2350_/X _2237_/X _1844_/X _3063_/Q VPWR VGND sg13cmos5l_mux2_1
XFILLER_9_291 VPWR VGND sg13cmos5l_fill_1
X_1996_ _1997_/B _2906_/Q _2902_/Q _2874_/Q _2870_/Q _2116_/Y _2014_/A VPWR VGND sg13cmos5l_mux4_1
X_3735_ E2BEGb[5] E2MID[5] VPWR VGND sg13cmos5l_buf_1
X_3597_ NN4BEG[15] _3597_/A VPWR VGND sg13cmos5l_buf_1
X_3666_ S2BEGb[4] S2MID[4] VPWR VGND sg13cmos5l_buf_1
X_2617_ _2617_/Y _2615_/Y _2616_/Y _3273_/Q VPWR VGND sg13cmos5l_a21oi_1
X_2548_ _2548_/X N2MID[2] E2MID[2] W2MID[2] _3742_/A _3156_/Q _3157_/Q VPWR VGND sg13cmos5l_mux4_1
X_2479_ _3597_/A _2479_/A _2479_/B VPWR VGND sg13cmos5l_nor2_1
XFILLER_11_202 VPWR VGND sg13cmos5l_fill_2
XFILLER_51_371 VPWR VGND sg13cmos5l_fill_1
Xclkload0 clkload0/Y clkload0/A VPWR VGND sg13cmos5l_inv_1
XANTENNA__3797__X WW4BEG[14] VPWR VGND sg13cmos5l_antennanp
XFILLER_19_357 VPWR VGND sg13cmos5l_decap_8
X_1781_ _1781_/X _1793_/S _1780_/X _1706_/Y VPWR VGND sg13cmos5l_a21o_1
X_1850_ _1850_/Y _3137_/Q _1849_/X _3138_/Q VPWR VGND sg13cmos5l_a21oi_1
X_3520_ _3520_/L_HI VPWR VGND sg13cmos5l_tiehi
X_3451_ _3451_/L_HI VPWR VGND sg13cmos5l_tiehi
X_3382_ _3382_/Q FrameData[12] FrameStrobe[0] VPWR VGND sg13cmos5l_dlhq_1
X_2402_ _2403_/A _3032_/Q _2401_/Y _3034_/Q VPWR VGND sg13cmos5l_o21ai_1
X_2333_ _2333_/X _2029_/X _1702_/X _1919_/B _2331_/X _3071_/Q _3072_/Q VPWR VGND sg13cmos5l_mux4_1
X_2195_ _2195_/Y _3304_/Q E2END[0] _2194_/Y VPWR VGND sg13cmos5l_o21ai_1
X_2264_ _2264_/Y _2264_/A VPWR VGND sg13cmos5l_inv_1
XFILLER_40_308 VPWR VGND sg13cmos5l_fill_1
XFILLER_40_319 VPWR VGND sg13cmos5l_fill_2
X_1979_ _3405_/D _1973_/Y _1978_/Y _1969_/X VPWR VGND sg13cmos5l_o21ai_1
X_3649_ FrameData_O[31] FrameData[31] VPWR VGND sg13cmos5l_buf_1
X_3718_ E6BEG[0] E6END[2] VPWR VGND sg13cmos5l_buf_1
XFILLER_28_154 VPWR VGND sg13cmos5l_decap_4
XFILLER_45_55 VPWR VGND sg13cmos5l_fill_1
XANTENNA_9 E2MID[6] VPWR VGND sg13cmos5l_antennanp
X_1902_ _1902_/Y _3330_/Q _1901_/X _1898_/B VPWR VGND sg13cmos5l_a21oi_1
X_2951_ _2951_/Q clkload7/A _2951_/D _3455_/L_HI VPWR VGND sg13cmos5l_dfrbpq_1
X_1764_ _1767_/B _2870_/Q _2052_/A _1624_/A _1624_/B _1763_/Y VPWR VGND sg13cmos5l_a221oi_1
X_1833_ _1833_/X _2058_/X _2087_/X _3356_/Q VPWR VGND sg13cmos5l_mux2_1
X_3503_ _3503_/L_HI VPWR VGND sg13cmos5l_tiehi
X_2882_ _2882_/Q _2914_/CLK _2882_/D _3524_/L_HI VPWR VGND sg13cmos5l_dfrbpq_1
X_1695_ _1695_/X _2058_/X _2029_/X _3328_/Q VPWR VGND sg13cmos5l_mux2_1
X_2316_ _2317_/B N1END[1] N2END[3] E6END[1] S2END[3] _3282_/Q _3284_/Q VPWR VGND sg13cmos5l_mux4_1
X_3434_ _3434_/L_HI VPWR VGND sg13cmos5l_tiehi
X_3365_ _3365_/Q FrameData[27] FrameStrobe[1] VPWR VGND sg13cmos5l_dlhq_1
X_3296_ _3296_/Q FrameData[22] FrameStrobe[3] VPWR VGND sg13cmos5l_dlhq_1
XFILLER_38_485 VPWR VGND sg13cmos5l_fill_1
X_2178_ _2178_/X _3246_/Q _2174_/Y _2177_/Y VPWR VGND sg13cmos5l_a21o_1
X_2247_ _3798_/A _2245_/X _2246_/X _3093_/Q VPWR VGND sg13cmos5l_mux2_1
XFILLER_13_319 VPWR VGND sg13cmos5l_fill_1
XFILLER_0_256 VPWR VGND sg13cmos5l_decap_8
XFILLER_16_113 VPWR VGND sg13cmos5l_decap_8
XFILLER_31_149 VPWR VGND sg13cmos5l_fill_1
XFILLER_8_367 VPWR VGND sg13cmos5l_fill_2
X_1480_ _1648_/S _3287_/Q VPWR VGND sg13cmos5l_inv_1
X_3150_ _3150_/Q FrameData[4] FrameStrobe[7] VPWR VGND sg13cmos5l_dlhq_1
XFILLER_11_4 VPWR VGND sg13cmos5l_fill_1
X_2032_ _2032_/X _1793_/S _2031_/X _1794_/S VPWR VGND sg13cmos5l_a21o_1
X_2101_ _2101_/Y _3554_/A VPWR VGND sg13cmos5l_inv_1
X_3081_ _3081_/Q FrameData[31] FrameStrobe[10] VPWR VGND sg13cmos5l_dlhq_1
XFILLER_50_458 VPWR VGND sg13cmos5l_fill_1
X_2934_ _2934_/Q _2970_/CLK _2934_/D _3472_/L_HI VPWR VGND sg13cmos5l_dfrbpq_1
X_2865_ _2865_/Q _2866_/CLK _2865_/D _3541_/L_HI VPWR VGND sg13cmos5l_dfrbpq_1
X_1678_ _1678_/X _2426_/B _2139_/B _2620_/B _1980_/X _3318_/Q _3320_/Q VPWR VGND sg13cmos5l_mux4_1
X_1747_ _1747_/Y _1744_/Y _1745_/Y _1746_/X _1793_/S VPWR VGND sg13cmos5l_a22oi_1
X_1816_ _1816_/Y _1816_/A _3362_/Q VPWR VGND sg13cmos5l_nor2b_1
X_2796_ _2812_/B _2839_/A _2796_/B VPWR VGND sg13cmos5l_nor2_1
X_3417_ _3417_/L_HI VPWR VGND sg13cmos5l_tiehi
X_3348_ _3348_/Q FrameData[10] FrameStrobe[1] VPWR VGND sg13cmos5l_dlhq_1
X_3279_ _3279_/Q FrameData[5] FrameStrobe[3] VPWR VGND sg13cmos5l_dlhq_1
XFILLER_29_293 VPWR VGND sg13cmos5l_fill_1
X_1532_ _1532_/Y _3254_/Q _1531_/Y _3255_/Q VPWR VGND sg13cmos5l_o21ai_1
X_1601_ _1601_/X _2426_/B _2620_/B _3352_/Q VPWR VGND sg13cmos5l_mux2_1
X_2650_ _2650_/X NN4END[1] EE4END[1] _3382_/Q VPWR VGND sg13cmos5l_mux2_1
X_2581_ _2581_/Y E2END[0] _3334_/Q VPWR VGND sg13cmos5l_nand2_1
X_1463_ _1463_/Y _3097_/Q VPWR VGND sg13cmos5l_inv_1
X_3202_ _3202_/Q FrameData[24] FrameStrobe[6] VPWR VGND sg13cmos5l_dlhq_1
X_3133_ _3133_/Q FrameData[19] FrameStrobe[8] VPWR VGND sg13cmos5l_dlhq_1
XFILLER_23_414 VPWR VGND sg13cmos5l_fill_1
XFILLER_27_219 VPWR VGND sg13cmos5l_fill_1
X_2015_ _2015_/Y _2116_/Y _2920_/Q VPWR VGND sg13cmos5l_nor2b_1
X_3064_ _3064_/Q FrameData[14] FrameStrobe[10] VPWR VGND sg13cmos5l_dlhq_1
XFILLER_31_480 VPWR VGND sg13cmos5l_fill_2
XFILLER_50_266 VPWR VGND sg13cmos5l_fill_1
X_2917_ _2917_/Q _2921_/CLK _2917_/D _3489_/L_HI VPWR VGND sg13cmos5l_dfrbpq_1
X_2848_ _2978_/D _2675_/X _2978_/Q _2849_/S VPWR VGND sg13cmos5l_mux2_1
X_2779_ _2926_/D _2675_/X _2926_/Q _2780_/S VPWR VGND sg13cmos5l_mux2_1
XFILLER_26_274 VPWR VGND sg13cmos5l_fill_1
XFILLER_41_222 VPWR VGND sg13cmos5l_fill_1
XFILLER_32_299 VPWR VGND sg13cmos5l_fill_1
X_3682_ S4BEG[12] _3682_/A VPWR VGND sg13cmos5l_buf_1
X_3751_ W1BEG[0] _3751_/A VPWR VGND sg13cmos5l_buf_1
X_2702_ _2870_/D _2870_/Q _2675_/X _2703_/S VPWR VGND sg13cmos5l_mux2_1
X_1515_ _1515_/X _3124_/Q _1515_/B VPWR VGND sg13cmos5l_or2_1
X_2633_ _2633_/Y N2END[0] _3118_/Q _2632_/Y VPWR VGND sg13cmos5l_o21ai_1
X_2564_ _2564_/X E2END[3] SS4END[3] _3378_/Q VPWR VGND sg13cmos5l_mux2_1
X_2495_ _2495_/Y _3009_/Q _2495_/B VPWR VGND sg13cmos5l_nand2_1
X_3116_ _3116_/Q FrameData[2] FrameStrobe[8] VPWR VGND sg13cmos5l_dlhq_1
X_3047_ _3047_/Q FrameData[29] FrameStrobe[11] VPWR VGND sg13cmos5l_dlhq_1
XFILLER_46_347 VPWR VGND sg13cmos5l_fill_1
XFILLER_37_347 VPWR VGND sg13cmos5l_fill_2
X_2280_ _2280_/Y _2276_/Y _2277_/Y _2279_/Y _3314_/Q _1508_/Y VPWR VGND sg13cmos5l_a221oi_1
X_1995_ _1995_/X _2898_/Q _2894_/Q _2866_/Q _2862_/Q _2116_/Y _2014_/A VPWR VGND sg13cmos5l_mux4_1
X_3665_ S2BEGb[3] S2MID[3] VPWR VGND sg13cmos5l_buf_1
X_3734_ E2BEGb[4] E2MID[4] VPWR VGND sg13cmos5l_buf_1
X_2616_ _2616_/Y _3272_/Q _2612_/X _1502_/Y VPWR VGND sg13cmos5l_a21oi_1
X_3596_ NN4BEG[14] _3596_/A VPWR VGND sg13cmos5l_buf_1
X_2547_ _3546_/A _2139_/B _3758_/A _2329_/X _2328_/X _2991_/Q _2990_/Q VPWR VGND sg13cmos5l_mux4_1
X_2478_ _2479_/B _2478_/A _2478_/B VPWR VGND sg13cmos5l_nor2_1
Xclkload1 clkload1/Y clkload1/A VPWR VGND sg13cmos5l_inv_1
X_1780_ _1780_/X _2930_/Q _2926_/Q _2962_/Q _2958_/Q _2052_/A _1623_/Y VPWR VGND sg13cmos5l_mux4_1
X_3450_ _3450_/L_HI VPWR VGND sg13cmos5l_tiehi
X_3381_ _3381_/Q FrameData[11] FrameStrobe[0] VPWR VGND sg13cmos5l_dlhq_1
X_2401_ _2401_/Y _3033_/Q _1849_/X _2400_/Y VPWR VGND sg13cmos5l_a21oi_1
X_2332_ _2332_/X N1END[1] E1END[1] W1END[1] _2058_/X _3071_/Q _3072_/Q VPWR VGND sg13cmos5l_mux4_1
X_2194_ _2194_/Y S2END[0] _3304_/Q VPWR VGND sg13cmos5l_nand2b_1
X_2263_ _2264_/A N1END[3] W1END[3] S1END[3] _2139_/B _3086_/Q _3085_/Q VPWR VGND sg13cmos5l_mux4_1
X_1978_ _1978_/Y _1976_/X _1977_/X _2075_/A VPWR VGND sg13cmos5l_o21ai_1
X_3579_ N4BEG[13] _3579_/A VPWR VGND sg13cmos5l_buf_1
X_3648_ FrameData_O[30] FrameData[30] VPWR VGND sg13cmos5l_buf_1
X_3717_ SS4BEG[15] _3717_/A VPWR VGND sg13cmos5l_buf_1
XFILLER_0_427 VPWR VGND sg13cmos5l_fill_2
XFILLER_29_35 VPWR VGND sg13cmos5l_fill_1
XFILLER_16_328 VPWR VGND sg13cmos5l_fill_1
XANTENNA__3601__X FrameStrobe_O[3] VPWR VGND sg13cmos5l_antennanp
X_1832_ _1832_/X _2426_/B _2620_/B _3356_/Q VPWR VGND sg13cmos5l_mux2_1
X_1901_ _1901_/X _2139_/B _1980_/X _3332_/Q VPWR VGND sg13cmos5l_mux2_1
X_2950_ _2950_/Q _2986_/CLK _2950_/D _3456_/L_HI VPWR VGND sg13cmos5l_dfrbpq_1
X_2881_ _2881_/Q _2913_/CLK _2881_/D _3525_/L_HI VPWR VGND sg13cmos5l_dfrbpq_1
XFILLER_30_386 VPWR VGND sg13cmos5l_fill_2
X_1694_ _1694_/X N1END[2] N2END[6] S1END[2] S2END[6] _3326_/Q _3328_/Q VPWR VGND sg13cmos5l_mux4_1
X_1763_ _1763_/Y _2052_/A _2874_/Q VPWR VGND sg13cmos5l_nor2b_1
X_3502_ _3502_/L_HI VPWR VGND sg13cmos5l_tiehi
X_3433_ _3433_/L_HI VPWR VGND sg13cmos5l_tiehi
XFILLER_32_0 VPWR VGND sg13cmos5l_fill_1
X_2246_ _2246_/X _2029_/X _1702_/X _1919_/B _2673_/B _3091_/Q _3092_/Q VPWR VGND sg13cmos5l_mux4_1
X_2315_ _2318_/B _3284_/Q _2312_/Y _2314_/Y VPWR VGND sg13cmos5l_o21ai_1
X_3364_ _3364_/Q FrameData[26] FrameStrobe[1] VPWR VGND sg13cmos5l_dlhq_1
X_3295_ _3295_/Q FrameData[21] FrameStrobe[3] VPWR VGND sg13cmos5l_dlhq_1
XFILLER_13_309 VPWR VGND sg13cmos5l_fill_2
XFILLER_38_453 VPWR VGND sg13cmos5l_fill_1
XFILLER_53_434 VPWR VGND sg13cmos5l_fill_2
X_2177_ _2177_/Y _3246_/Q _2176_/Y _3247_/Q VPWR VGND sg13cmos5l_o21ai_1
XFILLER_44_401 VPWR VGND sg13cmos5l_fill_1
XFILLER_48_217 VPWR VGND sg13cmos5l_fill_2
XFILLER_39_228 VPWR VGND sg13cmos5l_fill_1
XFILLER_39_239 VPWR VGND sg13cmos5l_fill_1
X_2100_ _3554_/A _2089_/Y _2091_/Y _2093_/Y _2099_/Y VPWR VGND sg13cmos5l_a22oi_1
X_3080_ _3080_/Q FrameData[30] FrameStrobe[10] VPWR VGND sg13cmos5l_dlhq_1
XFILLER_47_261 VPWR VGND sg13cmos5l_fill_1
X_2031_ _2031_/X _2880_/Q _2912_/Q _2876_/Q _2908_/Q _1623_/Y _2052_/A VPWR VGND sg13cmos5l_mux4_1
Xclkbuf_5_7__f_UserCLK_regs clkload5/A clkbuf_3_1_0_UserCLK_regs/X VPWR VGND sg13cmos5l_buf_8
X_1815_ _1816_/A E2END[7] W1END[3] _3364_/Q VPWR VGND sg13cmos5l_mux2_1
X_2933_ _2933_/Q clkload0/A _2933_/D _3473_/L_HI VPWR VGND sg13cmos5l_dfrbpq_1
X_2864_ _2864_/Q _2893_/CLK _2864_/D _3542_/L_HI VPWR VGND sg13cmos5l_dfrbpq_1
X_2795_ _2939_/D _2689_/Y _2939_/Q _2795_/S VPWR VGND sg13cmos5l_mux2_1
X_1677_ _1677_/Y _1676_/X _1681_/A VPWR VGND sg13cmos5l_nand2b_1
X_1746_ _1746_/X _2865_/Q _2897_/Q _2861_/Q _2893_/Q _1623_/Y _2052_/A VPWR VGND sg13cmos5l_mux4_1
X_3416_ _3416_/L_HI VPWR VGND sg13cmos5l_tiehi
X_2229_ _2229_/X _2029_/X _2620_/B _2087_/X _1980_/X _3099_/Q _3098_/Q VPWR VGND sg13cmos5l_mux4_1
X_3347_ _3347_/Q FrameData[9] FrameStrobe[1] VPWR VGND sg13cmos5l_dlhq_1
X_3278_ _3278_/Q FrameData[4] FrameStrobe[3] VPWR VGND sg13cmos5l_dlhq_1
XFILLER_26_445 VPWR VGND sg13cmos5l_decap_4
XFILLER_42_79 VPWR VGND sg13cmos5l_fill_1
XFILLER_5_305 VPWR VGND sg13cmos5l_fill_2
XFILLER_29_250 VPWR VGND sg13cmos5l_fill_2
XFILLER_8_176 VPWR VGND sg13cmos5l_fill_2
X_1462_ _1462_/Y _3094_/Q VPWR VGND sg13cmos5l_inv_1
X_1531_ _1531_/Y _3256_/Q W2END[4] _1530_/Y VPWR VGND sg13cmos5l_a21oi_1
X_1600_ _1600_/Y _1600_/A _3350_/Q VPWR VGND sg13cmos5l_nor2b_1
X_2580_ _2580_/X SS4END[0] W1END[0] _3334_/Q VPWR VGND sg13cmos5l_mux2_1
X_3201_ _3201_/Q FrameData[23] FrameStrobe[6] VPWR VGND sg13cmos5l_dlhq_1
X_3132_ _3132_/Q FrameData[18] FrameStrobe[8] VPWR VGND sg13cmos5l_dlhq_1
X_3063_ _3063_/Q FrameData[13] FrameStrobe[10] VPWR VGND sg13cmos5l_dlhq_1
XFILLER_23_448 VPWR VGND sg13cmos5l_fill_1
XFILLER_35_220 VPWR VGND sg13cmos5l_fill_2
XFILLER_50_201 VPWR VGND sg13cmos5l_fill_2
X_2014_ _2014_/Y _2014_/A _2014_/B VPWR VGND sg13cmos5l_nand2_1
Xclkbuf_3_4_0_UserCLK_regs clkbuf_3_4_0_UserCLK_regs/X clkbuf_0_UserCLK_regs/X VPWR
+ VGND sg13cmos5l_buf_8
X_2916_ _2916_/Q _2920_/CLK _2916_/D _3490_/L_HI VPWR VGND sg13cmos5l_dfrbpq_1
X_2847_ _2977_/D _2663_/X _2977_/Q _2849_/S VPWR VGND sg13cmos5l_mux2_1
X_2778_ _2925_/D _2663_/X _2925_/Q _2780_/S VPWR VGND sg13cmos5l_mux2_1
X_1729_ _1729_/Y _1726_/Y _1728_/Y _1474_/Y VPWR VGND sg13cmos5l_o21ai_1
XFILLER_37_46 VPWR VGND sg13cmos5l_fill_2
XFILLER_17_220 VPWR VGND sg13cmos5l_decap_4
XFILLER_32_245 VPWR VGND sg13cmos5l_fill_1
XFILLER_9_474 VPWR VGND sg13cmos5l_fill_1
X_3681_ S4BEG[11] S4END[15] VPWR VGND sg13cmos5l_buf_1
X_3750_ UserCLKo _3750_/A VPWR VGND sg13cmos5l_buf_1
X_2701_ _2869_/D _2869_/Q _2663_/X _2703_/S VPWR VGND sg13cmos5l_mux2_1
X_2632_ _2632_/Y S2END[0] _3118_/Q VPWR VGND sg13cmos5l_nand2b_1
X_1514_ _1515_/B N2END[7] EE4END[2] S2END[7] W2END[7] _3226_/Q _3227_/Q VPWR VGND
+ sg13cmos5l_mux4_1
X_2563_ _2563_/Y _3378_/Q _3552_/A _2562_/Y VPWR VGND sg13cmos5l_a21oi_1
X_2494_ _2500_/A _3011_/Q _2494_/B VPWR VGND sg13cmos5l_nor2_1
X_3115_ _3115_/Q FrameData[1] FrameStrobe[8] VPWR VGND sg13cmos5l_dlhq_1
X_3046_ _3046_/Q FrameData[28] FrameStrobe[11] VPWR VGND sg13cmos5l_dlhq_1
XFILLER_54_370 VPWR VGND sg13cmos5l_fill_1
XFILLER_10_440 VPWR VGND sg13cmos5l_fill_2
XFILLER_14_267 VPWR VGND sg13cmos5l_fill_2
XFILLER_6_422 VPWR VGND sg13cmos5l_fill_2
XANTENNA__3604__X FrameStrobe_O[6] VPWR VGND sg13cmos5l_antennanp
XFILLER_37_326 VPWR VGND sg13cmos5l_fill_2
X_1994_ _1994_/Y _2077_/A _1991_/X _1973_/A VPWR VGND sg13cmos5l_a21oi_1
X_3595_ NN4BEG[13] _3595_/A VPWR VGND sg13cmos5l_buf_1
X_3664_ S2BEGb[2] S2MID[2] VPWR VGND sg13cmos5l_buf_1
X_3733_ E2BEGb[3] E2MID[3] VPWR VGND sg13cmos5l_buf_1
X_2615_ _2615_/Y _3272_/Q _2615_/B VPWR VGND sg13cmos5l_nand2b_1
X_2546_ _3547_/A _1912_/B _1561_/X _3755_/A _1685_/X _2992_/Q _2993_/Q VPWR VGND sg13cmos5l_mux4_1
X_2477_ _2478_/B _3016_/Q _2476_/Y _3017_/Q VPWR VGND sg13cmos5l_o21ai_1
XFILLER_43_307 VPWR VGND sg13cmos5l_fill_1
X_3029_ _3029_/Q FrameData[11] FrameStrobe[11] VPWR VGND sg13cmos5l_dlhq_1
Xclkload2 clkload2/Y clkload2/A VPWR VGND sg13cmos5l_inv_1
XFILLER_19_304 VPWR VGND sg13cmos5l_fill_1
XFILLER_19_326 VPWR VGND sg13cmos5l_fill_2
X_2400_ _2400_/Y _3033_/Q _1980_/X VPWR VGND sg13cmos5l_nor2b_1
X_2262_ _2262_/Y _2262_/A _2262_/B VPWR VGND sg13cmos5l_nor2_1
X_3380_ _3380_/Q FrameData[10] FrameStrobe[0] VPWR VGND sg13cmos5l_dlhq_1
X_2331_ _2331_/X N2END[0] S2END[0] E2END[0] WW4END[3] _3217_/Q _3216_/Q VPWR VGND
+ sg13cmos5l_mux4_1
X_2193_ _2193_/Y _1453_/Y _3304_/Q _2192_/Y VPWR VGND sg13cmos5l_o21ai_1
X_1977_ _1977_/X _2077_/A _1974_/X _2080_/A VPWR VGND sg13cmos5l_a21o_1
X_3716_ SS4BEG[14] _3716_/A VPWR VGND sg13cmos5l_buf_1
XFILLER_0_406 VPWR VGND sg13cmos5l_fill_2
X_3578_ N4BEG[12] _3578_/A VPWR VGND sg13cmos5l_buf_1
X_3647_ FrameData_O[29] FrameData[29] VPWR VGND sg13cmos5l_buf_1
X_2529_ _3549_/A _2087_/X _1963_/A _3757_/A _2292_/X _2996_/Q _2997_/Q VPWR VGND sg13cmos5l_mux4_1
XFILLER_28_112 VPWR VGND sg13cmos5l_fill_2
XFILLER_29_69 VPWR VGND sg13cmos5l_fill_2
XFILLER_24_351 VPWR VGND sg13cmos5l_fill_1
XFILLER_47_432 VPWR VGND sg13cmos5l_fill_1
XFILLER_47_498 VPWR VGND sg13cmos5l_fill_1
XFILLER_30_332 VPWR VGND sg13cmos5l_fill_2
X_1831_ _1831_/X _2139_/B _1980_/X _3356_/Q VPWR VGND sg13cmos5l_mux2_1
X_1900_ _1900_/Y _3332_/Q _2087_/X _1899_/Y VPWR VGND sg13cmos5l_a21oi_1
X_2880_ _2880_/Q _2912_/CLK _2880_/D _3526_/L_HI VPWR VGND sg13cmos5l_dfrbpq_1
X_1693_ _1693_/Y _3329_/Q _1687_/X _1692_/Y VPWR VGND sg13cmos5l_o21ai_1
X_1762_ _1762_/X _1760_/X _1761_/X _1793_/S VPWR VGND sg13cmos5l_mux2_1
X_3501_ _3501_/L_HI VPWR VGND sg13cmos5l_tiehi
X_3432_ _3432_/L_HI VPWR VGND sg13cmos5l_tiehi
X_3363_ _3363_/Q FrameData[25] FrameStrobe[1] VPWR VGND sg13cmos5l_dlhq_1
X_2176_ _2176_/Y _1453_/Y _3248_/Q _2175_/Y VPWR VGND sg13cmos5l_o21ai_1
X_2245_ _2245_/X N1END[1] S1END[1] W1END[1] _2058_/X _3091_/Q _3092_/Q VPWR VGND sg13cmos5l_mux4_1
X_2314_ _2314_/Y _3284_/Q _2313_/X _1476_/Y VPWR VGND sg13cmos5l_a21oi_1
X_3294_ _3294_/Q FrameData[20] FrameStrobe[3] VPWR VGND sg13cmos5l_dlhq_1
XFILLER_38_498 VPWR VGND sg13cmos5l_fill_1
XFILLER_33_192 VPWR VGND sg13cmos5l_fill_2
XANTENNA__3702__X SS4BEG[0] VPWR VGND sg13cmos5l_antennanp
XFILLER_29_432 VPWR VGND sg13cmos5l_fill_2
XFILLER_29_498 VPWR VGND sg13cmos5l_fill_1
XANTENNA__3612__X FrameStrobe_O[14] VPWR VGND sg13cmos5l_antennanp
X_2030_ _2030_/X _2888_/Q _2920_/Q _2884_/Q _2916_/Q _1623_/Y _2052_/A VPWR VGND sg13cmos5l_mux4_1
X_2932_ _2932_/Q clkload2/A _2932_/D _3474_/L_HI VPWR VGND sg13cmos5l_dfrbpq_1
X_1745_ _1745_/Y _2051_/A _1741_/Y _1793_/S VPWR VGND sg13cmos5l_a21oi_1
X_1814_ _1814_/Y _3362_/Q _1811_/Y _1812_/Y _1813_/Y _3363_/Q VPWR VGND sg13cmos5l_a221oi_1
X_2863_ _2863_/Q _2899_/CLK _2863_/D _3543_/L_HI VPWR VGND sg13cmos5l_dfrbpq_1
X_2794_ _2938_/D _2675_/X _2938_/Q _2795_/S VPWR VGND sg13cmos5l_mux2_1
X_1676_ _1676_/X W6END[0] _2029_/X _2058_/X _2087_/X _3320_/Q _3318_/Q VPWR VGND sg13cmos5l_mux4_1
X_3415_ _3415_/L_HI VPWR VGND sg13cmos5l_tiehi
X_3346_ _3346_/Q FrameData[8] FrameStrobe[1] VPWR VGND sg13cmos5l_dlhq_1
X_2159_ _2159_/X N4END[2] S2END[2] _3280_/Q VPWR VGND sg13cmos5l_mux2_1
X_2228_ _2228_/Y _2216_/B _2219_/X _2227_/Y VPWR VGND sg13cmos5l_o21ai_1
X_3277_ _3277_/Q FrameData[3] FrameStrobe[3] VPWR VGND sg13cmos5l_dlhq_1
XFILLER_21_140 VPWR VGND sg13cmos5l_fill_2
XFILLER_26_59 VPWR VGND sg13cmos5l_fill_2
XFILLER_44_243 VPWR VGND sg13cmos5l_fill_1
XFILLER_12_162 VPWR VGND sg13cmos5l_fill_2
XFILLER_8_144 VPWR VGND sg13cmos5l_fill_2
XANTENNA__3607__X FrameStrobe_O[9] VPWR VGND sg13cmos5l_antennanp
XFILLER_4_350 VPWR VGND sg13cmos5l_fill_1
X_1461_ _2216_/B _3099_/Q VPWR VGND sg13cmos5l_inv_1
X_1530_ _1530_/Y _3256_/Q E1END[2] VPWR VGND sg13cmos5l_nor2b_1
X_3200_ _3200_/Q FrameData[22] FrameStrobe[6] VPWR VGND sg13cmos5l_dlhq_1
X_2013_ _2014_/B _2884_/Q _2116_/Y _2012_/Y VPWR VGND sg13cmos5l_a21oi_1
X_3131_ _3131_/Q FrameData[17] FrameStrobe[8] VPWR VGND sg13cmos5l_dlhq_1
X_3062_ _3062_/Q FrameData[12] FrameStrobe[10] VPWR VGND sg13cmos5l_dlhq_1
X_2915_ _2915_/Q _2915_/CLK _2915_/D _3491_/L_HI VPWR VGND sg13cmos5l_dfrbpq_1
X_1728_ _1728_/Y _3300_/Q _1727_/X _1718_/S VPWR VGND sg13cmos5l_o21ai_1
X_2846_ _2976_/D _2660_/X _2976_/Q _2849_/S VPWR VGND sg13cmos5l_mux2_1
X_2777_ _2924_/D _2660_/X _2924_/Q _2780_/S VPWR VGND sg13cmos5l_mux2_1
X_1659_ _1659_/Y _1656_/Y _1658_/Y _1477_/Y VPWR VGND sg13cmos5l_o21ai_1
X_3329_ _3329_/Q FrameData[23] FrameStrobe[2] VPWR VGND sg13cmos5l_dlhq_1
XFILLER_26_254 VPWR VGND sg13cmos5l_fill_2
XFILLER_22_471 VPWR VGND sg13cmos5l_fill_2
XFILLER_41_257 VPWR VGND sg13cmos5l_fill_2
X_3680_ S4BEG[10] S4END[14] VPWR VGND sg13cmos5l_buf_1
X_2700_ _2868_/D _2868_/Q _2660_/X _2703_/S VPWR VGND sg13cmos5l_mux2_1
X_2631_ _2631_/Y _3118_/Q _1641_/X _2630_/Y VPWR VGND sg13cmos5l_o21ai_1
X_2562_ _2562_/Y _2434_/A _3378_/Q _3379_/Q VPWR VGND sg13cmos5l_o21ai_1
X_1513_ _1513_/Y _2139_/B VPWR VGND sg13cmos5l_inv_1
X_2493_ _2494_/B N1END[3] E1END[3] W1END[3] _2139_/B _3009_/Q _3010_/Q VPWR VGND sg13cmos5l_mux4_1
X_3114_ _3114_/Q FrameData[0] FrameStrobe[8] VPWR VGND sg13cmos5l_dlhq_1
X_3045_ _3045_/Q FrameData[27] FrameStrobe[11] VPWR VGND sg13cmos5l_dlhq_1
X_2829_ _2833_/S _2850_/A _2834_/B VPWR VGND sg13cmos5l_nand2_1
XANTENNA__3710__X SS4BEG[8] VPWR VGND sg13cmos5l_antennanp
XFILLER_54_393 VPWR VGND sg13cmos5l_fill_1
XANTENNA__3620__X FrameData_O[2] VPWR VGND sg13cmos5l_antennanp
X_1993_ _1993_/Y _2083_/A _1993_/B VPWR VGND sg13cmos5l_nand2_1
X_3732_ E2BEGb[2] E2MID[2] VPWR VGND sg13cmos5l_buf_1
X_3594_ NN4BEG[12] _3594_/A VPWR VGND sg13cmos5l_buf_1
X_3663_ S2BEGb[1] S2MID[1] VPWR VGND sg13cmos5l_buf_1
Xclkload20 clkload20/Y _2923_/CLK VPWR VGND sg13cmos5l_inv_1
X_2614_ _2615_/B _1453_/Y _3270_/Q _2613_/Y VPWR VGND sg13cmos5l_a21oi_1
X_2545_ _3755_/A _2535_/Y _2536_/Y _2544_/X VPWR VGND sg13cmos5l_o21ai_1
X_2476_ _2476_/Y _3015_/Q _2029_/X _2475_/Y VPWR VGND sg13cmos5l_o21ai_1
X_3028_ _3028_/Q FrameData[10] FrameStrobe[11] VPWR VGND sg13cmos5l_dlhq_1
Xclkload3 clkload3/Y clkload3/A VPWR VGND sg13cmos5l_inv_1
XANTENNA__3705__X SS4BEG[3] VPWR VGND sg13cmos5l_antennanp
XFILLER_19_338 VPWR VGND sg13cmos5l_fill_2
XANTENNA__3615__X FrameStrobe_O[17] VPWR VGND sg13cmos5l_antennanp
X_2192_ _2192_/Y _3304_/Q S1END[2] VPWR VGND sg13cmos5l_nand2_1
X_2261_ _2262_/B _1465_/Y _1686_/X _3086_/Q VPWR VGND sg13cmos5l_o21ai_1
X_2330_ _3751_/A _2087_/X _3657_/A _2329_/X _2328_/X _3075_/Q _3074_/Q VPWR VGND sg13cmos5l_mux4_1
XFILLER_33_396 VPWR VGND sg13cmos5l_decap_4
X_1976_ _1976_/X _2083_/A _1976_/B VPWR VGND sg13cmos5l_and2_1
X_3715_ SS4BEG[13] _3715_/A VPWR VGND sg13cmos5l_buf_1
X_3577_ N4BEG[11] N4END[15] VPWR VGND sg13cmos5l_buf_1
X_3646_ FrameData_O[28] FrameData[28] VPWR VGND sg13cmos5l_buf_1
X_2528_ _3757_/A _2519_/Y _2520_/Y _2527_/Y VPWR VGND sg13cmos5l_a21o_1
Xclkbuf_5_2__f_UserCLK_regs clkload1/A clkbuf_3_0_0_UserCLK_regs/X VPWR VGND sg13cmos5l_buf_8
X_2459_ _2465_/B _3242_/Q _2457_/Y _2458_/Y VPWR VGND sg13cmos5l_o21ai_1
XFILLER_10_72 VPWR VGND sg13cmos5l_fill_1
X_1761_ _1761_/X _2914_/Q _2910_/Q _2882_/Q _2878_/Q _2052_/A _2051_/A VPWR VGND sg13cmos5l_mux4_1
X_1830_ _1848_/A _1823_/Y _1826_/Y _1829_/Y VPWR VGND sg13cmos5l_o21ai_1
X_3500_ _3500_/L_HI VPWR VGND sg13cmos5l_tiehi
X_1692_ _1692_/Y _1689_/Y _1691_/Y _1488_/Y VPWR VGND sg13cmos5l_a21oi_1
X_2313_ _2313_/X SS4END[2] W2END[3] _3282_/Q VPWR VGND sg13cmos5l_mux2_1
X_3431_ _3431_/L_HI VPWR VGND sg13cmos5l_tiehi
X_3362_ _3362_/Q FrameData[24] FrameStrobe[1] VPWR VGND sg13cmos5l_dlhq_1
XFILLER_18_0 VPWR VGND sg13cmos5l_fill_1
X_2175_ _2175_/Y S2END[2] _3248_/Q VPWR VGND sg13cmos5l_nand2_1
X_2244_ _2673_/B N2END[4] EE4END[0] S2END[4] W2END[4] _3214_/Q _3215_/Q VPWR VGND
+ sg13cmos5l_mux4_1
X_3293_ _3293_/Q FrameData[19] FrameStrobe[3] VPWR VGND sg13cmos5l_dlhq_1
XFILLER_25_138 VPWR VGND sg13cmos5l_fill_2
XFILLER_33_171 VPWR VGND sg13cmos5l_fill_1
XFILLER_21_388 VPWR VGND sg13cmos5l_decap_4
X_1959_ _1959_/X _1957_/Y _1958_/Y _1939_/Y VPWR VGND sg13cmos5l_a21o_1
X_3629_ FrameData_O[11] FrameData[11] VPWR VGND sg13cmos5l_buf_1
Xclkbuf_5_17__f_UserCLK_regs _3409_/CLK clkbuf_3_4_0_UserCLK_regs/X VPWR VGND sg13cmos5l_buf_8
XFILLER_21_82 VPWR VGND sg13cmos5l_fill_1
X_2931_ _2931_/Q clkload4/A _2931_/D _3475_/L_HI VPWR VGND sg13cmos5l_dfrbpq_1
XFILLER_30_163 VPWR VGND sg13cmos5l_fill_1
X_1744_ _1744_/Y _1742_/Y _1743_/Y _1623_/Y VPWR VGND sg13cmos5l_o21ai_1
X_1813_ _1813_/Y N1END[3] _1483_/Y _3362_/Q VPWR VGND sg13cmos5l_a21oi_1
X_2862_ _2862_/Q _2866_/CLK _2862_/D _3544_/L_HI VPWR VGND sg13cmos5l_dfrbpq_1
X_2793_ _2937_/D _2663_/X _2937_/Q _2795_/S VPWR VGND sg13cmos5l_mux2_1
X_1675_ _1709_/A _2051_/A _1625_/X _1674_/Y VPWR VGND sg13cmos5l_o21ai_1
X_3414_ _3414_/L_HI VPWR VGND sg13cmos5l_tiehi
X_3345_ _3345_/Q FrameData[7] FrameStrobe[1] VPWR VGND sg13cmos5l_dlhq_1
X_3276_ _3276_/Q FrameData[2] FrameStrobe[3] VPWR VGND sg13cmos5l_dlhq_1
XFILLER_26_27 VPWR VGND sg13cmos5l_fill_1
X_2089_ _2089_/Y _3259_/Q _2089_/B VPWR VGND sg13cmos5l_nand2b_1
X_2158_ _2158_/X N1END[0] N2END[2] E2END[2] E6END[0] _3278_/Q _3280_/Q VPWR VGND sg13cmos5l_mux4_1
X_2227_ _2227_/Y _3098_/Q _2495_/B _2226_/Y VPWR VGND sg13cmos5l_o21ai_1
XFILLER_5_307 VPWR VGND sg13cmos5l_fill_1
XANTENNA__3713__X SS4BEG[11] VPWR VGND sg13cmos5l_antennanp
XFILLER_8_178 VPWR VGND sg13cmos5l_fill_1
XANTENNA__3623__X FrameData_O[5] VPWR VGND sg13cmos5l_antennanp
X_1460_ _1460_/Y W1END[2] VPWR VGND sg13cmos5l_inv_1
X_3130_ _3130_/Q FrameData[16] FrameStrobe[8] VPWR VGND sg13cmos5l_dlhq_1
XFILLER_35_222 VPWR VGND sg13cmos5l_fill_1
X_2012_ _2012_/Y _2116_/Y _2888_/Q VPWR VGND sg13cmos5l_nor2b_1
X_3061_ _3061_/Q FrameData[11] FrameStrobe[10] VPWR VGND sg13cmos5l_dlhq_1
X_2914_ _2914_/Q _2914_/CLK _2914_/D _3492_/L_HI VPWR VGND sg13cmos5l_dfrbpq_1
X_2845_ _2849_/S _2845_/A _2855_/B VPWR VGND sg13cmos5l_nand2_1
X_1658_ _1658_/Y _3288_/Q _1657_/X _1648_/S VPWR VGND sg13cmos5l_o21ai_1
X_1727_ _1727_/X N1END[3] N2END[7] _3298_/Q VPWR VGND sg13cmos5l_mux2_1
X_2776_ _2780_/S _2840_/A _2791_/B VPWR VGND sg13cmos5l_nand2_1
X_1589_ _1589_/Y S2MID[1] _3200_/Q _3201_/Q VPWR VGND sg13cmos5l_o21ai_1
X_3328_ _3328_/Q FrameData[22] FrameStrobe[2] VPWR VGND sg13cmos5l_dlhq_1
X_3259_ _3259_/Q FrameData[17] FrameStrobe[4] VPWR VGND sg13cmos5l_dlhq_1
XANTENNA__3708__X SS4BEG[6] VPWR VGND sg13cmos5l_antennanp
XFILLER_5_148 VPWR VGND sg13cmos5l_fill_2
XANTENNA__3618__X FrameData_O[0] VPWR VGND sg13cmos5l_antennanp
XFILLER_9_498 VPWR VGND sg13cmos5l_fill_1
X_1512_ _1512_/Y _2620_/B VPWR VGND sg13cmos5l_inv_1
X_2630_ _2630_/Y _3118_/Q _2630_/B VPWR VGND sg13cmos5l_nand2_1
X_2561_ _2691_/A _2559_/Y _2560_/X _2550_/A VPWR VGND sg13cmos5l_o21ai_1
X_2492_ _3596_/A _2489_/Y _2491_/Y _2487_/Y VPWR VGND sg13cmos5l_a21oi_1
X_3113_ _3113_/Q FrameData[31] FrameStrobe[9] VPWR VGND sg13cmos5l_dlhq_1
X_3044_ _3044_/Q FrameData[26] FrameStrobe[11] VPWR VGND sg13cmos5l_dlhq_1
X_2828_ _2963_/D _2689_/Y _2963_/Q _2828_/S VPWR VGND sg13cmos5l_mux2_1
XFILLER_2_107 VPWR VGND sg13cmos5l_fill_1
Xclkbuf_3_0_0_UserCLK_regs clkbuf_3_0_0_UserCLK_regs/X clkbuf_0_UserCLK_regs/X VPWR
+ VGND sg13cmos5l_buf_8
X_2759_ _2763_/S _2845_/A _2769_/B VPWR VGND sg13cmos5l_nand2_1
XFILLER_46_328 VPWR VGND sg13cmos5l_fill_2
XFILLER_14_247 VPWR VGND sg13cmos5l_decap_8
XFILLER_10_497 VPWR VGND sg13cmos5l_fill_2
XFILLER_13_94 VPWR VGND sg13cmos5l_decap_8
XFILLER_37_317 VPWR VGND sg13cmos5l_decap_4
XFILLER_37_328 VPWR VGND sg13cmos5l_fill_1
X_1992_ _1993_/B _2922_/Q _2918_/Q _2890_/Q _2886_/Q _2116_/Y _2014_/A VPWR VGND sg13cmos5l_mux4_1
X_3662_ S2BEGb[0] S2MID[0] VPWR VGND sg13cmos5l_buf_1
X_3731_ E2BEGb[1] E2MID[1] VPWR VGND sg13cmos5l_buf_1
Xclkload10 clkload10/Y _2979_/CLK VPWR VGND sg13cmos5l_inv_1
X_3593_ NN4BEG[11] NN4END[15] VPWR VGND sg13cmos5l_buf_1
Xclkload21 clkload21/Y _2914_/CLK VPWR VGND sg13cmos5l_inv_1
X_2613_ _2613_/Y NN4END[0] _3270_/Q VPWR VGND sg13cmos5l_nor2_1
X_2544_ _2544_/X _3341_/Q _2544_/B _2544_/C VPWR VGND sg13cmos5l_or3_1
X_2475_ _2475_/Y _1702_/X _3015_/Q VPWR VGND sg13cmos5l_nand2b_1
X_3027_ _3027_/Q FrameData[9] FrameStrobe[11] VPWR VGND sg13cmos5l_dlhq_1
Xclkload4 clkload4/Y clkload4/A VPWR VGND sg13cmos5l_inv_1
XANTENNA__3721__X E6BEG[3] VPWR VGND sg13cmos5l_antennanp
XFILLER_27_394 VPWR VGND sg13cmos5l_fill_2
XFILLER_42_342 VPWR VGND sg13cmos5l_fill_2
XANTENNA__3631__X FrameData_O[13] VPWR VGND sg13cmos5l_antennanp
XFILLER_37_103 VPWR VGND sg13cmos5l_fill_1
X_2191_ _2191_/Y _3303_/Q _2191_/B VPWR VGND sg13cmos5l_nand2b_1
X_2260_ _2262_/A _3085_/Q _2646_/B VPWR VGND sg13cmos5l_nor2_1
Xclkbuf_5_25__f_UserCLK_regs _2921_/CLK clkbuf_3_6_0_UserCLK_regs/X VPWR VGND sg13cmos5l_buf_8
X_1975_ _1976_/B _2939_/Q _2935_/Q _2971_/Q _2967_/Q _2116_/Y _2071_/A VPWR VGND sg13cmos5l_mux4_1
X_3645_ FrameData_O[27] FrameData[27] VPWR VGND sg13cmos5l_buf_1
X_3714_ SS4BEG[12] _3714_/A VPWR VGND sg13cmos5l_buf_1
X_3576_ N4BEG[10] N4END[14] VPWR VGND sg13cmos5l_buf_1
X_2527_ _2527_/Y _2524_/Y _2525_/Y _2526_/Y VPWR VGND sg13cmos5l_a21oi_1
X_2458_ _2458_/Y _3242_/Q _2455_/X _3243_/Q VPWR VGND sg13cmos5l_a21oi_1
X_2389_ _2389_/Y _1702_/X _3035_/Q VPWR VGND sg13cmos5l_nand2b_1
XANTENNA__3716__X SS4BEG[14] VPWR VGND sg13cmos5l_antennanp
XANTENNA__3626__X FrameData_O[8] VPWR VGND sg13cmos5l_antennanp
XFILLER_30_334 VPWR VGND sg13cmos5l_fill_1
X_1691_ _1691_/Y _3326_/Q _1690_/X _1487_/Y VPWR VGND sg13cmos5l_a21oi_1
X_1760_ _1760_/X _2922_/Q _2918_/Q _2890_/Q _2886_/Q _2052_/A _2051_/A VPWR VGND sg13cmos5l_mux4_1
X_2312_ _2312_/Y E2END[3] _3282_/Q _2311_/Y VPWR VGND sg13cmos5l_a21oi_1
X_3430_ _3430_/L_HI VPWR VGND sg13cmos5l_tiehi
X_3361_ _3361_/Q FrameData[23] FrameStrobe[1] VPWR VGND sg13cmos5l_dlhq_1
X_3292_ _3292_/Q FrameData[18] FrameStrobe[3] VPWR VGND sg13cmos5l_dlhq_1
X_2174_ _2174_/Y E2END[2] _3248_/Q _2173_/Y VPWR VGND sg13cmos5l_o21ai_1
X_2243_ _3781_/A _1463_/Y _2236_/Y _2240_/Y _2242_/Y VPWR VGND sg13cmos5l_a22oi_1
XFILLER_33_194 VPWR VGND sg13cmos5l_fill_1
X_1889_ _1889_/X E1END[1] E2END[5] SS4END[3] W1END[1] _3322_/Q _3324_/Q VPWR VGND
+ sg13cmos5l_mux4_1
X_1958_ _1958_/Y _3143_/Q _3556_/A _3144_/Q VPWR VGND sg13cmos5l_a21oi_1
X_3628_ FrameData_O[10] FrameData[10] VPWR VGND sg13cmos5l_buf_1
X_3559_ N2BEGb[1] N2MID[1] VPWR VGND sg13cmos5l_buf_1
XFILLER_24_172 VPWR VGND sg13cmos5l_fill_1
XANTENNA_90 WW4END[0] VPWR VGND sg13cmos5l_antennanp
X_2930_ _2930_/Q _2962_/CLK _2930_/D _3476_/L_HI VPWR VGND sg13cmos5l_dfrbpq_1
X_2861_ _2861_/Q _2866_/CLK _2861_/D _3545_/L_HI VPWR VGND sg13cmos5l_dfrbpq_1
X_1674_ _1674_/Y _2051_/A _1673_/Y _1793_/S VPWR VGND sg13cmos5l_a21oi_1
X_1743_ _1743_/Y _2901_/Q _2052_/A VPWR VGND sg13cmos5l_nor2b_1
X_1812_ _1812_/Y S1END[1] _3364_/Q VPWR VGND sg13cmos5l_nand2_1
X_3413_ _3413_/L_HI VPWR VGND sg13cmos5l_tiehi
X_2792_ _2936_/D _2660_/X _2936_/Q _2795_/S VPWR VGND sg13cmos5l_mux2_1
X_2226_ _2226_/Y _3098_/Q _2646_/B _3099_/Q VPWR VGND sg13cmos5l_a21oi_1
X_3344_ _3344_/Q FrameData[6] FrameStrobe[1] VPWR VGND sg13cmos5l_dlhq_1
X_3275_ _3275_/Q FrameData[1] FrameStrobe[3] VPWR VGND sg13cmos5l_dlhq_1
X_2088_ _2089_/B N1END[1] E2END[5] N2END[5] S1END[1] _3260_/Q _3258_/Q VPWR VGND sg13cmos5l_mux4_1
X_2157_ _2157_/Y _3279_/Q _2156_/X _2155_/X VPWR VGND sg13cmos5l_a21oi_1
XFILLER_8_146 VPWR VGND sg13cmos5l_fill_1
X_3060_ _3060_/Q FrameData[10] FrameStrobe[10] VPWR VGND sg13cmos5l_dlhq_1
XFILLER_23_407 VPWR VGND sg13cmos5l_decap_8
X_2011_ _2011_/X _2880_/Q _2912_/Q _2876_/Q _2908_/Q _2071_/A _2116_/Y VPWR VGND sg13cmos5l_mux4_1
X_2913_ _2913_/Q _2913_/CLK _2913_/D _3493_/L_HI VPWR VGND sg13cmos5l_dfrbpq_1
X_2844_ _2975_/D _2689_/Y _2975_/Q _2844_/S VPWR VGND sg13cmos5l_mux2_1
X_1588_ _1588_/Y W2MID[1] _3200_/Q VPWR VGND sg13cmos5l_nor2b_1
X_1657_ _1657_/X N1END[2] N2END[4] _3286_/Q VPWR VGND sg13cmos5l_mux2_1
X_1726_ _1726_/Y _1726_/A _3300_/Q VPWR VGND sg13cmos5l_nor2b_1
X_2775_ _2791_/B _2818_/A _2796_/B VPWR VGND sg13cmos5l_nor2_1
X_2209_ _2209_/Y _3274_/Q _2208_/Y _3275_/Q VPWR VGND sg13cmos5l_o21ai_1
X_3327_ _3327_/Q FrameData[21] FrameStrobe[2] VPWR VGND sg13cmos5l_dlhq_1
X_3258_ _3258_/Q FrameData[16] FrameStrobe[4] VPWR VGND sg13cmos5l_dlhq_1
X_3189_ _3189_/Q FrameData[11] FrameStrobe[6] VPWR VGND sg13cmos5l_dlhq_1
XFILLER_22_495 VPWR VGND sg13cmos5l_fill_1
XANTENNA__3724__X E6BEG[6] VPWR VGND sg13cmos5l_antennanp
XFILLER_49_326 VPWR VGND sg13cmos5l_fill_2
XFILLER_40_270 VPWR VGND sg13cmos5l_fill_1
XANTENNA__3634__X FrameData_O[16] VPWR VGND sg13cmos5l_antennanp
X_1511_ _2579_/B _3335_/Q VPWR VGND sg13cmos5l_inv_1
X_2560_ _2560_/X _3123_/Q _2560_/B VPWR VGND sg13cmos5l_and2_1
X_2491_ _2491_/Y _3013_/Q _2490_/X _3014_/Q VPWR VGND sg13cmos5l_a21oi_1
XFILLER_4_64 VPWR VGND sg13cmos5l_fill_2
X_3112_ _3112_/Q FrameData[30] FrameStrobe[9] VPWR VGND sg13cmos5l_dlhq_1
X_3043_ _3043_/Q FrameData[25] FrameStrobe[11] VPWR VGND sg13cmos5l_dlhq_1
X_2827_ _2962_/D _2675_/X _2962_/Q _2828_/S VPWR VGND sg13cmos5l_mux2_1
X_2758_ _2911_/D _2911_/Q _2689_/Y _2758_/S VPWR VGND sg13cmos5l_mux2_1
X_1709_ _1709_/Y _1709_/A _1709_/B VPWR VGND sg13cmos5l_nand2_1
X_2689_ _2689_/Y _3109_/Q _2688_/Y _2684_/Y VPWR VGND sg13cmos5l_o21ai_1
XANTENNA__3719__X E6BEG[1] VPWR VGND sg13cmos5l_antennanp
XANTENNA__3629__X FrameData_O[11] VPWR VGND sg13cmos5l_antennanp
XFILLER_9_241 VPWR VGND sg13cmos5l_fill_1
X_1991_ _1991_/X _2914_/Q _2910_/Q _2882_/Q _2878_/Q _2116_/Y _2014_/A VPWR VGND sg13cmos5l_mux4_1
X_3592_ NN4BEG[10] NN4END[14] VPWR VGND sg13cmos5l_buf_1
X_3661_ S2BEG[7] _3661_/A VPWR VGND sg13cmos5l_buf_1
X_3730_ E2BEGb[0] E2MID[0] VPWR VGND sg13cmos5l_buf_1
Xclkload22 clkload22/Y _2912_/CLK VPWR VGND sg13cmos5l_inv_1
Xclkload11 clkload11/Y _2976_/CLK VPWR VGND sg13cmos5l_inv_1
X_2612_ _2612_/X S2END[0] W1END[0] _3270_/Q VPWR VGND sg13cmos5l_mux2_1
X_2543_ _2544_/C _3339_/Q _2543_/B VPWR VGND sg13cmos5l_nor2_1
X_2474_ _2478_/A _3015_/Q _2472_/Y _2473_/Y VPWR VGND sg13cmos5l_a21oi_1
XFILLER_28_318 VPWR VGND sg13cmos5l_decap_8
X_3026_ _3026_/Q FrameData[8] FrameStrobe[11] VPWR VGND sg13cmos5l_dlhq_1
XFILLER_34_28 VPWR VGND sg13cmos5l_fill_2
Xclkload5 clkload5/Y clkload5/A VPWR VGND sg13cmos5l_inv_1
XFILLER_6_211 VPWR VGND sg13cmos5l_decap_4
Xclkbuf_5_12__f_UserCLK_regs _2977_/CLK clkbuf_3_3_0_UserCLK_regs/X VPWR VGND sg13cmos5l_buf_8
XFILLER_27_6 VPWR VGND sg13cmos5l_fill_1
X_2190_ _2191_/B N1END[0] N2END[0] EE4END[0] S1END[0] _3302_/Q _3304_/Q VPWR VGND
+ sg13cmos5l_mux4_1
X_1974_ _1974_/X _2931_/Q _2927_/Q _2963_/Q _2959_/Q _2116_/Y _2071_/A VPWR VGND sg13cmos5l_mux4_1
X_3575_ N4BEG[9] N4END[13] VPWR VGND sg13cmos5l_buf_1
X_3644_ FrameData_O[26] FrameData[26] VPWR VGND sg13cmos5l_buf_1
X_3713_ SS4BEG[11] SS4END[15] VPWR VGND sg13cmos5l_buf_1
X_2526_ _2526_/Y _3347_/Q _2521_/X _3349_/Q VPWR VGND sg13cmos5l_o21ai_1
X_2457_ _2457_/Y _3244_/Q _2029_/X _2456_/Y VPWR VGND sg13cmos5l_a21oi_1
X_2388_ _2395_/A _3037_/Q _2388_/B VPWR VGND sg13cmos5l_nor2_1
X_3009_ _3009_/Q FrameData[23] FrameStrobe[12] VPWR VGND sg13cmos5l_dlhq_1
XANTENNA__3732__X E2BEGb[2] VPWR VGND sg13cmos5l_antennanp
XFILLER_19_50 VPWR VGND sg13cmos5l_fill_1
XFILLER_34_107 VPWR VGND sg13cmos5l_fill_1
XFILLER_30_379 VPWR VGND sg13cmos5l_decap_8
X_1690_ _1690_/X _2139_/B _1980_/X _3328_/Q VPWR VGND sg13cmos5l_mux2_1
XANTENNA__3642__X FrameData_O[24] VPWR VGND sg13cmos5l_antennanp
X_2242_ _2242_/Y _1462_/Y _2241_/X _1463_/Y VPWR VGND sg13cmos5l_a21oi_1
X_2311_ _2311_/Y _3282_/Q N4END[3] VPWR VGND sg13cmos5l_nor2b_1
X_3360_ _3360_/Q FrameData[22] FrameStrobe[1] VPWR VGND sg13cmos5l_dlhq_1
X_3291_ _3291_/Q FrameData[17] FrameStrobe[3] VPWR VGND sg13cmos5l_dlhq_1
X_2173_ _2173_/Y _2173_/A _3248_/Q VPWR VGND sg13cmos5l_nand2_1
XFILLER_21_346 VPWR VGND sg13cmos5l_fill_2
X_1957_ _1957_/Y _1961_/B _1957_/B VPWR VGND sg13cmos5l_nand2_1
X_1888_ _1888_/Y _1888_/A _1888_/B VPWR VGND sg13cmos5l_nand2_1
X_3558_ N2BEGb[0] N2MID[0] VPWR VGND sg13cmos5l_buf_1
X_3627_ FrameData_O[9] FrameData[9] VPWR VGND sg13cmos5l_buf_1
X_2509_ _3594_/A _2509_/A _2509_/B VPWR VGND sg13cmos5l_nor2_1
XANTENNA__3552__X N2BEG[2] VPWR VGND sg13cmos5l_antennanp
X_3489_ _3489_/L_HI VPWR VGND sg13cmos5l_tiehi
XFILLER_12_302 VPWR VGND sg13cmos5l_fill_2
XANTENNA_80 W2MID[7] VPWR VGND sg13cmos5l_antennanp
XANTENNA_91 WW4END[0] VPWR VGND sg13cmos5l_antennanp
XANTENNA__3727__X E6BEG[9] VPWR VGND sg13cmos5l_antennanp
XFILLER_12_368 VPWR VGND sg13cmos5l_fill_2
XANTENNA__3637__X FrameData_O[19] VPWR VGND sg13cmos5l_antennanp
X_1811_ _1811_/Y N2END[7] _1483_/Y _1810_/X VPWR VGND sg13cmos5l_a21oi_1
X_2860_ _2860_/Q _2893_/CLK _2860_/D _3410_/L_HI VPWR VGND sg13cmos5l_dfrbpq_1
X_2791_ _2795_/S _2855_/A _2791_/B VPWR VGND sg13cmos5l_nand2_1
XFILLER_7_361 VPWR VGND sg13cmos5l_fill_1
X_1673_ _1673_/Y _2889_/Q _2052_/A _1672_/Y VPWR VGND sg13cmos5l_o21ai_1
X_1742_ _1742_/Y _2905_/Q _2052_/A VPWR VGND sg13cmos5l_nor2_1
X_3412_ _3412_/L_HI VPWR VGND sg13cmos5l_tiehi
XFILLER_23_0 VPWR VGND sg13cmos5l_fill_2
X_2225_ _2646_/B N2MID[4] E2MID[4] S2MID[4] _3658_/A _3158_/Q _3159_/Q VPWR VGND sg13cmos5l_mux4_1
X_3343_ _3343_/Q FrameData[5] FrameStrobe[1] VPWR VGND sg13cmos5l_dlhq_1
X_3274_ _3274_/Q FrameData[0] FrameStrobe[3] VPWR VGND sg13cmos5l_dlhq_1
XFILLER_26_427 VPWR VGND sg13cmos5l_fill_1
XFILLER_26_449 VPWR VGND sg13cmos5l_fill_1
X_2087_ _2087_/X _3403_/D _3403_/Q _2989_/Q VPWR VGND sg13cmos5l_mux2_1
X_2156_ _2156_/X _2139_/B _1912_/B _2620_/B _1980_/X _3278_/Q _3280_/Q VPWR VGND sg13cmos5l_mux4_1
XANTENNA__3547__X N1BEG[1] VPWR VGND sg13cmos5l_antennanp
X_2989_ _2989_/Q FrameData[3] FrameStrobe[12] VPWR VGND sg13cmos5l_dlhq_1
XFILLER_29_243 VPWR VGND sg13cmos5l_decap_8
XFILLER_29_276 VPWR VGND sg13cmos5l_fill_2
XFILLER_44_235 VPWR VGND sg13cmos5l_fill_2
XFILLER_25_460 VPWR VGND sg13cmos5l_decap_4
XFILLER_44_279 VPWR VGND sg13cmos5l_fill_2
XFILLER_8_169 VPWR VGND sg13cmos5l_decap_8
X_2010_ _2010_/Y _2008_/Y _2009_/Y _1967_/Y VPWR VGND sg13cmos5l_a21oi_1
XFILLER_16_471 VPWR VGND sg13cmos5l_fill_1
X_2912_ _2912_/Q _2912_/CLK _2912_/D _3494_/L_HI VPWR VGND sg13cmos5l_dfrbpq_1
X_1725_ _1726_/A EE4END[1] S1END[1] _3298_/Q VPWR VGND sg13cmos5l_mux2_1
X_2843_ _2974_/D _2675_/X _2974_/Q _2844_/S VPWR VGND sg13cmos5l_mux2_1
X_2774_ _2796_/B _2817_/A _2774_/B VPWR VGND sg13cmos5l_nand2_1
X_1587_ _1587_/Y _1496_/Y _1586_/Y _3130_/Q VPWR VGND sg13cmos5l_a21oi_1
X_1656_ _1656_/Y _1656_/A _3288_/Q VPWR VGND sg13cmos5l_nor2b_1
X_3326_ _3326_/Q FrameData[20] FrameStrobe[2] VPWR VGND sg13cmos5l_dlhq_1
X_2139_ _2139_/Y _3312_/Q _2139_/B VPWR VGND sg13cmos5l_nor2_1
X_2208_ _2208_/Y _3276_/Q S2END[1] _2207_/Y VPWR VGND sg13cmos5l_a21oi_1
X_3257_ _3257_/Q FrameData[15] FrameStrobe[4] VPWR VGND sg13cmos5l_dlhq_1
X_3188_ _3188_/Q FrameData[10] FrameStrobe[6] VPWR VGND sg13cmos5l_dlhq_1
XANTENNA__3740__X E2BEG[2] VPWR VGND sg13cmos5l_antennanp
XFILLER_17_213 VPWR VGND sg13cmos5l_decap_8
XFILLER_13_452 VPWR VGND sg13cmos5l_fill_1
X_1510_ _1510_/Y _3325_/Q VPWR VGND sg13cmos5l_inv_1
X_2490_ _2490_/X W1END[0] _1912_/B _3012_/Q VPWR VGND sg13cmos5l_mux2_1
XANTENNA__3650__X S1BEG[0] VPWR VGND sg13cmos5l_antennanp
X_3111_ _3111_/Q FrameData[29] FrameStrobe[9] VPWR VGND sg13cmos5l_dlhq_1
X_3042_ _3042_/Q FrameData[24] FrameStrobe[11] VPWR VGND sg13cmos5l_dlhq_1
X_1708_ _1709_/B _1793_/S _1707_/X _1794_/S VPWR VGND sg13cmos5l_a21oi_1
X_2826_ _2961_/D _2663_/X _2961_/Q _2828_/S VPWR VGND sg13cmos5l_mux2_1
X_2757_ _2910_/D _2910_/Q _2675_/X _2758_/S VPWR VGND sg13cmos5l_mux2_1
X_2688_ _2688_/Y _3108_/Q _2687_/X _2686_/Y VPWR VGND sg13cmos5l_a21oi_1
XANTENNA__3560__X N2BEGb[2] VPWR VGND sg13cmos5l_antennanp
X_1639_ _1639_/Y _1470_/Y _1638_/X _3297_/Q VPWR VGND sg13cmos5l_a21oi_1
X_3309_ _3309_/Q FrameData[3] FrameStrobe[2] VPWR VGND sg13cmos5l_dlhq_1
XFILLER_54_341 VPWR VGND sg13cmos5l_fill_2
Xclkbuf_5_20__f_UserCLK_regs _2893_/CLK clkbuf_3_5_0_UserCLK_regs/X VPWR VGND sg13cmos5l_buf_8
XANTENNA__3735__X E2BEGb[5] VPWR VGND sg13cmos5l_antennanp
XFILLER_1_197 VPWR VGND sg13cmos5l_fill_2
X_1990_ _1990_/Y _1988_/Y _1989_/Y _1967_/Y VPWR VGND sg13cmos5l_a21oi_1
XANTENNA__3645__X FrameData_O[27] VPWR VGND sg13cmos5l_antennanp
X_3591_ NN4BEG[9] NN4END[13] VPWR VGND sg13cmos5l_buf_1
X_3660_ S2BEG[6] _3660_/A VPWR VGND sg13cmos5l_buf_1
Xclkload23 clkload23/Y _2915_/CLK VPWR VGND sg13cmos5l_inv_1
Xclkload12 clkload12/Y _3409_/CLK VPWR VGND sg13cmos5l_inv_1
X_2611_ _2611_/X N1END[0] E2END[0] N2END[0] S1END[0] _3272_/Q _3270_/Q VPWR VGND sg13cmos5l_mux4_1
X_2542_ _2543_/B N1END[3] N2END[1] S2END[1] S4END[1] _3338_/Q _3340_/Q VPWR VGND sg13cmos5l_mux4_1
X_2473_ _2473_/Y _3015_/Q _1919_/B _3016_/Q VPWR VGND sg13cmos5l_o21ai_1
X_3025_ _3025_/Q FrameData[7] FrameStrobe[11] VPWR VGND sg13cmos5l_dlhq_1
Xclkload6 clkload6/Y clkload6/A VPWR VGND sg13cmos5l_inv_1
XANTENNA__3555__X N2BEG[5] VPWR VGND sg13cmos5l_antennanp
X_3789_ WW4BEG[6] WW4END[10] VPWR VGND sg13cmos5l_buf_1
X_2809_ _2949_/D _2663_/X _2949_/Q _2811_/S VPWR VGND sg13cmos5l_mux2_1
XFILLER_27_396 VPWR VGND sg13cmos5l_fill_1
XFILLER_42_311 VPWR VGND sg13cmos5l_fill_1
XFILLER_10_296 VPWR VGND sg13cmos5l_fill_1
X_1973_ _1973_/Y _1973_/A _1973_/B VPWR VGND sg13cmos5l_nor2_1
X_3712_ SS4BEG[10] SS4END[14] VPWR VGND sg13cmos5l_buf_1
X_3574_ N4BEG[8] N4END[12] VPWR VGND sg13cmos5l_buf_1
X_3643_ FrameData_O[25] FrameData[25] VPWR VGND sg13cmos5l_buf_1
X_2525_ _2525_/Y _3346_/Q _2522_/X _2519_/B VPWR VGND sg13cmos5l_a21oi_1
X_2456_ _2456_/Y _3244_/Q W6END[1] VPWR VGND sg13cmos5l_nor2b_1
X_2387_ _2388_/B N1END[1] S1END[1] E1END[1] _2058_/X _3036_/Q _3035_/Q VPWR VGND sg13cmos5l_mux4_1
X_3008_ _3008_/Q FrameData[22] FrameStrobe[12] VPWR VGND sg13cmos5l_dlhq_1
XFILLER_10_31 VPWR VGND sg13cmos5l_fill_1
XFILLER_47_425 VPWR VGND sg13cmos5l_fill_2
X_2172_ _2172_/Y _2167_/Y _2170_/Y _2171_/X _1456_/Y VPWR VGND sg13cmos5l_a22oi_1
X_2241_ _2241_/X _2029_/X _2620_/B _2237_/X _1643_/A _3095_/Q _3096_/Q VPWR VGND sg13cmos5l_mux4_1
X_2310_ _3752_/A _2620_/B _1561_/X _3654_/A _1685_/X _3076_/Q _3077_/Q VPWR VGND sg13cmos5l_mux4_1
X_3290_ _3290_/Q FrameData[16] FrameStrobe[3] VPWR VGND sg13cmos5l_dlhq_1
X_1887_ _1888_/B N1END[1] S1END[1] N2END[5] S2END[5] _3324_/Q _3322_/Q VPWR VGND sg13cmos5l_mux4_1
X_1956_ _3556_/A _3269_/Q _1944_/Y _1955_/Y VPWR VGND sg13cmos5l_a21oi_1
X_3488_ _3488_/L_HI VPWR VGND sg13cmos5l_tiehi
X_3557_ N2BEG[7] _3557_/A VPWR VGND sg13cmos5l_buf_1
X_3626_ FrameData_O[8] FrameData[8] VPWR VGND sg13cmos5l_buf_1
X_2508_ _2509_/B _3008_/Q _2508_/B VPWR VGND sg13cmos5l_nor2_1
X_2439_ _3552_/A _3253_/Q _2430_/Y _2432_/Y _2438_/Y VPWR VGND sg13cmos5l_a22oi_1
XFILLER_12_347 VPWR VGND sg13cmos5l_decap_8
XANTENNA_70 W2MID[3] VPWR VGND sg13cmos5l_antennanp
XANTENNA_81 W2MID[7] VPWR VGND sg13cmos5l_antennanp
XANTENNA_92 WW4END[0] VPWR VGND sg13cmos5l_antennanp
XANTENNA__3743__X E2BEG[5] VPWR VGND sg13cmos5l_antennanp
XFILLER_46_60 VPWR VGND sg13cmos5l_fill_2
XFILLER_46_82 VPWR VGND sg13cmos5l_fill_2
XFILLER_47_244 VPWR VGND sg13cmos5l_fill_2
XFILLER_15_185 VPWR VGND sg13cmos5l_fill_2
X_1741_ _1741_/Y _2873_/Q _2052_/A _1740_/Y VPWR VGND sg13cmos5l_o21ai_1
X_1810_ _1810_/X S1END[3] _3364_/Q VPWR VGND sg13cmos5l_and2_1
X_2790_ _2935_/D _2689_/Y _2935_/Q _2790_/S VPWR VGND sg13cmos5l_mux2_1
XANTENNA__3653__X S1BEG[3] VPWR VGND sg13cmos5l_antennanp
X_1672_ _1672_/Y _2885_/Q _2052_/A VPWR VGND sg13cmos5l_nand2b_1
X_3411_ _3411_/L_HI VPWR VGND sg13cmos5l_tiehi
X_3342_ _3342_/Q FrameData[4] FrameStrobe[1] VPWR VGND sg13cmos5l_dlhq_1
X_2155_ _2155_/X _2155_/A _2155_/B VPWR VGND sg13cmos5l_and2_1
X_2224_ _2495_/B _3151_/Q _2220_/X _2223_/Y VPWR VGND sg13cmos5l_o21ai_1
X_3273_ _3273_/Q FrameData[31] FrameStrobe[4] VPWR VGND sg13cmos5l_dlhq_1
X_2086_ _3403_/D _2080_/Y _2085_/Y _2075_/Y VPWR VGND sg13cmos5l_a21o_1
X_1939_ _1939_/Y _1961_/B _3660_/A _1938_/Y VPWR VGND sg13cmos5l_a21oi_1
X_3609_ FrameStrobe_O[11] FrameStrobe[11] VPWR VGND sg13cmos5l_buf_1
X_2988_ _2988_/Q FrameData[2] FrameStrobe[12] VPWR VGND sg13cmos5l_dlhq_1
XANTENNA__3563__X N2BEGb[5] VPWR VGND sg13cmos5l_antennanp
XFILLER_29_299 VPWR VGND sg13cmos5l_decap_4
XANTENNA__3738__X E2BEG[0] VPWR VGND sg13cmos5l_antennanp
XANTENNA__3648__X FrameData_O[30] VPWR VGND sg13cmos5l_antennanp
X_2911_ _2911_/Q _2915_/CLK _2911_/D _3495_/L_HI VPWR VGND sg13cmos5l_dfrbpq_1
XFILLER_31_497 VPWR VGND sg13cmos5l_fill_2
X_1724_ _1724_/Y _3300_/Q _1722_/Y _1723_/Y VPWR VGND sg13cmos5l_a21oi_1
X_2842_ _2973_/D _2663_/X _2973_/Q _2844_/S VPWR VGND sg13cmos5l_mux2_1
X_2773_ _2923_/D _2689_/Y _2923_/Q _2773_/S VPWR VGND sg13cmos5l_mux2_1
X_1586_ _1586_/Y _1458_/Y _3168_/Q _1585_/Y VPWR VGND sg13cmos5l_o21ai_1
X_1655_ _1656_/A E6END[0] S2END[4] _3286_/Q VPWR VGND sg13cmos5l_mux2_1
X_3325_ _3325_/Q FrameData[19] FrameStrobe[2] VPWR VGND sg13cmos5l_dlhq_1
X_3256_ _3256_/Q FrameData[14] FrameStrobe[4] VPWR VGND sg13cmos5l_dlhq_1
XFILLER_26_214 VPWR VGND sg13cmos5l_decap_4
X_2069_ _2069_/Y _2116_/Y _2897_/Q VPWR VGND sg13cmos5l_nor2b_1
X_2138_ _2138_/Y _3312_/Q _1912_/B _2137_/Y VPWR VGND sg13cmos5l_o21ai_1
X_2207_ _2207_/Y _3276_/Q _2207_/B VPWR VGND sg13cmos5l_nor2_1
X_3187_ _3187_/Q FrameData[9] FrameStrobe[6] VPWR VGND sg13cmos5l_dlhq_1
XANTENNA__3558__X N2BEGb[0] VPWR VGND sg13cmos5l_antennanp
XFILLER_13_475 VPWR VGND sg13cmos5l_fill_1
X_3110_ _3110_/Q FrameData[28] FrameStrobe[9] VPWR VGND sg13cmos5l_dlhq_1
X_3041_ _3041_/Q FrameData[23] FrameStrobe[11] VPWR VGND sg13cmos5l_dlhq_1
XFILLER_23_228 VPWR VGND sg13cmos5l_fill_1
X_2825_ _2960_/D _2660_/X _2960_/Q _2828_/S VPWR VGND sg13cmos5l_mux2_1
X_1638_ _1638_/X N1END[2] N2END[6] EE4END[2] S1END[0] _3294_/Q _3296_/Q VPWR VGND
+ sg13cmos5l_mux4_1
X_1707_ _1707_/X _2881_/Q _2913_/Q _2877_/Q _2909_/Q _1623_/Y _2052_/A VPWR VGND sg13cmos5l_mux4_1
X_2756_ _2909_/D _2909_/Q _2663_/X _2758_/S VPWR VGND sg13cmos5l_mux2_1
X_2687_ _2687_/X N2MID[1] E2MID[1] S2MID[1] W2MID[1] _3184_/Q _3185_/Q VPWR VGND sg13cmos5l_mux4_1
X_1569_ _1569_/X S1END[0] S1END[2] _3358_/Q VPWR VGND sg13cmos5l_mux2_1
X_3308_ _3308_/Q FrameData[2] FrameStrobe[2] VPWR VGND sg13cmos5l_dlhq_1
X_3239_ _3239_/Q FrameData[29] FrameStrobe[5] VPWR VGND sg13cmos5l_dlhq_1
XFILLER_22_261 VPWR VGND sg13cmos5l_fill_1
XANTENNA__3751__X W1BEG[0] VPWR VGND sg13cmos5l_antennanp
X_3590_ NN4BEG[8] NN4END[12] VPWR VGND sg13cmos5l_buf_1
Xclkload13 clkload13/Y _2907_/CLK VPWR VGND sg13cmos5l_inv_1
X_2610_ _2610_/Y _3118_/Q _3762_/A _2597_/Y VPWR VGND sg13cmos5l_a21oi_1
X_2541_ _2544_/B _3338_/Q _2537_/X _2540_/Y VPWR VGND sg13cmos5l_a21oi_1
X_2472_ _2472_/Y _2472_/A VPWR VGND sg13cmos5l_inv_1
XANTENNA__3661__X S2BEG[7] VPWR VGND sg13cmos5l_antennanp
X_3024_ _3024_/Q FrameData[6] FrameStrobe[11] VPWR VGND sg13cmos5l_dlhq_1
Xclkload7 clkload7/Y clkload7/A VPWR VGND sg13cmos5l_inv_1
X_3788_ WW4BEG[5] WW4END[9] VPWR VGND sg13cmos5l_buf_1
X_2808_ _2948_/D _2660_/X _2948_/Q _2811_/S VPWR VGND sg13cmos5l_mux2_1
XANTENNA__3571__X N4BEG[5] VPWR VGND sg13cmos5l_antennanp
X_2739_ _2896_/D _2660_/X _2896_/Q _2742_/S VPWR VGND sg13cmos5l_mux2_1
XANTENNA__3746__X E1BEG[0] VPWR VGND sg13cmos5l_antennanp
XFILLER_1_56 VPWR VGND sg13cmos5l_fill_1
XANTENNA__3656__X S2BEG[2] VPWR VGND sg13cmos5l_antennanp
X_1972_ _1973_/B _1970_/X _1971_/X _2083_/A VPWR VGND sg13cmos5l_mux2_1
X_3642_ FrameData_O[24] FrameData[24] VPWR VGND sg13cmos5l_buf_1
X_3711_ SS4BEG[9] SS4END[13] VPWR VGND sg13cmos5l_buf_1
XFILLER_46_0 VPWR VGND sg13cmos5l_fill_2
X_3573_ N4BEG[7] N4END[11] VPWR VGND sg13cmos5l_buf_1
X_2524_ _2524_/Y _3346_/Q _2524_/B VPWR VGND sg13cmos5l_nand2b_1
X_2455_ _2455_/X _2426_/B _2087_/X _3244_/Q VPWR VGND sg13cmos5l_mux2_1
X_2386_ _3728_/A _2382_/X _2383_/X _2384_/X _2385_/X _3039_/Q _3041_/Q VPWR VGND sg13cmos5l_mux4_1
X_3007_ _3007_/Q FrameData[21] FrameStrobe[12] VPWR VGND sg13cmos5l_dlhq_1
XANTENNA__3566__X N4BEG[0] VPWR VGND sg13cmos5l_antennanp
XFILLER_27_194 VPWR VGND sg13cmos5l_fill_2
XFILLER_15_367 VPWR VGND sg13cmos5l_fill_2
X_2171_ _2171_/X W6END[0] _2029_/X _2058_/X _2087_/X _3248_/Q _3246_/Q VPWR VGND sg13cmos5l_mux4_1
X_2240_ _2240_/Y _3094_/Q _2240_/B VPWR VGND sg13cmos5l_nand2_1
XFILLER_18_161 VPWR VGND sg13cmos5l_fill_2
XFILLER_21_348 VPWR VGND sg13cmos5l_fill_1
X_1886_ _1886_/Y _1888_/A _1885_/X _1510_/Y VPWR VGND sg13cmos5l_a21oi_1
X_1955_ _1955_/Y _3269_/Q _1955_/B _1955_/C VPWR VGND sg13cmos5l_nor3_1
X_3625_ FrameData_O[7] FrameData[7] VPWR VGND sg13cmos5l_buf_1
X_3487_ _3487_/L_HI VPWR VGND sg13cmos5l_tiehi
X_3556_ N2BEG[6] _3556_/A VPWR VGND sg13cmos5l_buf_1
X_2507_ _2508_/B N1END[2] W1END[2] E1END[2] _2426_/B _3007_/Q _3006_/Q VPWR VGND sg13cmos5l_mux4_1
X_2438_ _2438_/Y _3253_/Q _2438_/B VPWR VGND sg13cmos5l_nor2_1
X_2369_ _2370_/A SS4END[3] W1END[2] _2139_/B _1912_/B _3042_/Q _3044_/Q VPWR VGND
+ sg13cmos5l_mux4_1
XANTENNA_60 SS4END[7] VPWR VGND sg13cmos5l_antennanp
XANTENNA_71 W2MID[3] VPWR VGND sg13cmos5l_antennanp
XANTENNA_82 WW4END[0] VPWR VGND sg13cmos5l_antennanp
XANTENNA_93 WW4END[0] VPWR VGND sg13cmos5l_antennanp
XFILLER_20_370 VPWR VGND sg13cmos5l_decap_4
XFILLER_47_201 VPWR VGND sg13cmos5l_fill_1
XFILLER_30_156 VPWR VGND sg13cmos5l_fill_2
XFILLER_30_189 VPWR VGND sg13cmos5l_decap_4
XFILLER_7_55 VPWR VGND sg13cmos5l_fill_1
X_1671_ _1800_/A _1667_/Y _1669_/Y _1645_/Y VPWR VGND sg13cmos5l_a21o_1
X_1740_ _1740_/Y _2869_/Q _2052_/A VPWR VGND sg13cmos5l_nand2b_1
X_3410_ _3410_/L_HI VPWR VGND sg13cmos5l_tiehi
X_3341_ _3341_/Q FrameData[3] FrameStrobe[1] VPWR VGND sg13cmos5l_dlhq_1
X_3272_ _3272_/Q FrameData[30] FrameStrobe[4] VPWR VGND sg13cmos5l_dlhq_1
XFILLER_53_215 VPWR VGND sg13cmos5l_fill_1
XFILLER_53_248 VPWR VGND sg13cmos5l_fill_2
X_2085_ _2085_/Y _2083_/Y _2084_/Y _1967_/Y VPWR VGND sg13cmos5l_a21oi_1
X_2154_ _2155_/B W6END[0] _2029_/X _2058_/X _2087_/X _3280_/Q _3278_/Q VPWR VGND sg13cmos5l_mux4_1
X_2223_ _2223_/Y _3151_/Q _2223_/B VPWR VGND sg13cmos5l_nand2_1
X_2987_ _2987_/Q clkload7/A _2987_/D _3419_/L_HI VPWR VGND sg13cmos5l_dfrbpq_1
X_1869_ _1869_/X N4END[2] SS4END[2] _3396_/Q VPWR VGND sg13cmos5l_mux2_1
X_1938_ _1938_/Y _1961_/B _1821_/A _3144_/Q VPWR VGND sg13cmos5l_o21ai_1
X_3608_ FrameStrobe_O[10] FrameStrobe[10] VPWR VGND sg13cmos5l_buf_1
X_3539_ _3539_/L_HI VPWR VGND sg13cmos5l_tiehi
XFILLER_29_278 VPWR VGND sg13cmos5l_fill_1
XFILLER_44_237 VPWR VGND sg13cmos5l_fill_1
XANTENNA__3754__X W1BEG[3] VPWR VGND sg13cmos5l_antennanp
XFILLER_35_204 VPWR VGND sg13cmos5l_decap_4
X_2910_ _2910_/Q _2914_/CLK _2910_/D _3496_/L_HI VPWR VGND sg13cmos5l_dfrbpq_1
X_2841_ _2972_/D _2660_/X _2972_/Q _2844_/S VPWR VGND sg13cmos5l_mux2_1
XANTENNA__3664__X S2BEGb[2] VPWR VGND sg13cmos5l_antennanp
X_1654_ _1654_/Y _3288_/Q _1652_/Y _1653_/Y VPWR VGND sg13cmos5l_a21oi_1
X_1723_ _1723_/Y _3300_/Q _1720_/X _3299_/Q VPWR VGND sg13cmos5l_o21ai_1
X_2772_ _2922_/D _2675_/X _2922_/Q _2773_/S VPWR VGND sg13cmos5l_mux2_1
X_1585_ _1585_/Y S2MID[0] _3168_/Q VPWR VGND sg13cmos5l_nand2_1
X_2206_ _2206_/X NN4END[0] W2END[1] _3276_/Q VPWR VGND sg13cmos5l_mux2_1
X_3324_ _3324_/Q FrameData[18] FrameStrobe[2] VPWR VGND sg13cmos5l_dlhq_1
X_3255_ _3255_/Q FrameData[13] FrameStrobe[4] VPWR VGND sg13cmos5l_dlhq_1
X_2068_ _2068_/Y _2861_/Q _2116_/Y _2067_/Y VPWR VGND sg13cmos5l_a21oi_1
X_2137_ _2137_/Y _1980_/X _3312_/Q VPWR VGND sg13cmos5l_nand2b_1
X_3186_ _3186_/Q FrameData[8] FrameStrobe[6] VPWR VGND sg13cmos5l_dlhq_1
XANTENNA__3574__X N4BEG[8] VPWR VGND sg13cmos5l_antennanp
XANTENNA__3749__X E1BEG[3] VPWR VGND sg13cmos5l_antennanp
XFILLER_40_262 VPWR VGND sg13cmos5l_fill_1
XFILLER_9_436 VPWR VGND sg13cmos5l_fill_1
XANTENNA__3659__X S2BEG[5] VPWR VGND sg13cmos5l_antennanp
X_3040_ _3040_/Q FrameData[22] FrameStrobe[11] VPWR VGND sg13cmos5l_dlhq_1
X_2824_ _2828_/S _2845_/A _2834_/B VPWR VGND sg13cmos5l_nand2_1
X_1637_ _1637_/X _3294_/Q _1634_/Y _1636_/Y VPWR VGND sg13cmos5l_a21o_1
X_1706_ _1706_/Y _1794_/S VPWR VGND sg13cmos5l_inv_1
X_2755_ _2908_/D _2908_/Q _2660_/X _2758_/S VPWR VGND sg13cmos5l_mux2_1
X_2686_ _2686_/Y _3108_/Q _2685_/X VPWR VGND sg13cmos5l_nor2b_1
X_1499_ _1499_/Y _3351_/Q VPWR VGND sg13cmos5l_inv_1
X_1568_ _1568_/Y _3360_/Q _1565_/Y _1567_/Y VPWR VGND sg13cmos5l_o21ai_1
X_3307_ _3307_/Q FrameData[1] FrameStrobe[2] VPWR VGND sg13cmos5l_dlhq_1
X_3238_ _3238_/Q FrameData[28] FrameStrobe[5] VPWR VGND sg13cmos5l_dlhq_1
X_3169_ _3169_/Q FrameData[23] FrameStrobe[7] VPWR VGND sg13cmos5l_dlhq_1
XANTENNA__3569__X N4BEG[3] VPWR VGND sg13cmos5l_antennanp
XFILLER_45_387 VPWR VGND sg13cmos5l_fill_2
XFILLER_48_4 VPWR VGND sg13cmos5l_fill_2
Xclkload14 clkload14/Y _2905_/CLK VPWR VGND sg13cmos5l_inv_1
X_2540_ _2540_/Y _3338_/Q _2539_/Y _3339_/Q VPWR VGND sg13cmos5l_o21ai_1
X_2471_ _2472_/A NN4END[0] S2END[2] E2END[2] W2END[2] _3213_/Q _3212_/Q VPWR VGND
+ sg13cmos5l_mux4_1
X_3023_ _3023_/Q FrameData[5] FrameStrobe[11] VPWR VGND sg13cmos5l_dlhq_1
Xclkload8 clkload8/Y clkload8/A VPWR VGND sg13cmos5l_inv_1
X_3787_ WW4BEG[4] WW4END[8] VPWR VGND sg13cmos5l_buf_1
X_2807_ _2811_/S _2850_/A _2812_/B VPWR VGND sg13cmos5l_nand2_1
X_2738_ _2742_/S _2845_/A _2748_/B VPWR VGND sg13cmos5l_nand2_1
X_2669_ _2672_/B _3375_/Q _2669_/B _2669_/C VPWR VGND sg13cmos5l_nand3_1
XFILLER_27_387 VPWR VGND sg13cmos5l_decap_8
XFILLER_24_42 VPWR VGND sg13cmos5l_fill_2
XANTENNA__3762__X W2BEG[7] VPWR VGND sg13cmos5l_antennanp
XANTENNA_150 WW4END[3] VPWR VGND sg13cmos5l_antennanp
XFILLER_33_357 VPWR VGND sg13cmos5l_fill_1
X_1971_ _1971_/X _2955_/Q _2951_/Q _2987_/Q _2983_/Q _2116_/Y _2071_/A VPWR VGND sg13cmos5l_mux4_1
X_3572_ N4BEG[6] N4END[10] VPWR VGND sg13cmos5l_buf_1
X_3641_ FrameData_O[23] FrameData[23] VPWR VGND sg13cmos5l_buf_1
X_3710_ SS4BEG[8] SS4END[12] VPWR VGND sg13cmos5l_buf_1
XANTENNA__3672__X S4BEG[2] VPWR VGND sg13cmos5l_antennanp
X_2523_ _2524_/B _2426_/B _2620_/B _3348_/Q VPWR VGND sg13cmos5l_mux2_1
X_2454_ _2466_/A _2444_/Y _2447_/Y _2453_/Y VPWR VGND sg13cmos5l_o21ai_1
X_2385_ _2385_/X _2620_/B _1980_/X _1643_/A _1849_/X _3038_/Q _3040_/Q VPWR VGND sg13cmos5l_mux4_1
X_3006_ _3006_/Q FrameData[20] FrameStrobe[12] VPWR VGND sg13cmos5l_dlhq_1
XFILLER_24_379 VPWR VGND sg13cmos5l_decap_8
XANTENNA__3582__X NN4BEG[0] VPWR VGND sg13cmos5l_antennanp
XFILLER_19_64 VPWR VGND sg13cmos5l_fill_2
XFILLER_27_140 VPWR VGND sg13cmos5l_fill_2
XANTENNA__3757__X W2BEG[2] VPWR VGND sg13cmos5l_antennanp
Xclkbuf_5_8__f_UserCLK_regs _2986_/CLK clkbuf_3_2_0_UserCLK_regs/X VPWR VGND sg13cmos5l_buf_8
X_2170_ _2170_/Y _3246_/Q _2169_/Y _1456_/Y VPWR VGND sg13cmos5l_a21oi_1
XANTENNA__3667__X S2BEGb[5] VPWR VGND sg13cmos5l_antennanp
X_1954_ _1955_/C _3268_/Q _1951_/Y _1953_/Y VPWR VGND sg13cmos5l_a21oi_1
X_1885_ _1885_/X W1END[3] _1912_/B _2058_/X _2087_/X _3324_/Q _3322_/Q VPWR VGND sg13cmos5l_mux4_1
X_3555_ N2BEG[5] _3555_/A VPWR VGND sg13cmos5l_buf_1
X_3624_ FrameData_O[6] FrameData[6] VPWR VGND sg13cmos5l_buf_1
X_3486_ _3486_/L_HI VPWR VGND sg13cmos5l_tiehi
X_2506_ _2509_/A _2506_/A _2506_/B VPWR VGND sg13cmos5l_nor2_1
X_2437_ _2438_/B _3250_/Q _2435_/Y _2436_/Y VPWR VGND sg13cmos5l_a21oi_1
X_2368_ _2368_/X NN4END[3] _2058_/X E1END[2] _2426_/B _3044_/Q _3042_/Q VPWR VGND
+ sg13cmos5l_mux4_1
XFILLER_24_110 VPWR VGND sg13cmos5l_fill_2
X_2299_ _2302_/B _3308_/Q _2297_/X _2298_/Y VPWR VGND sg13cmos5l_a21oi_1
XANTENNA_50 SS4END[0] VPWR VGND sg13cmos5l_antennanp
XANTENNA_61 SS4END[8] VPWR VGND sg13cmos5l_antennanp
XANTENNA_72 W2MID[7] VPWR VGND sg13cmos5l_antennanp
XANTENNA_83 WW4END[0] VPWR VGND sg13cmos5l_antennanp
XANTENNA__3577__X N4BEG[11] VPWR VGND sg13cmos5l_antennanp
XANTENNA_94 WW4END[0] VPWR VGND sg13cmos5l_antennanp
XFILLER_28_471 VPWR VGND sg13cmos5l_fill_1
Xclkbuf_1_0__f_UserCLK _3750_/A clkbuf_0_UserCLK/X VPWR VGND sg13cmos5l_buf_8
XFILLER_7_23 VPWR VGND sg13cmos5l_fill_2
X_1670_ _1793_/S _1667_/Y _1669_/Y _1645_/Y VPWR VGND sg13cmos5l_a21oi_1
XFILLER_30_4 VPWR VGND sg13cmos5l_fill_1
X_2222_ _2223_/B _3150_/Q _3657_/A _2221_/Y VPWR VGND sg13cmos5l_a21oi_1
X_3340_ _3340_/Q FrameData[2] FrameStrobe[1] VPWR VGND sg13cmos5l_dlhq_1
X_3271_ _3271_/Q FrameData[29] FrameStrobe[4] VPWR VGND sg13cmos5l_dlhq_1
X_2084_ _2084_/Y _2077_/A _2081_/X _2080_/A VPWR VGND sg13cmos5l_a21oi_1
X_2153_ _3655_/A _3313_/Q _2143_/Y _2145_/Y _2152_/Y VPWR VGND sg13cmos5l_a22oi_1
X_1937_ _1969_/B _1934_/Y _1935_/Y _1936_/X _2083_/A _2080_/A VPWR VGND sg13cmos5l_a221oi_1
X_2986_ _2986_/Q _2986_/CLK _2986_/D _3420_/L_HI VPWR VGND sg13cmos5l_dfrbpq_1
X_1799_ _1800_/B _2939_/Q _2935_/Q _2971_/Q _2967_/Q _2052_/A _1623_/Y VPWR VGND sg13cmos5l_mux4_1
X_1868_ _1868_/Y _3396_/Q _3742_/A _1867_/Y VPWR VGND sg13cmos5l_a21oi_1
X_3538_ _3538_/L_HI VPWR VGND sg13cmos5l_tiehi
X_3607_ FrameStrobe_O[9] FrameStrobe[9] VPWR VGND sg13cmos5l_buf_1
X_3469_ _3469_/L_HI VPWR VGND sg13cmos5l_tiehi
XFILLER_4_301 VPWR VGND sg13cmos5l_decap_8
XANTENNA__3770__X W2BEGb[7] VPWR VGND sg13cmos5l_antennanp
X_2840_ _2844_/S _2840_/A _2855_/B VPWR VGND sg13cmos5l_nand2_1
X_2771_ _2921_/D _2663_/X _2921_/Q _2773_/S VPWR VGND sg13cmos5l_mux2_1
X_1584_ _1584_/Y _1497_/Y _3760_/A _1583_/Y VPWR VGND sg13cmos5l_o21ai_1
X_1653_ _1653_/Y _3288_/Q _1650_/X _3287_/Q VPWR VGND sg13cmos5l_o21ai_1
X_1722_ _1722_/Y S2END[7] _3298_/Q _1721_/Y VPWR VGND sg13cmos5l_a21oi_1
XANTENNA__3680__X S4BEG[10] VPWR VGND sg13cmos5l_antennanp
XFILLER_21_0 VPWR VGND sg13cmos5l_fill_2
X_2205_ _2205_/Y _3275_/Q _2200_/X _3277_/Q VPWR VGND sg13cmos5l_o21ai_1
X_3323_ _3323_/Q FrameData[17] FrameStrobe[2] VPWR VGND sg13cmos5l_dlhq_1
X_3254_ _3254_/Q FrameData[12] FrameStrobe[4] VPWR VGND sg13cmos5l_dlhq_1
X_3185_ _3185_/Q FrameData[7] FrameStrobe[6] VPWR VGND sg13cmos5l_dlhq_1
X_2067_ _2067_/Y _2116_/Y _2865_/Q VPWR VGND sg13cmos5l_nor2b_1
X_2136_ _2136_/X W6END[0] _2029_/X _2058_/X _2087_/X _3312_/Q _3310_/Q VPWR VGND sg13cmos5l_mux4_1
X_2969_ _2969_/Q _2970_/CLK _2969_/D _3437_/L_HI VPWR VGND sg13cmos5l_dfrbpq_1
XANTENNA__3590__X NN4BEG[8] VPWR VGND sg13cmos5l_antennanp
XANTENNA__3765__X W2BEGb[2] VPWR VGND sg13cmos5l_antennanp
XANTENNA__3675__X S4BEG[5] VPWR VGND sg13cmos5l_antennanp
XFILLER_31_274 VPWR VGND sg13cmos5l_decap_4
X_1705_ _1794_/S _1702_/X _1704_/A _1686_/X _1685_/X _3128_/Q _3129_/Q VPWR VGND sg13cmos5l_mux4_1
X_2823_ _2959_/D _2689_/Y _2959_/Q _2823_/S VPWR VGND sg13cmos5l_mux2_1
X_2754_ _2758_/S _2840_/A _2769_/B VPWR VGND sg13cmos5l_and2_1
X_1567_ _1567_/Y _3360_/Q _1566_/X _1490_/Y VPWR VGND sg13cmos5l_a21oi_1
X_1636_ _1636_/Y _3294_/Q _1635_/X _3295_/Q VPWR VGND sg13cmos5l_o21ai_1
X_3306_ _3306_/Q FrameData[0] FrameStrobe[2] VPWR VGND sg13cmos5l_dlhq_1
X_2685_ _2685_/X N2MID[0] E2MID[0] S2MID[0] _3758_/A _3152_/Q _3153_/Q VPWR VGND sg13cmos5l_mux4_1
X_1498_ _1606_/A _3353_/Q VPWR VGND sg13cmos5l_inv_1
X_2119_ _2119_/Y _1980_/X _3344_/Q VPWR VGND sg13cmos5l_nand2b_1
X_3237_ _3237_/Q FrameData[27] FrameStrobe[5] VPWR VGND sg13cmos5l_dlhq_1
X_3168_ _3168_/Q FrameData[22] FrameStrobe[7] VPWR VGND sg13cmos5l_dlhq_1
X_3099_ _3099_/Q FrameData[17] FrameStrobe[9] VPWR VGND sg13cmos5l_dlhq_1
XANTENNA__3585__X NN4BEG[3] VPWR VGND sg13cmos5l_antennanp
XFILLER_13_44 VPWR VGND sg13cmos5l_fill_1
XFILLER_1_134 VPWR VGND sg13cmos5l_fill_2
XFILLER_1_156 VPWR VGND sg13cmos5l_fill_2
XFILLER_13_274 VPWR VGND sg13cmos5l_fill_1
XFILLER_9_289 VPWR VGND sg13cmos5l_fill_2
Xclkload15 clkload15/Y _2866_/CLK VPWR VGND sg13cmos5l_inv_1
Xclkbuf_3_7_0_UserCLK_regs clkbuf_3_7_0_UserCLK_regs/X clkbuf_0_UserCLK_regs/X VPWR
+ VGND sg13cmos5l_buf_8
X_2470_ _2479_/A _3017_/Q _2470_/B VPWR VGND sg13cmos5l_nor2_1
X_3022_ _3022_/Q FrameData[4] FrameStrobe[11] VPWR VGND sg13cmos5l_dlhq_1
Xclkload9 clkload9/Y clkload9/A VPWR VGND sg13cmos5l_inv_1
X_3786_ WW4BEG[3] WW4END[7] VPWR VGND sg13cmos5l_buf_1
X_2806_ _2947_/D _2689_/Y _2947_/Q _2806_/S VPWR VGND sg13cmos5l_mux2_1
X_2737_ _2895_/D _2895_/Q _2689_/Y _2737_/S VPWR VGND sg13cmos5l_mux2_1
X_2668_ _2669_/C _3374_/Q W6END[1] VPWR VGND sg13cmos5l_nand2b_1
X_1619_ _1957_/B NN4END[2] E2END[1] S2END[1] W2END[1] _3232_/Q _3233_/Q VPWR VGND
+ sg13cmos5l_mux4_1
X_2599_ _2599_/X _2599_/A _2599_/B VPWR VGND sg13cmos5l_and2_1
XFILLER_6_204 VPWR VGND sg13cmos5l_decap_8
XFILLER_40_31 VPWR VGND sg13cmos5l_fill_1
XFILLER_2_476 VPWR VGND sg13cmos5l_fill_1
XANTENNA_140 FrameData[30] VPWR VGND sg13cmos5l_antennanp
XANTENNA_151 WW4END[3] VPWR VGND sg13cmos5l_antennanp
X_1970_ _1970_/X _2947_/Q _2943_/Q _2979_/Q _2975_/Q _2116_/Y _2071_/A VPWR VGND sg13cmos5l_mux4_1
X_3571_ N4BEG[5] N4END[9] VPWR VGND sg13cmos5l_buf_1
X_3640_ FrameData_O[22] FrameData[22] VPWR VGND sg13cmos5l_buf_1
X_2522_ _2522_/X _1912_/B _1980_/X _3348_/Q VPWR VGND sg13cmos5l_mux2_1
X_2453_ _2453_/Y _2451_/Y _2452_/Y _3245_/Q VPWR VGND sg13cmos5l_a21oi_1
X_2384_ _2384_/X _2029_/X _2237_/X _2087_/X _2238_/X _3040_/Q _3038_/Q VPWR VGND sg13cmos5l_mux4_1
X_3005_ _3005_/Q FrameData[19] FrameStrobe[12] VPWR VGND sg13cmos5l_dlhq_1
X_3769_ W2BEGb[6] W2MID[6] VPWR VGND sg13cmos5l_buf_1
XANTENNA__3773__X W6BEG[2] VPWR VGND sg13cmos5l_antennanp
XFILLER_21_328 VPWR VGND sg13cmos5l_fill_1
X_1884_ _1884_/Y _3322_/Q _1880_/Y _1883_/Y VPWR VGND sg13cmos5l_o21ai_1
X_1953_ _1953_/Y _3268_/Q _1952_/X _3267_/Q VPWR VGND sg13cmos5l_o21ai_1
XANTENNA__3683__X S4BEG[13] VPWR VGND sg13cmos5l_antennanp
XFILLER_51_0 VPWR VGND sg13cmos5l_fill_1
X_3485_ _3485_/L_HI VPWR VGND sg13cmos5l_tiehi
X_3554_ N2BEG[4] _3554_/A VPWR VGND sg13cmos5l_buf_1
X_3623_ FrameData_O[5] FrameData[5] VPWR VGND sg13cmos5l_buf_1
X_2505_ _2506_/B _3006_/Q _2504_/Y _3008_/Q VPWR VGND sg13cmos5l_o21ai_1
XFILLER_29_428 VPWR VGND sg13cmos5l_decap_4
X_2298_ _2298_/Y _3308_/Q _2296_/Y _3307_/Q VPWR VGND sg13cmos5l_o21ai_1
X_2436_ _2436_/Y _3250_/Q _2433_/X _3251_/Q VPWR VGND sg13cmos5l_o21ai_1
X_2367_ _3650_/A _2029_/X _3741_/A _2329_/X _2328_/X _3047_/Q _3046_/Q VPWR VGND sg13cmos5l_mux4_1
XFILLER_52_464 VPWR VGND sg13cmos5l_fill_2
XANTENNA_40 S4END[1] VPWR VGND sg13cmos5l_antennanp
XANTENNA_51 SS4END[0] VPWR VGND sg13cmos5l_antennanp
XANTENNA_62 SS4END[9] VPWR VGND sg13cmos5l_antennanp
XANTENNA_73 W2MID[7] VPWR VGND sg13cmos5l_antennanp
XANTENNA_84 WW4END[0] VPWR VGND sg13cmos5l_antennanp
XANTENNA_95 WW4END[0] VPWR VGND sg13cmos5l_antennanp
XANTENNA__3593__X NN4BEG[11] VPWR VGND sg13cmos5l_antennanp
XFILLER_12_328 VPWR VGND sg13cmos5l_fill_2
XANTENNA__3768__X W2BEGb[5] VPWR VGND sg13cmos5l_antennanp
XFILLER_43_420 VPWR VGND sg13cmos5l_fill_1
XFILLER_11_394 VPWR VGND sg13cmos5l_fill_2
X_2152_ _2152_/Y _3313_/Q _2152_/B VPWR VGND sg13cmos5l_nor2_1
X_2221_ _2221_/Y _3150_/Q W2MID[4] VPWR VGND sg13cmos5l_nor2b_1
X_3270_ _3270_/Q FrameData[28] FrameStrobe[4] VPWR VGND sg13cmos5l_dlhq_1
XANTENNA__3678__X S4BEG[8] VPWR VGND sg13cmos5l_antennanp
XFILLER_26_409 VPWR VGND sg13cmos5l_fill_1
X_2083_ _2083_/Y _2083_/A _2083_/B VPWR VGND sg13cmos5l_nand2_1
XFILLER_21_136 VPWR VGND sg13cmos5l_decap_4
X_1867_ _1867_/Y _2173_/A _3396_/Q _3397_/Q VPWR VGND sg13cmos5l_o21ai_1
X_1936_ _1936_/X _2907_/Q _2903_/Q _2875_/Q _2871_/Q _2116_/Y _2014_/A VPWR VGND sg13cmos5l_mux4_1
X_2985_ _2985_/Q clkload6/A _2985_/D _3421_/L_HI VPWR VGND sg13cmos5l_dfrbpq_1
X_1798_ _1798_/Y _1793_/S _1797_/X _1794_/S VPWR VGND sg13cmos5l_a21oi_1
X_3537_ _3537_/L_HI VPWR VGND sg13cmos5l_tiehi
X_3606_ FrameStrobe_O[8] FrameStrobe[8] VPWR VGND sg13cmos5l_buf_1
X_3468_ _3468_/L_HI VPWR VGND sg13cmos5l_tiehi
XFILLER_29_236 VPWR VGND sg13cmos5l_decap_8
XFILLER_29_269 VPWR VGND sg13cmos5l_decap_8
X_3399_ _3399_/Q FrameData[29] FrameStrobe[0] VPWR VGND sg13cmos5l_dlhq_1
X_2419_ _2422_/A _2419_/A _2419_/B VPWR VGND sg13cmos5l_nor2_1
XANTENNA__3588__X NN4BEG[6] VPWR VGND sg13cmos5l_antennanp
XFILLER_25_442 VPWR VGND sg13cmos5l_fill_1
XFILLER_25_464 VPWR VGND sg13cmos5l_fill_1
XFILLER_16_497 VPWR VGND sg13cmos5l_fill_2
XFILLER_31_456 VPWR VGND sg13cmos5l_fill_2
X_1721_ _1721_/Y _3298_/Q S1END[3] VPWR VGND sg13cmos5l_nor2b_1
X_2770_ _2920_/D _2660_/X _2920_/Q _2773_/S VPWR VGND sg13cmos5l_mux2_1
X_1583_ _1583_/Y _1583_/A VPWR VGND sg13cmos5l_inv_1
X_1652_ _1652_/Y W2END[4] _3286_/Q _1651_/Y VPWR VGND sg13cmos5l_a21oi_1
X_3322_ _3322_/Q FrameData[16] FrameStrobe[2] VPWR VGND sg13cmos5l_dlhq_1
X_2135_ _2135_/Y _3756_/A VPWR VGND sg13cmos5l_inv_1
X_2204_ _2204_/Y _3274_/Q _2201_/X _2203_/Y VPWR VGND sg13cmos5l_a21oi_1
X_3253_ _3253_/Q FrameData[11] FrameStrobe[4] VPWR VGND sg13cmos5l_dlhq_1
X_3184_ _3184_/Q FrameData[6] FrameStrobe[6] VPWR VGND sg13cmos5l_dlhq_1
XFILLER_22_445 VPWR VGND sg13cmos5l_fill_1
X_2066_ _2075_/B _2063_/Y _2064_/Y _2065_/X _2083_/A _1973_/A VPWR VGND sg13cmos5l_a221oi_1
X_1919_ _1919_/Y _3139_/Q _1919_/B VPWR VGND sg13cmos5l_nand2b_1
X_2968_ _2968_/Q clkload2/A _2968_/D _3438_/L_HI VPWR VGND sg13cmos5l_dfrbpq_1
X_2899_ _2899_/Q _2899_/CLK _2899_/D _3507_/L_HI VPWR VGND sg13cmos5l_dfrbpq_1
XFILLER_32_209 VPWR VGND sg13cmos5l_fill_1
XFILLER_40_275 VPWR VGND sg13cmos5l_fill_2
XANTENNA__3781__X W6BEG[10] VPWR VGND sg13cmos5l_antennanp
X_1704_ _2630_/B _1704_/A VPWR VGND sg13cmos5l_inv_1
X_2822_ _2958_/D _2675_/X _2958_/Q _2823_/S VPWR VGND sg13cmos5l_mux2_1
X_2753_ _2769_/B _2839_/A _2753_/B VPWR VGND sg13cmos5l_nor2_1
X_2684_ _2684_/Y _2678_/Y _2681_/Y _2683_/Y VPWR VGND sg13cmos5l_o21ai_1
XANTENNA__3691__X EE4BEG[5] VPWR VGND sg13cmos5l_antennanp
X_1497_ _1497_/Y _3168_/Q VPWR VGND sg13cmos5l_inv_1
X_1566_ _1566_/X S2END[6] W1END[2] _3358_/Q VPWR VGND sg13cmos5l_mux2_1
X_1635_ _1635_/X E1END[2] S1END[2] _3296_/Q VPWR VGND sg13cmos5l_mux2_1
X_3305_ _3305_/Q FrameData[31] FrameStrobe[3] VPWR VGND sg13cmos5l_dlhq_1
X_2049_ _2049_/Y _2052_/A _2928_/Q VPWR VGND sg13cmos5l_nor2b_1
X_2118_ _2118_/Y _3343_/Q _2118_/B VPWR VGND sg13cmos5l_nand2b_1
X_3236_ _3236_/Q FrameData[26] FrameStrobe[5] VPWR VGND sg13cmos5l_dlhq_1
X_3167_ _3167_/Q FrameData[21] FrameStrobe[7] VPWR VGND sg13cmos5l_dlhq_1
X_3098_ _3098_/Q FrameData[16] FrameStrobe[9] VPWR VGND sg13cmos5l_dlhq_1
XFILLER_49_117 VPWR VGND sg13cmos5l_fill_2
XANTENNA__3776__X W6BEG[5] VPWR VGND sg13cmos5l_antennanp
Xclkload16 clkload16/Y _2899_/CLK VPWR VGND sg13cmos5l_inv_1
X_3021_ _3021_/Q FrameData[3] FrameStrobe[11] VPWR VGND sg13cmos5l_dlhq_1
XANTENNA__3686__X EE4BEG[0] VPWR VGND sg13cmos5l_antennanp
X_2805_ _2946_/D _2675_/X _2946_/Q _2806_/S VPWR VGND sg13cmos5l_mux2_1
X_1618_ _1618_/X _3130_/Q _1618_/B VPWR VGND sg13cmos5l_and2_1
X_3785_ WW4BEG[2] WW4END[6] VPWR VGND sg13cmos5l_buf_1
X_2736_ _2894_/D _2894_/Q _2675_/X _2737_/S VPWR VGND sg13cmos5l_mux2_1
X_2667_ _2669_/B _3374_/Q _3655_/A VPWR VGND sg13cmos5l_nand2_1
X_1549_ _1549_/Y _3262_/Q _1549_/B _1549_/C VPWR VGND sg13cmos5l_nor3_1
Xclkbuf_5_3__f_UserCLK_regs clkload2/A clkbuf_3_0_0_UserCLK_regs/X VPWR VGND sg13cmos5l_buf_8
X_3219_ _3219_/Q FrameData[9] FrameStrobe[5] VPWR VGND sg13cmos5l_dlhq_1
X_2598_ _2599_/B WW4END[0] _1912_/B _2058_/X _2029_/X _3368_/Q _3366_/Q VPWR VGND
+ sg13cmos5l_mux4_1
XANTENNA__3596__X NN4BEG[14] VPWR VGND sg13cmos5l_antennanp
XFILLER_10_256 VPWR VGND sg13cmos5l_fill_2
Xclkbuf_regs_0_UserCLK clkbuf_regs_0_UserCLK/X UserCLK VPWR VGND sg13cmos5l_buf_8
XANTENNA_130 FrameData[30] VPWR VGND sg13cmos5l_antennanp
XANTENNA_141 FrameData[30] VPWR VGND sg13cmos5l_antennanp
XANTENNA_152 WW4END[3] VPWR VGND sg13cmos5l_antennanp
X_3570_ N4BEG[4] N4END[8] VPWR VGND sg13cmos5l_buf_1
X_2521_ _2521_/X W6END[1] _2029_/X _2058_/X _2087_/X _3348_/Q _3346_/Q VPWR VGND sg13cmos5l_mux4_1
X_2452_ _2452_/Y _3244_/Q _2448_/X _3243_/Q VPWR VGND sg13cmos5l_a21oi_1
X_2383_ _2383_/X SS4END[0] _2139_/B W1END[3] _1912_/B _3040_/Q _3038_/Q VPWR VGND
+ sg13cmos5l_mux4_1
Xclkbuf_5_18__f_UserCLK_regs _2907_/CLK clkbuf_3_4_0_UserCLK_regs/X VPWR VGND sg13cmos5l_buf_8
X_3004_ _3004_/Q FrameData[18] FrameStrobe[12] VPWR VGND sg13cmos5l_dlhq_1
X_3768_ W2BEGb[5] W2MID[5] VPWR VGND sg13cmos5l_buf_1
XFILLER_10_13 VPWR VGND sg13cmos5l_fill_1
X_3699_ EE4BEG[13] _3699_/A VPWR VGND sg13cmos5l_buf_1
X_2719_ _2882_/D _2675_/X _2882_/Q _2720_/S VPWR VGND sg13cmos5l_mux2_1
XFILLER_27_142 VPWR VGND sg13cmos5l_fill_1
XFILLER_35_10 VPWR VGND sg13cmos5l_fill_1
X_1883_ _1883_/Y _3322_/Q _1882_/Y _1888_/A VPWR VGND sg13cmos5l_a21oi_1
X_1952_ _1952_/X NN4END[1] E1END[3] _3266_/Q VPWR VGND sg13cmos5l_mux2_1
X_3622_ FrameData_O[4] FrameData[4] VPWR VGND sg13cmos5l_buf_1
XFILLER_44_0 VPWR VGND sg13cmos5l_fill_2
X_3484_ _3484_/L_HI VPWR VGND sg13cmos5l_tiehi
X_3553_ N2BEG[3] _3553_/A VPWR VGND sg13cmos5l_buf_1
X_2504_ _2504_/Y _3007_/Q _2238_/X _2503_/Y VPWR VGND sg13cmos5l_a21oi_1
X_2435_ _2435_/Y E2END[3] _3252_/Q _2434_/Y VPWR VGND sg13cmos5l_o21ai_1
X_2297_ _2297_/X W2END[1] WW4END[0] _3306_/Q VPWR VGND sg13cmos5l_mux2_1
X_2366_ _3651_/A _2087_/X _1561_/X _3738_/A _1685_/X _3048_/Q _3049_/Q VPWR VGND sg13cmos5l_mux4_1
XFILLER_24_112 VPWR VGND sg13cmos5l_fill_1
XFILLER_52_487 VPWR VGND sg13cmos5l_fill_1
XANTENNA_30 N2MID[2] VPWR VGND sg13cmos5l_antennanp
XANTENNA_41 S4END[1] VPWR VGND sg13cmos5l_antennanp
XANTENNA_52 SS4END[0] VPWR VGND sg13cmos5l_antennanp
XANTENNA_63 W2END[0] VPWR VGND sg13cmos5l_antennanp
XANTENNA_74 W2MID[7] VPWR VGND sg13cmos5l_antennanp
XANTENNA_85 WW4END[0] VPWR VGND sg13cmos5l_antennanp
XANTENNA_96 WW4END[0] VPWR VGND sg13cmos5l_antennanp
XANTENNA__3784__X WW4BEG[1] VPWR VGND sg13cmos5l_antennanp
XFILLER_7_366 VPWR VGND sg13cmos5l_fill_1
X_2082_ _2083_/B _2937_/Q _2969_/Q _2933_/Q _2965_/Q _2071_/A _2116_/Y VPWR VGND sg13cmos5l_mux4_1
X_2151_ _2152_/B _3310_/Q _2149_/Y _2150_/Y VPWR VGND sg13cmos5l_a21oi_1
X_2220_ _2220_/X N2MID[4] E2MID[4] _3150_/Q VPWR VGND sg13cmos5l_mux2_1
XFILLER_34_454 VPWR VGND sg13cmos5l_fill_1
X_2984_ _2984_/Q clkload8/A _2984_/D _3422_/L_HI VPWR VGND sg13cmos5l_dfrbpq_1
XANTENNA__3694__X EE4BEG[8] VPWR VGND sg13cmos5l_antennanp
X_1797_ _1797_/X _2947_/Q _2943_/Q _2979_/Q _2975_/Q _2052_/A _1623_/Y VPWR VGND sg13cmos5l_mux4_1
X_1866_ _3742_/A _1858_/Y _1866_/B VPWR VGND sg13cmos5l_nand2b_1
X_1935_ _1935_/Y _2014_/A _1931_/Y _2083_/A VPWR VGND sg13cmos5l_a21oi_1
X_3605_ FrameStrobe_O[7] FrameStrobe[7] VPWR VGND sg13cmos5l_buf_1
X_3536_ _3536_/L_HI VPWR VGND sg13cmos5l_tiehi
X_3467_ _3467_/L_HI VPWR VGND sg13cmos5l_tiehi
X_3398_ _3398_/Q FrameData[28] FrameStrobe[0] VPWR VGND sg13cmos5l_dlhq_1
X_2418_ _2419_/B _3027_/Q _2417_/Y _3028_/Q VPWR VGND sg13cmos5l_o21ai_1
XFILLER_37_281 VPWR VGND sg13cmos5l_fill_1
X_2349_ _3715_/A _2347_/X _2348_/X _2345_/Y _2346_/X _3066_/Q _3067_/Q VPWR VGND sg13cmos5l_mux4_1
XFILLER_16_78 VPWR VGND sg13cmos5l_fill_1
XFILLER_25_498 VPWR VGND sg13cmos5l_fill_1
XFILLER_32_33 VPWR VGND sg13cmos5l_fill_2
XANTENNA__3779__X W6BEG[8] VPWR VGND sg13cmos5l_antennanp
XFILLER_31_402 VPWR VGND sg13cmos5l_fill_2
XFILLER_43_262 VPWR VGND sg13cmos5l_fill_2
X_1651_ _1651_/Y _3286_/Q SS4END[3] VPWR VGND sg13cmos5l_nor2b_1
X_1720_ _1720_/X E1END[3] E2END[7] _3298_/Q VPWR VGND sg13cmos5l_mux2_1
X_1582_ _1583_/A W2MID[0] _3168_/Q _3169_/Q VPWR VGND sg13cmos5l_o21ai_1
X_3321_ _3321_/Q FrameData[15] FrameStrobe[2] VPWR VGND sg13cmos5l_dlhq_1
X_3252_ _3252_/Q FrameData[10] FrameStrobe[4] VPWR VGND sg13cmos5l_dlhq_1
XANTENNA__3689__X EE4BEG[3] VPWR VGND sg13cmos5l_antennanp
XFILLER_26_218 VPWR VGND sg13cmos5l_fill_2
X_2065_ _2065_/X _2889_/Q _2921_/Q _2885_/Q _2917_/Q _2071_/A _2116_/Y VPWR VGND sg13cmos5l_mux4_1
X_2134_ _3756_/A _2118_/Y _2125_/Y _2127_/Y _2133_/Y VPWR VGND sg13cmos5l_a22oi_1
X_2203_ _2203_/Y _3274_/Q _2202_/X _3275_/Q VPWR VGND sg13cmos5l_o21ai_1
X_3183_ _3183_/Q FrameData[5] FrameStrobe[6] VPWR VGND sg13cmos5l_dlhq_1
X_2967_ _2967_/Q clkload1/A _2967_/D _3439_/L_HI VPWR VGND sg13cmos5l_dfrbpq_1
X_1849_ _1849_/X N2MID[3] E2MID[3] S2MID[3] W2MID[3] _3204_/Q _3205_/Q VPWR VGND sg13cmos5l_mux4_1
X_1918_ _1919_/B E2MID[4] W2MID[4] S2MID[4] _3660_/A _3175_/Q _3174_/Q VPWR VGND sg13cmos5l_mux4_1
X_2898_ _2898_/Q _2898_/CLK _2898_/D _3508_/L_HI VPWR VGND sg13cmos5l_dfrbpq_1
X_3519_ _3519_/L_HI VPWR VGND sg13cmos5l_tiehi
XANTENNA__3599__X FrameStrobe_O[1] VPWR VGND sg13cmos5l_antennanp
XFILLER_13_424 VPWR VGND sg13cmos5l_fill_2
XFILLER_4_100 VPWR VGND sg13cmos5l_fill_2
X_2821_ _2957_/D _2663_/X _2957_/Q _2823_/S VPWR VGND sg13cmos5l_mux2_1
X_1634_ _1634_/Y _3296_/Q S2END[6] _1633_/Y VPWR VGND sg13cmos5l_a21oi_1
X_1703_ _1704_/A N2MID[5] E2MID[5] S2MID[5] W2MID[5] _3198_/Q _3199_/Q VPWR VGND sg13cmos5l_mux4_1
X_2752_ _2907_/D _2689_/Y _2907_/Q _2752_/S VPWR VGND sg13cmos5l_mux2_1
X_2683_ _2683_/Y _2683_/A VPWR VGND sg13cmos5l_inv_1
XFILLER_39_310 VPWR VGND sg13cmos5l_fill_1
X_1496_ _1496_/Y _3169_/Q VPWR VGND sg13cmos5l_inv_1
X_1565_ _1565_/Y E2END[6] _3358_/Q _1564_/Y VPWR VGND sg13cmos5l_a21oi_1
X_3304_ _3304_/Q FrameData[30] FrameStrobe[3] VPWR VGND sg13cmos5l_dlhq_1
X_3235_ _3235_/Q FrameData[25] FrameStrobe[5] VPWR VGND sg13cmos5l_dlhq_1
X_2048_ _2048_/X _2936_/Q _2968_/Q _2932_/Q _2964_/Q _1623_/Y _2052_/A VPWR VGND sg13cmos5l_mux4_1
X_2117_ _2118_/B W6END[0] _2029_/X _2058_/X _2087_/X _3344_/Q _3342_/Q VPWR VGND sg13cmos5l_mux4_1
X_3166_ _3166_/Q FrameData[20] FrameStrobe[7] VPWR VGND sg13cmos5l_dlhq_1
X_3097_ _3097_/Q FrameData[15] FrameStrobe[9] VPWR VGND sg13cmos5l_dlhq_1
XFILLER_38_54 VPWR VGND sg13cmos5l_fill_2
XANTENNA__3792__X WW4BEG[9] VPWR VGND sg13cmos5l_antennanp
Xclkload17 clkload17/Y _2898_/CLK VPWR VGND sg13cmos5l_inv_1
XFILLER_0_180 VPWR VGND sg13cmos5l_fill_1
Xclkbuf_5_26__f_UserCLK_regs _2920_/CLK clkbuf_3_6_0_UserCLK_regs/X VPWR VGND sg13cmos5l_buf_8
X_3020_ _3020_/Q FrameData[2] FrameStrobe[11] VPWR VGND sg13cmos5l_dlhq_1
X_3784_ WW4BEG[1] WW4END[5] VPWR VGND sg13cmos5l_buf_1
X_2804_ _2945_/D _2663_/X _2945_/Q _2806_/S VPWR VGND sg13cmos5l_mux2_1
XFILLER_8_291 VPWR VGND sg13cmos5l_fill_2
X_1617_ _1618_/B EE4END[3] _3392_/Q _1616_/Y VPWR VGND sg13cmos5l_o21ai_1
X_2735_ _2893_/D _2893_/Q _2663_/X _2737_/S VPWR VGND sg13cmos5l_mux2_1
X_2666_ _2675_/A _3106_/Q _2495_/B _2665_/Y VPWR VGND sg13cmos5l_o21ai_1
X_2597_ _2597_/Y _3118_/Q _2597_/B VPWR VGND sg13cmos5l_nor2_1
X_1479_ _1479_/Y _3144_/Q VPWR VGND sg13cmos5l_inv_1
X_1548_ _1549_/C _2620_/B _3264_/Q VPWR VGND sg13cmos5l_nor2b_1
X_3218_ _3218_/Q FrameData[8] FrameStrobe[5] VPWR VGND sg13cmos5l_dlhq_1
X_3149_ _3149_/Q FrameData[3] FrameStrobe[7] VPWR VGND sg13cmos5l_dlhq_1
XFILLER_54_187 VPWR VGND sg13cmos5l_fill_2
Xclkbuf_0_UserCLK_regs clkbuf_0_UserCLK_regs/X clkbuf_regs_0_UserCLK/X VPWR VGND sg13cmos5l_buf_8
XFILLER_2_445 VPWR VGND sg13cmos5l_fill_1
XFILLER_49_64 VPWR VGND sg13cmos5l_fill_1
XFILLER_49_75 VPWR VGND sg13cmos5l_fill_2
XANTENNA_120 FrameData[3] VPWR VGND sg13cmos5l_antennanp
XANTENNA_131 FrameData[30] VPWR VGND sg13cmos5l_antennanp
XANTENNA_142 FrameData[30] VPWR VGND sg13cmos5l_antennanp
XANTENNA__3787__X WW4BEG[4] VPWR VGND sg13cmos5l_antennanp
XFILLER_5_261 VPWR VGND sg13cmos5l_fill_2
X_2520_ _2520_/Y _2515_/Y _2517_/Y _3349_/Q VPWR VGND sg13cmos5l_a21oi_1
X_2451_ _2451_/Y _3244_/Q _2451_/B VPWR VGND sg13cmos5l_nand2b_1
X_3003_ _3003_/Q FrameData[17] FrameStrobe[12] VPWR VGND sg13cmos5l_dlhq_1
X_2382_ _2382_/X NN4END[0] E1END[3] _2058_/X _2426_/B _3038_/Q _3040_/Q VPWR VGND
+ sg13cmos5l_mux4_1
XANTENNA__3697__X EE4BEG[11] VPWR VGND sg13cmos5l_antennanp
XFILLER_36_198 VPWR VGND sg13cmos5l_fill_1
Xclkbuf_3_3_0_UserCLK_regs clkbuf_3_3_0_UserCLK_regs/X clkbuf_0_UserCLK_regs/X VPWR
+ VGND sg13cmos5l_buf_8
X_3767_ W2BEGb[4] W2MID[4] VPWR VGND sg13cmos5l_buf_1
X_2718_ _2881_/D _2663_/X _2881_/Q _2720_/S VPWR VGND sg13cmos5l_mux2_1
X_3698_ EE4BEG[12] _3698_/A VPWR VGND sg13cmos5l_buf_1
X_2649_ _2649_/Y _3382_/Q _3656_/A _2648_/Y VPWR VGND sg13cmos5l_a21oi_1
XFILLER_15_305 VPWR VGND sg13cmos5l_decap_4
XFILLER_27_176 VPWR VGND sg13cmos5l_fill_1
XFILLER_4_0 VPWR VGND sg13cmos5l_fill_1
XFILLER_18_110 VPWR VGND sg13cmos5l_fill_2
XFILLER_18_154 VPWR VGND sg13cmos5l_decap_8
X_1882_ _1882_/Y _3324_/Q _2139_/B _1881_/Y VPWR VGND sg13cmos5l_o21ai_1
X_1951_ _1951_/Y S2END[7] _1481_/Y _1950_/X VPWR VGND sg13cmos5l_a21oi_1
X_3552_ N2BEG[2] _3552_/A VPWR VGND sg13cmos5l_buf_1
X_3621_ FrameData_O[3] FrameData[3] VPWR VGND sg13cmos5l_buf_1
XFILLER_37_0 VPWR VGND sg13cmos5l_fill_2
X_3483_ _3483_/L_HI VPWR VGND sg13cmos5l_tiehi
X_2503_ _2503_/Y _3007_/Q _2087_/X VPWR VGND sg13cmos5l_nor2b_1
X_2434_ _2434_/Y _2434_/A _3252_/Q VPWR VGND sg13cmos5l_nand2_1
X_2365_ _3652_/A _2620_/B _1849_/X _3739_/A _1843_/A _3050_/Q _3051_/Q VPWR VGND sg13cmos5l_mux4_1
X_2296_ _2296_/Y E6END[1] _3306_/Q _2295_/Y VPWR VGND sg13cmos5l_a21oi_1
XANTENNA_20 N2MID[2] VPWR VGND sg13cmos5l_antennanp
XANTENNA_31 N2MID[4] VPWR VGND sg13cmos5l_antennanp
XANTENNA_42 S4END[1] VPWR VGND sg13cmos5l_antennanp
XANTENNA_53 SS4END[0] VPWR VGND sg13cmos5l_antennanp
XANTENNA_64 W2END[0] VPWR VGND sg13cmos5l_antennanp
XANTENNA_75 W2MID[7] VPWR VGND sg13cmos5l_antennanp
XANTENNA_86 WW4END[0] VPWR VGND sg13cmos5l_antennanp
XANTENNA_97 WW4END[0] VPWR VGND sg13cmos5l_antennanp
XFILLER_11_396 VPWR VGND sg13cmos5l_fill_1
XFILLER_38_205 VPWR VGND sg13cmos5l_fill_2
X_2081_ _2081_/X _2929_/Q _2961_/Q _2925_/Q _2957_/Q _2071_/A _2116_/Y VPWR VGND sg13cmos5l_mux4_1
X_2150_ _2150_/Y _3310_/Q _2147_/Y _3311_/Q VPWR VGND sg13cmos5l_o21ai_1
XFILLER_46_271 VPWR VGND sg13cmos5l_fill_1
X_1934_ _1934_/Y _2071_/A _1934_/B VPWR VGND sg13cmos5l_nand2_1
X_2983_ _2983_/Q clkload7/A _2983_/D _3423_/L_HI VPWR VGND sg13cmos5l_dfrbpq_1
X_1796_ _1796_/Y _1800_/A _1796_/B VPWR VGND sg13cmos5l_nand2_1
X_1865_ _1866_/B _1862_/Y _1863_/Y _1864_/Y VPWR VGND sg13cmos5l_a21o_1
X_3535_ _3535_/L_HI VPWR VGND sg13cmos5l_tiehi
X_3604_ FrameStrobe_O[6] FrameStrobe[6] VPWR VGND sg13cmos5l_buf_1
X_3466_ _3466_/L_HI VPWR VGND sg13cmos5l_tiehi
X_3397_ _3397_/Q FrameData[27] FrameStrobe[0] VPWR VGND sg13cmos5l_dlhq_1
X_2417_ _2417_/Y _3026_/Q _2237_/X _2416_/Y VPWR VGND sg13cmos5l_a21oi_1
X_2348_ _2348_/X W1END[3] _2139_/B _3065_/Q VPWR VGND sg13cmos5l_mux2_1
XFILLER_16_24 VPWR VGND sg13cmos5l_fill_1
XFILLER_16_57 VPWR VGND sg13cmos5l_fill_1
X_2279_ _2279_/Y _3316_/Q _1912_/B _2278_/Y VPWR VGND sg13cmos5l_o21ai_1
XFILLER_35_208 VPWR VGND sg13cmos5l_fill_2
XANTENNA__3795__X WW4BEG[12] VPWR VGND sg13cmos5l_antennanp
XFILLER_31_425 VPWR VGND sg13cmos5l_decap_4
XFILLER_43_252 VPWR VGND sg13cmos5l_fill_1
XFILLER_11_160 VPWR VGND sg13cmos5l_fill_2
X_1581_ _3760_/A _1568_/Y _1573_/Y _1580_/Y VPWR VGND sg13cmos5l_a21o_1
X_1650_ _1650_/X N4END[0] E2END[4] _3286_/Q VPWR VGND sg13cmos5l_mux2_1
X_2202_ _2202_/X _1513_/Y _1512_/Y _3276_/Q VPWR VGND sg13cmos5l_mux2_1
X_3320_ _3320_/Q FrameData[14] FrameStrobe[2] VPWR VGND sg13cmos5l_dlhq_1
X_3251_ _3251_/Q FrameData[9] FrameStrobe[4] VPWR VGND sg13cmos5l_dlhq_1
X_3182_ _3182_/Q FrameData[4] FrameStrobe[6] VPWR VGND sg13cmos5l_dlhq_1
X_2064_ _2064_/Y _2014_/A _2060_/Y _2083_/A VPWR VGND sg13cmos5l_a21oi_1
X_2133_ _2133_/Y _3345_/Q _2133_/B VPWR VGND sg13cmos5l_nor2_1
X_1917_ _3660_/A _1909_/Y _1916_/Y _1904_/Y VPWR VGND sg13cmos5l_o21ai_1
X_2966_ _2966_/Q _2970_/CLK _2966_/D _3440_/L_HI VPWR VGND sg13cmos5l_dfrbpq_1
X_2897_ _2897_/Q _2898_/CLK _2897_/D _3509_/L_HI VPWR VGND sg13cmos5l_dfrbpq_1
X_1779_ _1779_/X _2938_/Q _2934_/Q _2970_/Q _2966_/Q _2052_/A _1623_/Y VPWR VGND sg13cmos5l_mux4_1
X_1848_ _2014_/A _1848_/A _1848_/B VPWR VGND sg13cmos5l_nand2_1
X_3518_ _3518_/L_HI VPWR VGND sg13cmos5l_tiehi
XFILLER_27_45 VPWR VGND sg13cmos5l_fill_2
X_3449_ _3449_/L_HI VPWR VGND sg13cmos5l_tiehi
XFILLER_25_296 VPWR VGND sg13cmos5l_fill_1
XFILLER_43_33 VPWR VGND sg13cmos5l_fill_1
XFILLER_4_156 VPWR VGND sg13cmos5l_fill_1
XFILLER_48_377 VPWR VGND sg13cmos5l_fill_2
X_2820_ _2956_/D _2660_/X _2956_/Q _2823_/S VPWR VGND sg13cmos5l_mux2_1
X_2751_ _2906_/D _2675_/X _2906_/Q _2752_/S VPWR VGND sg13cmos5l_mux2_1
X_1564_ _1564_/Y _3358_/Q E1END[2] VPWR VGND sg13cmos5l_nor2b_1
X_1633_ _1633_/Y _3296_/Q E2END[6] VPWR VGND sg13cmos5l_nor2b_1
X_1702_ _1702_/X N2MID[4] W2MID[4] S2MID[4] _3659_/A _3167_/Q _3166_/Q VPWR VGND sg13cmos5l_mux4_1
X_2682_ _2683_/A _3108_/Q _2331_/X _3109_/Q VPWR VGND sg13cmos5l_o21ai_1
X_1495_ _1495_/Y _3133_/Q VPWR VGND sg13cmos5l_inv_1
X_3303_ _3303_/Q FrameData[29] FrameStrobe[3] VPWR VGND sg13cmos5l_dlhq_1
X_3234_ _3234_/Q FrameData[24] FrameStrobe[5] VPWR VGND sg13cmos5l_dlhq_1
X_3165_ _3165_/Q FrameData[19] FrameStrobe[7] VPWR VGND sg13cmos5l_dlhq_1
XFILLER_54_336 VPWR VGND sg13cmos5l_fill_1
XFILLER_54_347 VPWR VGND sg13cmos5l_fill_1
X_2047_ _2056_/B _1800_/A _2040_/X _2043_/Y _2046_/Y _1794_/S VPWR VGND sg13cmos5l_a221oi_1
X_2116_ _2116_/Y _3136_/Q _2115_/Y _2111_/Y VPWR VGND sg13cmos5l_o21ai_1
X_3096_ _3096_/Q FrameData[14] FrameStrobe[9] VPWR VGND sg13cmos5l_dlhq_1
X_2949_ _2949_/Q _2986_/CLK _2949_/D _3457_/L_HI VPWR VGND sg13cmos5l_dfrbpq_1
Xclkbuf_5_13__f_UserCLK_regs clkload9/A clkbuf_3_3_0_UserCLK_regs/X VPWR VGND sg13cmos5l_buf_8
Xclkload18 clkload18/Y _2921_/CLK VPWR VGND sg13cmos5l_inv_1
X_3783_ WW4BEG[0] WW4END[4] VPWR VGND sg13cmos5l_buf_1
X_2803_ _2944_/D _2660_/X _2944_/Q _2806_/S VPWR VGND sg13cmos5l_mux2_1
X_2734_ _2892_/D _2892_/Q _2660_/X _2737_/S VPWR VGND sg13cmos5l_mux2_1
X_1547_ _1549_/B _3264_/Q _2426_/B VPWR VGND sg13cmos5l_nor2_1
X_1616_ _1616_/Y _1459_/Y _3392_/Q _3393_/Q VPWR VGND sg13cmos5l_a21oi_1
X_2665_ _2665_/Y _3106_/Q _1963_/A _3107_/Q VPWR VGND sg13cmos5l_a21oi_1
X_2596_ _3661_/A _2597_/B VPWR VGND sg13cmos5l_inv_1
X_1478_ _1961_/B _3143_/Q VPWR VGND sg13cmos5l_inv_1
X_3217_ _3217_/Q FrameData[7] FrameStrobe[5] VPWR VGND sg13cmos5l_dlhq_1
X_3148_ _3148_/Q FrameData[2] FrameStrobe[7] VPWR VGND sg13cmos5l_dlhq_1
XFILLER_42_317 VPWR VGND sg13cmos5l_fill_2
X_3079_ _3079_/Q FrameData[29] FrameStrobe[10] VPWR VGND sg13cmos5l_dlhq_1
XANTENNA_110 FrameData[3] VPWR VGND sg13cmos5l_antennanp
XANTENNA_121 FrameData[3] VPWR VGND sg13cmos5l_antennanp
XANTENNA_132 FrameData[30] VPWR VGND sg13cmos5l_antennanp
XANTENNA_143 FrameData[30] VPWR VGND sg13cmos5l_antennanp
X_2450_ _2451_/B _2207_/B _3242_/Q _2449_/Y VPWR VGND sg13cmos5l_a21oi_1
X_2381_ _3729_/A _2378_/Y _2380_/Y _2372_/Y VPWR VGND sg13cmos5l_o21ai_1
X_3002_ _3002_/Q FrameData[16] FrameStrobe[12] VPWR VGND sg13cmos5l_dlhq_1
XFILLER_36_177 VPWR VGND sg13cmos5l_decap_4
X_3697_ EE4BEG[11] EE4END[15] VPWR VGND sg13cmos5l_buf_1
X_3766_ W2BEGb[3] W2MID[3] VPWR VGND sg13cmos5l_buf_1
X_2717_ _2880_/D _2660_/X _2880_/Q _2720_/S VPWR VGND sg13cmos5l_mux2_1
X_2648_ _2648_/Y _1466_/Y _3382_/Q _3383_/Q VPWR VGND sg13cmos5l_o21ai_1
X_2579_ _2579_/Y _2578_/X _2579_/B VPWR VGND sg13cmos5l_nand2b_1
XANTENNA__3798__X WW4BEG[15] VPWR VGND sg13cmos5l_antennanp
XFILLER_14_383 VPWR VGND sg13cmos5l_fill_2
XFILLER_18_199 VPWR VGND sg13cmos5l_fill_2
XFILLER_33_114 VPWR VGND sg13cmos5l_fill_1
XFILLER_33_147 VPWR VGND sg13cmos5l_fill_2
X_1950_ _1950_/X W1END[1] _3266_/Q VPWR VGND sg13cmos5l_and2_1
X_1881_ _1881_/Y _1980_/X _3324_/Q VPWR VGND sg13cmos5l_nand2b_1
X_3551_ N2BEG[1] _3551_/A VPWR VGND sg13cmos5l_buf_1
X_3620_ FrameData_O[2] FrameData[2] VPWR VGND sg13cmos5l_buf_1
X_2502_ _2506_/A _3007_/Q _1872_/Y _2501_/Y VPWR VGND sg13cmos5l_a21oi_1
X_3482_ _3482_/L_HI VPWR VGND sg13cmos5l_tiehi
X_2433_ _2433_/X E1END[1] W2END[3] _3252_/Q VPWR VGND sg13cmos5l_mux2_1
X_2364_ _3653_/A _1980_/X _1963_/A _3740_/A _2292_/X _3052_/Q _3053_/Q VPWR VGND sg13cmos5l_mux4_1
XFILLER_37_497 VPWR VGND sg13cmos5l_fill_2
X_2295_ _2295_/Y _3306_/Q E2END[1] VPWR VGND sg13cmos5l_nor2b_1
XANTENNA_10 E2MID[6] VPWR VGND sg13cmos5l_antennanp
XANTENNA_21 N2MID[2] VPWR VGND sg13cmos5l_antennanp
XANTENNA_32 N2MID[4] VPWR VGND sg13cmos5l_antennanp
XANTENNA_43 S4END[1] VPWR VGND sg13cmos5l_antennanp
XANTENNA_54 SS4END[10] VPWR VGND sg13cmos5l_antennanp
XANTENNA_65 W2END[0] VPWR VGND sg13cmos5l_antennanp
XFILLER_20_342 VPWR VGND sg13cmos5l_fill_1
XANTENNA_76 W2MID[7] VPWR VGND sg13cmos5l_antennanp
XANTENNA_87 WW4END[0] VPWR VGND sg13cmos5l_antennanp
XANTENNA_98 FrameData[3] VPWR VGND sg13cmos5l_antennanp
XFILLER_20_397 VPWR VGND sg13cmos5l_fill_1
X_3749_ E1BEG[3] _3749_/A VPWR VGND sg13cmos5l_buf_1
XFILLER_28_431 VPWR VGND sg13cmos5l_fill_2
XFILLER_46_22 VPWR VGND sg13cmos5l_fill_1
XFILLER_28_497 VPWR VGND sg13cmos5l_fill_2
X_2080_ _2080_/Y _2080_/A _2080_/B _2080_/C VPWR VGND sg13cmos5l_nand3_1
X_1933_ _1934_/B _2895_/Q _2116_/Y _1932_/Y VPWR VGND sg13cmos5l_a21oi_1
X_2982_ _2982_/Q _2986_/CLK _2982_/D _3424_/L_HI VPWR VGND sg13cmos5l_dfrbpq_1
X_1795_ _1796_/B _2955_/Q _2951_/Q _2987_/Q _2983_/Q _2052_/A _1623_/Y VPWR VGND sg13cmos5l_mux4_1
X_1864_ _1864_/Y _3291_/Q _1859_/X _3293_/Q VPWR VGND sg13cmos5l_o21ai_1
X_3534_ _3534_/L_HI VPWR VGND sg13cmos5l_tiehi
X_3603_ FrameStrobe_O[5] FrameStrobe[5] VPWR VGND sg13cmos5l_buf_1
X_3465_ _3465_/L_HI VPWR VGND sg13cmos5l_tiehi
X_2278_ _2278_/Y _1980_/X _3316_/Q VPWR VGND sg13cmos5l_nand2b_1
X_3396_ _3396_/Q FrameData[26] FrameStrobe[0] VPWR VGND sg13cmos5l_dlhq_1
X_2416_ _2416_/Y _3026_/Q _2087_/X VPWR VGND sg13cmos5l_nor2b_1
X_2347_ _2347_/X N1END[3] E1END[3] _3065_/Q VPWR VGND sg13cmos5l_mux2_1
XFILLER_37_261 VPWR VGND sg13cmos5l_decap_4
XFILLER_20_172 VPWR VGND sg13cmos5l_decap_4
XFILLER_43_264 VPWR VGND sg13cmos5l_fill_1
XFILLER_7_154 VPWR VGND sg13cmos5l_fill_1
XFILLER_7_198 VPWR VGND sg13cmos5l_fill_2
X_1580_ _1580_/Y _1575_/Y _1577_/Y _1579_/Y VPWR VGND sg13cmos5l_a21oi_1
X_2132_ _2133_/B _3342_/Q _2130_/Y _2131_/Y VPWR VGND sg13cmos5l_a21oi_1
X_2201_ _2201_/X _1912_/B _1980_/X _3276_/Q VPWR VGND sg13cmos5l_mux2_1
X_3250_ _3250_/Q FrameData[8] FrameStrobe[4] VPWR VGND sg13cmos5l_dlhq_1
X_3181_ _3181_/Q FrameData[3] FrameStrobe[6] VPWR VGND sg13cmos5l_dlhq_1
X_2063_ _2063_/Y _2071_/A _2063_/B VPWR VGND sg13cmos5l_nand2_1
X_1847_ _2071_/A _1848_/A _1848_/B VPWR VGND sg13cmos5l_and2_1
X_1916_ _1916_/Y _1914_/Y _1915_/Y _1485_/Y VPWR VGND sg13cmos5l_o21ai_1
X_2965_ _2965_/Q clkload0/A _2965_/D _3441_/L_HI VPWR VGND sg13cmos5l_dfrbpq_1
X_2896_ _2896_/Q _2899_/CLK _2896_/D _3510_/L_HI VPWR VGND sg13cmos5l_dfrbpq_1
X_1778_ _1783_/B _1800_/A _1771_/X _1774_/Y _1777_/Y _1794_/S VPWR VGND sg13cmos5l_a221oi_1
X_3517_ _3517_/L_HI VPWR VGND sg13cmos5l_tiehi
X_3448_ _3448_/L_HI VPWR VGND sg13cmos5l_tiehi
Xclkbuf_5_21__f_UserCLK_regs _2866_/CLK clkbuf_3_5_0_UserCLK_regs/X VPWR VGND sg13cmos5l_buf_8
X_3379_ _3379_/Q FrameData[9] FrameStrobe[0] VPWR VGND sg13cmos5l_dlhq_1
XFILLER_0_374 VPWR VGND sg13cmos5l_fill_2
X_1701_ _3659_/A _3327_/Q _1700_/Y _1693_/Y VPWR VGND sg13cmos5l_o21ai_1
X_2750_ _2905_/D _2663_/X _2905_/Q _2752_/S VPWR VGND sg13cmos5l_mux2_1
X_2681_ _2681_/Y _3377_/Q _2680_/Y _3108_/Q VPWR VGND sg13cmos5l_o21ai_1
X_1494_ _1681_/A _3319_/Q VPWR VGND sg13cmos5l_inv_1
X_1563_ _2052_/A _3125_/Q _1543_/Y _1560_/Y _1562_/Y VPWR VGND sg13cmos5l_a22oi_1
X_1632_ _1632_/Y _1470_/Y _1626_/X _1471_/Y VPWR VGND sg13cmos5l_a21oi_1
X_3302_ _3302_/Q FrameData[28] FrameStrobe[3] VPWR VGND sg13cmos5l_dlhq_1
XFILLER_12_0 VPWR VGND sg13cmos5l_fill_1
X_2115_ _2115_/Y _3135_/Q _2114_/X _2113_/Y VPWR VGND sg13cmos5l_a21oi_1
X_3233_ _3233_/Q FrameData[23] FrameStrobe[5] VPWR VGND sg13cmos5l_dlhq_1
X_3164_ _3164_/Q FrameData[18] FrameStrobe[7] VPWR VGND sg13cmos5l_dlhq_1
X_3095_ _3095_/Q FrameData[13] FrameStrobe[9] VPWR VGND sg13cmos5l_dlhq_1
X_2046_ _2046_/Y _1623_/Y _2045_/Y _1800_/A VPWR VGND sg13cmos5l_a21oi_1
XFILLER_13_26 VPWR VGND sg13cmos5l_fill_1
X_2948_ _2948_/Q clkload8/A _2948_/D _3458_/L_HI VPWR VGND sg13cmos5l_dfrbpq_1
X_2879_ _2879_/Q _2915_/CLK _2879_/D _3527_/L_HI VPWR VGND sg13cmos5l_dfrbpq_1
XFILLER_54_44 VPWR VGND sg13cmos5l_fill_2
XFILLER_5_466 VPWR VGND sg13cmos5l_fill_2
Xclkload19 clkload19/Y _2920_/CLK VPWR VGND sg13cmos5l_inv_1
X_3782_ W6BEG[11] _3782_/A VPWR VGND sg13cmos5l_buf_1
X_2802_ _2806_/S _2845_/A _2812_/B VPWR VGND sg13cmos5l_nand2_1
X_2733_ _2737_/S _2840_/A _2748_/B VPWR VGND sg13cmos5l_and2_1
X_2664_ _2861_/D _2861_/Q _2663_/X _2690_/S VPWR VGND sg13cmos5l_mux2_1
X_1477_ _1477_/Y _3289_/Q VPWR VGND sg13cmos5l_inv_1
X_1546_ _1546_/X _2139_/B _1980_/X _3264_/Q VPWR VGND sg13cmos5l_mux2_1
X_1615_ _1615_/X _3392_/Q _1613_/A _1614_/Y VPWR VGND sg13cmos5l_a21o_1
X_2595_ _2597_/B _2579_/Y _2585_/Y _2593_/Y _2594_/Y VPWR VGND sg13cmos5l_a22oi_1
XFILLER_27_326 VPWR VGND sg13cmos5l_fill_2
X_3216_ _3216_/Q FrameData[6] FrameStrobe[5] VPWR VGND sg13cmos5l_dlhq_1
X_3147_ _3147_/Q FrameData[1] FrameStrobe[7] VPWR VGND sg13cmos5l_dlhq_1
X_3078_ _3078_/Q FrameData[28] FrameStrobe[10] VPWR VGND sg13cmos5l_dlhq_1
X_2029_ _2029_/X _3402_/D _3402_/Q _2989_/Q VPWR VGND sg13cmos5l_mux2_1
XFILLER_40_57 VPWR VGND sg13cmos5l_fill_1
XANTENNA_100 FrameData[3] VPWR VGND sg13cmos5l_antennanp
XANTENNA_111 FrameData[3] VPWR VGND sg13cmos5l_antennanp
XANTENNA_122 FrameData[3] VPWR VGND sg13cmos5l_antennanp
XANTENNA_133 FrameData[30] VPWR VGND sg13cmos5l_antennanp
XANTENNA_144 S2MID[3] VPWR VGND sg13cmos5l_antennanp
XFILLER_5_263 VPWR VGND sg13cmos5l_fill_1
X_2380_ _2380_/Y _3044_/Q _2379_/X _3045_/Q VPWR VGND sg13cmos5l_o21ai_1
X_3001_ _3001_/Q FrameData[15] FrameStrobe[12] VPWR VGND sg13cmos5l_dlhq_1
XFILLER_32_384 VPWR VGND sg13cmos5l_fill_2
X_3696_ EE4BEG[10] EE4END[14] VPWR VGND sg13cmos5l_buf_1
X_3765_ W2BEGb[2] W2MID[2] VPWR VGND sg13cmos5l_buf_1
X_2716_ _2720_/S _2845_/A _2726_/B VPWR VGND sg13cmos5l_nand2_1
X_2647_ _2647_/Y _3114_/Q _2556_/A _3115_/Q VPWR VGND sg13cmos5l_a21oi_1
X_1529_ _1529_/X E2END[4] WW4END[3] _3256_/Q VPWR VGND sg13cmos5l_mux2_1
X_2578_ _2578_/X N1END[0] N2END[0] S1END[0] S2END[0] _3334_/Q _3336_/Q VPWR VGND sg13cmos5l_mux4_1
XFILLER_41_181 VPWR VGND sg13cmos5l_fill_2
X_1880_ _1880_/Y _3324_/Q _1512_/Y _1879_/Y VPWR VGND sg13cmos5l_a21oi_1
X_3550_ N2BEG[0] _3550_/A VPWR VGND sg13cmos5l_buf_1
X_3481_ _3481_/L_HI VPWR VGND sg13cmos5l_tiehi
X_2501_ _2501_/Y _3007_/Q _2237_/X _3006_/Q VPWR VGND sg13cmos5l_o21ai_1
X_2294_ _3753_/A _1980_/X _1849_/X _3655_/A _1843_/A _3078_/Q _3079_/Q VPWR VGND sg13cmos5l_mux4_1
X_2432_ _2432_/Y _2432_/A _2432_/B VPWR VGND sg13cmos5l_nand2_1
X_2363_ _3682_/A E6END[1] S4END[1] S2END[2] _2058_/X _3055_/Q _3054_/Q VPWR VGND sg13cmos5l_mux4_1
XANTENNA_11 N2MID[0] VPWR VGND sg13cmos5l_antennanp
XANTENNA_22 N2MID[2] VPWR VGND sg13cmos5l_antennanp
XANTENNA_33 N2MID[4] VPWR VGND sg13cmos5l_antennanp
XANTENNA_44 SS4END[0] VPWR VGND sg13cmos5l_antennanp
XANTENNA_55 SS4END[11] VPWR VGND sg13cmos5l_antennanp
XANTENNA_66 W2END[0] VPWR VGND sg13cmos5l_antennanp
XANTENNA_77 W2MID[7] VPWR VGND sg13cmos5l_antennanp
XANTENNA_88 WW4END[0] VPWR VGND sg13cmos5l_antennanp
XANTENNA_99 FrameData[3] VPWR VGND sg13cmos5l_antennanp
X_3748_ E1BEG[2] _3748_/A VPWR VGND sg13cmos5l_buf_1
X_3679_ S4BEG[9] S4END[13] VPWR VGND sg13cmos5l_buf_1
XFILLER_15_159 VPWR VGND sg13cmos5l_fill_1
XFILLER_30_9 VPWR VGND sg13cmos5l_fill_2
XANTENNA__3602__X FrameStrobe_O[4] VPWR VGND sg13cmos5l_antennanp
XFILLER_19_498 VPWR VGND sg13cmos5l_fill_1
XFILLER_34_424 VPWR VGND sg13cmos5l_fill_1
XFILLER_42_490 VPWR VGND sg13cmos5l_fill_2
X_1863_ _1863_/Y _3290_/Q _1860_/X _1505_/Y VPWR VGND sg13cmos5l_a21oi_1
X_1932_ _1932_/Y _2116_/Y _2899_/Q VPWR VGND sg13cmos5l_nor2b_1
X_3602_ FrameStrobe_O[4] FrameStrobe[4] VPWR VGND sg13cmos5l_buf_1
X_2981_ _2981_/Q clkload6/A _2981_/D _3425_/L_HI VPWR VGND sg13cmos5l_dfrbpq_1
X_1794_ _1794_/X _1790_/X _1793_/X _1794_/S VPWR VGND sg13cmos5l_mux2_1
X_3533_ _3533_/L_HI VPWR VGND sg13cmos5l_tiehi
X_3464_ _3464_/L_HI VPWR VGND sg13cmos5l_tiehi
X_2415_ _2419_/A _3026_/Q _2108_/Y _2414_/Y VPWR VGND sg13cmos5l_a21oi_1
XFILLER_29_229 VPWR VGND sg13cmos5l_decap_8
X_2277_ _2277_/Y _1506_/Y _2426_/B _3314_/Q VPWR VGND sg13cmos5l_a21oi_1
X_3395_ _3395_/Q FrameData[25] FrameStrobe[0] VPWR VGND sg13cmos5l_dlhq_1
X_2346_ _2346_/X _2646_/B _1957_/B _3065_/Q VPWR VGND sg13cmos5l_mux2_1
XFILLER_7_122 VPWR VGND sg13cmos5l_fill_1
X_2062_ _2063_/B _2909_/Q _2116_/Y _2061_/Y VPWR VGND sg13cmos5l_a21oi_1
X_2131_ _2131_/Y _3342_/Q _2128_/X _3343_/Q VPWR VGND sg13cmos5l_o21ai_1
X_2200_ _2200_/X W6END[1] _2029_/X _2426_/B _2087_/X _3276_/Q _3274_/Q VPWR VGND sg13cmos5l_mux4_1
X_3180_ _3180_/Q FrameData[2] FrameStrobe[6] VPWR VGND sg13cmos5l_dlhq_1
XFILLER_22_405 VPWR VGND sg13cmos5l_fill_2
X_2964_ _2964_/Q clkload2/A _2964_/D _3442_/L_HI VPWR VGND sg13cmos5l_dfrbpq_1
X_1777_ _1777_/Y _1623_/Y _1776_/Y _1800_/A VPWR VGND sg13cmos5l_a21oi_1
X_1846_ _1848_/B _3141_/Q _1843_/Y _1845_/Y VPWR VGND sg13cmos5l_a21o_1
X_1915_ _1915_/Y _1910_/Y _1911_/Y _3333_/Q VPWR VGND sg13cmos5l_o21ai_1
X_2895_ _2895_/Q _2898_/CLK _2895_/D _3511_/L_HI VPWR VGND sg13cmos5l_dfrbpq_1
X_3516_ _3516_/L_HI VPWR VGND sg13cmos5l_tiehi
X_3447_ _3447_/L_HI VPWR VGND sg13cmos5l_tiehi
X_3378_ _3378_/Q FrameData[8] FrameStrobe[0] VPWR VGND sg13cmos5l_dlhq_1
X_2329_ _2329_/X N2MID[1] E2MID[1] S2MID[1] W2MID[1] _3192_/Q _3193_/Q VPWR VGND sg13cmos5l_mux4_1
XFILLER_0_386 VPWR VGND sg13cmos5l_fill_1
X_1631_ _1631_/X _3294_/Q _1628_/Y _1630_/Y VPWR VGND sg13cmos5l_a21o_1
X_1700_ _1700_/Y _3329_/Q _1694_/X _1699_/Y VPWR VGND sg13cmos5l_o21ai_1
X_2680_ _2680_/Y E6END[0] _3376_/Q _2679_/Y VPWR VGND sg13cmos5l_a21oi_1
X_1493_ _1493_/Y _3263_/Q VPWR VGND sg13cmos5l_inv_1
X_1562_ _1562_/Y _3124_/Q _1561_/X _3125_/Q VPWR VGND sg13cmos5l_a21oi_1
X_3301_ _3301_/Q FrameData[27] FrameStrobe[3] VPWR VGND sg13cmos5l_dlhq_1
X_3232_ _3232_/Q FrameData[22] FrameStrobe[5] VPWR VGND sg13cmos5l_dlhq_1
X_2045_ _2045_/Y _2972_/Q _2052_/A _2044_/Y VPWR VGND sg13cmos5l_a21oi_1
X_2114_ _2114_/X N2MID[7] E2MID[7] S2MID[7] W2MID[7] _3202_/Q _3203_/Q VPWR VGND sg13cmos5l_mux4_1
X_3163_ _3163_/Q FrameData[17] FrameStrobe[7] VPWR VGND sg13cmos5l_dlhq_1
X_3094_ _3094_/Q FrameData[12] FrameStrobe[9] VPWR VGND sg13cmos5l_dlhq_1
XFILLER_10_419 VPWR VGND sg13cmos5l_fill_1
XFILLER_22_213 VPWR VGND sg13cmos5l_fill_1
X_2947_ _2947_/Q _2979_/CLK _2947_/D _3459_/L_HI VPWR VGND sg13cmos5l_dfrbpq_1
X_1829_ _1829_/Y _3141_/Q _1828_/Y _3142_/Q VPWR VGND sg13cmos5l_a21oi_1
X_2878_ _2878_/Q _2914_/CLK _2878_/D _3528_/L_HI VPWR VGND sg13cmos5l_dfrbpq_1
XANTENNA__3700__X EE4BEG[14] VPWR VGND sg13cmos5l_antennanp
XFILLER_5_478 VPWR VGND sg13cmos5l_fill_1
XANTENNA__3610__X FrameStrobe_O[12] VPWR VGND sg13cmos5l_antennanp
X_3781_ W6BEG[10] _3781_/A VPWR VGND sg13cmos5l_buf_1
X_2801_ _2943_/D _2689_/Y _2943_/Q _2801_/S VPWR VGND sg13cmos5l_mux2_1
X_1614_ _1614_/Y WW4END[1] _3392_/Q _3393_/Q VPWR VGND sg13cmos5l_o21ai_1
X_2732_ _2748_/B _2818_/A _2753_/B VPWR VGND sg13cmos5l_nor2_1
X_2663_ _2663_/X _1960_/X _2237_/X _2472_/A _2662_/X _3104_/Q _3105_/Q VPWR VGND sg13cmos5l_mux4_1
X_2594_ _2594_/Y _2594_/A _3337_/Q VPWR VGND sg13cmos5l_nor2b_1
X_1476_ _1476_/Y _3283_/Q VPWR VGND sg13cmos5l_inv_1
X_1545_ _1545_/Y _3263_/Q _1545_/B VPWR VGND sg13cmos5l_nor2_1
X_3215_ _3215_/Q FrameData[5] FrameStrobe[5] VPWR VGND sg13cmos5l_dlhq_1
XFILLER_27_349 VPWR VGND sg13cmos5l_fill_2
XFILLER_42_319 VPWR VGND sg13cmos5l_fill_1
X_2028_ _3402_/D _2005_/X _2010_/Y _2027_/Y VPWR VGND sg13cmos5l_a21o_1
X_3146_ _3146_/Q FrameData[0] FrameStrobe[7] VPWR VGND sg13cmos5l_dlhq_1
X_3077_ _3077_/Q FrameData[27] FrameStrobe[10] VPWR VGND sg13cmos5l_dlhq_1
XFILLER_18_327 VPWR VGND sg13cmos5l_fill_2
XANTENNA_101 FrameData[3] VPWR VGND sg13cmos5l_antennanp
XANTENNA_112 FrameData[3] VPWR VGND sg13cmos5l_antennanp
XANTENNA_123 FrameData[3] VPWR VGND sg13cmos5l_antennanp
XANTENNA_134 FrameData[30] VPWR VGND sg13cmos5l_antennanp
XANTENNA_145 S2MID[3] VPWR VGND sg13cmos5l_antennanp
XANTENNA__3605__X FrameStrobe_O[7] VPWR VGND sg13cmos5l_antennanp
X_3000_ _3000_/Q FrameData[14] FrameStrobe[12] VPWR VGND sg13cmos5l_dlhq_1
X_3764_ W2BEGb[1] W2MID[1] VPWR VGND sg13cmos5l_buf_1
X_3695_ EE4BEG[9] EE4END[13] VPWR VGND sg13cmos5l_buf_1
X_2715_ _2879_/D _2879_/Q _2689_/Y _2715_/S VPWR VGND sg13cmos5l_mux2_1
X_2646_ _2646_/X _3114_/Q _2646_/B VPWR VGND sg13cmos5l_or2_1
X_2577_ _2840_/A _2691_/A _2698_/A VPWR VGND sg13cmos5l_nor2_1
X_1459_ _1459_/Y S4END[0] VPWR VGND sg13cmos5l_inv_1
X_1528_ _1528_/X N2END[4] E6END[0] N4END[0] S2END[4] _3256_/Q _3254_/Q VPWR VGND sg13cmos5l_mux4_1
X_3129_ _3129_/Q FrameData[15] FrameStrobe[8] VPWR VGND sg13cmos5l_dlhq_1
X_3480_ _3480_/L_HI VPWR VGND sg13cmos5l_tiehi
X_2500_ _3595_/A _2500_/A _2500_/B VPWR VGND sg13cmos5l_nor2_1
X_2431_ _2432_/B N2END[3] E6END[1] N4END[3] S2END[3] _3252_/Q _3250_/Q VPWR VGND sg13cmos5l_mux4_1
X_2293_ _3754_/A _2058_/X _1963_/A _3656_/A _2292_/X _3080_/Q _3081_/Q VPWR VGND sg13cmos5l_mux4_1
X_2362_ _3683_/A E6END[0] S4END[2] S2END[3] _2426_/B _3057_/Q _3056_/Q VPWR VGND sg13cmos5l_mux4_1
XANTENNA_12 N2MID[0] VPWR VGND sg13cmos5l_antennanp
XANTENNA_23 N2MID[2] VPWR VGND sg13cmos5l_antennanp
XANTENNA_34 N2MID[4] VPWR VGND sg13cmos5l_antennanp
XANTENNA_45 SS4END[0] VPWR VGND sg13cmos5l_antennanp
XANTENNA_56 SS4END[12] VPWR VGND sg13cmos5l_antennanp
XANTENNA_67 W2MID[3] VPWR VGND sg13cmos5l_antennanp
XANTENNA_78 W2MID[7] VPWR VGND sg13cmos5l_antennanp
XANTENNA_89 WW4END[0] VPWR VGND sg13cmos5l_antennanp
XFILLER_20_300 VPWR VGND sg13cmos5l_decap_4
X_3747_ E1BEG[1] _3747_/A VPWR VGND sg13cmos5l_buf_1
X_3678_ S4BEG[8] S4END[12] VPWR VGND sg13cmos5l_buf_1
X_2629_ _2629_/Y _3118_/Q _3557_/A _2628_/Y VPWR VGND sg13cmos5l_a21oi_1
XFILLER_11_377 VPWR VGND sg13cmos5l_fill_2
XFILLER_19_422 VPWR VGND sg13cmos5l_fill_2
XFILLER_46_241 VPWR VGND sg13cmos5l_fill_1
X_2980_ _2980_/Q clkload8/A _2980_/D _3426_/L_HI VPWR VGND sg13cmos5l_dfrbpq_1
X_1793_ _1793_/X _1791_/X _1792_/X _1793_/S VPWR VGND sg13cmos5l_mux2_1
X_1862_ _1862_/Y _3290_/Q _1862_/B VPWR VGND sg13cmos5l_nand2b_1
X_1931_ _1931_/Y _2863_/Q _2116_/Y _1930_/Y VPWR VGND sg13cmos5l_a21oi_1
X_3601_ FrameStrobe_O[3] FrameStrobe[3] VPWR VGND sg13cmos5l_buf_1
XFILLER_35_0 VPWR VGND sg13cmos5l_fill_2
X_3532_ _3532_/L_HI VPWR VGND sg13cmos5l_tiehi
X_3463_ _3463_/L_HI VPWR VGND sg13cmos5l_tiehi
X_3394_ _3394_/Q FrameData[24] FrameStrobe[0] VPWR VGND sg13cmos5l_dlhq_1
X_2414_ _2414_/Y _3026_/Q _2238_/X _3027_/Q VPWR VGND sg13cmos5l_o21ai_1
X_2276_ _2276_/Y _3316_/Q _2620_/B VPWR VGND sg13cmos5l_nand2_1
X_2345_ _2345_/Y _3065_/Q _2495_/B _2344_/Y VPWR VGND sg13cmos5l_a21oi_1
XFILLER_52_299 VPWR VGND sg13cmos5l_fill_1
XANTENNA__3703__X SS4BEG[1] VPWR VGND sg13cmos5l_antennanp
XFILLER_28_296 VPWR VGND sg13cmos5l_fill_2
XFILLER_43_244 VPWR VGND sg13cmos5l_fill_1
XFILLER_11_196 VPWR VGND sg13cmos5l_fill_1
XANTENNA__3613__X FrameStrobe_O[15] VPWR VGND sg13cmos5l_antennanp
X_2061_ _2061_/Y _2116_/Y _2913_/Q VPWR VGND sg13cmos5l_nor2b_1
X_2130_ _2130_/Y _3344_/Q W2END[2] _2129_/Y VPWR VGND sg13cmos5l_a21oi_1
X_1914_ _1914_/Y _1912_/Y _1913_/Y _3330_/Q VPWR VGND sg13cmos5l_a21oi_1
X_2963_ _2963_/Q clkload6/A _2963_/D _3443_/L_HI VPWR VGND sg13cmos5l_dfrbpq_1
XFILLER_30_472 VPWR VGND sg13cmos5l_fill_1
X_1776_ _1776_/Y _2974_/Q _2052_/A _1775_/Y VPWR VGND sg13cmos5l_a21oi_1
X_1845_ _1845_/Y _3141_/Q _1844_/X _3142_/Q VPWR VGND sg13cmos5l_o21ai_1
X_3515_ _3515_/L_HI VPWR VGND sg13cmos5l_tiehi
X_2894_ _2894_/Q _2898_/CLK _2894_/D _3512_/L_HI VPWR VGND sg13cmos5l_dfrbpq_1
X_2328_ _2328_/X N4END[2] E2END[2] W2END[7] _3740_/A _3380_/Q _3381_/Q VPWR VGND sg13cmos5l_mux4_1
X_3446_ _3446_/L_HI VPWR VGND sg13cmos5l_tiehi
X_3377_ _3377_/Q FrameData[7] FrameStrobe[0] VPWR VGND sg13cmos5l_dlhq_1
X_2259_ _2259_/Y _3085_/Q _2495_/B _2258_/X VPWR VGND sg13cmos5l_a21oi_1
XFILLER_40_258 VPWR VGND sg13cmos5l_decap_4
XFILLER_0_398 VPWR VGND sg13cmos5l_fill_1
XFILLER_16_244 VPWR VGND sg13cmos5l_fill_2
XANTENNA__3608__X FrameStrobe_O[10] VPWR VGND sg13cmos5l_antennanp
X_1630_ _1630_/Y _3294_/Q _1629_/X _3295_/Q VPWR VGND sg13cmos5l_o21ai_1
X_1492_ _1492_/Y _3127_/Q VPWR VGND sg13cmos5l_inv_1
X_1561_ _1561_/X N2MID[7] E2MID[7] S2MID[7] W2MID[7] _3194_/Q _3195_/Q VPWR VGND sg13cmos5l_mux4_1
X_3300_ _3300_/Q FrameData[26] FrameStrobe[3] VPWR VGND sg13cmos5l_dlhq_1
X_3231_ _3231_/Q FrameData[21] FrameStrobe[5] VPWR VGND sg13cmos5l_dlhq_1
X_3162_ _3162_/Q FrameData[16] FrameStrobe[7] VPWR VGND sg13cmos5l_dlhq_1
X_2044_ _2044_/Y _2052_/A _2976_/Q VPWR VGND sg13cmos5l_nor2b_1
X_2113_ _2113_/Y _3135_/Q _2112_/X VPWR VGND sg13cmos5l_nor2b_1
X_3093_ _3093_/Q FrameData[11] FrameStrobe[9] VPWR VGND sg13cmos5l_dlhq_1
X_2946_ _2946_/Q clkload9/A _2946_/D _3460_/L_HI VPWR VGND sg13cmos5l_dfrbpq_1
X_2877_ _2877_/Q _2913_/CLK _2877_/D _3529_/L_HI VPWR VGND sg13cmos5l_dfrbpq_1
X_1759_ _2426_/B _3407_/D _3407_/Q _2988_/Q VPWR VGND sg13cmos5l_mux2_1
X_1828_ _1828_/Y _1828_/A VPWR VGND sg13cmos5l_inv_1
X_3429_ _3429_/L_HI VPWR VGND sg13cmos5l_tiehi
XFILLER_45_328 VPWR VGND sg13cmos5l_fill_1
XFILLER_0_173 VPWR VGND sg13cmos5l_fill_2
XFILLER_36_317 VPWR VGND sg13cmos5l_fill_2
X_3780_ W6BEG[9] W6END[11] VPWR VGND sg13cmos5l_buf_1
X_2800_ _2942_/D _2675_/X _2942_/Q _2801_/S VPWR VGND sg13cmos5l_mux2_1
X_2731_ _2753_/B _2817_/A _2817_/B VPWR VGND sg13cmos5l_nand2b_1
X_1544_ _1545_/B W1END[2] _1912_/B _2058_/X _2029_/X _3264_/Q _3262_/Q VPWR VGND sg13cmos5l_mux4_1
X_1613_ _3758_/A _1613_/A VPWR VGND sg13cmos5l_inv_1
X_2662_ _2662_/X EE4END[2] S4END[2] W2END[7] _3739_/A _3372_/Q _3373_/Q VPWR VGND
+ sg13cmos5l_mux4_1
X_2593_ _2593_/Y _3334_/Q _2591_/Y _2592_/Y VPWR VGND sg13cmos5l_o21ai_1
X_1475_ _2434_/A WW4END[2] VPWR VGND sg13cmos5l_inv_1
X_3214_ _3214_/Q FrameData[4] FrameStrobe[5] VPWR VGND sg13cmos5l_dlhq_1
X_3145_ _3145_/Q FrameData[31] FrameStrobe[8] VPWR VGND sg13cmos5l_dlhq_1
X_2027_ _2027_/Y _2075_/A _2027_/B _2027_/C VPWR VGND sg13cmos5l_nor3_1
X_3076_ _3076_/Q FrameData[26] FrameStrobe[10] VPWR VGND sg13cmos5l_dlhq_1
X_2929_ _2929_/Q _2962_/CLK _2929_/D _3477_/L_HI VPWR VGND sg13cmos5l_dfrbpq_1
XANTENNA_102 FrameData[3] VPWR VGND sg13cmos5l_antennanp
XANTENNA_113 FrameData[3] VPWR VGND sg13cmos5l_antennanp
XANTENNA_124 FrameData[3] VPWR VGND sg13cmos5l_antennanp
XANTENNA__3711__X SS4BEG[9] VPWR VGND sg13cmos5l_antennanp
XFILLER_45_103 VPWR VGND sg13cmos5l_fill_1
XANTENNA_135 FrameData[30] VPWR VGND sg13cmos5l_antennanp
XANTENNA_146 S2MID[3] VPWR VGND sg13cmos5l_antennanp
XFILLER_5_254 VPWR VGND sg13cmos5l_decap_8
XFILLER_5_298 VPWR VGND sg13cmos5l_decap_8
Xclkbuf_5_9__f_UserCLK_regs clkload6/A clkbuf_3_2_0_UserCLK_regs/X VPWR VGND sg13cmos5l_buf_8
XFILLER_49_464 VPWR VGND sg13cmos5l_fill_1
XANTENNA__3621__X FrameData_O[3] VPWR VGND sg13cmos5l_antennanp
XFILLER_17_394 VPWR VGND sg13cmos5l_fill_2
XFILLER_44_180 VPWR VGND sg13cmos5l_fill_1
X_3694_ EE4BEG[8] EE4END[12] VPWR VGND sg13cmos5l_buf_1
X_3763_ W2BEGb[0] W2MID[0] VPWR VGND sg13cmos5l_buf_1
X_2714_ _2878_/D _2878_/Q _2675_/X _2715_/S VPWR VGND sg13cmos5l_mux2_1
X_1527_ _1527_/Y _3257_/Q _1527_/B VPWR VGND sg13cmos5l_nand2_1
X_2645_ _2774_/B _3117_/Q _2640_/Y _2643_/Y VPWR VGND sg13cmos5l_a21oi_1
X_2576_ _2698_/A _2566_/Y _2567_/Y _2575_/X VPWR VGND sg13cmos5l_o21ai_1
X_1458_ _1458_/Y E2MID[0] VPWR VGND sg13cmos5l_inv_1
X_3128_ _3128_/Q FrameData[14] FrameStrobe[8] VPWR VGND sg13cmos5l_dlhq_1
X_3059_ _3059_/Q FrameData[9] FrameStrobe[10] VPWR VGND sg13cmos5l_dlhq_1
XANTENNA__3706__X SS4BEG[4] VPWR VGND sg13cmos5l_antennanp
XFILLER_18_136 VPWR VGND sg13cmos5l_fill_1
XFILLER_25_70 VPWR VGND sg13cmos5l_fill_1
XANTENNA__3616__X FrameStrobe_O[18] VPWR VGND sg13cmos5l_antennanp
X_2430_ _2430_/Y _2432_/A _2423_/X _2429_/Y VPWR VGND sg13cmos5l_a21oi_1
X_2361_ _3684_/A S2END[0] W6END[1] S4END[3] _2139_/B _3059_/Q _3058_/Q VPWR VGND sg13cmos5l_mux4_1
XFILLER_37_401 VPWR VGND sg13cmos5l_fill_2
X_2292_ _2292_/X NN4END[3] WW4END[0] S4END[3] _3551_/A _3371_/Q _3370_/Q VPWR VGND
+ sg13cmos5l_mux4_1
XANTENNA_13 N2MID[0] VPWR VGND sg13cmos5l_antennanp
XFILLER_52_448 VPWR VGND sg13cmos5l_fill_2
XANTENNA_24 N2MID[2] VPWR VGND sg13cmos5l_antennanp
XANTENNA_35 N2MID[4] VPWR VGND sg13cmos5l_antennanp
XANTENNA_46 SS4END[0] VPWR VGND sg13cmos5l_antennanp
XANTENNA_57 SS4END[13] VPWR VGND sg13cmos5l_antennanp
XANTENNA_68 W2MID[3] VPWR VGND sg13cmos5l_antennanp
XANTENNA_79 W2MID[7] VPWR VGND sg13cmos5l_antennanp
X_3677_ S4BEG[7] S4END[11] VPWR VGND sg13cmos5l_buf_1
X_3746_ E1BEG[0] _3746_/A VPWR VGND sg13cmos5l_buf_1
X_2628_ _2628_/Y _3118_/Q _2331_/X VPWR VGND sg13cmos5l_nor2b_1
X_2559_ _2559_/Y _3123_/Q _2558_/X VPWR VGND sg13cmos5l_nor2b_1
X_1930_ _1930_/Y _2116_/Y _2867_/Q VPWR VGND sg13cmos5l_nor2b_1
X_1792_ _1792_/X _2899_/Q _2895_/Q _2867_/Q _2863_/Q _2052_/A _2051_/A VPWR VGND sg13cmos5l_mux4_1
X_1861_ _1862_/B _2426_/B _2620_/B _3292_/Q VPWR VGND sg13cmos5l_mux2_1
X_3531_ _3531_/L_HI VPWR VGND sg13cmos5l_tiehi
X_3600_ FrameStrobe_O[2] FrameStrobe[2] VPWR VGND sg13cmos5l_buf_1
X_3462_ _3462_/L_HI VPWR VGND sg13cmos5l_tiehi
X_3393_ _3393_/Q FrameData[23] FrameStrobe[0] VPWR VGND sg13cmos5l_dlhq_1
X_2413_ _3699_/A _2412_/X _2411_/Y _3031_/Q VPWR VGND sg13cmos5l_mux2_1
X_2344_ _2344_/Y _3065_/Q _2620_/B VPWR VGND sg13cmos5l_nor2_1
XFILLER_37_220 VPWR VGND sg13cmos5l_fill_2
X_2275_ _3795_/A _2275_/A _2275_/B VPWR VGND sg13cmos5l_nor2_1
XFILLER_4_308 VPWR VGND sg13cmos5l_decap_4
X_3729_ E6BEG[11] _3729_/A VPWR VGND sg13cmos5l_buf_1
XFILLER_31_407 VPWR VGND sg13cmos5l_fill_2
XFILLER_31_429 VPWR VGND sg13cmos5l_fill_1
XFILLER_7_146 VPWR VGND sg13cmos5l_decap_4
X_2060_ _2060_/Y _2877_/Q _2116_/Y _2059_/Y VPWR VGND sg13cmos5l_a21oi_1
X_1913_ _1913_/Y _3332_/Q W1END[3] VPWR VGND sg13cmos5l_nand2b_1
X_2962_ _2962_/Q _2962_/CLK _2962_/D _3444_/L_HI VPWR VGND sg13cmos5l_dfrbpq_1
X_2893_ _2893_/Q _2893_/CLK _2893_/D _3513_/L_HI VPWR VGND sg13cmos5l_dfrbpq_1
X_1775_ _1775_/Y _2052_/A _2978_/Q VPWR VGND sg13cmos5l_nor2b_1
X_1844_ _1844_/X N2END[1] EE4END[3] S2END[1] W2END[1] _3240_/Q _3241_/Q VPWR VGND
+ sg13cmos5l_mux4_1
X_3514_ _3514_/L_HI VPWR VGND sg13cmos5l_tiehi
X_3445_ _3445_/L_HI VPWR VGND sg13cmos5l_tiehi
X_2258_ _2258_/X _1465_/Y _1512_/Y _3086_/Q VPWR VGND sg13cmos5l_a21o_1
X_2327_ _3740_/A _2317_/Y _2318_/Y _2326_/Y VPWR VGND sg13cmos5l_o21ai_1
X_3376_ _3376_/Q FrameData[6] FrameStrobe[0] VPWR VGND sg13cmos5l_dlhq_1
X_2189_ _2189_/X _3305_/Q _2189_/B VPWR VGND sg13cmos5l_and2_1
XANTENNA__3714__X SS4BEG[12] VPWR VGND sg13cmos5l_antennanp
XFILLER_4_149 VPWR VGND sg13cmos5l_fill_2
XFILLER_0_366 VPWR VGND sg13cmos5l_fill_1
XFILLER_12_462 VPWR VGND sg13cmos5l_fill_2
X_1560_ _1560_/Y _3124_/Q _1560_/B VPWR VGND sg13cmos5l_nand2b_1
XANTENNA__3624__X FrameData_O[6] VPWR VGND sg13cmos5l_antennanp
X_1491_ _1491_/Y _3126_/Q VPWR VGND sg13cmos5l_inv_1
X_2112_ _2112_/X N2MID[6] E2MID[6] S2MID[6] _3556_/A _3170_/Q _3171_/Q VPWR VGND sg13cmos5l_mux4_1
X_3230_ _3230_/Q FrameData[20] FrameStrobe[5] VPWR VGND sg13cmos5l_dlhq_1
X_3161_ _3161_/Q FrameData[15] FrameStrobe[7] VPWR VGND sg13cmos5l_dlhq_1
X_2043_ _2043_/Y _2051_/A _2043_/B VPWR VGND sg13cmos5l_nand2_1
X_3092_ _3092_/Q FrameData[10] FrameStrobe[9] VPWR VGND sg13cmos5l_dlhq_1
XFILLER_22_237 VPWR VGND sg13cmos5l_fill_1
X_1827_ _1828_/A N2MID[1] E2MID[1] S2MID[1] W2MID[1] _3208_/Q _3209_/Q VPWR VGND sg13cmos5l_mux4_1
X_2945_ _2945_/Q _2977_/CLK _2945_/D _3461_/L_HI VPWR VGND sg13cmos5l_dfrbpq_1
X_2876_ _2876_/Q _2912_/CLK _2876_/D _3530_/L_HI VPWR VGND sg13cmos5l_dfrbpq_1
X_1689_ _1689_/Y _3326_/Q _1689_/B VPWR VGND sg13cmos5l_nand2b_1
X_1758_ _3407_/D _1709_/Y _1748_/Y _1757_/Y VPWR VGND sg13cmos5l_a21o_1
X_3428_ _3428_/L_HI VPWR VGND sg13cmos5l_tiehi
X_3359_ _3359_/Q FrameData[21] FrameStrobe[1] VPWR VGND sg13cmos5l_dlhq_1
XANTENNA__3709__X SS4BEG[7] VPWR VGND sg13cmos5l_antennanp
XANTENNA__3619__X FrameData_O[1] VPWR VGND sg13cmos5l_antennanp
X_2730_ _2891_/D _2689_/Y _2891_/Q _2730_/S VPWR VGND sg13cmos5l_mux2_1
X_2661_ _2860_/D _2860_/Q _2660_/X _2690_/S VPWR VGND sg13cmos5l_mux2_1
X_1474_ _1474_/Y _3301_/Q VPWR VGND sg13cmos5l_inv_1
X_1543_ _1543_/Y _1539_/Y _1542_/Y _1515_/X VPWR VGND sg13cmos5l_o21ai_1
X_1612_ _1613_/A _3351_/Q _1611_/Y _1604_/Y VPWR VGND sg13cmos5l_o21ai_1
X_2592_ _2592_/Y _3334_/Q _2589_/Y _2579_/B VPWR VGND sg13cmos5l_a21oi_1
XFILLER_10_0 VPWR VGND sg13cmos5l_fill_1
X_3213_ _3213_/Q FrameData[3] FrameStrobe[5] VPWR VGND sg13cmos5l_dlhq_1
X_3144_ _3144_/Q FrameData[30] FrameStrobe[8] VPWR VGND sg13cmos5l_dlhq_1
X_3075_ _3075_/Q FrameData[25] FrameStrobe[10] VPWR VGND sg13cmos5l_dlhq_1
XFILLER_50_321 VPWR VGND sg13cmos5l_fill_1
X_2026_ _2027_/C _2023_/Y _2024_/Y _2025_/X _2083_/A _2080_/A VPWR VGND sg13cmos5l_a221oi_1
X_2928_ _2928_/Q clkload4/A _2928_/D _3478_/L_HI VPWR VGND sg13cmos5l_dfrbpq_1
X_2859_ _2987_/D _2689_/Y _2987_/Q _2859_/S VPWR VGND sg13cmos5l_mux2_1
XANTENNA_103 FrameData[3] VPWR VGND sg13cmos5l_antennanp
XANTENNA_114 FrameData[3] VPWR VGND sg13cmos5l_antennanp
XANTENNA_125 FrameData[3] VPWR VGND sg13cmos5l_antennanp
XANTENNA_136 FrameData[30] VPWR VGND sg13cmos5l_antennanp
XANTENNA_147 S2MID[3] VPWR VGND sg13cmos5l_antennanp
X_3693_ EE4BEG[7] EE4END[11] VPWR VGND sg13cmos5l_buf_1
X_3762_ W2BEG[7] _3762_/A VPWR VGND sg13cmos5l_buf_1
X_2713_ _2877_/D _2877_/Q _2663_/X _2715_/S VPWR VGND sg13cmos5l_mux2_1
X_2644_ _2817_/B _3117_/Q _2640_/Y _2643_/Y VPWR VGND sg13cmos5l_a21o_1
XFILLER_19_28 VPWR VGND sg13cmos5l_fill_2
X_1457_ _2207_/B N4END[1] VPWR VGND sg13cmos5l_inv_1
X_1526_ _1527_/B _3254_/Q _1524_/Y _1525_/Y VPWR VGND sg13cmos5l_o21ai_1
X_2575_ _2575_/X _3111_/Q _2575_/B _2575_/C VPWR VGND sg13cmos5l_or3_1
XFILLER_27_148 VPWR VGND sg13cmos5l_decap_8
X_3127_ _3127_/Q FrameData[13] FrameStrobe[8] VPWR VGND sg13cmos5l_dlhq_1
X_3058_ _3058_/Q FrameData[8] FrameStrobe[10] VPWR VGND sg13cmos5l_dlhq_1
X_2009_ _2009_/Y _2077_/A _2006_/X _2080_/A VPWR VGND sg13cmos5l_a21oi_1
XANTENNA__3722__X E6BEG[4] VPWR VGND sg13cmos5l_antennanp
XANTENNA__3632__X FrameData_O[14] VPWR VGND sg13cmos5l_antennanp
X_2291_ _3656_/A _3317_/Q _2282_/Y _2284_/Y _2290_/Y VPWR VGND sg13cmos5l_a22oi_1
X_2360_ _3685_/A S2END[1] S4END[0] W6END[0] _1912_/B _3060_/Q _3061_/Q VPWR VGND sg13cmos5l_mux4_1
XANTENNA_14 N2MID[0] VPWR VGND sg13cmos5l_antennanp
XANTENNA_25 N2MID[2] VPWR VGND sg13cmos5l_antennanp
XANTENNA_36 N2MID[4] VPWR VGND sg13cmos5l_antennanp
XANTENNA_47 SS4END[0] VPWR VGND sg13cmos5l_antennanp
XANTENNA_58 SS4END[5] VPWR VGND sg13cmos5l_antennanp
XANTENNA_69 W2MID[3] VPWR VGND sg13cmos5l_antennanp
X_3676_ S4BEG[6] S4END[10] VPWR VGND sg13cmos5l_buf_1
X_3745_ E2BEG[7] _3745_/A VPWR VGND sg13cmos5l_buf_1
X_2627_ _3557_/A _1501_/Y _2626_/Y _2618_/Y VPWR VGND sg13cmos5l_o21ai_1
X_1509_ _1888_/A _3323_/Q VPWR VGND sg13cmos5l_inv_1
X_2558_ _2558_/X N2END[3] _2548_/X S2END[3] _2556_/Y _3122_/Q _3121_/Q VPWR VGND sg13cmos5l_mux4_1
X_2489_ _2489_/Y N1END[0] _3012_/Q _2488_/Y VPWR VGND sg13cmos5l_o21ai_1
XANTENNA__3717__X SS4BEG[15] VPWR VGND sg13cmos5l_antennanp
XFILLER_11_95 VPWR VGND sg13cmos5l_fill_1
XFILLER_34_405 VPWR VGND sg13cmos5l_fill_2
X_1860_ _1860_/X _2139_/B _1980_/X _3292_/Q VPWR VGND sg13cmos5l_mux2_1
XANTENNA__3627__X FrameData_O[9] VPWR VGND sg13cmos5l_antennanp
X_1791_ _1791_/X _2907_/Q _2903_/Q _2875_/Q _2871_/Q _2052_/A _2051_/A VPWR VGND sg13cmos5l_mux4_1
X_3530_ _3530_/L_HI VPWR VGND sg13cmos5l_tiehi
X_3461_ _3461_/L_HI VPWR VGND sg13cmos5l_tiehi
X_2274_ _2275_/B _3084_/Q _2274_/B VPWR VGND sg13cmos5l_nor2_1
X_3392_ _3392_/Q FrameData[22] FrameStrobe[0] VPWR VGND sg13cmos5l_dlhq_1
X_2412_ _2412_/X N1END[3] E1END[3] S1END[3] _2139_/B _3029_/Q _3030_/Q VPWR VGND sg13cmos5l_mux4_1
X_2343_ _3716_/A _2343_/A _2343_/B VPWR VGND sg13cmos5l_nor2_1
XFILLER_37_265 VPWR VGND sg13cmos5l_fill_2
X_1989_ _1989_/Y _2077_/A _1986_/X _2080_/A VPWR VGND sg13cmos5l_a21oi_1
X_3659_ S2BEG[5] _3659_/A VPWR VGND sg13cmos5l_buf_1
X_3728_ E6BEG[10] _3728_/A VPWR VGND sg13cmos5l_buf_1
XFILLER_28_221 VPWR VGND sg13cmos5l_fill_1
XFILLER_28_243 VPWR VGND sg13cmos5l_fill_1
XFILLER_3_375 VPWR VGND sg13cmos5l_fill_1
XFILLER_19_210 VPWR VGND sg13cmos5l_fill_1
X_1843_ _1843_/Y _1843_/A VPWR VGND sg13cmos5l_inv_1
X_1912_ _1912_/Y _3332_/Q _1912_/B VPWR VGND sg13cmos5l_nand2_1
X_2961_ _2961_/Q clkload3/A _2961_/D _3445_/L_HI VPWR VGND sg13cmos5l_dfrbpq_1
X_2892_ _2892_/Q _2893_/CLK _2892_/D _3514_/L_HI VPWR VGND sg13cmos5l_dfrbpq_1
X_1774_ _1774_/Y _2051_/A _1774_/B VPWR VGND sg13cmos5l_nand2_1
X_3513_ _3513_/L_HI VPWR VGND sg13cmos5l_tiehi
X_3444_ _3444_/L_HI VPWR VGND sg13cmos5l_tiehi
X_2257_ _3797_/A _2257_/A _2257_/B VPWR VGND sg13cmos5l_nor2_1
X_2326_ _2326_/Y _2325_/Y _2326_/B VPWR VGND sg13cmos5l_nand2b_1
X_3375_ _3375_/Q FrameData[5] FrameStrobe[0] VPWR VGND sg13cmos5l_dlhq_1
XFILLER_25_246 VPWR VGND sg13cmos5l_fill_1
X_2188_ _2189_/B _3303_/Q _2188_/B VPWR VGND sg13cmos5l_nand2b_1
XANTENNA__3730__X E2BEGb[0] VPWR VGND sg13cmos5l_antennanp
XFILLER_16_246 VPWR VGND sg13cmos5l_fill_1
XFILLER_3_161 VPWR VGND sg13cmos5l_decap_4
X_1490_ _1490_/Y _3359_/Q VPWR VGND sg13cmos5l_inv_1
XANTENNA__3640__X FrameData_O[22] VPWR VGND sg13cmos5l_antennanp
X_2042_ _2043_/B _2940_/Q _2052_/A _2041_/Y VPWR VGND sg13cmos5l_a21oi_1
X_2111_ _2111_/Y _2103_/Y _2106_/Y _2110_/Y VPWR VGND sg13cmos5l_o21ai_1
X_3160_ _3160_/Q FrameData[14] FrameStrobe[7] VPWR VGND sg13cmos5l_dlhq_1
X_3091_ _3091_/Q FrameData[9] FrameStrobe[9] VPWR VGND sg13cmos5l_dlhq_1
XFILLER_47_382 VPWR VGND sg13cmos5l_fill_2
X_1826_ _1826_/Y _3141_/Q _1826_/B VPWR VGND sg13cmos5l_nand2b_1
Xclkbuf_5_4__f_UserCLK_regs _2962_/CLK clkbuf_3_1_0_UserCLK_regs/X VPWR VGND sg13cmos5l_buf_8
X_2944_ _2944_/Q _2976_/CLK _2944_/D _3462_/L_HI VPWR VGND sg13cmos5l_dfrbpq_1
X_2875_ _2875_/Q _2921_/CLK _2875_/D _3531_/L_HI VPWR VGND sg13cmos5l_dfrbpq_1
X_1688_ _1689_/B _2426_/B _2620_/B _3328_/Q VPWR VGND sg13cmos5l_mux2_1
X_1757_ _1757_/Y _1751_/Y _1752_/Y _1754_/Y _1756_/Y _2056_/A VPWR VGND sg13cmos5l_a221oi_1
X_3427_ _3427_/L_HI VPWR VGND sg13cmos5l_tiehi
X_3358_ _3358_/Q FrameData[20] FrameStrobe[1] VPWR VGND sg13cmos5l_dlhq_1
XANTENNA__3550__X N2BEG[0] VPWR VGND sg13cmos5l_antennanp
X_2309_ _3654_/A _2307_/Y _2308_/Y _2302_/X VPWR VGND sg13cmos5l_o21ai_1
X_3289_ _3289_/Q FrameData[15] FrameStrobe[3] VPWR VGND sg13cmos5l_dlhq_1
XANTENNA__3725__X E6BEG[7] VPWR VGND sg13cmos5l_antennanp
XFILLER_0_175 VPWR VGND sg13cmos5l_fill_1
XFILLER_36_319 VPWR VGND sg13cmos5l_fill_1
X_1611_ _1611_/Y _1609_/Y _1610_/Y _1606_/Y VPWR VGND sg13cmos5l_o21ai_1
X_2660_ _2660_/X _2659_/X _2658_/X _2391_/X _2292_/X _3102_/Q _3103_/Q VPWR VGND sg13cmos5l_mux4_1
XANTENNA__3635__X FrameData_O[17] VPWR VGND sg13cmos5l_antennanp
X_1473_ _1718_/S _3299_/Q VPWR VGND sg13cmos5l_inv_1
X_1542_ _1542_/Y _3387_/Q _1541_/Y _3124_/Q VPWR VGND sg13cmos5l_o21ai_1
X_3212_ _3212_/Q FrameData[2] FrameStrobe[5] VPWR VGND sg13cmos5l_dlhq_1
X_2591_ _2591_/Y _3336_/Q _2087_/X _2590_/Y VPWR VGND sg13cmos5l_a21oi_1
X_2025_ _2025_/X _2872_/Q _2904_/Q _2868_/Q _2900_/Q _2071_/A _2116_/Y VPWR VGND sg13cmos5l_mux4_1
Xclkbuf_5_19__f_UserCLK_regs _2905_/CLK clkbuf_3_4_0_UserCLK_regs/X VPWR VGND sg13cmos5l_buf_8
X_3143_ _3143_/Q FrameData[29] FrameStrobe[8] VPWR VGND sg13cmos5l_dlhq_1
X_3074_ _3074_/Q FrameData[24] FrameStrobe[10] VPWR VGND sg13cmos5l_dlhq_1
X_2927_ _2927_/Q clkload4/A _2927_/D _3479_/L_HI VPWR VGND sg13cmos5l_dfrbpq_1
X_1809_ _1809_/Y _1808_/X _3365_/Q VPWR VGND sg13cmos5l_nand2b_1
X_2858_ _2986_/D _2675_/X _2986_/Q _2859_/S VPWR VGND sg13cmos5l_mux2_1
X_2789_ _2934_/D _2675_/X _2934_/Q _2790_/S VPWR VGND sg13cmos5l_mux2_1
XANTENNA_104 FrameData[3] VPWR VGND sg13cmos5l_antennanp
XANTENNA_115 FrameData[3] VPWR VGND sg13cmos5l_antennanp
XANTENNA_126 FrameData[3] VPWR VGND sg13cmos5l_antennanp
XANTENNA_137 FrameData[30] VPWR VGND sg13cmos5l_antennanp
XANTENNA_148 S2MID[3] VPWR VGND sg13cmos5l_antennanp
X_3761_ W2BEG[6] _3761_/A VPWR VGND sg13cmos5l_buf_1
X_3692_ EE4BEG[6] EE4END[10] VPWR VGND sg13cmos5l_buf_1
X_2712_ _2876_/D _2876_/Q _2660_/X _2715_/S VPWR VGND sg13cmos5l_mux2_1
X_2643_ _2643_/Y _3117_/Q _2643_/B VPWR VGND sg13cmos5l_nor2_1
X_2574_ _2575_/C _3187_/Q _2572_/Y _2573_/Y VPWR VGND sg13cmos5l_a21oi_1
X_1456_ _1456_/Y _3247_/Q VPWR VGND sg13cmos5l_inv_1
X_1525_ _1525_/Y _3254_/Q _1522_/X _3255_/Q VPWR VGND sg13cmos5l_a21oi_1
XFILLER_27_116 VPWR VGND sg13cmos5l_fill_2
X_2008_ _2008_/Y _2083_/A _2008_/B VPWR VGND sg13cmos5l_nand2_1
X_3126_ _3126_/Q FrameData[12] FrameStrobe[8] VPWR VGND sg13cmos5l_dlhq_1
X_3057_ _3057_/Q FrameData[7] FrameStrobe[10] VPWR VGND sg13cmos5l_dlhq_1
XFILLER_46_414 VPWR VGND sg13cmos5l_fill_1
X_2290_ _2290_/Y _3317_/Q _2290_/B VPWR VGND sg13cmos5l_nor2_1
XANTENNA_15 N2MID[2] VPWR VGND sg13cmos5l_antennanp
XANTENNA_26 N2MID[2] VPWR VGND sg13cmos5l_antennanp
XANTENNA_37 N2MID[4] VPWR VGND sg13cmos5l_antennanp
XANTENNA_48 SS4END[0] VPWR VGND sg13cmos5l_antennanp
XANTENNA_59 SS4END[6] VPWR VGND sg13cmos5l_antennanp
X_3744_ E2BEG[6] _3744_/A VPWR VGND sg13cmos5l_buf_1
X_3675_ S4BEG[5] S4END[9] VPWR VGND sg13cmos5l_buf_1
X_2626_ _2626_/Y _3271_/Q _2619_/X _2625_/Y VPWR VGND sg13cmos5l_o21ai_1
X_2557_ _2560_/B _1844_/X _3654_/A _3550_/A _3755_/A _3122_/Q _3121_/Q VPWR VGND sg13cmos5l_mux4_1
X_1508_ _1508_/Y _3315_/Q VPWR VGND sg13cmos5l_inv_1
X_2488_ _2488_/Y _1453_/Y _3012_/Q _3013_/Q VPWR VGND sg13cmos5l_a21oi_1
X_3109_ _3109_/Q FrameData[27] FrameStrobe[9] VPWR VGND sg13cmos5l_dlhq_1
XFILLER_11_336 VPWR VGND sg13cmos5l_fill_2
XANTENNA__3733__X E2BEGb[3] VPWR VGND sg13cmos5l_antennanp
XFILLER_14_141 VPWR VGND sg13cmos5l_fill_2
XFILLER_14_152 VPWR VGND sg13cmos5l_fill_2
X_1790_ _1790_/X _1788_/X _1789_/X _1793_/S VPWR VGND sg13cmos5l_mux2_1
XANTENNA__3643__X FrameData_O[25] VPWR VGND sg13cmos5l_antennanp
X_3460_ _3460_/L_HI VPWR VGND sg13cmos5l_tiehi
X_3391_ _3391_/Q FrameData[21] FrameStrobe[0] VPWR VGND sg13cmos5l_dlhq_1
X_2411_ _2411_/Y _3030_/Q _2408_/Y _2410_/Y VPWR VGND sg13cmos5l_o21ai_1
XFILLER_37_222 VPWR VGND sg13cmos5l_fill_1
X_2273_ _2274_/B N1END[2] W1END[2] S1END[2] _2426_/B _3083_/Q _3082_/Q VPWR VGND sg13cmos5l_mux4_1
X_2342_ _2343_/B _3070_/Q _2342_/B VPWR VGND sg13cmos5l_nor2_1
XFILLER_37_277 VPWR VGND sg13cmos5l_decap_4
X_1988_ _1988_/Y _2083_/A _1988_/B VPWR VGND sg13cmos5l_nand2_1
X_3727_ E6BEG[9] E6END[11] VPWR VGND sg13cmos5l_buf_1
XANTENNA__3553__X N2BEG[3] VPWR VGND sg13cmos5l_antennanp
X_3589_ NN4BEG[7] NN4END[11] VPWR VGND sg13cmos5l_buf_1
X_3658_ S2BEG[4] _3658_/A VPWR VGND sg13cmos5l_buf_1
X_2609_ _3762_/A _3369_/Q _2601_/Y _2607_/Y _2608_/Y VPWR VGND sg13cmos5l_a22oi_1
XANTENNA__3728__X E6BEG[10] VPWR VGND sg13cmos5l_antennanp
XFILLER_31_409 VPWR VGND sg13cmos5l_fill_1
XFILLER_11_177 VPWR VGND sg13cmos5l_fill_2
XFILLER_0_0 VPWR VGND sg13cmos5l_fill_1
XFILLER_3_398 VPWR VGND sg13cmos5l_fill_1
XFILLER_34_269 VPWR VGND sg13cmos5l_fill_2
X_2960_ _2960_/Q clkload5/A _2960_/D _3446_/L_HI VPWR VGND sg13cmos5l_dfrbpq_1
XANTENNA__3638__X FrameData_O[20] VPWR VGND sg13cmos5l_antennanp
XFILLER_30_453 VPWR VGND sg13cmos5l_fill_2
XFILLER_30_497 VPWR VGND sg13cmos5l_fill_2
X_1773_ _1774_/B _2942_/Q _2052_/A _1772_/Y VPWR VGND sg13cmos5l_a21oi_1
X_1842_ _1843_/A NN4END[0] W2END[0] E6END[0] _3759_/A _3401_/Q _3400_/Q VPWR VGND
+ sg13cmos5l_mux4_1
X_1911_ _1911_/Y _3332_/Q _2058_/X _3330_/Q VPWR VGND sg13cmos5l_o21ai_1
X_2891_ _2891_/Q _2923_/CLK _2891_/D _3515_/L_HI VPWR VGND sg13cmos5l_dfrbpq_1
X_3512_ _3512_/L_HI VPWR VGND sg13cmos5l_tiehi
X_3443_ _3443_/L_HI VPWR VGND sg13cmos5l_tiehi
X_3374_ _3374_/Q FrameData[4] FrameStrobe[0] VPWR VGND sg13cmos5l_dlhq_1
X_2187_ _2188_/B W1END[0] _1912_/B _2058_/X _2029_/X _3304_/Q _3302_/Q VPWR VGND sg13cmos5l_mux4_1
X_2256_ _2257_/B _3090_/Q _2256_/B VPWR VGND sg13cmos5l_nor2_1
X_2325_ _2325_/Y _3283_/Q _2319_/X _3285_/Q VPWR VGND sg13cmos5l_o21ai_1
XANTENNA__3548__X N1BEG[2] VPWR VGND sg13cmos5l_antennanp
XFILLER_33_280 VPWR VGND sg13cmos5l_decap_4
XFILLER_21_497 VPWR VGND sg13cmos5l_fill_2
XFILLER_33_83 VPWR VGND sg13cmos5l_fill_1
Xclkbuf_5_27__f_UserCLK_regs _2923_/CLK clkbuf_3_6_0_UserCLK_regs/X VPWR VGND sg13cmos5l_buf_8
X_2041_ _2041_/Y _2052_/A _2944_/Q VPWR VGND sg13cmos5l_nor2b_1
X_2110_ _2110_/Y _2110_/A VPWR VGND sg13cmos5l_inv_1
X_3090_ _3090_/Q FrameData[8] FrameStrobe[9] VPWR VGND sg13cmos5l_dlhq_1
X_2943_ _2943_/Q _2979_/CLK _2943_/D _3463_/L_HI VPWR VGND sg13cmos5l_dfrbpq_1
X_1756_ _1756_/Y _1793_/S _1755_/X _1706_/Y VPWR VGND sg13cmos5l_a21oi_1
X_1825_ _1826_/B N2MID[0] _3176_/Q _1824_/Y VPWR VGND sg13cmos5l_o21ai_1
X_2874_ _2874_/Q _3408_/CLK _2874_/D _3532_/L_HI VPWR VGND sg13cmos5l_dfrbpq_1
X_1687_ _1687_/X E1END[2] E2END[6] SS4END[2] W1END[0] _3326_/Q _3328_/Q VPWR VGND
+ sg13cmos5l_mux4_1
X_2308_ _2308_/Y _3307_/Q _2303_/X _3309_/Q VPWR VGND sg13cmos5l_o21ai_1
X_3426_ _3426_/L_HI VPWR VGND sg13cmos5l_tiehi
X_3357_ _3357_/Q FrameData[19] FrameStrobe[1] VPWR VGND sg13cmos5l_dlhq_1
XFILLER_38_361 VPWR VGND sg13cmos5l_fill_1
X_2239_ _2240_/B _2087_/X _1980_/X _2238_/X _1849_/X _3095_/Q _3096_/Q VPWR VGND sg13cmos5l_mux4_1
X_3288_ _3288_/Q FrameData[14] FrameStrobe[3] VPWR VGND sg13cmos5l_dlhq_1
XANTENNA__3741__X E2BEG[3] VPWR VGND sg13cmos5l_antennanp
XFILLER_48_158 VPWR VGND sg13cmos5l_fill_1
X_1610_ _1610_/Y _3350_/Q _1607_/X _3353_/Q VPWR VGND sg13cmos5l_o21ai_1
X_2590_ _2590_/Y _3336_/Q _2426_/B VPWR VGND sg13cmos5l_nor2b_1
XANTENNA__3651__X S1BEG[1] VPWR VGND sg13cmos5l_antennanp
XFILLER_4_493 VPWR VGND sg13cmos5l_fill_1
X_1472_ _1472_/Y W2MID[2] VPWR VGND sg13cmos5l_inv_1
X_1541_ _1541_/Y E2END[3] _3386_/Q _1540_/Y VPWR VGND sg13cmos5l_a21oi_1
X_3211_ _3211_/Q FrameData[1] FrameStrobe[5] VPWR VGND sg13cmos5l_dlhq_1
X_3142_ _3142_/Q FrameData[28] FrameStrobe[8] VPWR VGND sg13cmos5l_dlhq_1
X_2024_ _2024_/Y _2014_/A _2020_/Y _2083_/A VPWR VGND sg13cmos5l_a21oi_1
X_3073_ _3073_/Q FrameData[23] FrameStrobe[10] VPWR VGND sg13cmos5l_dlhq_1
X_2926_ _2926_/Q clkload0/A _2926_/D _3480_/L_HI VPWR VGND sg13cmos5l_dfrbpq_1
X_2857_ _2985_/D _2663_/X _2985_/Q _2859_/S VPWR VGND sg13cmos5l_mux2_1
X_1739_ _1804_/S _2056_/A VPWR VGND sg13cmos5l_inv_1
X_1808_ _1808_/X _1807_/X _1806_/X _3363_/Q VPWR VGND sg13cmos5l_mux2_1
X_2788_ _2933_/D _2663_/X _2933_/Q _2790_/S VPWR VGND sg13cmos5l_mux2_1
XANTENNA__3561__X N2BEGb[3] VPWR VGND sg13cmos5l_antennanp
X_3409_ _3409_/Q _3409_/CLK _3409_/D _3411_/L_HI VPWR VGND sg13cmos5l_dfrbpq_1
XANTENNA_105 FrameData[3] VPWR VGND sg13cmos5l_antennanp
XANTENNA_116 FrameData[3] VPWR VGND sg13cmos5l_antennanp
XANTENNA_127 FrameData[3] VPWR VGND sg13cmos5l_antennanp
XANTENNA_138 FrameData[30] VPWR VGND sg13cmos5l_antennanp
XANTENNA_149 WW4END[3] VPWR VGND sg13cmos5l_antennanp
XANTENNA__3736__X E2BEGb[6] VPWR VGND sg13cmos5l_antennanp
XFILLER_14_85 VPWR VGND sg13cmos5l_decap_4
XFILLER_29_180 VPWR VGND sg13cmos5l_fill_2
XFILLER_49_489 VPWR VGND sg13cmos5l_fill_2
X_3760_ W2BEG[5] _3760_/A VPWR VGND sg13cmos5l_buf_1
X_2711_ _2715_/S _2840_/A _2726_/B VPWR VGND sg13cmos5l_and2_1
XANTENNA__3646__X FrameData_O[28] VPWR VGND sg13cmos5l_antennanp
X_1524_ _1524_/Y _3256_/Q _2029_/X _1523_/Y VPWR VGND sg13cmos5l_a21oi_1
X_3691_ EE4BEG[5] EE4END[9] VPWR VGND sg13cmos5l_buf_1
X_2642_ _2643_/B _2329_/X _2641_/X _2642_/S VPWR VGND sg13cmos5l_mux2_1
X_2573_ _2573_/Y _3187_/Q _2570_/X _3110_/Q VPWR VGND sg13cmos5l_o21ai_1
X_1455_ _1455_/Y _3248_/Q VPWR VGND sg13cmos5l_inv_1
X_3125_ _3125_/Q FrameData[11] FrameStrobe[8] VPWR VGND sg13cmos5l_dlhq_1
X_2007_ _2008_/B _2936_/Q _2968_/Q _2932_/Q _2964_/Q _2071_/A _2116_/Y VPWR VGND sg13cmos5l_mux4_1
X_3056_ _3056_/Q FrameData[6] FrameStrobe[10] VPWR VGND sg13cmos5l_dlhq_1
XANTENNA__3556__X N2BEG[6] VPWR VGND sg13cmos5l_antennanp
XFILLER_23_378 VPWR VGND sg13cmos5l_decap_4
XFILLER_50_186 VPWR VGND sg13cmos5l_fill_1
X_2909_ _2909_/Q _2913_/CLK _2909_/D _3497_/L_HI VPWR VGND sg13cmos5l_dfrbpq_1
XFILLER_2_238 VPWR VGND sg13cmos5l_fill_1
XFILLER_18_106 VPWR VGND sg13cmos5l_decap_4
XFILLER_2_66 VPWR VGND sg13cmos5l_fill_1
XANTENNA_16 N2MID[2] VPWR VGND sg13cmos5l_antennanp
XANTENNA_27 N2MID[2] VPWR VGND sg13cmos5l_antennanp
XANTENNA_38 N2MID[4] VPWR VGND sg13cmos5l_antennanp
XANTENNA_49 SS4END[0] VPWR VGND sg13cmos5l_antennanp
XFILLER_20_304 VPWR VGND sg13cmos5l_fill_1
XFILLER_32_175 VPWR VGND sg13cmos5l_fill_2
XFILLER_32_186 VPWR VGND sg13cmos5l_fill_1
X_3674_ S4BEG[4] S4END[8] VPWR VGND sg13cmos5l_buf_1
X_3743_ E2BEG[5] _3743_/A VPWR VGND sg13cmos5l_buf_1
X_1507_ _1507_/Y _3314_/Q VPWR VGND sg13cmos5l_inv_1
X_2625_ _2625_/Y _3270_/Q _2623_/Y _2624_/Y VPWR VGND sg13cmos5l_o21ai_1
X_2556_ _2556_/Y _2556_/A VPWR VGND sg13cmos5l_inv_1
X_2487_ _2487_/Y _2487_/A _2487_/B VPWR VGND sg13cmos5l_nor2_1
X_3108_ _3108_/Q FrameData[26] FrameStrobe[9] VPWR VGND sg13cmos5l_dlhq_1
XFILLER_23_164 VPWR VGND sg13cmos5l_fill_2
X_3039_ _3039_/Q FrameData[21] FrameStrobe[11] VPWR VGND sg13cmos5l_dlhq_1
XFILLER_14_186 VPWR VGND sg13cmos5l_fill_1
XFILLER_14_197 VPWR VGND sg13cmos5l_fill_2
X_3390_ _3390_/Q FrameData[20] FrameStrobe[0] VPWR VGND sg13cmos5l_dlhq_1
X_2410_ _2410_/Y _3030_/Q _2410_/B VPWR VGND sg13cmos5l_nand2_1
X_2341_ _2342_/B N1END[0] E1END[0] W1END[0] _1912_/B _3068_/Q _3069_/Q VPWR VGND sg13cmos5l_mux4_1
X_2272_ _2275_/A _2272_/A _2272_/B VPWR VGND sg13cmos5l_nor2_1
Xclkbuf_3_6_0_UserCLK_regs clkbuf_3_6_0_UserCLK_regs/X clkbuf_0_UserCLK_regs/X VPWR
+ VGND sg13cmos5l_buf_8
X_1987_ _1988_/B _2938_/Q _2934_/Q _2970_/Q _2966_/Q _2116_/Y _2071_/A VPWR VGND sg13cmos5l_mux4_1
X_3657_ S2BEG[3] _3657_/A VPWR VGND sg13cmos5l_buf_1
X_3726_ E6BEG[8] E6END[10] VPWR VGND sg13cmos5l_buf_1
X_3588_ NN4BEG[6] NN4END[10] VPWR VGND sg13cmos5l_buf_1
X_2608_ _2608_/Y _2599_/A _2602_/X _3369_/Q VPWR VGND sg13cmos5l_a21oi_1
X_2539_ _2539_/Y SS4END[0] _3340_/Q _2538_/Y VPWR VGND sg13cmos5l_a21oi_1
XFILLER_28_267 VPWR VGND sg13cmos5l_fill_2
XFILLER_43_237 VPWR VGND sg13cmos5l_decap_8
XANTENNA__3744__X E2BEG[6] VPWR VGND sg13cmos5l_antennanp
X_1910_ _1910_/Y _2029_/X _3332_/Q VPWR VGND sg13cmos5l_nor2b_1
X_2890_ _2890_/Q _2922_/CLK _2890_/D _3516_/L_HI VPWR VGND sg13cmos5l_dfrbpq_1
XANTENNA__3654__X S2BEG[0] VPWR VGND sg13cmos5l_antennanp
X_1772_ _1772_/Y _2052_/A _2946_/Q VPWR VGND sg13cmos5l_nor2b_1
X_1841_ _3759_/A _1840_/X _1835_/X _3357_/Q VPWR VGND sg13cmos5l_mux2_1
X_3511_ _3511_/L_HI VPWR VGND sg13cmos5l_tiehi
X_2324_ _2326_/B _3282_/Q _2322_/Y _2323_/Y VPWR VGND sg13cmos5l_o21ai_1
X_3442_ _3442_/L_HI VPWR VGND sg13cmos5l_tiehi
X_3373_ _3373_/Q FrameData[3] FrameStrobe[0] VPWR VGND sg13cmos5l_dlhq_1
X_2186_ _2186_/Y _3302_/Q _2182_/X _2185_/Y VPWR VGND sg13cmos5l_o21ai_1
X_2255_ _2256_/B N1END[0] W1END[0] S1END[0] _1912_/B _3089_/Q _3088_/Q VPWR VGND sg13cmos5l_mux4_1
XANTENNA__3564__X N2BEGb[6] VPWR VGND sg13cmos5l_antennanp
X_3709_ SS4BEG[7] SS4END[11] VPWR VGND sg13cmos5l_buf_1
Xclkbuf_5_14__f_UserCLK_regs _2979_/CLK clkbuf_3_3_0_UserCLK_regs/X VPWR VGND sg13cmos5l_buf_8
XANTENNA__3739__X E2BEG[1] VPWR VGND sg13cmos5l_antennanp
XFILLER_16_226 VPWR VGND sg13cmos5l_fill_1
X_2040_ _2040_/X _2952_/Q _2984_/Q _2948_/Q _2980_/Q _1623_/Y _2052_/A VPWR VGND sg13cmos5l_mux4_1
XANTENNA__3649__X FrameData_O[31] VPWR VGND sg13cmos5l_antennanp
X_2942_ _2942_/Q clkload9/A _2942_/D _3464_/L_HI VPWR VGND sg13cmos5l_dfrbpq_1
X_2873_ _2873_/Q _3409_/CLK _2873_/D _3533_/L_HI VPWR VGND sg13cmos5l_dfrbpq_1
X_1686_ _1686_/X N2END[5] E2END[5] SS4END[1] W2END[5] _3230_/Q _3231_/Q VPWR VGND
+ sg13cmos5l_mux4_1
X_1755_ _1755_/X _2929_/Q _2961_/Q _2925_/Q _2957_/Q _1623_/Y _2052_/A VPWR VGND sg13cmos5l_mux4_1
X_1824_ _1824_/Y _1458_/Y _3176_/Q _3177_/Q VPWR VGND sg13cmos5l_a21oi_1
X_2238_ _2238_/X N2MID[3] E2MID[3] S2MID[3] W2MID[3] _3188_/Q _3189_/Q VPWR VGND sg13cmos5l_mux4_1
X_2307_ _2307_/Y _3306_/Q _2304_/X _2306_/Y VPWR VGND sg13cmos5l_a21oi_1
X_3425_ _3425_/L_HI VPWR VGND sg13cmos5l_tiehi
X_3356_ _3356_/Q FrameData[18] FrameStrobe[1] VPWR VGND sg13cmos5l_dlhq_1
X_3287_ _3287_/Q FrameData[13] FrameStrobe[3] VPWR VGND sg13cmos5l_dlhq_1
XANTENNA__3559__X N2BEGb[1] VPWR VGND sg13cmos5l_antennanp
XFILLER_38_384 VPWR VGND sg13cmos5l_fill_1
X_2169_ _2169_/Y _3248_/Q _1912_/B _2168_/Y VPWR VGND sg13cmos5l_o21ai_1
XFILLER_44_83 VPWR VGND sg13cmos5l_fill_1
XFILLER_12_284 VPWR VGND sg13cmos5l_fill_1
X_1540_ _1540_/Y _3386_/Q N4END[3] VPWR VGND sg13cmos5l_nor2b_1
X_1471_ _1471_/Y _3297_/Q VPWR VGND sg13cmos5l_inv_1
X_3210_ _3210_/Q FrameData[0] FrameStrobe[5] VPWR VGND sg13cmos5l_dlhq_1
X_3141_ _3141_/Q FrameData[27] FrameStrobe[8] VPWR VGND sg13cmos5l_dlhq_1
XFILLER_35_365 VPWR VGND sg13cmos5l_fill_2
XFILLER_54_118 VPWR VGND sg13cmos5l_fill_1
X_2023_ _2023_/Y _2071_/A _2023_/B VPWR VGND sg13cmos5l_nand2_1
X_3072_ _3072_/Q FrameData[22] FrameStrobe[10] VPWR VGND sg13cmos5l_dlhq_1
X_1807_ _1807_/X WW4END[1] _1912_/B _2058_/X _2029_/X _3364_/Q _3362_/Q VPWR VGND
+ sg13cmos5l_mux4_1
X_2925_ _2925_/Q _2962_/CLK _2925_/D _3481_/L_HI VPWR VGND sg13cmos5l_dfrbpq_1
X_2856_ _2984_/D _2660_/X _2984_/Q _2859_/S VPWR VGND sg13cmos5l_mux2_1
X_1669_ _1669_/Y _1491_/Y _1668_/X _1492_/Y VPWR VGND sg13cmos5l_a21oi_1
X_1738_ _2056_/A _3134_/Q _1715_/Y _1735_/Y _1737_/Y VPWR VGND sg13cmos5l_a22oi_1
X_3408_ _3408_/Q _3408_/CLK _3408_/D _3418_/L_HI VPWR VGND sg13cmos5l_dfrbpq_1
X_2787_ _2932_/D _2660_/X _2932_/Q _2790_/S VPWR VGND sg13cmos5l_mux2_1
XANTENNA_106 FrameData[3] VPWR VGND sg13cmos5l_antennanp
XFILLER_26_321 VPWR VGND sg13cmos5l_decap_4
X_3339_ _3339_/Q FrameData[1] FrameStrobe[1] VPWR VGND sg13cmos5l_dlhq_1
XANTENNA_117 FrameData[3] VPWR VGND sg13cmos5l_antennanp
XANTENNA_128 FrameData[3] VPWR VGND sg13cmos5l_antennanp
XANTENNA_139 FrameData[30] VPWR VGND sg13cmos5l_antennanp
XANTENNA__3752__X W1BEG[1] VPWR VGND sg13cmos5l_antennanp
XFILLER_17_310 VPWR VGND sg13cmos5l_fill_1
X_3690_ EE4BEG[4] EE4END[8] VPWR VGND sg13cmos5l_buf_1
X_2710_ _2726_/B _2817_/A _2817_/B _2839_/A VPWR VGND sg13cmos5l_nor3_1
XANTENNA__3662__X S2BEGb[0] VPWR VGND sg13cmos5l_antennanp
X_1454_ _2155_/A _3279_/Q VPWR VGND sg13cmos5l_inv_1
X_1523_ _1523_/Y _3256_/Q W6END[0] VPWR VGND sg13cmos5l_nor2b_1
X_2641_ _2641_/X N2MID[0] S2MID[0] W2MID[0] _3759_/A _3160_/Q _3161_/Q VPWR VGND sg13cmos5l_mux4_1
X_2572_ _2572_/Y W2MID[7] _3186_/Q _2571_/Y VPWR VGND sg13cmos5l_a21oi_1
XFILLER_27_118 VPWR VGND sg13cmos5l_fill_1
X_3124_ _3124_/Q FrameData[10] FrameStrobe[8] VPWR VGND sg13cmos5l_dlhq_1
X_3055_ _3055_/Q FrameData[5] FrameStrobe[10] VPWR VGND sg13cmos5l_dlhq_1
X_2006_ _2006_/X _2928_/Q _2960_/Q _2924_/Q _2956_/Q _2071_/A _2116_/Y VPWR VGND sg13cmos5l_mux4_1
X_2908_ _2908_/Q _2912_/CLK _2908_/D _3498_/L_HI VPWR VGND sg13cmos5l_dfrbpq_1
X_2839_ _2855_/B _2839_/A _2839_/B VPWR VGND sg13cmos5l_nor2_1
XANTENNA__3572__X N4BEG[6] VPWR VGND sg13cmos5l_antennanp
XFILLER_26_151 VPWR VGND sg13cmos5l_fill_2
XFILLER_54_471 VPWR VGND sg13cmos5l_fill_2
XANTENNA__3747__X E1BEG[1] VPWR VGND sg13cmos5l_antennanp
XFILLER_14_335 VPWR VGND sg13cmos5l_fill_1
XFILLER_14_357 VPWR VGND sg13cmos5l_fill_1
XFILLER_54_493 VPWR VGND sg13cmos5l_fill_1
XFILLER_41_62 VPWR VGND sg13cmos5l_fill_1
XFILLER_1_250 VPWR VGND sg13cmos5l_fill_1
XFILLER_52_419 VPWR VGND sg13cmos5l_fill_2
XANTENNA_17 N2MID[2] VPWR VGND sg13cmos5l_antennanp
XANTENNA_28 N2MID[2] VPWR VGND sg13cmos5l_antennanp
XANTENNA_39 S4END[1] VPWR VGND sg13cmos5l_antennanp
XANTENNA__3657__X S2BEG[3] VPWR VGND sg13cmos5l_antennanp
XFILLER_20_327 VPWR VGND sg13cmos5l_fill_1
X_3673_ S4BEG[3] S4END[7] VPWR VGND sg13cmos5l_buf_1
X_3742_ E2BEG[4] _3742_/A VPWR VGND sg13cmos5l_buf_1
X_2624_ _2624_/Y _3270_/Q _2621_/Y _1502_/Y VPWR VGND sg13cmos5l_a21oi_1
X_1506_ _1506_/Y _3316_/Q VPWR VGND sg13cmos5l_inv_1
X_2555_ _2556_/A _3191_/Q _2554_/X _2553_/Y VPWR VGND sg13cmos5l_o21ai_1
X_2486_ _2487_/B _3013_/Q _2485_/Y _3014_/Q VPWR VGND sg13cmos5l_o21ai_1
X_3107_ _3107_/Q FrameData[25] FrameStrobe[9] VPWR VGND sg13cmos5l_dlhq_1
X_3038_ _3038_/Q FrameData[20] FrameStrobe[11] VPWR VGND sg13cmos5l_dlhq_1
XANTENNA__3567__X N4BEG[1] VPWR VGND sg13cmos5l_antennanp
XFILLER_11_305 VPWR VGND sg13cmos5l_fill_2
XFILLER_14_143 VPWR VGND sg13cmos5l_fill_1
X_2271_ _2272_/B _3082_/Q _2270_/Y _3084_/Q VPWR VGND sg13cmos5l_o21ai_1
X_2340_ _2343_/A _2340_/A _2340_/B VPWR VGND sg13cmos5l_nor2_1
XFILLER_33_430 VPWR VGND sg13cmos5l_fill_1
X_1986_ _1986_/X _2930_/Q _2926_/Q _2962_/Q _2958_/Q _2116_/Y _2071_/A VPWR VGND sg13cmos5l_mux4_1
X_3587_ NN4BEG[5] NN4END[9] VPWR VGND sg13cmos5l_buf_1
X_3656_ S2BEG[2] _3656_/A VPWR VGND sg13cmos5l_buf_1
X_3725_ E6BEG[7] E6END[9] VPWR VGND sg13cmos5l_buf_1
X_2607_ _2607_/Y _3366_/Q _2603_/X _2606_/Y VPWR VGND sg13cmos5l_o21ai_1
Xclkbuf_5_22__f_UserCLK_regs _2899_/CLK clkbuf_3_5_0_UserCLK_regs/X VPWR VGND sg13cmos5l_buf_8
X_2538_ _2538_/Y _3340_/Q E2END[1] VPWR VGND sg13cmos5l_nor2b_1
X_2469_ _2470_/B N1END[1] E1END[1] W1END[1] _2058_/X _3015_/Q _3016_/Q VPWR VGND sg13cmos5l_mux4_1
XANTENNA__3760__X W2BEG[5] VPWR VGND sg13cmos5l_antennanp
XFILLER_15_430 VPWR VGND sg13cmos5l_fill_1
XFILLER_30_411 VPWR VGND sg13cmos5l_decap_8
XFILLER_34_227 VPWR VGND sg13cmos5l_fill_2
XFILLER_42_260 VPWR VGND sg13cmos5l_decap_4
XFILLER_42_282 VPWR VGND sg13cmos5l_fill_1
XFILLER_8_33 VPWR VGND sg13cmos5l_fill_1
X_1840_ _1840_/X _1837_/X _1839_/X _1836_/X _1838_/X _3355_/Q _3354_/Q VPWR VGND sg13cmos5l_mux4_1
XFILLER_8_44 VPWR VGND sg13cmos5l_fill_1
X_1771_ _1771_/X _2954_/Q _2950_/Q _2986_/Q _2982_/Q _2052_/A _1623_/Y VPWR VGND sg13cmos5l_mux4_1
X_3510_ _3510_/L_HI VPWR VGND sg13cmos5l_tiehi
X_3441_ _3441_/L_HI VPWR VGND sg13cmos5l_tiehi
XANTENNA__3670__X S4BEG[0] VPWR VGND sg13cmos5l_antennanp
X_2254_ _2257_/A _2254_/A _2254_/B VPWR VGND sg13cmos5l_nor2_1
X_2323_ _2323_/Y _3282_/Q _2320_/X _1476_/Y VPWR VGND sg13cmos5l_a21oi_1
X_3372_ _3372_/Q FrameData[2] FrameStrobe[0] VPWR VGND sg13cmos5l_dlhq_1
X_2185_ _2185_/Y _2185_/A _3303_/Q VPWR VGND sg13cmos5l_nor2b_1
X_1969_ _1969_/X _1969_/A _1969_/B _2075_/A VPWR VGND sg13cmos5l_or3_1
XFILLER_0_337 VPWR VGND sg13cmos5l_fill_1
X_3639_ FrameData_O[21] FrameData[21] VPWR VGND sg13cmos5l_buf_1
X_3708_ SS4BEG[6] SS4END[10] VPWR VGND sg13cmos5l_buf_1
XANTENNA__3580__X N4BEG[14] VPWR VGND sg13cmos5l_antennanp
XFILLER_24_293 VPWR VGND sg13cmos5l_fill_2
XANTENNA__3755__X W2BEG[0] VPWR VGND sg13cmos5l_antennanp
XFILLER_8_459 VPWR VGND sg13cmos5l_fill_2
XFILLER_39_308 VPWR VGND sg13cmos5l_fill_2
XANTENNA__3665__X S2BEGb[3] VPWR VGND sg13cmos5l_antennanp
XFILLER_22_219 VPWR VGND sg13cmos5l_fill_1
X_1823_ _1823_/Y _3176_/Q _1821_/A _1822_/Y VPWR VGND sg13cmos5l_a21oi_1
X_2941_ _2941_/Q _2979_/CLK _2941_/D _3465_/L_HI VPWR VGND sg13cmos5l_dfrbpq_1
X_2872_ _2872_/Q _2893_/CLK _2872_/D _3534_/L_HI VPWR VGND sg13cmos5l_dfrbpq_1
X_1685_ _1685_/X N4END[1] SS4END[1] W2END[4] _3657_/A _3390_/Q _3391_/Q VPWR VGND
+ sg13cmos5l_mux4_1
X_1754_ _1754_/Y _1800_/A _1754_/B VPWR VGND sg13cmos5l_nand2_1
X_3424_ _3424_/L_HI VPWR VGND sg13cmos5l_tiehi
X_2237_ _2237_/X N2MID[3] E2MID[3] S2MID[3] W2MID[3] _3180_/Q _3181_/Q VPWR VGND sg13cmos5l_mux4_1
X_2306_ _2306_/Y _3306_/Q _2305_/X _3307_/Q VPWR VGND sg13cmos5l_o21ai_1
X_3355_ _3355_/Q FrameData[17] FrameStrobe[1] VPWR VGND sg13cmos5l_dlhq_1
X_3286_ _3286_/Q FrameData[12] FrameStrobe[3] VPWR VGND sg13cmos5l_dlhq_1
XFILLER_21_230 VPWR VGND sg13cmos5l_fill_1
X_2099_ _2099_/Y _2099_/A _3261_/Q VPWR VGND sg13cmos5l_nor2b_1
X_2168_ _2168_/Y _1980_/X _3248_/Q VPWR VGND sg13cmos5l_nand2b_1
XANTENNA__3575__X N4BEG[9] VPWR VGND sg13cmos5l_antennanp
XFILLER_28_63 VPWR VGND sg13cmos5l_fill_1
XFILLER_4_451 VPWR VGND sg13cmos5l_fill_2
X_1470_ _1470_/Y _3295_/Q VPWR VGND sg13cmos5l_inv_1
X_3140_ _3140_/Q FrameData[26] FrameStrobe[8] VPWR VGND sg13cmos5l_dlhq_1
X_3071_ _3071_/Q FrameData[21] FrameStrobe[10] VPWR VGND sg13cmos5l_dlhq_1
X_2022_ _2023_/B _2896_/Q _2116_/Y _2021_/Y VPWR VGND sg13cmos5l_o21ai_1
X_1806_ _1806_/X _2426_/B _2139_/B _2087_/X _1980_/X _3362_/Q _3364_/Q VPWR VGND sg13cmos5l_mux4_1
X_2924_ _2924_/Q clkload4/A _2924_/D _3482_/L_HI VPWR VGND sg13cmos5l_dfrbpq_1
X_2855_ _2859_/S _2855_/A _2855_/B VPWR VGND sg13cmos5l_nand2_1
X_2786_ _2790_/S _2850_/A _2791_/B VPWR VGND sg13cmos5l_nand2_1
X_1599_ _1600_/A _2139_/B _1980_/X _3352_/Q VPWR VGND sg13cmos5l_mux2_1
X_1668_ _1668_/X N2END[3] S2END[3] E2END[3] WW4END[1] _3229_/Q _3228_/Q VPWR VGND
+ sg13cmos5l_mux4_1
X_1737_ _1737_/Y _1495_/Y _1736_/X _3134_/Q VPWR VGND sg13cmos5l_a21oi_1
X_3407_ _3407_/Q _3408_/CLK _3407_/D _3417_/L_HI VPWR VGND sg13cmos5l_dfrbpq_1
X_3338_ _3338_/Q FrameData[0] FrameStrobe[1] VPWR VGND sg13cmos5l_dlhq_1
XANTENNA_107 FrameData[3] VPWR VGND sg13cmos5l_antennanp
XANTENNA_118 FrameData[3] VPWR VGND sg13cmos5l_antennanp
XANTENNA_129 FrameData[3] VPWR VGND sg13cmos5l_antennanp
X_3269_ _3269_/Q FrameData[27] FrameStrobe[4] VPWR VGND sg13cmos5l_dlhq_1
XFILLER_14_32 VPWR VGND sg13cmos5l_fill_2
XFILLER_14_54 VPWR VGND sg13cmos5l_fill_1
XFILLER_5_204 VPWR VGND sg13cmos5l_fill_2
XFILLER_5_237 VPWR VGND sg13cmos5l_fill_2
XFILLER_1_465 VPWR VGND sg13cmos5l_fill_1
X_2640_ _2640_/Y _2642_/S _1712_/A _2639_/Y VPWR VGND sg13cmos5l_a21oi_1
X_1453_ _1453_/Y E1END[0] VPWR VGND sg13cmos5l_inv_1
X_1522_ _1522_/X _2058_/X _2087_/X _3256_/Q VPWR VGND sg13cmos5l_mux2_1
X_2571_ _2571_/Y _3186_/Q S2MID[7] VPWR VGND sg13cmos5l_nor2b_1
XFILLER_48_491 VPWR VGND sg13cmos5l_fill_2
X_2005_ _2005_/X _2083_/A _2003_/X _2004_/X VPWR VGND sg13cmos5l_a21o_1
X_3123_ _3123_/Q FrameData[9] FrameStrobe[8] VPWR VGND sg13cmos5l_dlhq_1
X_3054_ _3054_/Q FrameData[4] FrameStrobe[10] VPWR VGND sg13cmos5l_dlhq_1
XFILLER_35_174 VPWR VGND sg13cmos5l_decap_4
XFILLER_35_196 VPWR VGND sg13cmos5l_fill_1
X_2907_ _2907_/Q _2907_/CLK _2907_/D _3499_/L_HI VPWR VGND sg13cmos5l_dfrbpq_1
XFILLER_2_229 VPWR VGND sg13cmos5l_fill_2
X_2838_ _2971_/D _2689_/Y _2971_/Q _2838_/S VPWR VGND sg13cmos5l_mux2_1
X_2769_ _2773_/S _2855_/A _2769_/B VPWR VGND sg13cmos5l_nand2_1
XFILLER_26_174 VPWR VGND sg13cmos5l_decap_4
XANTENNA__3763__X W2BEGb[0] VPWR VGND sg13cmos5l_antennanp
XFILLER_37_439 VPWR VGND sg13cmos5l_fill_1
XANTENNA_18 N2MID[2] VPWR VGND sg13cmos5l_antennanp
XANTENNA_29 N2MID[2] VPWR VGND sg13cmos5l_antennanp
XFILLER_32_177 VPWR VGND sg13cmos5l_fill_1
X_3741_ E2BEG[3] _3741_/A VPWR VGND sg13cmos5l_buf_1
XANTENNA__3673__X S4BEG[3] VPWR VGND sg13cmos5l_antennanp
X_3672_ S4BEG[2] S4END[6] VPWR VGND sg13cmos5l_buf_1
Xclkbuf_5_30__f_UserCLK_regs _2912_/CLK clkbuf_3_7_0_UserCLK_regs/X VPWR VGND sg13cmos5l_buf_8
X_2623_ _2623_/Y _3272_/Q _2087_/X _2622_/Y VPWR VGND sg13cmos5l_a21oi_1
X_2554_ _2554_/X N2MID[5] E2MID[5] _3190_/Q VPWR VGND sg13cmos5l_mux2_1
X_1505_ _1505_/Y _3291_/Q VPWR VGND sg13cmos5l_inv_1
X_2485_ _2485_/Y _3012_/Q _1980_/X _2484_/Y VPWR VGND sg13cmos5l_o21ai_1
X_3106_ _3106_/Q FrameData[24] FrameStrobe[9] VPWR VGND sg13cmos5l_dlhq_1
X_3037_ _3037_/Q FrameData[19] FrameStrobe[11] VPWR VGND sg13cmos5l_dlhq_1
XFILLER_51_497 VPWR VGND sg13cmos5l_fill_2
XANTENNA__3583__X NN4BEG[1] VPWR VGND sg13cmos5l_antennanp
XANTENNA__3758__X W2BEG[3] VPWR VGND sg13cmos5l_antennanp
XFILLER_36_63 VPWR VGND sg13cmos5l_fill_1
XFILLER_10_383 VPWR VGND sg13cmos5l_fill_1
XFILLER_6_332 VPWR VGND sg13cmos5l_fill_1
X_2270_ _2270_/Y _3083_/Q _2238_/X _2269_/Y VPWR VGND sg13cmos5l_a21oi_1
XANTENNA__3668__X S2BEGb[6] VPWR VGND sg13cmos5l_antennanp
X_1985_ _1985_/Y _2080_/A _1985_/B _1985_/C VPWR VGND sg13cmos5l_nand3_1
X_3724_ E6BEG[6] E6END[8] VPWR VGND sg13cmos5l_buf_1
X_3586_ NN4BEG[4] NN4END[8] VPWR VGND sg13cmos5l_buf_1
X_3655_ S2BEG[1] _3655_/A VPWR VGND sg13cmos5l_buf_1
X_2606_ _2606_/Y _3366_/Q _2605_/Y _2599_/A VPWR VGND sg13cmos5l_a21oi_1
X_2537_ _2537_/X E6END[1] W2END[1] _3340_/Q VPWR VGND sg13cmos5l_mux2_1
XFILLER_28_203 VPWR VGND sg13cmos5l_fill_1
X_2468_ _3746_/A _1912_/B _3553_/A _2329_/X _2328_/X _3019_/Q _3018_/Q VPWR VGND sg13cmos5l_mux4_1
X_2399_ _2399_/Y _3033_/Q _1643_/A _2398_/Y VPWR VGND sg13cmos5l_o21ai_1
XANTENNA__3578__X N4BEG[12] VPWR VGND sg13cmos5l_antennanp
XFILLER_11_136 VPWR VGND sg13cmos5l_fill_1
XFILLER_19_203 VPWR VGND sg13cmos5l_fill_2
X_1770_ _1770_/X _1762_/X _1769_/X _1794_/S VPWR VGND sg13cmos5l_mux2_1
XFILLER_8_89 VPWR VGND sg13cmos5l_fill_2
X_3440_ _3440_/L_HI VPWR VGND sg13cmos5l_tiehi
X_3371_ _3371_/Q FrameData[1] FrameStrobe[0] VPWR VGND sg13cmos5l_dlhq_1
X_2184_ _2185_/A _3304_/Q _2620_/B _2183_/Y VPWR VGND sg13cmos5l_a21oi_1
X_2253_ _2254_/B _3088_/Q _2252_/Y _3090_/Q VPWR VGND sg13cmos5l_o21ai_1
X_2322_ _2322_/Y _3284_/Q _2620_/B _2321_/Y VPWR VGND sg13cmos5l_a21oi_1
X_1899_ _1899_/Y _3332_/Q _2426_/B VPWR VGND sg13cmos5l_nor2b_1
X_1968_ _2075_/A _3145_/Q _1959_/X _1966_/Y VPWR VGND sg13cmos5l_a21o_1
X_3707_ SS4BEG[5] SS4END[9] VPWR VGND sg13cmos5l_buf_1
Xclkbuf_3_2_0_UserCLK_regs clkbuf_3_2_0_UserCLK_regs/X clkbuf_0_UserCLK_regs/X VPWR
+ VGND sg13cmos5l_buf_8
XFILLER_0_349 VPWR VGND sg13cmos5l_fill_1
X_3569_ N4BEG[3] N4END[7] VPWR VGND sg13cmos5l_buf_1
X_3638_ FrameData_O[20] FrameData[20] VPWR VGND sg13cmos5l_buf_1
XFILLER_12_423 VPWR VGND sg13cmos5l_fill_1
XANTENNA__3771__X W6BEG[0] VPWR VGND sg13cmos5l_antennanp
X_2940_ _2940_/Q _2976_/CLK _2940_/D _3466_/L_HI VPWR VGND sg13cmos5l_dfrbpq_1
XFILLER_30_220 VPWR VGND sg13cmos5l_fill_1
X_1753_ _1754_/B _2937_/Q _2969_/Q _2933_/Q _2965_/Q _1623_/Y _2052_/A VPWR VGND sg13cmos5l_mux4_1
X_1822_ _1822_/Y _3176_/Q W2MID[0] _3177_/Q VPWR VGND sg13cmos5l_o21ai_1
X_2871_ _2871_/Q _2921_/CLK _2871_/D _3535_/L_HI VPWR VGND sg13cmos5l_dfrbpq_1
XANTENNA__3681__X S4BEG[11] VPWR VGND sg13cmos5l_antennanp
XFILLER_31_0 VPWR VGND sg13cmos5l_fill_1
X_1684_ _3657_/A _3321_/Q _1679_/Y _1681_/Y _1683_/Y VPWR VGND sg13cmos5l_a22oi_1
X_3423_ _3423_/L_HI VPWR VGND sg13cmos5l_tiehi
X_3354_ _3354_/Q FrameData[16] FrameStrobe[1] VPWR VGND sg13cmos5l_dlhq_1
X_2167_ _2167_/Y _1455_/Y _1512_/Y _2166_/Y VPWR VGND sg13cmos5l_o21ai_1
X_2236_ _2236_/Y _3095_/Q _2235_/X _2234_/Y VPWR VGND sg13cmos5l_a21oi_1
X_2305_ _2305_/X _1513_/Y _1512_/Y _3308_/Q VPWR VGND sg13cmos5l_mux2_1
X_3285_ _3285_/Q FrameData[11] FrameStrobe[3] VPWR VGND sg13cmos5l_dlhq_1
X_2098_ _2099_/A _3258_/Q _2095_/Y _2097_/Y VPWR VGND sg13cmos5l_a21oi_1
XANTENNA__3591__X NN4BEG[9] VPWR VGND sg13cmos5l_antennanp
XFILLER_0_168 VPWR VGND sg13cmos5l_fill_1
XFILLER_44_301 VPWR VGND sg13cmos5l_fill_2
XFILLER_44_389 VPWR VGND sg13cmos5l_fill_2
XANTENNA__3766__X W2BEGb[3] VPWR VGND sg13cmos5l_antennanp
X_2021_ _2021_/Y _2892_/Q _2116_/Y VPWR VGND sg13cmos5l_nand2b_1
X_3070_ _3070_/Q FrameData[20] FrameStrobe[10] VPWR VGND sg13cmos5l_dlhq_1
XANTENNA__3676__X S4BEG[6] VPWR VGND sg13cmos5l_antennanp
X_2923_ _2923_/Q _2923_/CLK _2923_/D _3483_/L_HI VPWR VGND sg13cmos5l_dfrbpq_1
X_1736_ _1736_/X N2END[1] S2END[1] _3132_/Q VPWR VGND sg13cmos5l_mux2_1
X_1805_ _1912_/B _3409_/D _3409_/Q _2988_/Q VPWR VGND sg13cmos5l_mux2_1
X_2854_ _2983_/D _2689_/Y _2983_/Q _2854_/S VPWR VGND sg13cmos5l_mux2_1
X_2785_ _2931_/D _2689_/Y _2931_/Q _2785_/S VPWR VGND sg13cmos5l_mux2_1
X_1598_ _1598_/X NN4END[3] S4END[0] E2END[4] W2END[4] _3352_/Q _3350_/Q VPWR VGND
+ sg13cmos5l_mux4_1
X_1667_ _1667_/Y _1663_/Y _1666_/Y _3126_/Q VPWR VGND sg13cmos5l_o21ai_1
X_3406_ _3406_/Q _3408_/CLK _3406_/D _3416_/L_HI VPWR VGND sg13cmos5l_dfrbpq_1
X_3337_ _3337_/Q FrameData[31] FrameStrobe[2] VPWR VGND sg13cmos5l_dlhq_1
XANTENNA_108 FrameData[3] VPWR VGND sg13cmos5l_antennanp
XANTENNA_119 FrameData[3] VPWR VGND sg13cmos5l_antennanp
XFILLER_26_356 VPWR VGND sg13cmos5l_decap_4
X_2219_ _2219_/X _1702_/X _1919_/B _3098_/Q VPWR VGND sg13cmos5l_mux2_1
X_3268_ _3268_/Q FrameData[26] FrameStrobe[4] VPWR VGND sg13cmos5l_dlhq_1
X_3199_ _3199_/Q FrameData[21] FrameStrobe[6] VPWR VGND sg13cmos5l_dlhq_1
XANTENNA__3586__X NN4BEG[4] VPWR VGND sg13cmos5l_antennanp
XFILLER_17_356 VPWR VGND sg13cmos5l_decap_8
XFILLER_32_348 VPWR VGND sg13cmos5l_fill_1
XFILLER_44_175 VPWR VGND sg13cmos5l_fill_1
X_2570_ _2570_/X N2MID[7] E2MID[7] _3186_/Q VPWR VGND sg13cmos5l_mux2_1
XFILLER_4_271 VPWR VGND sg13cmos5l_fill_2
X_1452_ _2145_/A _3311_/Q VPWR VGND sg13cmos5l_inv_1
X_1521_ _1521_/Y _3254_/Q _1517_/Y _1520_/Y VPWR VGND sg13cmos5l_a21oi_1
X_3122_ _3122_/Q FrameData[8] FrameStrobe[8] VPWR VGND sg13cmos5l_dlhq_1
XFILLER_35_120 VPWR VGND sg13cmos5l_fill_1
X_2004_ _2004_/X _2077_/A _2002_/X _1973_/A VPWR VGND sg13cmos5l_a21o_1
X_3053_ _3053_/Q FrameData[3] FrameStrobe[10] VPWR VGND sg13cmos5l_dlhq_1
XFILLER_23_315 VPWR VGND sg13cmos5l_fill_2
X_2906_ _2906_/Q _2907_/CLK _2906_/D _3500_/L_HI VPWR VGND sg13cmos5l_dfrbpq_1
X_1719_ _1719_/Y _1718_/X _3301_/Q VPWR VGND sg13cmos5l_nand2b_1
X_2837_ _2970_/D _2675_/X _2970_/Q _2838_/S VPWR VGND sg13cmos5l_mux2_1
X_2768_ _2919_/D _2919_/Q _2689_/Y _2768_/S VPWR VGND sg13cmos5l_mux2_1
X_2699_ _2703_/S _2705_/A _2850_/A VPWR VGND sg13cmos5l_and2_1
XFILLER_2_25 VPWR VGND sg13cmos5l_fill_2
XFILLER_49_223 VPWR VGND sg13cmos5l_fill_1
XFILLER_9_0 VPWR VGND sg13cmos5l_fill_1
XFILLER_45_473 VPWR VGND sg13cmos5l_fill_1
XANTENNA_19 N2MID[2] VPWR VGND sg13cmos5l_antennanp
X_3740_ E2BEG[2] _3740_/A VPWR VGND sg13cmos5l_buf_1
X_1504_ _2642_/S _3116_/Q VPWR VGND sg13cmos5l_inv_1
X_3671_ S4BEG[1] S4END[5] VPWR VGND sg13cmos5l_buf_1
X_2622_ _2622_/Y _3272_/Q _2426_/B VPWR VGND sg13cmos5l_nor2b_1
X_2553_ _2553_/Y _3191_/Q _2553_/B _2553_/C VPWR VGND sg13cmos5l_nand3_1
X_3105_ _3105_/Q FrameData[23] FrameStrobe[9] VPWR VGND sg13cmos5l_dlhq_1
X_2484_ _2484_/Y _3012_/Q _2484_/B VPWR VGND sg13cmos5l_nand2_1
X_3036_ _3036_/Q FrameData[18] FrameStrobe[11] VPWR VGND sg13cmos5l_dlhq_1
XFILLER_51_476 VPWR VGND sg13cmos5l_fill_2
XFILLER_11_34 VPWR VGND sg13cmos5l_fill_2
XFILLER_14_134 VPWR VGND sg13cmos5l_decap_8
XFILLER_54_270 VPWR VGND sg13cmos5l_fill_2
XANTENNA__3774__X W6BEG[3] VPWR VGND sg13cmos5l_antennanp
XFILLER_10_340 VPWR VGND sg13cmos5l_fill_2
XFILLER_37_204 VPWR VGND sg13cmos5l_fill_2
XANTENNA__3684__X S4BEG[14] VPWR VGND sg13cmos5l_antennanp
X_1984_ _1985_/C _2083_/A _1984_/B VPWR VGND sg13cmos5l_nand2_1
X_3654_ S2BEG[0] _3654_/A VPWR VGND sg13cmos5l_buf_1
X_3723_ E6BEG[5] E6END[7] VPWR VGND sg13cmos5l_buf_1
X_3585_ NN4BEG[3] NN4END[7] VPWR VGND sg13cmos5l_buf_1
X_2605_ _2605_/Y W1END[0] _3368_/Q _2604_/Y VPWR VGND sg13cmos5l_a21oi_1
X_2536_ _2536_/Y _3339_/Q _2531_/X _3341_/Q VPWR VGND sg13cmos5l_o21ai_1
X_2467_ _3747_/A _2029_/X _1561_/X _3550_/A _1685_/X _3020_/Q _3021_/Q VPWR VGND sg13cmos5l_mux4_1
X_2398_ _2398_/Y _3033_/Q _2566_/B _1467_/Y VPWR VGND sg13cmos5l_a21oi_1
X_3019_ _3019_/Q FrameData[1] FrameStrobe[11] VPWR VGND sg13cmos5l_dlhq_1
XANTENNA__3594__X NN4BEG[12] VPWR VGND sg13cmos5l_antennanp
XFILLER_3_336 VPWR VGND sg13cmos5l_fill_2
XANTENNA__3769__X W2BEGb[6] VPWR VGND sg13cmos5l_antennanp
XFILLER_34_229 VPWR VGND sg13cmos5l_fill_1
X_2321_ _2321_/Y _3284_/Q _2426_/B VPWR VGND sg13cmos5l_nor2b_1
X_3370_ _3370_/Q FrameData[0] FrameStrobe[0] VPWR VGND sg13cmos5l_dlhq_1
XFILLER_33_4 VPWR VGND sg13cmos5l_fill_1
X_2183_ _2183_/Y _3304_/Q _1513_/Y _3302_/Q VPWR VGND sg13cmos5l_o21ai_1
X_2252_ _2252_/Y _3089_/Q _1849_/X _2251_/Y VPWR VGND sg13cmos5l_a21oi_1
XANTENNA__3679__X S4BEG[9] VPWR VGND sg13cmos5l_antennanp
XFILLER_21_402 VPWR VGND sg13cmos5l_decap_4
X_1898_ _1904_/B _1897_/X _1898_/B VPWR VGND sg13cmos5l_nand2b_1
X_1967_ _1967_/Y _3145_/Q _1959_/X _1966_/Y VPWR VGND sg13cmos5l_a21oi_1
X_3637_ FrameData_O[19] FrameData[19] VPWR VGND sg13cmos5l_buf_1
X_3706_ SS4BEG[4] SS4END[8] VPWR VGND sg13cmos5l_buf_1
X_3499_ _3499_/L_HI VPWR VGND sg13cmos5l_tiehi
X_3568_ N4BEG[2] N4END[6] VPWR VGND sg13cmos5l_buf_1
X_2519_ _2519_/Y _2518_/X _2519_/B VPWR VGND sg13cmos5l_nand2b_1
XANTENNA__3589__X NN4BEG[7] VPWR VGND sg13cmos5l_antennanp
XFILLER_12_446 VPWR VGND sg13cmos5l_fill_1
XFILLER_24_295 VPWR VGND sg13cmos5l_fill_1
XFILLER_33_65 VPWR VGND sg13cmos5l_fill_1
X_2870_ _2870_/Q _3408_/CLK _2870_/D _3536_/L_HI VPWR VGND sg13cmos5l_dfrbpq_1
XFILLER_7_494 VPWR VGND sg13cmos5l_fill_2
X_1683_ _1683_/Y _3319_/Q _1682_/X _3321_/Q VPWR VGND sg13cmos5l_a21oi_1
X_1752_ _1752_/Y _1800_/A _1749_/X _1794_/S VPWR VGND sg13cmos5l_a21oi_1
X_1821_ _3761_/A _1821_/A VPWR VGND sg13cmos5l_inv_1
X_2304_ _2304_/X _1912_/B _1980_/X _3308_/Q VPWR VGND sg13cmos5l_mux2_1
X_3422_ _3422_/L_HI VPWR VGND sg13cmos5l_tiehi
X_3353_ _3353_/Q FrameData[15] FrameStrobe[1] VPWR VGND sg13cmos5l_dlhq_1
X_3284_ _3284_/Q FrameData[10] FrameStrobe[3] VPWR VGND sg13cmos5l_dlhq_1
X_2097_ _2097_/Y _3258_/Q _2096_/X _3259_/Q VPWR VGND sg13cmos5l_o21ai_1
X_2166_ _2166_/Y _1455_/Y _2139_/B _3246_/Q VPWR VGND sg13cmos5l_a21oi_1
X_2235_ _2235_/X SS4END[1] W1END[3] _2139_/B _1912_/B _3094_/Q _3096_/Q VPWR VGND
+ sg13cmos5l_mux4_1
X_2999_ _2999_/Q FrameData[13] FrameStrobe[12] VPWR VGND sg13cmos5l_dlhq_1
XFILLER_44_346 VPWR VGND sg13cmos5l_fill_1
XFILLER_8_247 VPWR VGND sg13cmos5l_fill_1
XANTENNA__3782__X W6BEG[11] VPWR VGND sg13cmos5l_antennanp
XFILLER_4_497 VPWR VGND sg13cmos5l_fill_2
X_2020_ _2020_/Y _2860_/Q _2116_/Y _2019_/Y VPWR VGND sg13cmos5l_a21oi_1
XFILLER_50_349 VPWR VGND sg13cmos5l_fill_1
X_2922_ _2922_/Q _2922_/CLK _2922_/D _3484_/L_HI VPWR VGND sg13cmos5l_dfrbpq_1
X_2853_ _2982_/D _2675_/X _2982_/Q _2854_/S VPWR VGND sg13cmos5l_mux2_1
XANTENNA__3692__X EE4BEG[6] VPWR VGND sg13cmos5l_antennanp
X_1666_ _1666_/Y _3389_/Q _1666_/B _1666_/C VPWR VGND sg13cmos5l_nor3_1
X_1735_ _1735_/Y _1710_/S _1733_/X _1734_/Y VPWR VGND sg13cmos5l_o21ai_1
X_1804_ _3409_/D _1794_/X _1803_/Y _1804_/S VPWR VGND sg13cmos5l_mux2_1
X_2784_ _2930_/D _2675_/X _2930_/Q _2785_/S VPWR VGND sg13cmos5l_mux2_1
X_1597_ _1624_/A _1584_/Y _1587_/Y _1595_/Y VPWR VGND sg13cmos5l_a21o_1
X_3405_ _3405_/Q clkload3/A _3405_/D _3415_/L_HI VPWR VGND sg13cmos5l_dfrbpq_1
X_3336_ _3336_/Q FrameData[30] FrameStrobe[2] VPWR VGND sg13cmos5l_dlhq_1
X_3267_ _3267_/Q FrameData[25] FrameStrobe[4] VPWR VGND sg13cmos5l_dlhq_1
XANTENNA_109 FrameData[3] VPWR VGND sg13cmos5l_antennanp
XFILLER_38_173 VPWR VGND sg13cmos5l_fill_1
XFILLER_53_176 VPWR VGND sg13cmos5l_fill_2
X_2149_ _2149_/Y E6END[0] _3312_/Q _2148_/Y VPWR VGND sg13cmos5l_o21ai_1
X_2218_ _2218_/Y _2216_/B _2217_/X _2216_/Y VPWR VGND sg13cmos5l_o21ai_1
X_3198_ _3198_/Q FrameData[20] FrameStrobe[6] VPWR VGND sg13cmos5l_dlhq_1
XFILLER_30_55 VPWR VGND sg13cmos5l_fill_2
XFILLER_5_239 VPWR VGND sg13cmos5l_fill_1
XFILLER_29_173 VPWR VGND sg13cmos5l_decap_8
XANTENNA__3777__X W6BEG[6] VPWR VGND sg13cmos5l_antennanp
XFILLER_44_165 VPWR VGND sg13cmos5l_fill_2
X_1520_ _1520_/Y _3254_/Q _1519_/Y _3255_/Q VPWR VGND sg13cmos5l_o21ai_1
X_1451_ _2173_/A W2END[2] VPWR VGND sg13cmos5l_inv_1
X_3121_ _3121_/Q FrameData[7] FrameStrobe[8] VPWR VGND sg13cmos5l_dlhq_1
XANTENNA__3687__X EE4BEG[1] VPWR VGND sg13cmos5l_antennanp
XFILLER_35_165 VPWR VGND sg13cmos5l_decap_4
X_2003_ _2003_/X _2952_/Q _2984_/Q _2948_/Q _2980_/Q _2071_/A _2116_/Y VPWR VGND sg13cmos5l_mux4_1
X_3052_ _3052_/Q FrameData[2] FrameStrobe[10] VPWR VGND sg13cmos5l_dlhq_1
XFILLER_23_349 VPWR VGND sg13cmos5l_fill_2
X_2905_ _2905_/Q _2905_/CLK _2905_/D _3501_/L_HI VPWR VGND sg13cmos5l_dfrbpq_1
X_2836_ _2969_/D _2663_/X _2969_/Q _2838_/S VPWR VGND sg13cmos5l_mux2_1
X_1649_ _1649_/Y _1648_/X _3289_/Q VPWR VGND sg13cmos5l_nand2b_1
X_1718_ _1718_/X _1716_/X _1717_/X _1718_/S VPWR VGND sg13cmos5l_mux2_1
X_2767_ _2918_/D _2918_/Q _2675_/X _2768_/S VPWR VGND sg13cmos5l_mux2_1
X_2698_ _2850_/A _2698_/A _2704_/A VPWR VGND sg13cmos5l_nor2_1
X_3319_ _3319_/Q FrameData[13] FrameStrobe[2] VPWR VGND sg13cmos5l_dlhq_1
XANTENNA__3597__X NN4BEG[15] VPWR VGND sg13cmos5l_antennanp
X_3670_ S4BEG[0] S4END[4] VPWR VGND sg13cmos5l_buf_1
X_1503_ _2519_/B _3347_/Q VPWR VGND sg13cmos5l_inv_1
X_2621_ _2621_/Y _3272_/Q _1513_/Y _2620_/Y VPWR VGND sg13cmos5l_o21ai_1
X_2552_ _2553_/C _3190_/Q S2MID[5] VPWR VGND sg13cmos5l_nand2b_1
X_2483_ _2487_/A _3012_/Q _2481_/Y _2482_/Y VPWR VGND sg13cmos5l_a21oi_1
X_3104_ _3104_/Q FrameData[22] FrameStrobe[9] VPWR VGND sg13cmos5l_dlhq_1
X_3035_ _3035_/Q FrameData[17] FrameStrobe[11] VPWR VGND sg13cmos5l_dlhq_1
X_2819_ _2823_/S _2840_/A _2834_/B VPWR VGND sg13cmos5l_nand2_1
XFILLER_52_64 VPWR VGND sg13cmos5l_fill_2
XANTENNA__3790__X WW4BEG[7] VPWR VGND sg13cmos5l_antennanp
XFILLER_18_485 VPWR VGND sg13cmos5l_fill_1
X_1983_ _1984_/B _2954_/Q _2950_/Q _2986_/Q _2982_/Q _2116_/Y _2071_/A VPWR VGND sg13cmos5l_mux4_1
X_3653_ S1BEG[3] _3653_/A VPWR VGND sg13cmos5l_buf_1
X_3722_ E6BEG[4] E6END[6] VPWR VGND sg13cmos5l_buf_1
X_2604_ _2604_/Y _3368_/Q E2END[0] VPWR VGND sg13cmos5l_nor2b_1
XFILLER_54_0 VPWR VGND sg13cmos5l_fill_2
X_3584_ NN4BEG[2] NN4END[6] VPWR VGND sg13cmos5l_buf_1
X_2535_ _2535_/Y _3338_/Q _2532_/X _2534_/Y VPWR VGND sg13cmos5l_a21oi_1
X_2466_ _3550_/A _2466_/A _2466_/B VPWR VGND sg13cmos5l_nand2_1
X_3018_ _3018_/Q FrameData[0] FrameStrobe[11] VPWR VGND sg13cmos5l_dlhq_1
X_2397_ _2566_/B _2397_/A VPWR VGND sg13cmos5l_inv_1
XFILLER_3_359 VPWR VGND sg13cmos5l_fill_1
XANTENNA__3785__X WW4BEG[2] VPWR VGND sg13cmos5l_antennanp
XFILLER_30_425 VPWR VGND sg13cmos5l_fill_1
XFILLER_42_274 VPWR VGND sg13cmos5l_fill_1
XFILLER_42_296 VPWR VGND sg13cmos5l_fill_2
XFILLER_6_164 VPWR VGND sg13cmos5l_fill_2
X_2251_ _2251_/Y _3089_/Q _1980_/X VPWR VGND sg13cmos5l_nor2b_1
X_2320_ _2320_/X _1912_/B _1980_/X _3284_/Q VPWR VGND sg13cmos5l_mux2_1
X_2182_ _2182_/X _2426_/B _2087_/X _3304_/Q VPWR VGND sg13cmos5l_mux2_1
XANTENNA__3695__X EE4BEG[9] VPWR VGND sg13cmos5l_antennanp
XFILLER_33_230 VPWR VGND sg13cmos5l_decap_8
X_1966_ _1966_/Y _1961_/Y _1964_/Y _1965_/X _1479_/Y _3145_/Q VPWR VGND sg13cmos5l_a221oi_1
X_1897_ _1897_/X E1END[3] SS4END[1] E2END[7] W1END[1] _3332_/Q _3330_/Q VPWR VGND
+ sg13cmos5l_mux4_1
X_3567_ N4BEG[1] N4END[5] VPWR VGND sg13cmos5l_buf_1
X_3636_ FrameData_O[18] FrameData[18] VPWR VGND sg13cmos5l_buf_1
X_3705_ SS4BEG[3] SS4END[7] VPWR VGND sg13cmos5l_buf_1
X_3498_ _3498_/L_HI VPWR VGND sg13cmos5l_tiehi
X_2518_ _2518_/X N1END[1] N2END[3] E6END[1] S2END[3] _3346_/Q _3348_/Q VPWR VGND sg13cmos5l_mux4_1
X_2449_ _2449_/Y N2END[1] _3242_/Q VPWR VGND sg13cmos5l_nor2_1
XFILLER_16_208 VPWR VGND sg13cmos5l_fill_1
XFILLER_17_45 VPWR VGND sg13cmos5l_fill_1
XFILLER_8_418 VPWR VGND sg13cmos5l_fill_1
XFILLER_3_112 VPWR VGND sg13cmos5l_fill_2
X_1820_ _1821_/A _1814_/Y _1819_/Y _1809_/Y VPWR VGND sg13cmos5l_o21ai_1
XFILLER_7_451 VPWR VGND sg13cmos5l_fill_2
X_1682_ _1682_/X E2END[4] S4END[0] EE4END[3] W2END[4] _3320_/Q _3318_/Q VPWR VGND
+ sg13cmos5l_mux4_1
X_1751_ _1751_/Y _1793_/S _1751_/B VPWR VGND sg13cmos5l_nand2_1
X_3421_ _3421_/L_HI VPWR VGND sg13cmos5l_tiehi
X_2234_ _2234_/Y _3095_/Q _2233_/X VPWR VGND sg13cmos5l_nor2b_1
X_2303_ _2303_/X W6END[1] _2029_/X _2426_/B _2087_/X _3308_/Q _3306_/Q VPWR VGND sg13cmos5l_mux4_1
X_3352_ _3352_/Q FrameData[14] FrameStrobe[1] VPWR VGND sg13cmos5l_dlhq_1
X_3283_ _3283_/Q FrameData[9] FrameStrobe[3] VPWR VGND sg13cmos5l_dlhq_1
XFILLER_38_333 VPWR VGND sg13cmos5l_fill_2
X_2096_ _2096_/X _2426_/B _2620_/B _3260_/Q VPWR VGND sg13cmos5l_mux2_1
X_2165_ _3739_/A _3281_/Q _2157_/Y _2163_/Y _2164_/Y VPWR VGND sg13cmos5l_a22oi_1
X_1949_ _1955_/B _3268_/Q _1946_/Y _1947_/Y _1948_/Y _3267_/Q VPWR VGND sg13cmos5l_a221oi_1
X_2998_ _2998_/Q FrameData[12] FrameStrobe[12] VPWR VGND sg13cmos5l_dlhq_1
X_3619_ FrameData_O[1] FrameData[1] VPWR VGND sg13cmos5l_buf_1
XFILLER_29_366 VPWR VGND sg13cmos5l_fill_2
XFILLER_48_119 VPWR VGND sg13cmos5l_fill_2
XFILLER_8_237 VPWR VGND sg13cmos5l_fill_2
XFILLER_35_325 VPWR VGND sg13cmos5l_fill_1
XFILLER_35_336 VPWR VGND sg13cmos5l_fill_2
XFILLER_43_391 VPWR VGND sg13cmos5l_fill_2
X_1803_ _1803_/Y _1796_/Y _1798_/Y _1800_/Y _1802_/Y VPWR VGND sg13cmos5l_a22oi_1
X_2921_ _2921_/Q _2921_/CLK _2921_/D _3485_/L_HI VPWR VGND sg13cmos5l_dfrbpq_1
X_2852_ _2981_/D _2663_/X _2981_/Q _2854_/S VPWR VGND sg13cmos5l_mux2_1
X_2783_ _2929_/D _2663_/X _2929_/Q _2785_/S VPWR VGND sg13cmos5l_mux2_1
X_1596_ _1766_/A _1584_/Y _1587_/Y _1595_/Y VPWR VGND sg13cmos5l_a21oi_1
X_1665_ _1666_/C E2END[2] _3388_/Q VPWR VGND sg13cmos5l_nor2b_1
X_1734_ _1734_/Y _1710_/S _1732_/X _1495_/Y VPWR VGND sg13cmos5l_a21oi_1
X_3404_ _3404_/Q clkload3/A _3404_/D _3414_/L_HI VPWR VGND sg13cmos5l_dfrbpq_1
X_2217_ _2217_/X SS4END[2] _2139_/B W1END[2] _1912_/B _3100_/Q _3098_/Q VPWR VGND
+ sg13cmos5l_mux4_1
X_3335_ _3335_/Q FrameData[29] FrameStrobe[2] VPWR VGND sg13cmos5l_dlhq_1
X_3266_ _3266_/Q FrameData[24] FrameStrobe[4] VPWR VGND sg13cmos5l_dlhq_1
X_3197_ _3197_/Q FrameData[19] FrameStrobe[6] VPWR VGND sg13cmos5l_dlhq_1
XFILLER_26_325 VPWR VGND sg13cmos5l_fill_1
X_2079_ _2080_/C _2083_/A _2079_/B VPWR VGND sg13cmos5l_nand2_1
X_2148_ _2148_/Y WW4END[1] _3312_/Q VPWR VGND sg13cmos5l_nand2b_1
XFILLER_1_479 VPWR VGND sg13cmos5l_fill_1
XFILLER_17_336 VPWR VGND sg13cmos5l_fill_2
XANTENNA__3793__X WW4BEG[10] VPWR VGND sg13cmos5l_antennanp
XFILLER_4_273 VPWR VGND sg13cmos5l_fill_1
X_3120_ _3120_/Q FrameData[6] FrameStrobe[8] VPWR VGND sg13cmos5l_dlhq_1
X_3051_ _3051_/Q FrameData[1] FrameStrobe[10] VPWR VGND sg13cmos5l_dlhq_1
XFILLER_23_317 VPWR VGND sg13cmos5l_fill_1
X_2002_ _2002_/X _2944_/Q _2976_/Q _2940_/Q _2972_/Q _2071_/A _2116_/Y VPWR VGND sg13cmos5l_mux4_1
X_2904_ _2904_/Q _2905_/CLK _2904_/D _3502_/L_HI VPWR VGND sg13cmos5l_dfrbpq_1
X_2835_ _2968_/D _2660_/X _2968_/Q _2838_/S VPWR VGND sg13cmos5l_mux2_1
X_2766_ _2917_/D _2917_/Q _2663_/X _2768_/S VPWR VGND sg13cmos5l_mux2_1
X_1579_ _1579_/Y _3359_/Q _1578_/X _3361_/Q VPWR VGND sg13cmos5l_o21ai_1
X_1648_ _1648_/X _1646_/X _1647_/X _1648_/S VPWR VGND sg13cmos5l_mux2_1
X_1717_ _1717_/X W1END[3] _1912_/B _2058_/X _2029_/X _3300_/Q _3298_/Q VPWR VGND sg13cmos5l_mux4_1
X_3318_ _3318_/Q FrameData[12] FrameStrobe[2] VPWR VGND sg13cmos5l_dlhq_1
X_2697_ _2704_/A _2559_/Y _2560_/X _2550_/Y VPWR VGND sg13cmos5l_o21ai_1
XFILLER_26_144 VPWR VGND sg13cmos5l_decap_8
X_3249_ _3249_/Q FrameData[7] FrameStrobe[4] VPWR VGND sg13cmos5l_dlhq_1
XFILLER_14_328 VPWR VGND sg13cmos5l_decap_8
XFILLER_25_34 VPWR VGND sg13cmos5l_fill_1
XANTENNA__3788__X WW4BEG[5] VPWR VGND sg13cmos5l_antennanp
XFILLER_20_309 VPWR VGND sg13cmos5l_fill_1
XFILLER_9_343 VPWR VGND sg13cmos5l_fill_2
XFILLER_9_376 VPWR VGND sg13cmos5l_fill_1
X_2620_ _2620_/Y _3272_/Q _2620_/B VPWR VGND sg13cmos5l_nand2_1
X_1502_ _1502_/Y _3271_/Q VPWR VGND sg13cmos5l_inv_1
X_2551_ _2553_/B W2MID[5] _3190_/Q VPWR VGND sg13cmos5l_nand2_1
X_2482_ _2482_/Y _3012_/Q _1849_/X _3013_/Q VPWR VGND sg13cmos5l_o21ai_1
XANTENNA__3698__X EE4BEG[12] VPWR VGND sg13cmos5l_antennanp
X_3103_ _3103_/Q FrameData[21] FrameStrobe[9] VPWR VGND sg13cmos5l_dlhq_1
X_3034_ _3034_/Q FrameData[16] FrameStrobe[11] VPWR VGND sg13cmos5l_dlhq_1
XFILLER_23_125 VPWR VGND sg13cmos5l_fill_1
X_3798_ WW4BEG[15] _3798_/A VPWR VGND sg13cmos5l_buf_1
X_2818_ _2834_/B _2818_/A _2839_/B VPWR VGND sg13cmos5l_nor2_1
X_2749_ _2904_/D _2660_/X _2904_/Q _2752_/S VPWR VGND sg13cmos5l_mux2_1
XFILLER_54_250 VPWR VGND sg13cmos5l_fill_1
XFILLER_37_206 VPWR VGND sg13cmos5l_fill_1
X_1982_ _1985_/B _2077_/A _1982_/B VPWR VGND sg13cmos5l_nand2_1
X_3583_ NN4BEG[1] NN4END[5] VPWR VGND sg13cmos5l_buf_1
X_3652_ S1BEG[2] _3652_/A VPWR VGND sg13cmos5l_buf_1
X_3721_ E6BEG[3] E6END[5] VPWR VGND sg13cmos5l_buf_1
X_2603_ _2603_/X E1END[0] S2END[0] _3368_/Q VPWR VGND sg13cmos5l_mux2_1
X_2534_ _2534_/Y _3338_/Q _2533_/X _3339_/Q VPWR VGND sg13cmos5l_o21ai_1
X_2465_ _2466_/B _3245_/Q _2465_/B _2465_/C VPWR VGND sg13cmos5l_nand3_1
X_2396_ _2397_/A NN4END[3] E2END[6] S2END[6] W2END[6] _3218_/Q _3219_/Q VPWR VGND
+ sg13cmos5l_mux4_1
XFILLER_24_445 VPWR VGND sg13cmos5l_fill_2
XFILLER_28_239 VPWR VGND sg13cmos5l_decap_4
XFILLER_36_294 VPWR VGND sg13cmos5l_fill_2
X_3017_ _3017_/Q FrameData[31] FrameStrobe[12] VPWR VGND sg13cmos5l_dlhq_1
XFILLER_47_54 VPWR VGND sg13cmos5l_fill_2
XFILLER_10_150 VPWR VGND sg13cmos5l_fill_1
XFILLER_6_132 VPWR VGND sg13cmos5l_fill_1
X_2250_ _2254_/A _1464_/Y _2484_/B _2249_/Y VPWR VGND sg13cmos5l_a21oi_1
X_2181_ _3551_/A _3249_/Q _2172_/Y _2178_/X _2180_/Y VPWR VGND sg13cmos5l_a22oi_1
X_1965_ _1965_/X N2END[2] S2END[2] _3143_/Q VPWR VGND sg13cmos5l_mux2_1
X_3704_ SS4BEG[2] SS4END[6] VPWR VGND sg13cmos5l_buf_1
Xclkbuf_5_5__f_UserCLK_regs clkload3/A clkbuf_3_1_0_UserCLK_regs/X VPWR VGND sg13cmos5l_buf_8
X_1896_ _1896_/Y _3139_/Q _1892_/X _1895_/Y VPWR VGND sg13cmos5l_a21oi_1
X_3497_ _3497_/L_HI VPWR VGND sg13cmos5l_tiehi
X_3566_ N4BEG[0] N4END[4] VPWR VGND sg13cmos5l_buf_1
X_3635_ FrameData_O[17] FrameData[17] VPWR VGND sg13cmos5l_buf_1
X_2517_ _2517_/Y _3348_/Q _2516_/X _2519_/B VPWR VGND sg13cmos5l_a21oi_1
X_2448_ _2448_/X EE4END[0] E6END[1] _3242_/Q VPWR VGND sg13cmos5l_mux2_1
X_2379_ _2379_/X _2029_/X _2620_/B _2087_/X _1980_/X _3043_/Q _3042_/Q VPWR VGND sg13cmos5l_mux4_1
XFILLER_33_34 VPWR VGND sg13cmos5l_fill_1
XANTENNA__3796__X WW4BEG[13] VPWR VGND sg13cmos5l_antennanp
XFILLER_15_231 VPWR VGND sg13cmos5l_fill_2
X_1750_ _1751_/B _2945_/Q _2941_/Q _2977_/Q _2973_/Q _2052_/A _1623_/Y VPWR VGND sg13cmos5l_mux4_1
X_1681_ _1681_/Y _1681_/A _1681_/B VPWR VGND sg13cmos5l_nand2_1
X_3420_ _3420_/L_HI VPWR VGND sg13cmos5l_tiehi
X_3351_ _3351_/Q FrameData[13] FrameStrobe[1] VPWR VGND sg13cmos5l_dlhq_1
X_2164_ _2164_/Y _2155_/A _2158_/X _3281_/Q VPWR VGND sg13cmos5l_a21oi_1
X_2233_ _2233_/X NN4END[1] E1END[3] _2058_/X _2426_/B _3094_/Q _3096_/Q VPWR VGND
+ sg13cmos5l_mux4_1
X_2302_ _2302_/X _3309_/Q _2302_/B _2302_/C VPWR VGND sg13cmos5l_or3_1
X_3282_ _3282_/Q FrameData[8] FrameStrobe[3] VPWR VGND sg13cmos5l_dlhq_1
XFILLER_21_212 VPWR VGND sg13cmos5l_fill_1
XFILLER_53_348 VPWR VGND sg13cmos5l_fill_1
X_2095_ _2095_/Y _3260_/Q _2139_/B _2094_/Y VPWR VGND sg13cmos5l_o21ai_1
XFILLER_21_289 VPWR VGND sg13cmos5l_fill_1
X_1879_ _1879_/Y _3324_/Q _2426_/B VPWR VGND sg13cmos5l_nor2_1
X_1948_ _1948_/Y N1END[3] _1481_/Y _3268_/Q VPWR VGND sg13cmos5l_a21oi_1
X_2997_ _2997_/Q FrameData[11] FrameStrobe[12] VPWR VGND sg13cmos5l_dlhq_1
X_3549_ N1BEG[3] _3549_/A VPWR VGND sg13cmos5l_buf_1
X_3618_ FrameData_O[0] FrameData[0] VPWR VGND sg13cmos5l_buf_1
XFILLER_4_444 VPWR VGND sg13cmos5l_fill_2
X_2920_ _2920_/Q _2920_/CLK _2920_/D _3486_/L_HI VPWR VGND sg13cmos5l_dfrbpq_1
X_1733_ _1733_/X N2MID[5] E2MID[5] S2MID[5] W2MID[5] _3206_/Q _3207_/Q VPWR VGND sg13cmos5l_mux4_1
X_1802_ _1802_/Y _1793_/S _1801_/X _1706_/Y VPWR VGND sg13cmos5l_a21oi_1
X_2851_ _2980_/D _2660_/X _2980_/Q _2854_/S VPWR VGND sg13cmos5l_mux2_1
X_2782_ _2928_/D _2660_/X _2928_/Q _2785_/S VPWR VGND sg13cmos5l_mux2_1
X_1595_ _1595_/Y _3131_/Q _1595_/B VPWR VGND sg13cmos5l_nand2b_1
X_1664_ _1666_/B NN4END[2] _3388_/Q VPWR VGND sg13cmos5l_nor2_1
X_3403_ _3403_/Q clkload3/A _3403_/D _3413_/L_HI VPWR VGND sg13cmos5l_dfrbpq_1
X_3334_ _3334_/Q FrameData[28] FrameStrobe[2] VPWR VGND sg13cmos5l_dlhq_1
X_2147_ _2147_/Y _2173_/A _3312_/Q _2146_/Y VPWR VGND sg13cmos5l_a21oi_1
X_2216_ _2216_/Y _2215_/X _2216_/B VPWR VGND sg13cmos5l_nand2b_1
X_3265_ _3265_/Q FrameData[23] FrameStrobe[4] VPWR VGND sg13cmos5l_dlhq_1
X_3196_ _3196_/Q FrameData[18] FrameStrobe[6] VPWR VGND sg13cmos5l_dlhq_1
X_2078_ _2079_/B _2953_/Q _2949_/Q _2985_/Q _2981_/Q _2116_/Y _2071_/A VPWR VGND sg13cmos5l_mux4_1
XFILLER_30_35 VPWR VGND sg13cmos5l_fill_2
X_2001_ _2620_/B _3404_/D _3404_/Q _2989_/Q VPWR VGND sg13cmos5l_mux2_1
X_3050_ _3050_/Q FrameData[0] FrameStrobe[10] VPWR VGND sg13cmos5l_dlhq_1
XFILLER_31_362 VPWR VGND sg13cmos5l_fill_2
X_2903_ _2903_/Q _2905_/CLK _2903_/D _3503_/L_HI VPWR VGND sg13cmos5l_dfrbpq_1
X_1716_ _1716_/X _2426_/B _2139_/B _2087_/X _1980_/X _3298_/Q _3300_/Q VPWR VGND sg13cmos5l_mux4_1
X_2834_ _2838_/S _2855_/A _2834_/B VPWR VGND sg13cmos5l_nand2_1
X_2765_ _2916_/D _2916_/Q _2660_/X _2768_/S VPWR VGND sg13cmos5l_mux2_1
X_2696_ _2867_/D _2689_/Y _2867_/Q _2696_/S VPWR VGND sg13cmos5l_mux2_1
X_1578_ _1578_/X WW4END[2] _1912_/B _2058_/X _2029_/X _3360_/Q _3358_/Q VPWR VGND
+ sg13cmos5l_mux4_1
X_1647_ _1647_/X W6END[0] _2029_/X _2058_/X _2087_/X _3288_/Q _3286_/Q VPWR VGND sg13cmos5l_mux4_1
X_3317_ _3317_/Q FrameData[11] FrameStrobe[2] VPWR VGND sg13cmos5l_dlhq_1
XFILLER_26_178 VPWR VGND sg13cmos5l_fill_2
XFILLER_54_498 VPWR VGND sg13cmos5l_fill_1
X_3248_ _3248_/Q FrameData[6] FrameStrobe[4] VPWR VGND sg13cmos5l_dlhq_1
X_3179_ _3179_/Q FrameData[1] FrameStrobe[6] VPWR VGND sg13cmos5l_dlhq_1
XFILLER_41_115 VPWR VGND sg13cmos5l_fill_1
XFILLER_41_56 VPWR VGND sg13cmos5l_fill_2
XFILLER_13_351 VPWR VGND sg13cmos5l_fill_2
XFILLER_32_104 VPWR VGND sg13cmos5l_fill_1
XFILLER_45_498 VPWR VGND sg13cmos5l_fill_1
X_2550_ _2550_/Y _2550_/A VPWR VGND sg13cmos5l_inv_1
X_1501_ _1501_/Y _3273_/Q VPWR VGND sg13cmos5l_inv_1
X_2481_ _2481_/Y _2481_/A VPWR VGND sg13cmos5l_inv_1
X_3102_ _3102_/Q FrameData[20] FrameStrobe[9] VPWR VGND sg13cmos5l_dlhq_1
X_3033_ _3033_/Q FrameData[15] FrameStrobe[11] VPWR VGND sg13cmos5l_dlhq_1
XFILLER_36_498 VPWR VGND sg13cmos5l_fill_1
X_3797_ WW4BEG[14] _3797_/A VPWR VGND sg13cmos5l_buf_1
X_2817_ _2839_/B _2817_/A _2817_/B VPWR VGND sg13cmos5l_nand2_1
X_2748_ _2752_/S _2855_/A _2748_/B VPWR VGND sg13cmos5l_nand2_1
X_2679_ _2679_/Y _3376_/Q N4END[0] VPWR VGND sg13cmos5l_nor2b_1
XFILLER_39_270 VPWR VGND sg13cmos5l_fill_1
XFILLER_27_498 VPWR VGND sg13cmos5l_fill_1
XFILLER_6_325 VPWR VGND sg13cmos5l_decap_8
XFILLER_18_498 VPWR VGND sg13cmos5l_fill_1
X_1981_ _1982_/B _2946_/Q _2942_/Q _2978_/Q _2974_/Q _2116_/Y _2071_/A VPWR VGND sg13cmos5l_mux4_1
X_3720_ E6BEG[2] E6END[4] VPWR VGND sg13cmos5l_buf_1
X_3582_ NN4BEG[0] NN4END[4] VPWR VGND sg13cmos5l_buf_1
X_3651_ S1BEG[1] _3651_/A VPWR VGND sg13cmos5l_buf_1
X_2602_ _2602_/X N1END[0] N2END[0] S1END[0] S1END[2] _3366_/Q _3368_/Q VPWR VGND sg13cmos5l_mux4_1
X_2533_ _2533_/X _1513_/Y _1512_/Y _3340_/Q VPWR VGND sg13cmos5l_mux2_1
X_2464_ _2465_/C _3243_/Q _2464_/B _2464_/C VPWR VGND sg13cmos5l_nand3_1
X_2395_ _3701_/A _2395_/A _2395_/B VPWR VGND sg13cmos5l_nor2_1
X_3016_ _3016_/Q FrameData[30] FrameStrobe[12] VPWR VGND sg13cmos5l_dlhq_1
XFILLER_42_298 VPWR VGND sg13cmos5l_fill_1
XFILLER_6_166 VPWR VGND sg13cmos5l_fill_1
Xclkbuf_5_28__f_UserCLK_regs _2913_/CLK clkbuf_3_7_0_UserCLK_regs/X VPWR VGND sg13cmos5l_buf_8
X_2180_ _2180_/Y _1456_/Y _2179_/X _3249_/Q VPWR VGND sg13cmos5l_a21oi_1
XFILLER_21_449 VPWR VGND sg13cmos5l_decap_8
X_1895_ _1895_/Y _3139_/Q _1894_/Y _3140_/Q VPWR VGND sg13cmos5l_o21ai_1
X_1964_ _1964_/Y _3143_/Q _1963_/Y _1479_/Y VPWR VGND sg13cmos5l_a21oi_1
X_3634_ FrameData_O[16] FrameData[16] VPWR VGND sg13cmos5l_buf_1
X_3703_ SS4BEG[1] SS4END[5] VPWR VGND sg13cmos5l_buf_1
X_3496_ _3496_/L_HI VPWR VGND sg13cmos5l_tiehi
X_3565_ N2BEGb[7] N2MID[7] VPWR VGND sg13cmos5l_buf_1
X_2516_ _2516_/X S4END[3] W2END[3] _3346_/Q VPWR VGND sg13cmos5l_mux2_1
X_2447_ _2447_/Y _2445_/Y _2446_/Y _3243_/Q VPWR VGND sg13cmos5l_o21ai_1
X_2378_ _2378_/Y _2378_/A _3044_/Q VPWR VGND sg13cmos5l_nor2b_1
XFILLER_11_493 VPWR VGND sg13cmos5l_fill_1
X_1680_ _1681_/B N2END[4] E6END[0] E1END[2] S2END[4] _3320_/Q _3318_/Q VPWR VGND sg13cmos5l_mux4_1
X_2301_ _2302_/C _3307_/Q _2301_/B VPWR VGND sg13cmos5l_nor2_1
X_3350_ _3350_/Q FrameData[12] FrameStrobe[1] VPWR VGND sg13cmos5l_dlhq_1
X_2163_ _2163_/Y _3278_/Q _2159_/X _2162_/Y VPWR VGND sg13cmos5l_o21ai_1
X_2232_ _3782_/A _3101_/Q _2218_/Y _2231_/X VPWR VGND sg13cmos5l_o21ai_1
X_3281_ _3281_/Q FrameData[7] FrameStrobe[3] VPWR VGND sg13cmos5l_dlhq_1
X_2094_ _2094_/Y _1980_/X _3260_/Q VPWR VGND sg13cmos5l_nand2b_1
X_1878_ _1878_/X _2915_/Q _2911_/Q _2883_/Q _2879_/Q _2116_/Y _2014_/A VPWR VGND sg13cmos5l_mux4_1
X_1947_ _1947_/Y N2END[7] _3266_/Q VPWR VGND sg13cmos5l_nand2_1
X_3617_ FrameStrobe_O[19] FrameStrobe[19] VPWR VGND sg13cmos5l_buf_1
X_2996_ _2996_/Q FrameData[10] FrameStrobe[12] VPWR VGND sg13cmos5l_dlhq_1
X_3548_ N1BEG[2] _3548_/A VPWR VGND sg13cmos5l_buf_1
X_3479_ _3479_/L_HI VPWR VGND sg13cmos5l_tiehi
XFILLER_29_368 VPWR VGND sg13cmos5l_fill_1
XFILLER_12_213 VPWR VGND sg13cmos5l_fill_2
XFILLER_4_434 VPWR VGND sg13cmos5l_fill_2
XANTENNA__3600__X FrameStrobe_O[2] VPWR VGND sg13cmos5l_antennanp
X_2850_ _2854_/S _2850_/A _2855_/B VPWR VGND sg13cmos5l_nand2_1
X_1663_ _1663_/Y _3388_/Q _1661_/A _1662_/Y VPWR VGND sg13cmos5l_a21oi_1
X_1732_ _1732_/X _1468_/Y _1469_/Y _1472_/Y _1731_/A _3172_/Q _3173_/Q VPWR VGND sg13cmos5l_mux4_1
X_1801_ _1801_/X _2931_/Q _2927_/Q _2963_/Q _2959_/Q _2052_/A _1623_/Y VPWR VGND sg13cmos5l_mux4_1
X_2781_ _2785_/S _2845_/A _2791_/B VPWR VGND sg13cmos5l_nand2_1
XFILLER_22_0 VPWR VGND sg13cmos5l_fill_2
X_1594_ _1595_/B _1588_/Y _1589_/Y _1593_/Y VPWR VGND sg13cmos5l_o21ai_1
X_3402_ _3402_/Q clkload5/A _3402_/D _3412_/L_HI VPWR VGND sg13cmos5l_dfrbpq_1
X_3333_ _3333_/Q FrameData[27] FrameStrobe[2] VPWR VGND sg13cmos5l_dlhq_1
X_3264_ _3264_/Q FrameData[22] FrameStrobe[4] VPWR VGND sg13cmos5l_dlhq_1
XFILLER_26_349 VPWR VGND sg13cmos5l_decap_8
X_2077_ _2080_/B _2077_/A _2077_/B VPWR VGND sg13cmos5l_nand2_1
X_2146_ _2146_/Y E2END[2] _3312_/Q VPWR VGND sg13cmos5l_nor2_1
X_2215_ _2215_/X NN4END[2] _2058_/X E1END[2] _2426_/B _3100_/Q _3098_/Q VPWR VGND
+ sg13cmos5l_mux4_1
X_3195_ _3195_/Q FrameData[17] FrameStrobe[6] VPWR VGND sg13cmos5l_dlhq_1
X_2979_ _2979_/Q _2979_/CLK _2979_/D _3427_/L_HI VPWR VGND sg13cmos5l_dfrbpq_1
XFILLER_17_338 VPWR VGND sg13cmos5l_fill_1
XFILLER_4_220 VPWR VGND sg13cmos5l_fill_1
XFILLER_4_231 VPWR VGND sg13cmos5l_fill_1
XFILLER_0_481 VPWR VGND sg13cmos5l_fill_1
X_2000_ _3404_/D _1985_/Y _1990_/Y _1999_/Y VPWR VGND sg13cmos5l_a21o_1
XFILLER_50_138 VPWR VGND sg13cmos5l_fill_1
X_2902_ _2902_/Q _2907_/CLK _2902_/D _3504_/L_HI VPWR VGND sg13cmos5l_dfrbpq_1
X_2833_ _2967_/D _2689_/Y _2967_/Q _2833_/S VPWR VGND sg13cmos5l_mux2_1
XFILLER_6_60 VPWR VGND sg13cmos5l_fill_2
X_1646_ _1646_/X _2426_/B _2139_/B _2620_/B _1980_/X _3286_/Q _3288_/Q VPWR VGND sg13cmos5l_mux4_1
X_1715_ _1715_/Y _1495_/Y _1710_/X _1714_/Y VPWR VGND sg13cmos5l_o21ai_1
X_2764_ _2768_/S _2850_/A _2769_/B VPWR VGND sg13cmos5l_and2_1
X_2695_ _2866_/D _2675_/X _2866_/Q _2696_/S VPWR VGND sg13cmos5l_mux2_1
X_1577_ _1577_/Y _3358_/Q _1576_/X _1490_/Y VPWR VGND sg13cmos5l_a21oi_1
X_3316_ _3316_/Q FrameData[10] FrameStrobe[2] VPWR VGND sg13cmos5l_dlhq_1
X_3247_ _3247_/Q FrameData[5] FrameStrobe[4] VPWR VGND sg13cmos5l_dlhq_1
X_2129_ _2129_/Y _3344_/Q E6END[0] VPWR VGND sg13cmos5l_nor2b_1
X_3178_ _3178_/Q FrameData[0] FrameStrobe[6] VPWR VGND sg13cmos5l_dlhq_1
XFILLER_13_363 VPWR VGND sg13cmos5l_fill_2
XFILLER_13_385 VPWR VGND sg13cmos5l_fill_1
XFILLER_15_91 VPWR VGND sg13cmos5l_fill_2
XFILLER_32_149 VPWR VGND sg13cmos5l_fill_2
X_1500_ _2599_/A _3367_/Q VPWR VGND sg13cmos5l_inv_1
X_2480_ _2481_/A N2END[2] S2END[2] E2END[2] WW4END[2] _3221_/Q _3220_/Q VPWR VGND
+ sg13cmos5l_mux4_1
X_3101_ _3101_/Q FrameData[19] FrameStrobe[9] VPWR VGND sg13cmos5l_dlhq_1
X_3032_ _3032_/Q FrameData[14] FrameStrobe[11] VPWR VGND sg13cmos5l_dlhq_1
X_3796_ WW4BEG[13] _3796_/A VPWR VGND sg13cmos5l_buf_1
X_2816_ _2955_/D _2689_/Y _2955_/Q _2816_/S VPWR VGND sg13cmos5l_mux2_1
X_1629_ _1629_/X _2426_/B _2620_/B _3296_/Q VPWR VGND sg13cmos5l_mux2_1
X_2747_ _2903_/D _2903_/Q _2689_/Y _2747_/S VPWR VGND sg13cmos5l_mux2_1
X_2678_ _2678_/Y _3376_/Q _2135_/Y _2677_/Y VPWR VGND sg13cmos5l_a21oi_1
XFILLER_27_400 VPWR VGND sg13cmos5l_decap_4
XFILLER_14_127 VPWR VGND sg13cmos5l_decap_8
XFILLER_22_160 VPWR VGND sg13cmos5l_fill_2
Xclkbuf_5_0__f_UserCLK_regs _2970_/CLK clkbuf_3_0_0_UserCLK_regs/X VPWR VGND sg13cmos5l_buf_8
XFILLER_10_333 VPWR VGND sg13cmos5l_decap_8
X_1980_ _1980_/X _3405_/D _3405_/Q _2989_/Q VPWR VGND sg13cmos5l_mux2_1
X_3650_ S1BEG[0] _3650_/A VPWR VGND sg13cmos5l_buf_1
X_3581_ N4BEG[15] _3581_/A VPWR VGND sg13cmos5l_buf_1
X_2601_ _2601_/Y _3367_/Q _2600_/X _2599_/X VPWR VGND sg13cmos5l_a21oi_1
X_2532_ _2532_/X _1912_/B _1980_/X _3340_/Q VPWR VGND sg13cmos5l_mux2_1
X_2463_ _2464_/C _3244_/Q _2139_/B _2462_/Y VPWR VGND sg13cmos5l_o21ai_1
X_3015_ _3015_/Q FrameData[29] FrameStrobe[12] VPWR VGND sg13cmos5l_dlhq_1
X_2394_ _2395_/B _3036_/Q _2392_/X _2393_/Y VPWR VGND sg13cmos5l_a21oi_1
XFILLER_36_296 VPWR VGND sg13cmos5l_fill_1
X_3779_ W6BEG[8] W6END[10] VPWR VGND sg13cmos5l_buf_1
Xclkbuf_5_15__f_UserCLK_regs _2976_/CLK clkbuf_3_3_0_UserCLK_regs/X VPWR VGND sg13cmos5l_buf_8
XFILLER_27_274 VPWR VGND sg13cmos5l_fill_2
XFILLER_10_196 VPWR VGND sg13cmos5l_fill_2
XANTENNA__3603__X FrameStrobe_O[5] VPWR VGND sg13cmos5l_antennanp
XFILLER_21_406 VPWR VGND sg13cmos5l_fill_1
X_1894_ _1894_/Y _1894_/A VPWR VGND sg13cmos5l_inv_1
X_1963_ _1963_/Y _1963_/A VPWR VGND sg13cmos5l_inv_1
X_3633_ FrameData_O[15] FrameData[15] VPWR VGND sg13cmos5l_buf_1
X_3702_ SS4BEG[0] SS4END[4] VPWR VGND sg13cmos5l_buf_1
X_3495_ _3495_/L_HI VPWR VGND sg13cmos5l_tiehi
X_3564_ N2BEGb[6] N2MID[6] VPWR VGND sg13cmos5l_buf_1
X_2515_ _2515_/Y _3348_/Q _2515_/B VPWR VGND sg13cmos5l_nand2b_1
X_2446_ _2446_/Y S2END[1] _3242_/Q _3244_/Q VPWR VGND sg13cmos5l_o21ai_1
X_2377_ _2378_/A _3043_/Q _2374_/Y _2375_/X _2376_/Y VPWR VGND sg13cmos5l_a22oi_1
XFILLER_15_233 VPWR VGND sg13cmos5l_fill_1
XFILLER_30_214 VPWR VGND sg13cmos5l_fill_1
X_2231_ _2231_/X _3100_/Q _2228_/Y _2230_/Y VPWR VGND sg13cmos5l_a21o_1
X_2300_ _2301_/B N2END[1] E1END[3] S2END[1] S4END[1] _3306_/Q _3308_/Q VPWR VGND sg13cmos5l_mux4_1
X_3280_ _3280_/Q FrameData[6] FrameStrobe[3] VPWR VGND sg13cmos5l_dlhq_1
X_2093_ _2093_/Y _3259_/Q _2093_/B VPWR VGND sg13cmos5l_nand2b_1
X_2162_ _2162_/Y _3278_/Q _2161_/Y _2155_/A VPWR VGND sg13cmos5l_a21oi_1
XFILLER_0_95 VPWR VGND sg13cmos5l_fill_2
X_2995_ _2995_/Q FrameData[9] FrameStrobe[12] VPWR VGND sg13cmos5l_dlhq_1
X_1877_ _2083_/A _1877_/A _1877_/B VPWR VGND sg13cmos5l_nand2_1
X_1946_ _1946_/Y E2END[7] _1481_/Y _1945_/X VPWR VGND sg13cmos5l_a21oi_1
X_3547_ N1BEG[1] _3547_/A VPWR VGND sg13cmos5l_buf_1
X_3616_ FrameStrobe_O[18] FrameStrobe[18] VPWR VGND sg13cmos5l_buf_1
X_3478_ _3478_/L_HI VPWR VGND sg13cmos5l_tiehi
X_2429_ _2429_/Y _3250_/Q _2425_/Y _2428_/Y VPWR VGND sg13cmos5l_a21oi_1
X_1800_ _1800_/Y _1800_/A _1800_/B VPWR VGND sg13cmos5l_nand2_1
X_1662_ _1662_/Y S4END[2] _3388_/Q _3389_/Q VPWR VGND sg13cmos5l_o21ai_1
X_1731_ _3744_/A _1731_/A VPWR VGND sg13cmos5l_inv_1
X_3401_ _3401_/Q FrameData[31] FrameStrobe[0] VPWR VGND sg13cmos5l_dlhq_1
X_2780_ _2927_/D _2689_/Y _2927_/Q _2780_/S VPWR VGND sg13cmos5l_mux2_1
X_1593_ _1593_/Y _1593_/A _3130_/Q VPWR VGND sg13cmos5l_nor2b_1
X_2214_ _3738_/A _2204_/Y _2205_/Y _2213_/Y VPWR VGND sg13cmos5l_o21ai_1
X_3332_ _3332_/Q FrameData[26] FrameStrobe[2] VPWR VGND sg13cmos5l_dlhq_1
X_3263_ _3263_/Q FrameData[21] FrameStrobe[4] VPWR VGND sg13cmos5l_dlhq_1
X_3194_ _3194_/Q FrameData[16] FrameStrobe[6] VPWR VGND sg13cmos5l_dlhq_1
XFILLER_15_0 VPWR VGND sg13cmos5l_fill_1
X_2076_ _2077_/B _2945_/Q _2941_/Q _2977_/Q _2973_/Q _2116_/Y _2071_/A VPWR VGND sg13cmos5l_mux4_1
X_2145_ _2145_/Y _2145_/A _2145_/B VPWR VGND sg13cmos5l_nand2_1
X_1929_ _1969_/A _2077_/A _1878_/X _1925_/Y _1928_/Y _1973_/A VPWR VGND sg13cmos5l_a221oi_1
X_2978_ _2978_/Q clkload9/A _2978_/D _3428_/L_HI VPWR VGND sg13cmos5l_dfrbpq_1
XANTENNA__3701__X EE4BEG[15] VPWR VGND sg13cmos5l_antennanp
XFILLER_29_166 VPWR VGND sg13cmos5l_decap_8
XFILLER_25_350 VPWR VGND sg13cmos5l_fill_1
XFILLER_25_383 VPWR VGND sg13cmos5l_fill_2
XFILLER_29_199 VPWR VGND sg13cmos5l_decap_8
XANTENNA__3611__X FrameStrobe_O[13] VPWR VGND sg13cmos5l_antennanp
XFILLER_35_158 VPWR VGND sg13cmos5l_fill_2
XFILLER_35_169 VPWR VGND sg13cmos5l_fill_1
XFILLER_48_497 VPWR VGND sg13cmos5l_fill_2
XFILLER_31_364 VPWR VGND sg13cmos5l_fill_1
XFILLER_31_375 VPWR VGND sg13cmos5l_decap_4
X_2901_ _2901_/Q _2907_/CLK _2901_/D _3505_/L_HI VPWR VGND sg13cmos5l_dfrbpq_1
X_2832_ _2966_/D _2675_/X _2966_/Q _2833_/S VPWR VGND sg13cmos5l_mux2_1
X_2763_ _2915_/D _2689_/Y _2915_/Q _2763_/S VPWR VGND sg13cmos5l_mux2_1
X_1576_ _1576_/X _2139_/B _1980_/X _3360_/Q VPWR VGND sg13cmos5l_mux2_1
X_1645_ _1645_/Y _1491_/Y _1641_/X _1644_/Y VPWR VGND sg13cmos5l_a21oi_1
X_1714_ _1714_/Y _3132_/Q _1712_/Y _1713_/Y VPWR VGND sg13cmos5l_o21ai_1
X_2694_ _2865_/D _2663_/X _2865_/Q _2696_/S VPWR VGND sg13cmos5l_mux2_1
X_3315_ _3315_/Q FrameData[9] FrameStrobe[2] VPWR VGND sg13cmos5l_dlhq_1
X_3246_ _3246_/Q FrameData[4] FrameStrobe[4] VPWR VGND sg13cmos5l_dlhq_1
X_3177_ _3177_/Q FrameData[31] FrameStrobe[7] VPWR VGND sg13cmos5l_dlhq_1
XFILLER_34_191 VPWR VGND sg13cmos5l_fill_1
X_2059_ _2059_/Y _2116_/Y _2881_/Q VPWR VGND sg13cmos5l_nor2b_1
X_2128_ _2128_/X E2END[2] SS4END[1] _3344_/Q VPWR VGND sg13cmos5l_mux2_1
XFILLER_22_353 VPWR VGND sg13cmos5l_fill_2
XFILLER_9_5 VPWR VGND sg13cmos5l_fill_1
XANTENNA__3606__X FrameStrobe_O[8] VPWR VGND sg13cmos5l_antennanp
X_3100_ _3100_/Q FrameData[18] FrameStrobe[9] VPWR VGND sg13cmos5l_dlhq_1
X_3031_ _3031_/Q FrameData[13] FrameStrobe[11] VPWR VGND sg13cmos5l_dlhq_1
XFILLER_23_106 VPWR VGND sg13cmos5l_fill_2
XFILLER_31_194 VPWR VGND sg13cmos5l_fill_2
Xclkbuf_5_23__f_UserCLK_regs _2898_/CLK clkbuf_3_5_0_UserCLK_regs/X VPWR VGND sg13cmos5l_buf_8
X_3795_ WW4BEG[12] _3795_/A VPWR VGND sg13cmos5l_buf_1
X_2815_ _2954_/D _2675_/X _2954_/Q _2816_/S VPWR VGND sg13cmos5l_mux2_1
X_2746_ _2902_/D _2902_/Q _2675_/X _2747_/S VPWR VGND sg13cmos5l_mux2_1
X_1559_ _1560_/B N2MID[6] E2MID[6] W2MID[6] _3555_/A _3162_/Q _3163_/Q VPWR VGND sg13cmos5l_mux4_1
X_1628_ _1628_/Y _3296_/Q _2139_/B _1627_/Y VPWR VGND sg13cmos5l_o21ai_1
X_2677_ _2677_/Y _3376_/Q S4END[0] _3377_/Q VPWR VGND sg13cmos5l_o21ai_1
X_3229_ _3229_/Q FrameData[19] FrameStrobe[5] VPWR VGND sg13cmos5l_dlhq_1
X_3580_ N4BEG[14] _3580_/A VPWR VGND sg13cmos5l_buf_1
X_2600_ _2600_/X _2426_/B _2139_/B _2087_/X _2620_/B _3366_/Q _3368_/Q VPWR VGND sg13cmos5l_mux4_1
X_2531_ _2531_/X W6END[1] _2029_/X _2426_/B _2087_/X _3340_/Q _3338_/Q VPWR VGND sg13cmos5l_mux4_1
X_2462_ _2462_/Y _3244_/Q _1512_/Y _3242_/Q VPWR VGND sg13cmos5l_a21oi_1
X_2393_ _2393_/Y _3036_/Q _2390_/Y _3037_/Q VPWR VGND sg13cmos5l_o21ai_1
X_3014_ _3014_/Q FrameData[28] FrameStrobe[12] VPWR VGND sg13cmos5l_dlhq_1
X_3778_ W6BEG[7] W6END[9] VPWR VGND sg13cmos5l_buf_1
X_2729_ _2890_/D _2675_/X _2890_/Q _2730_/S VPWR VGND sg13cmos5l_mux2_1
XFILLER_30_418 VPWR VGND sg13cmos5l_decap_8
X_1962_ _1963_/A N2MID[5] E2MID[5] S2MID[5] W2MID[5] _3182_/Q _3183_/Q VPWR VGND sg13cmos5l_mux4_1
X_1893_ _1894_/A NN4END[1] E2END[5] S2END[5] W2END[5] _3238_/Q _3239_/Q VPWR VGND
+ sg13cmos5l_mux4_1
X_3563_ N2BEGb[5] N2MID[5] VPWR VGND sg13cmos5l_buf_1
X_3632_ FrameData_O[14] FrameData[14] VPWR VGND sg13cmos5l_buf_1
X_3701_ EE4BEG[15] _3701_/A VPWR VGND sg13cmos5l_buf_1
X_3494_ _3494_/L_HI VPWR VGND sg13cmos5l_tiehi
X_2514_ _2515_/B NN4END[2] E2END[3] _3346_/Q VPWR VGND sg13cmos5l_mux2_1
X_2445_ _2445_/Y W2END[1] _3242_/Q VPWR VGND sg13cmos5l_nor2b_1
X_2376_ _2376_/Y _3042_/Q _2646_/B _3043_/Q VPWR VGND sg13cmos5l_a21oi_1
XFILLER_20_495 VPWR VGND sg13cmos5l_fill_1
XANTENNA__3704__X SS4BEG[2] VPWR VGND sg13cmos5l_antennanp
XFILLER_11_462 VPWR VGND sg13cmos5l_fill_1
XFILLER_23_70 VPWR VGND sg13cmos5l_fill_2
XANTENNA__3614__X FrameStrobe_O[16] VPWR VGND sg13cmos5l_antennanp
X_2230_ _2230_/Y _3100_/Q _2229_/X _3101_/Q VPWR VGND sg13cmos5l_o21ai_1
X_2092_ _2093_/B W1END[3] _1912_/B _2058_/X _2087_/X _3260_/Q _3258_/Q VPWR VGND sg13cmos5l_mux4_1
X_2161_ _2161_/Y W2END[2] _3280_/Q _2160_/Y VPWR VGND sg13cmos5l_a21oi_1
X_1945_ _1945_/X S1END[3] _3266_/Q VPWR VGND sg13cmos5l_and2_1
X_2994_ _2994_/Q FrameData[8] FrameStrobe[12] VPWR VGND sg13cmos5l_dlhq_1
X_1876_ _2077_/A _1877_/A _1877_/B VPWR VGND sg13cmos5l_and2_1
X_3546_ N1BEG[0] _3546_/A VPWR VGND sg13cmos5l_buf_1
X_3615_ FrameStrobe_O[17] FrameStrobe[17] VPWR VGND sg13cmos5l_buf_1
XFILLER_28_26 VPWR VGND sg13cmos5l_fill_1
X_3477_ _3477_/L_HI VPWR VGND sg13cmos5l_tiehi
X_2428_ _2428_/Y _3250_/Q _2427_/Y _3251_/Q VPWR VGND sg13cmos5l_o21ai_1
X_2359_ _3714_/A _2356_/Y _2358_/Y _2354_/Y VPWR VGND sg13cmos5l_a21oi_1
XFILLER_12_215 VPWR VGND sg13cmos5l_fill_1
XFILLER_44_307 VPWR VGND sg13cmos5l_fill_2
XFILLER_18_70 VPWR VGND sg13cmos5l_fill_2
XFILLER_28_381 VPWR VGND sg13cmos5l_fill_2
XFILLER_47_112 VPWR VGND sg13cmos5l_fill_1
XANTENNA__3609__X FrameStrobe_O[11] VPWR VGND sg13cmos5l_antennanp
X_1592_ _1593_/A _3201_/Q _1592_/B _1592_/C VPWR VGND sg13cmos5l_nor3_1
X_1661_ _3741_/A _1661_/A VPWR VGND sg13cmos5l_inv_1
X_1730_ _1731_/A _1724_/Y _1729_/Y _1719_/Y VPWR VGND sg13cmos5l_o21ai_1
X_3400_ _3400_/Q FrameData[30] FrameStrobe[0] VPWR VGND sg13cmos5l_dlhq_1
X_3331_ _3331_/Q FrameData[25] FrameStrobe[2] VPWR VGND sg13cmos5l_dlhq_1
X_2144_ _2145_/B N2END[2] S2END[2] E1END[0] S4END[2] _3312_/Q _3310_/Q VPWR VGND sg13cmos5l_mux4_1
X_2213_ _2213_/Y _3275_/Q _2211_/X _2212_/Y VPWR VGND sg13cmos5l_o21ai_1
X_3262_ _3262_/Q FrameData[20] FrameStrobe[4] VPWR VGND sg13cmos5l_dlhq_1
X_3193_ _3193_/Q FrameData[15] FrameStrobe[6] VPWR VGND sg13cmos5l_dlhq_1
X_2075_ _2075_/Y _2075_/A _2075_/B _2075_/C VPWR VGND sg13cmos5l_nor3_1
X_1859_ _1859_/X W1END[1] _1912_/B _2058_/X _2087_/X _3292_/Q _3290_/Q VPWR VGND sg13cmos5l_mux4_1
X_1928_ _1928_/Y _2071_/A _1927_/Y _2077_/A VPWR VGND sg13cmos5l_a21oi_1
X_2977_ _2977_/Q _2977_/CLK _2977_/D _3429_/L_HI VPWR VGND sg13cmos5l_dfrbpq_1
X_3529_ _3529_/L_HI VPWR VGND sg13cmos5l_tiehi
XFILLER_44_126 VPWR VGND sg13cmos5l_fill_1
XFILLER_20_82 VPWR VGND sg13cmos5l_decap_4
X_2900_ _2900_/Q _2905_/CLK _2900_/D _3506_/L_HI VPWR VGND sg13cmos5l_dfrbpq_1
XFILLER_31_321 VPWR VGND sg13cmos5l_decap_4
XFILLER_31_398 VPWR VGND sg13cmos5l_decap_4
X_1713_ _1713_/Y _3132_/Q _3555_/A _3133_/Q VPWR VGND sg13cmos5l_a21oi_1
Xclkbuf_5_31__f_UserCLK_regs _2915_/CLK clkbuf_3_7_0_UserCLK_regs/X VPWR VGND sg13cmos5l_buf_8
X_2831_ _2965_/D _2663_/X _2965_/Q _2833_/S VPWR VGND sg13cmos5l_mux2_1
X_2762_ _2914_/D _2675_/X _2914_/Q _2763_/S VPWR VGND sg13cmos5l_mux2_1
X_1575_ _1575_/Y _3358_/Q _1575_/B VPWR VGND sg13cmos5l_nand2b_1
X_1644_ _1644_/Y _1491_/Y _2484_/B _1492_/Y VPWR VGND sg13cmos5l_o21ai_1
X_3314_ _3314_/Q FrameData[8] FrameStrobe[2] VPWR VGND sg13cmos5l_dlhq_1
X_2693_ _2864_/D _2660_/X _2864_/Q _2696_/S VPWR VGND sg13cmos5l_mux2_1
X_2127_ _2127_/Y _3343_/Q _2127_/B VPWR VGND sg13cmos5l_nand2b_1
X_3245_ _3245_/Q FrameData[3] FrameStrobe[4] VPWR VGND sg13cmos5l_dlhq_1
X_3176_ _3176_/Q FrameData[30] FrameStrobe[7] VPWR VGND sg13cmos5l_dlhq_1
XFILLER_25_16 VPWR VGND sg13cmos5l_fill_1
X_2058_ _2058_/X _3406_/D _3406_/Q _2988_/Q VPWR VGND sg13cmos5l_mux2_1
XANTENNA__3712__X SS4BEG[10] VPWR VGND sg13cmos5l_antennanp
XFILLER_13_332 VPWR VGND sg13cmos5l_fill_2
XFILLER_15_93 VPWR VGND sg13cmos5l_fill_1
Xclkbuf_5_10__f_UserCLK_regs clkload7/A clkbuf_3_2_0_UserCLK_regs/X VPWR VGND sg13cmos5l_buf_8
XANTENNA__3622__X FrameData_O[4] VPWR VGND sg13cmos5l_antennanp
X_3030_ _3030_/Q FrameData[12] FrameStrobe[11] VPWR VGND sg13cmos5l_dlhq_1
XFILLER_16_170 VPWR VGND sg13cmos5l_fill_2
X_3794_ WW4BEG[11] WW4END[15] VPWR VGND sg13cmos5l_buf_1
X_2814_ _2953_/D _2663_/X _2953_/Q _2816_/S VPWR VGND sg13cmos5l_mux2_1
X_2745_ _2901_/D _2901_/Q _2663_/X _2747_/S VPWR VGND sg13cmos5l_mux2_1
X_2676_ _2862_/D _2862_/Q _2675_/X _2690_/S VPWR VGND sg13cmos5l_mux2_1
X_1489_ _1710_/S _3132_/Q VPWR VGND sg13cmos5l_inv_1
X_1558_ _3555_/A _1545_/Y _1551_/Y _1557_/Y VPWR VGND sg13cmos5l_o21ai_1
X_1627_ _1627_/Y _1980_/X _3296_/Q VPWR VGND sg13cmos5l_nand2b_1
X_3228_ _3228_/Q FrameData[18] FrameStrobe[5] VPWR VGND sg13cmos5l_dlhq_1
X_3159_ _3159_/Q FrameData[13] FrameStrobe[7] VPWR VGND sg13cmos5l_dlhq_1
XFILLER_22_162 VPWR VGND sg13cmos5l_fill_1
XFILLER_52_14 VPWR VGND sg13cmos5l_fill_2
XANTENNA__3707__X SS4BEG[5] VPWR VGND sg13cmos5l_antennanp
XFILLER_18_457 VPWR VGND sg13cmos5l_fill_1
XFILLER_45_243 VPWR VGND sg13cmos5l_fill_1
XANTENNA__3617__X FrameStrobe_O[19] VPWR VGND sg13cmos5l_antennanp
XFILLER_9_111 VPWR VGND sg13cmos5l_decap_8
X_2530_ _3548_/A _2029_/X _1849_/X _3756_/A _1843_/A _2994_/Q _2995_/Q VPWR VGND sg13cmos5l_mux4_1
X_2461_ _2464_/B _3242_/Q _2461_/B VPWR VGND sg13cmos5l_nand2_1
X_2392_ _2392_/X _1919_/B _2391_/X _3035_/Q VPWR VGND sg13cmos5l_mux2_1
X_3013_ _3013_/Q FrameData[27] FrameStrobe[12] VPWR VGND sg13cmos5l_dlhq_1
XFILLER_51_246 VPWR VGND sg13cmos5l_fill_2
X_3777_ W6BEG[6] W6END[8] VPWR VGND sg13cmos5l_buf_1
X_2728_ _2889_/D _2663_/X _2889_/Q _2730_/S VPWR VGND sg13cmos5l_mux2_1
X_2659_ _2659_/X N2MID[6] W2MID[6] S2MID[6] _3553_/A _3147_/Q _3146_/Q VPWR VGND sg13cmos5l_mux4_1
XFILLER_27_298 VPWR VGND sg13cmos5l_fill_1
XFILLER_10_176 VPWR VGND sg13cmos5l_fill_2
XFILLER_10_198 VPWR VGND sg13cmos5l_fill_1
XFILLER_5_0 VPWR VGND sg13cmos5l_fill_1
X_1892_ _1892_/X E6END[1] S4END[1] WW4END[3] _3658_/A _3398_/Q _3399_/Q VPWR VGND
+ sg13cmos5l_mux4_1
X_1961_ _1961_/Y _1960_/X _1961_/B VPWR VGND sg13cmos5l_nand2b_1
X_3700_ EE4BEG[14] _3700_/A VPWR VGND sg13cmos5l_buf_1
X_3493_ _3493_/L_HI VPWR VGND sg13cmos5l_tiehi
X_3562_ N2BEGb[4] N2MID[4] VPWR VGND sg13cmos5l_buf_1
X_3631_ FrameData_O[13] FrameData[13] VPWR VGND sg13cmos5l_buf_1
X_2513_ _3578_/A N2END[2] N4END[1] E6END[1] _2029_/X _2998_/Q _2999_/Q VPWR VGND sg13cmos5l_mux4_1
X_2444_ _2444_/Y _2442_/Y _2443_/Y _3244_/Q VPWR VGND sg13cmos5l_a21oi_1
X_2375_ _2375_/X _3042_/Q _2495_/B VPWR VGND sg13cmos5l_or2_1
XANTENNA__3720__X E6BEG[2] VPWR VGND sg13cmos5l_antennanp
X_2160_ _2160_/Y _3280_/Q NN4END[1] VPWR VGND sg13cmos5l_nor2b_1
XANTENNA__3630__X FrameData_O[12] VPWR VGND sg13cmos5l_antennanp
X_2091_ _2091_/Y _3259_/Q _2090_/X _3261_/Q VPWR VGND sg13cmos5l_a21oi_1
X_1875_ _1877_/B _1868_/Y _1870_/Y _1874_/X VPWR VGND sg13cmos5l_o21ai_1
X_1944_ _1944_/Y _3267_/Q _1943_/X _1942_/Y VPWR VGND sg13cmos5l_o21ai_1
X_3614_ FrameStrobe_O[16] FrameStrobe[16] VPWR VGND sg13cmos5l_buf_1
X_2993_ _2993_/Q FrameData[7] FrameStrobe[12] VPWR VGND sg13cmos5l_dlhq_1
X_3545_ _3545_/L_HI VPWR VGND sg13cmos5l_tiehi
X_3476_ _3476_/L_HI VPWR VGND sg13cmos5l_tiehi
X_2427_ _2427_/Y _3252_/Q _1512_/Y _2426_/Y VPWR VGND sg13cmos5l_a21oi_1
X_2289_ _2290_/B _1507_/Y _2286_/Y _2288_/Y VPWR VGND sg13cmos5l_a21oi_1
X_2358_ _2358_/Y _3062_/Q _2357_/X _3064_/Q VPWR VGND sg13cmos5l_a21oi_1
XANTENNA__3715__X SS4BEG[13] VPWR VGND sg13cmos5l_antennanp
XANTENNA__3625__X FrameData_O[7] VPWR VGND sg13cmos5l_antennanp
X_1591_ _1592_/C N2MID[1] _3200_/Q VPWR VGND sg13cmos5l_nor2_1
X_1660_ _1661_/A _1654_/Y _1659_/Y _1649_/Y VPWR VGND sg13cmos5l_o21ai_1
X_3330_ _3330_/Q FrameData[24] FrameStrobe[2] VPWR VGND sg13cmos5l_dlhq_1
X_2143_ _2143_/Y _2145_/A _2136_/X _2142_/Y VPWR VGND sg13cmos5l_a21oi_1
X_2212_ _2212_/Y _3277_/Q _2212_/B VPWR VGND sg13cmos5l_nor2_1
Xclkbuf_3_5_0_UserCLK_regs clkbuf_3_5_0_UserCLK_regs/X clkbuf_0_UserCLK_regs/X VPWR
+ VGND sg13cmos5l_buf_8
X_3261_ _3261_/Q FrameData[19] FrameStrobe[4] VPWR VGND sg13cmos5l_dlhq_1
X_3192_ _3192_/Q FrameData[14] FrameStrobe[6] VPWR VGND sg13cmos5l_dlhq_1
XFILLER_19_393 VPWR VGND sg13cmos5l_decap_4
X_2074_ _2075_/C _2071_/Y _2072_/Y _2073_/X _2083_/A _2080_/A VPWR VGND sg13cmos5l_a221oi_1
X_1858_ _1858_/Y _1505_/Y _1853_/Y _1856_/Y _1857_/Y _3293_/Q VPWR VGND sg13cmos5l_a221oi_1
X_1927_ _1927_/Y _2919_/Q _2116_/Y _1926_/Y VPWR VGND sg13cmos5l_a21oi_1
X_2976_ _2976_/Q _2976_/CLK _2976_/D _3430_/L_HI VPWR VGND sg13cmos5l_dfrbpq_1
X_1789_ _1789_/X _2915_/Q _2911_/Q _2883_/Q _2879_/Q _2052_/A _2051_/A VPWR VGND sg13cmos5l_mux4_1
X_3528_ _3528_/L_HI VPWR VGND sg13cmos5l_tiehi
X_3459_ _3459_/L_HI VPWR VGND sg13cmos5l_tiehi
XFILLER_25_385 VPWR VGND sg13cmos5l_fill_1
XFILLER_20_61 VPWR VGND sg13cmos5l_fill_1
XFILLER_0_473 VPWR VGND sg13cmos5l_fill_2
XFILLER_35_149 VPWR VGND sg13cmos5l_fill_1
X_2830_ _2964_/D _2660_/X _2964_/Q _2833_/S VPWR VGND sg13cmos5l_mux2_1
XANTENNA_1 E2MID[0] VPWR VGND sg13cmos5l_antennanp
X_1643_ _2484_/B _1643_/A VPWR VGND sg13cmos5l_inv_1
X_1712_ _1712_/Y _1712_/A VPWR VGND sg13cmos5l_inv_1
X_2761_ _2913_/D _2663_/X _2913_/Q _2763_/S VPWR VGND sg13cmos5l_mux2_1
X_2692_ _2696_/S _2705_/A _2845_/A VPWR VGND sg13cmos5l_nand2_1
X_1574_ _1575_/B _2426_/B _2620_/B _3360_/Q VPWR VGND sg13cmos5l_mux2_1
X_3313_ _3313_/Q FrameData[7] FrameStrobe[2] VPWR VGND sg13cmos5l_dlhq_1
X_3244_ _3244_/Q FrameData[2] FrameStrobe[4] VPWR VGND sg13cmos5l_dlhq_1
X_2057_ _3406_/D _2033_/Y _2039_/Y _2056_/X VPWR VGND sg13cmos5l_o21ai_1
X_2126_ _2127_/B N1END[0] S2END[2] N2END[2] S4END[2] _3344_/Q _3342_/Q VPWR VGND sg13cmos5l_mux4_1
X_3175_ _3175_/Q FrameData[29] FrameStrobe[7] VPWR VGND sg13cmos5l_dlhq_1
XFILLER_22_377 VPWR VGND sg13cmos5l_fill_1
X_2959_ _2959_/Q _2977_/CLK _2959_/D _3447_/L_HI VPWR VGND sg13cmos5l_dfrbpq_1
XFILLER_48_296 VPWR VGND sg13cmos5l_fill_2
X_2813_ _2952_/D _2660_/X _2952_/Q _2816_/S VPWR VGND sg13cmos5l_mux2_1
X_1626_ _1626_/X W1END[2] _1912_/B _2058_/X _2029_/X _3296_/Q _3294_/Q VPWR VGND sg13cmos5l_mux4_1
X_3793_ WW4BEG[10] WW4END[14] VPWR VGND sg13cmos5l_buf_1
X_2744_ _2900_/D _2900_/Q _2660_/X _2747_/S VPWR VGND sg13cmos5l_mux2_1
X_2675_ _2675_/X _2675_/A _2675_/B VPWR VGND sg13cmos5l_and2_1
X_1488_ _1488_/Y _3327_/Q VPWR VGND sg13cmos5l_inv_1
X_1557_ _1557_/Y _3265_/Q _1557_/B VPWR VGND sg13cmos5l_nand2b_1
X_3227_ _3227_/Q FrameData[17] FrameStrobe[5] VPWR VGND sg13cmos5l_dlhq_1
XFILLER_39_263 VPWR VGND sg13cmos5l_fill_2
X_2109_ _2110_/A _3135_/Q _2108_/A _3136_/Q VPWR VGND sg13cmos5l_o21ai_1
X_3158_ _3158_/Q FrameData[12] FrameStrobe[7] VPWR VGND sg13cmos5l_dlhq_1
X_3089_ _3089_/Q FrameData[7] FrameStrobe[9] VPWR VGND sg13cmos5l_dlhq_1
XANTENNA__3723__X E6BEG[5] VPWR VGND sg13cmos5l_antennanp
XFILLER_13_141 VPWR VGND sg13cmos5l_fill_1
XFILLER_26_491 VPWR VGND sg13cmos5l_fill_1
X_2460_ _2461_/B _1912_/B _1980_/X _3244_/Q VPWR VGND sg13cmos5l_mux2_1
XANTENNA__3633__X FrameData_O[15] VPWR VGND sg13cmos5l_antennanp
XFILLER_3_86 VPWR VGND sg13cmos5l_fill_2
X_2391_ _2391_/X N2END[6] E2END[6] SS4END[3] W2END[6] _3210_/Q _3211_/Q VPWR VGND
+ sg13cmos5l_mux4_1
XFILLER_24_439 VPWR VGND sg13cmos5l_fill_1
XFILLER_36_211 VPWR VGND sg13cmos5l_decap_8
X_3012_ _3012_/Q FrameData[26] FrameStrobe[12] VPWR VGND sg13cmos5l_dlhq_1
X_3776_ W6BEG[5] W6END[7] VPWR VGND sg13cmos5l_buf_1
X_1609_ _1609_/Y _1609_/A _3350_/Q VPWR VGND sg13cmos5l_nor2b_1
X_2727_ _2888_/D _2660_/X _2888_/Q _2730_/S VPWR VGND sg13cmos5l_mux2_1
X_2658_ _2658_/X N2MID[7] E2MID[7] S2MID[7] W2MID[7] _3178_/Q _3179_/Q VPWR VGND sg13cmos5l_mux4_1
X_2589_ _2589_/Y _3336_/Q _1513_/Y _2588_/Y VPWR VGND sg13cmos5l_o21ai_1
XFILLER_15_428 VPWR VGND sg13cmos5l_fill_2
XFILLER_42_269 VPWR VGND sg13cmos5l_fill_1
XANTENNA__3718__X E6BEG[0] VPWR VGND sg13cmos5l_antennanp
XFILLER_10_111 VPWR VGND sg13cmos5l_fill_1
XFILLER_18_277 VPWR VGND sg13cmos5l_fill_2
XANTENNA__3628__X FrameData_O[10] VPWR VGND sg13cmos5l_antennanp
X_1891_ _3658_/A _1884_/Y _1886_/Y _1888_/Y _1890_/Y VPWR VGND sg13cmos5l_a22oi_1
X_1960_ _1960_/X E2MID[2] S2MID[2] W2MID[2] _3741_/A _3148_/Q _3149_/Q VPWR VGND sg13cmos5l_mux4_1
X_3630_ FrameData_O[12] FrameData[12] VPWR VGND sg13cmos5l_buf_1
X_3492_ _3492_/L_HI VPWR VGND sg13cmos5l_tiehi
X_3561_ N2BEGb[3] N2MID[3] VPWR VGND sg13cmos5l_buf_1
X_2512_ _3579_/A N2END[3] N4END[2] E6END[0] _2087_/X _3000_/Q _3001_/Q VPWR VGND sg13cmos5l_mux4_1
X_2443_ _2443_/Y _3242_/Q E1END[3] VPWR VGND sg13cmos5l_nand2b_1
X_2374_ _2374_/Y _3042_/Q _1919_/B _2373_/Y VPWR VGND sg13cmos5l_a21oi_1
X_3759_ W2BEG[4] _3759_/A VPWR VGND sg13cmos5l_buf_1
X_2090_ _2090_/X NN4END[3] E1END[1] S2END[5] W1END[1] _3258_/Q _3260_/Q VPWR VGND
+ sg13cmos5l_mux4_1
XFILLER_0_76 VPWR VGND sg13cmos5l_fill_1
X_2992_ _2992_/Q FrameData[6] FrameStrobe[12] VPWR VGND sg13cmos5l_dlhq_1
X_1874_ _1874_/X _3138_/Q _1874_/B VPWR VGND sg13cmos5l_and2_1
X_1943_ _1943_/X W1END[3] _1912_/B _2058_/X _2029_/X _3268_/Q _3266_/Q VPWR VGND sg13cmos5l_mux4_1
X_3613_ FrameStrobe_O[15] FrameStrobe[15] VPWR VGND sg13cmos5l_buf_1
X_3544_ _3544_/L_HI VPWR VGND sg13cmos5l_tiehi
Xclkbuf_0_UserCLK clkbuf_0_UserCLK/X UserCLK VPWR VGND sg13cmos5l_buf_8
X_3475_ _3475_/L_HI VPWR VGND sg13cmos5l_tiehi
X_2426_ _2426_/Y _3252_/Q _2426_/B VPWR VGND sg13cmos5l_nor2_1
X_2288_ _2288_/Y _1507_/Y _2287_/X _3315_/Q VPWR VGND sg13cmos5l_o21ai_1
X_2357_ _2357_/X E1END[2] _2426_/B _3063_/Q VPWR VGND sg13cmos5l_mux2_1
XFILLER_20_283 VPWR VGND sg13cmos5l_decap_8
XANTENNA__3731__X E2BEGb[1] VPWR VGND sg13cmos5l_antennanp
XFILLER_18_94 VPWR VGND sg13cmos5l_fill_2
XFILLER_28_383 VPWR VGND sg13cmos5l_fill_1
XFILLER_11_283 VPWR VGND sg13cmos5l_fill_1
XFILLER_7_265 VPWR VGND sg13cmos5l_fill_2
XFILLER_3_493 VPWR VGND sg13cmos5l_fill_2
X_1590_ _1592_/B E2MID[1] _3200_/Q VPWR VGND sg13cmos5l_nor2b_1
X_3260_ _3260_/Q FrameData[18] FrameStrobe[4] VPWR VGND sg13cmos5l_dlhq_1
XANTENNA__3641__X FrameData_O[23] VPWR VGND sg13cmos5l_antennanp
X_2073_ _2073_/X _2873_/Q _2905_/Q _2869_/Q _2901_/Q _2071_/A _2116_/Y VPWR VGND sg13cmos5l_mux4_1
X_2142_ _2142_/Y _3310_/Q _2138_/Y _2141_/Y VPWR VGND sg13cmos5l_a21oi_1
X_2211_ _2211_/X N1END[3] E2END[1] N2END[1] E6END[1] _3276_/Q _3274_/Q VPWR VGND sg13cmos5l_mux4_1
X_3191_ _3191_/Q FrameData[13] FrameStrobe[6] VPWR VGND sg13cmos5l_dlhq_1
XFILLER_46_180 VPWR VGND sg13cmos5l_fill_2
X_2975_ _2975_/Q _2977_/CLK _2975_/D _3431_/L_HI VPWR VGND sg13cmos5l_dfrbpq_1
X_1788_ _1788_/X _2923_/Q _2919_/Q _2891_/Q _2887_/Q _2052_/A _2051_/A VPWR VGND sg13cmos5l_mux4_1
X_1857_ _1857_/Y _3292_/Q _1854_/X _1505_/Y VPWR VGND sg13cmos5l_a21oi_1
X_1926_ _1926_/Y _2116_/Y _2923_/Q VPWR VGND sg13cmos5l_nor2b_1
X_3527_ _3527_/L_HI VPWR VGND sg13cmos5l_tiehi
XANTENNA__3551__X N2BEG[1] VPWR VGND sg13cmos5l_antennanp
X_3458_ _3458_/L_HI VPWR VGND sg13cmos5l_tiehi
X_3389_ _3389_/Q FrameData[19] FrameStrobe[0] VPWR VGND sg13cmos5l_dlhq_1
X_2409_ _2410_/B _2646_/B _1515_/B _3029_/Q VPWR VGND sg13cmos5l_mux2_1
XANTENNA__3726__X E6BEG[8] VPWR VGND sg13cmos5l_antennanp
XFILLER_16_397 VPWR VGND sg13cmos5l_fill_1
XFILLER_43_161 VPWR VGND sg13cmos5l_fill_1
XANTENNA_2 E2MID[0] VPWR VGND sg13cmos5l_antennanp
XANTENNA__3636__X FrameData_O[18] VPWR VGND sg13cmos5l_antennanp
X_1642_ _1643_/A N2MID[3] E2MID[3] S2MID[3] W2MID[3] _3196_/Q _3197_/Q VPWR VGND sg13cmos5l_mux4_1
X_1711_ _1712_/A N2END[0] S2END[0] EE4END[1] W2END[0] _3225_/Q _3224_/Q VPWR VGND
+ sg13cmos5l_mux4_1
X_2760_ _2912_/D _2660_/X _2912_/Q _2763_/S VPWR VGND sg13cmos5l_mux2_1
X_2691_ _2845_/A _2691_/A _2698_/A VPWR VGND sg13cmos5l_nor2b_1
X_1573_ _1573_/Y _1571_/Y _1572_/Y _3361_/Q VPWR VGND sg13cmos5l_a21oi_1
X_3312_ _3312_/Q FrameData[6] FrameStrobe[2] VPWR VGND sg13cmos5l_dlhq_1
X_3243_ _3243_/Q FrameData[1] FrameStrobe[4] VPWR VGND sg13cmos5l_dlhq_1
XFILLER_13_0 VPWR VGND sg13cmos5l_fill_1
X_2056_ _2056_/X _2056_/A _2056_/B _2056_/C VPWR VGND sg13cmos5l_or3_1
X_2125_ _2125_/Y _2125_/A _3345_/Q VPWR VGND sg13cmos5l_nor2b_1
X_3174_ _3174_/Q FrameData[28] FrameStrobe[7] VPWR VGND sg13cmos5l_dlhq_1
X_1909_ _1909_/Y _3330_/Q _1905_/X _1906_/Y _1908_/Y _3333_/Q VPWR VGND sg13cmos5l_a221oi_1
X_2958_ _2958_/Q _2962_/CLK _2958_/D _3448_/L_HI VPWR VGND sg13cmos5l_dfrbpq_1
XANTENNA__3546__X N1BEG[0] VPWR VGND sg13cmos5l_antennanp
X_2889_ _2889_/Q _2922_/CLK _2889_/D _3517_/L_HI VPWR VGND sg13cmos5l_dfrbpq_1
XFILLER_13_323 VPWR VGND sg13cmos5l_decap_4
XFILLER_15_73 VPWR VGND sg13cmos5l_fill_1
XFILLER_36_448 VPWR VGND sg13cmos5l_fill_1
XFILLER_44_492 VPWR VGND sg13cmos5l_fill_2
X_3792_ WW4BEG[9] WW4END[13] VPWR VGND sg13cmos5l_buf_1
X_2812_ _2816_/S _2855_/A _2812_/B VPWR VGND sg13cmos5l_nand2_1
X_2743_ _2747_/S _2850_/A _2748_/B VPWR VGND sg13cmos5l_and2_1
X_1556_ _1557_/B _1553_/X _1555_/X _1552_/X _1554_/X _3263_/Q _3264_/Q VPWR VGND sg13cmos5l_mux4_1
X_1625_ _1625_/X _2921_/Q _2917_/Q _2052_/A VPWR VGND sg13cmos5l_mux2_1
X_2674_ _2675_/B _3107_/Q _2674_/B _2674_/C VPWR VGND sg13cmos5l_nand3_1
XFILLER_27_404 VPWR VGND sg13cmos5l_fill_1
X_1487_ _1487_/Y _3329_/Q VPWR VGND sg13cmos5l_inv_1
X_3226_ _3226_/Q FrameData[16] FrameStrobe[5] VPWR VGND sg13cmos5l_dlhq_1
X_3157_ _3157_/Q FrameData[11] FrameStrobe[7] VPWR VGND sg13cmos5l_dlhq_1
XFILLER_36_39 VPWR VGND sg13cmos5l_fill_2
X_2039_ _2039_/Y _1706_/Y _2038_/X _2056_/A VPWR VGND sg13cmos5l_o21ai_1
X_2108_ _2108_/Y _2108_/A VPWR VGND sg13cmos5l_inv_1
X_3088_ _3088_/Q FrameData[6] FrameStrobe[9] VPWR VGND sg13cmos5l_dlhq_1
XFILLER_7_5 VPWR VGND sg13cmos5l_fill_1
XFILLER_5_352 VPWR VGND sg13cmos5l_fill_2
X_3011_ _3011_/Q FrameData[25] FrameStrobe[12] VPWR VGND sg13cmos5l_dlhq_1
X_2390_ _2390_/Y _3035_/Q _2029_/X _2389_/Y VPWR VGND sg13cmos5l_o21ai_1
XFILLER_51_204 VPWR VGND sg13cmos5l_fill_1
X_3775_ W6BEG[4] W6END[6] VPWR VGND sg13cmos5l_buf_1
X_2726_ _2730_/S _2855_/A _2726_/B VPWR VGND sg13cmos5l_nand2_1
X_1539_ _1539_/Y _3386_/Q _1537_/Y _1538_/Y VPWR VGND sg13cmos5l_a21oi_1
X_1608_ _1609_/A _2058_/X _2087_/X _3352_/Q VPWR VGND sg13cmos5l_mux2_1
X_2657_ _2690_/S _2840_/A _2705_/A VPWR VGND sg13cmos5l_and2_1
X_2588_ _2588_/Y _3336_/Q _2620_/B VPWR VGND sg13cmos5l_nand2_1
X_3209_ _3209_/Q FrameData[31] FrameStrobe[6] VPWR VGND sg13cmos5l_dlhq_1
XFILLER_42_226 VPWR VGND sg13cmos5l_fill_2
XANTENNA__3734__X E2BEGb[4] VPWR VGND sg13cmos5l_antennanp
XFILLER_10_178 VPWR VGND sg13cmos5l_fill_1
XFILLER_12_96 VPWR VGND sg13cmos5l_fill_2
XFILLER_6_105 VPWR VGND sg13cmos5l_fill_1
XFILLER_2_399 VPWR VGND sg13cmos5l_fill_1
XFILLER_18_289 VPWR VGND sg13cmos5l_fill_1
XFILLER_33_237 VPWR VGND sg13cmos5l_fill_1
X_1890_ _1890_/Y _3323_/Q _1889_/X _3325_/Q VPWR VGND sg13cmos5l_a21oi_1
X_3560_ N2BEGb[2] N2MID[2] VPWR VGND sg13cmos5l_buf_1
XANTENNA__3644__X FrameData_O[26] VPWR VGND sg13cmos5l_antennanp
X_3491_ _3491_/L_HI VPWR VGND sg13cmos5l_tiehi
X_2511_ _3580_/A N2END[0] W6END[1] N4END[3] _2620_/B _3003_/Q _3002_/Q VPWR VGND sg13cmos5l_mux4_1
X_2442_ _2442_/Y E2END[1] _3242_/Q VPWR VGND sg13cmos5l_nand2_1
X_2373_ _2373_/Y _3042_/Q _1702_/X VPWR VGND sg13cmos5l_nor2b_1
XANTENNA__3554__X N2BEG[4] VPWR VGND sg13cmos5l_antennanp
XFILLER_20_465 VPWR VGND sg13cmos5l_fill_2
X_3689_ EE4BEG[3] EE4END[7] VPWR VGND sg13cmos5l_buf_1
X_3758_ W2BEG[3] _3758_/A VPWR VGND sg13cmos5l_buf_1
X_2709_ _2875_/D _2689_/Y _2875_/Q _2709_/S VPWR VGND sg13cmos5l_mux2_1
XANTENNA__3729__X E6BEG[11] VPWR VGND sg13cmos5l_antennanp
XFILLER_11_498 VPWR VGND sg13cmos5l_fill_1
XANTENNA__3639__X FrameData_O[21] VPWR VGND sg13cmos5l_antennanp
XFILLER_46_373 VPWR VGND sg13cmos5l_fill_1
X_1942_ _1942_/Y _3267_/Q _1942_/B VPWR VGND sg13cmos5l_nand2_1
X_2991_ _2991_/Q FrameData[5] FrameStrobe[12] VPWR VGND sg13cmos5l_dlhq_1
X_1873_ _1874_/B _3137_/Q _1873_/B VPWR VGND sg13cmos5l_nand2b_1
X_3543_ _3543_/L_HI VPWR VGND sg13cmos5l_tiehi
X_3612_ FrameStrobe_O[14] FrameStrobe[14] VPWR VGND sg13cmos5l_buf_1
XFILLER_43_0 VPWR VGND sg13cmos5l_fill_2
X_3474_ _3474_/L_HI VPWR VGND sg13cmos5l_tiehi
X_2425_ _2425_/Y _3252_/Q _1912_/B _2424_/Y VPWR VGND sg13cmos5l_o21ai_1
X_2356_ _2356_/Y N1END[2] _3063_/Q _2355_/Y VPWR VGND sg13cmos5l_o21ai_1
XFILLER_52_332 VPWR VGND sg13cmos5l_fill_1
X_2287_ _2287_/X EE4END[2] W2END[3] _3316_/Q VPWR VGND sg13cmos5l_mux2_1
XANTENNA__3549__X N1BEG[3] VPWR VGND sg13cmos5l_antennanp
XFILLER_18_51 VPWR VGND sg13cmos5l_fill_2
X_2210_ _2212_/B _3274_/Q _2206_/X _2209_/Y VPWR VGND sg13cmos5l_a21oi_1
X_3190_ _3190_/Q FrameData[12] FrameStrobe[6] VPWR VGND sg13cmos5l_dlhq_1
XFILLER_46_170 VPWR VGND sg13cmos5l_fill_1
XFILLER_46_192 VPWR VGND sg13cmos5l_fill_2
X_2072_ _2072_/Y _2014_/A _2068_/Y _2083_/A VPWR VGND sg13cmos5l_a21oi_1
X_2141_ _2141_/Y _3310_/Q _2140_/Y _3311_/Q VPWR VGND sg13cmos5l_o21ai_1
XFILLER_34_398 VPWR VGND sg13cmos5l_decap_8
X_1925_ _1925_/Y _2014_/A _1925_/B VPWR VGND sg13cmos5l_nand2_1
X_2974_ _2974_/Q clkload9/A _2974_/D _3432_/L_HI VPWR VGND sg13cmos5l_dfrbpq_1
X_1787_ _2139_/B _2988_/Q _1785_/A _1786_/Y VPWR VGND sg13cmos5l_o21ai_1
X_1856_ _1856_/Y _3292_/Q _1856_/B VPWR VGND sg13cmos5l_nand2b_1
X_3526_ _3526_/L_HI VPWR VGND sg13cmos5l_tiehi
X_3457_ _3457_/L_HI VPWR VGND sg13cmos5l_tiehi
X_3388_ _3388_/Q FrameData[18] FrameStrobe[0] VPWR VGND sg13cmos5l_dlhq_1
X_2408_ _2408_/Y _3029_/Q _2620_/B _2407_/Y VPWR VGND sg13cmos5l_o21ai_1
X_2339_ _2340_/B _3068_/Q _2338_/Y _3070_/Q VPWR VGND sg13cmos5l_o21ai_1
XANTENNA__3742__X E2BEG[4] VPWR VGND sg13cmos5l_antennanp
XFILLER_31_379 VPWR VGND sg13cmos5l_fill_2
XANTENNA_3 E2MID[0] VPWR VGND sg13cmos5l_antennanp
X_1572_ _1572_/Y _3360_/Q _1569_/X _3359_/Q VPWR VGND sg13cmos5l_a21oi_1
X_1641_ _1641_/X N2MID[2] E2MID[2] S2MID[2] _3743_/A _3164_/Q _3165_/Q VPWR VGND sg13cmos5l_mux4_1
X_1710_ _1710_/X _3760_/A _3659_/A _1710_/S VPWR VGND sg13cmos5l_mux2_1
X_3311_ _3311_/Q FrameData[5] FrameStrobe[2] VPWR VGND sg13cmos5l_dlhq_1
X_2690_ _2863_/D _2863_/Q _2689_/Y _2690_/S VPWR VGND sg13cmos5l_mux2_1
XANTENNA__3652__X S1BEG[2] VPWR VGND sg13cmos5l_antennanp
X_2124_ _2125_/A _3342_/Q _2120_/Y _2123_/Y VPWR VGND sg13cmos5l_a21oi_1
X_3242_ _3242_/Q FrameData[0] FrameStrobe[4] VPWR VGND sg13cmos5l_dlhq_1
X_3173_ _3173_/Q FrameData[27] FrameStrobe[7] VPWR VGND sg13cmos5l_dlhq_1
XFILLER_34_173 VPWR VGND sg13cmos5l_fill_1
X_2055_ _2056_/C _1800_/A _2048_/X _2051_/Y _2054_/Y _1706_/Y VPWR VGND sg13cmos5l_a221oi_1
X_1839_ _1839_/X E1END[1] S2END[5] _3356_/Q VPWR VGND sg13cmos5l_mux2_1
X_1908_ _1908_/Y _3330_/Q _1908_/B VPWR VGND sg13cmos5l_nor2_1
Xclkbuf_3_1_0_UserCLK_regs clkbuf_3_1_0_UserCLK_regs/X clkbuf_0_UserCLK_regs/X VPWR
+ VGND sg13cmos5l_buf_8
X_2957_ _2957_/Q clkload5/A _2957_/D _3449_/L_HI VPWR VGND sg13cmos5l_dfrbpq_1
X_2888_ _2888_/Q _2920_/CLK _2888_/D _3518_/L_HI VPWR VGND sg13cmos5l_dfrbpq_1
XANTENNA__3562__X N2BEGb[4] VPWR VGND sg13cmos5l_antennanp
X_3509_ _3509_/L_HI VPWR VGND sg13cmos5l_tiehi
XANTENNA__3737__X E2BEGb[7] VPWR VGND sg13cmos5l_antennanp
XFILLER_31_110 VPWR VGND sg13cmos5l_fill_1
XANTENNA__3647__X FrameData_O[29] VPWR VGND sg13cmos5l_antennanp
XFILLER_8_361 VPWR VGND sg13cmos5l_fill_1
X_3791_ WW4BEG[8] WW4END[12] VPWR VGND sg13cmos5l_buf_1
X_2811_ _2951_/D _2689_/Y _2951_/Q _2811_/S VPWR VGND sg13cmos5l_mux2_1
X_2742_ _2899_/D _2689_/Y _2899_/Q _2742_/S VPWR VGND sg13cmos5l_mux2_1
X_1555_ _1555_/X NN4END[2] E1END[2] _3262_/Q VPWR VGND sg13cmos5l_mux2_1
X_1624_ _2051_/A _1624_/A _1624_/B VPWR VGND sg13cmos5l_nand2_1
X_2673_ _2674_/C _3106_/Q _2673_/B VPWR VGND sg13cmos5l_nand2b_1
XFILLER_39_265 VPWR VGND sg13cmos5l_fill_1
X_1486_ _2432_/A _3251_/Q VPWR VGND sg13cmos5l_inv_1
X_2107_ _2108_/A N2END[7] E2END[7] S2END[7] WW4END[0] _3234_/Q _3235_/Q VPWR VGND
+ sg13cmos5l_mux4_1
X_3225_ _3225_/Q FrameData[15] FrameStrobe[5] VPWR VGND sg13cmos5l_dlhq_1
X_3156_ _3156_/Q FrameData[10] FrameStrobe[7] VPWR VGND sg13cmos5l_dlhq_1
X_3087_ _3087_/Q FrameData[5] FrameStrobe[9] VPWR VGND sg13cmos5l_dlhq_1
X_2038_ _2038_/X _2034_/X _2035_/X _2037_/X _2036_/X _1623_/Y _1793_/S VPWR VGND sg13cmos5l_mux4_1
XANTENNA__3557__X N2BEG[7] VPWR VGND sg13cmos5l_antennanp
XFILLER_3_22 VPWR VGND sg13cmos5l_fill_2
X_3010_ _3010_/Q FrameData[24] FrameStrobe[12] VPWR VGND sg13cmos5l_dlhq_1
Xclkbuf_5_6__f_UserCLK_regs clkload4/A clkbuf_3_1_0_UserCLK_regs/X VPWR VGND sg13cmos5l_buf_8
X_3774_ W6BEG[3] W6END[5] VPWR VGND sg13cmos5l_buf_1
X_2725_ _2887_/D _2887_/Q _2689_/Y _2725_/S VPWR VGND sg13cmos5l_mux2_1
X_2656_ _2705_/A _2817_/A _2817_/B _2818_/A VPWR VGND sg13cmos5l_nor3_1
X_1469_ _1469_/Y S2MID[2] VPWR VGND sg13cmos5l_inv_1
X_1538_ _1538_/Y _3386_/Q W2END[3] _3387_/Q VPWR VGND sg13cmos5l_o21ai_1
X_1607_ _1607_/X W6END[0] _2029_/X _3352_/Q VPWR VGND sg13cmos5l_mux2_1
X_2587_ _2594_/A _3335_/Q _2587_/B VPWR VGND sg13cmos5l_nor2_1
X_3208_ _3208_/Q FrameData[30] FrameStrobe[6] VPWR VGND sg13cmos5l_dlhq_1
X_3139_ _3139_/Q FrameData[25] FrameStrobe[8] VPWR VGND sg13cmos5l_dlhq_1
XANTENNA__3750__X UserCLKo VPWR VGND sg13cmos5l_antennanp
XFILLER_53_60 VPWR VGND sg13cmos5l_fill_1
X_3490_ _3490_/L_HI VPWR VGND sg13cmos5l_tiehi
X_2510_ _3581_/A N2END[1] W6END[0] N4END[0] _1980_/X _3005_/Q _3004_/Q VPWR VGND sg13cmos5l_mux4_1
XFILLER_5_150 VPWR VGND sg13cmos5l_fill_1
X_2441_ _3748_/A _2087_/X _1849_/X _3551_/A _1843_/A _3022_/Q _3023_/Q VPWR VGND sg13cmos5l_mux4_1
X_2372_ _2372_/Y _3043_/Q _2368_/X _2371_/Y VPWR VGND sg13cmos5l_o21ai_1
XANTENNA__3660__X S2BEG[6] VPWR VGND sg13cmos5l_antennanp
XFILLER_17_290 VPWR VGND sg13cmos5l_fill_2
X_3688_ EE4BEG[2] EE4END[6] VPWR VGND sg13cmos5l_buf_1
X_3757_ W2BEG[2] _3757_/A VPWR VGND sg13cmos5l_buf_1
X_2708_ _2874_/D _2675_/X _2874_/Q _2709_/S VPWR VGND sg13cmos5l_mux2_1
X_2639_ _2639_/Y _3385_/Q _2636_/Y _2638_/Y VPWR VGND sg13cmos5l_a21oi_1
XANTENNA__3570__X N4BEG[4] VPWR VGND sg13cmos5l_antennanp
XANTENNA__3745__X E2BEG[7] VPWR VGND sg13cmos5l_antennanp
XFILLER_3_0 VPWR VGND sg13cmos5l_fill_1
XFILLER_48_60 VPWR VGND sg13cmos5l_fill_2
X_1872_ _1872_/Y _1873_/B VPWR VGND sg13cmos5l_inv_1
X_1941_ _1942_/B _1941_/A VPWR VGND sg13cmos5l_inv_1
X_2990_ _2990_/Q FrameData[4] FrameStrobe[12] VPWR VGND sg13cmos5l_dlhq_1
XANTENNA__3655__X S2BEG[1] VPWR VGND sg13cmos5l_antennanp
X_3542_ _3542_/L_HI VPWR VGND sg13cmos5l_tiehi
X_3611_ FrameStrobe_O[13] FrameStrobe[13] VPWR VGND sg13cmos5l_buf_1
X_3473_ _3473_/L_HI VPWR VGND sg13cmos5l_tiehi
XFILLER_36_0 VPWR VGND sg13cmos5l_fill_1
X_2286_ _2286_/Y E2END[3] _3316_/Q _2285_/Y VPWR VGND sg13cmos5l_o21ai_1
X_2424_ _2424_/Y _1980_/X _3252_/Q VPWR VGND sg13cmos5l_nand2b_1
X_2355_ _2355_/Y _1460_/Y _3063_/Q _3062_/Q VPWR VGND sg13cmos5l_a21oi_1
XANTENNA__3565__X N2BEGb[7] VPWR VGND sg13cmos5l_antennanp
XFILLER_20_263 VPWR VGND sg13cmos5l_fill_2
XFILLER_7_267 VPWR VGND sg13cmos5l_fill_1
X_2140_ _2140_/Y _3312_/Q _1512_/Y _2139_/Y VPWR VGND sg13cmos5l_a21oi_1
X_2071_ _2071_/Y _2071_/A _2071_/B VPWR VGND sg13cmos5l_nand2_1
X_1855_ _1856_/B E1END[1] E2END[5] _3290_/Q VPWR VGND sg13cmos5l_mux2_1
X_1924_ _1925_/B _2887_/Q _2116_/Y _1923_/Y VPWR VGND sg13cmos5l_a21oi_1
X_2973_ _2973_/Q _2977_/CLK _2973_/D _3433_/L_HI VPWR VGND sg13cmos5l_dfrbpq_1
X_1786_ _1786_/Y _2988_/Q _3408_/Q VPWR VGND sg13cmos5l_nand2_1
X_3525_ _3525_/L_HI VPWR VGND sg13cmos5l_tiehi
X_3456_ _3456_/L_HI VPWR VGND sg13cmos5l_tiehi
X_2269_ _2269_/Y _3083_/Q _2087_/X VPWR VGND sg13cmos5l_nor2b_1
X_3387_ _3387_/Q FrameData[17] FrameStrobe[0] VPWR VGND sg13cmos5l_dlhq_1
X_2407_ _2407_/Y _3029_/Q _2495_/B VPWR VGND sg13cmos5l_nand2_1
X_2338_ _2338_/Y _3069_/Q _1849_/X _2337_/Y VPWR VGND sg13cmos5l_a21oi_1
XFILLER_37_182 VPWR VGND sg13cmos5l_fill_2
XFILLER_40_336 VPWR VGND sg13cmos5l_fill_1
XFILLER_16_366 VPWR VGND sg13cmos5l_fill_2
XFILLER_31_303 VPWR VGND sg13cmos5l_fill_1
XFILLER_31_325 VPWR VGND sg13cmos5l_fill_2
XANTENNA_4 E2MID[0] VPWR VGND sg13cmos5l_antennanp
X_1571_ _1571_/Y _3360_/Q _1571_/B VPWR VGND sg13cmos5l_nand2b_1
X_1640_ _3743_/A _1631_/X _1632_/Y _1637_/X _1639_/Y VPWR VGND sg13cmos5l_a22oi_1
X_3310_ _3310_/Q FrameData[4] FrameStrobe[2] VPWR VGND sg13cmos5l_dlhq_1
XFILLER_54_417 VPWR VGND sg13cmos5l_fill_2
X_2123_ _2123_/Y _3342_/Q _2122_/Y _3343_/Q VPWR VGND sg13cmos5l_o21ai_1
X_3241_ _3241_/Q FrameData[31] FrameStrobe[5] VPWR VGND sg13cmos5l_dlhq_1
X_3172_ _3172_/Q FrameData[26] FrameStrobe[7] VPWR VGND sg13cmos5l_dlhq_1
XFILLER_22_314 VPWR VGND sg13cmos5l_fill_2
X_2054_ _2054_/Y _1623_/Y _2053_/Y _1800_/A VPWR VGND sg13cmos5l_a21oi_1
X_1838_ _1838_/X E2END[5] W1END[1] _3356_/Q VPWR VGND sg13cmos5l_mux2_1
X_1907_ _1908_/B N1END[3] _3332_/Q VPWR VGND sg13cmos5l_nor2_1
X_2956_ _2956_/Q clkload5/A _2956_/D _3450_/L_HI VPWR VGND sg13cmos5l_dfrbpq_1
X_2887_ _2887_/Q _2923_/CLK _2887_/D _3519_/L_HI VPWR VGND sg13cmos5l_dfrbpq_1
X_1769_ _1769_/X _1793_/S _1768_/X _1767_/Y VPWR VGND sg13cmos5l_a21o_1
X_3508_ _3508_/L_HI VPWR VGND sg13cmos5l_tiehi
X_3439_ _3439_/L_HI VPWR VGND sg13cmos5l_tiehi
XFILLER_13_358 VPWR VGND sg13cmos5l_fill_1
XFILLER_25_174 VPWR VGND sg13cmos5l_decap_8
XANTENNA__3753__X W1BEG[2] VPWR VGND sg13cmos5l_antennanp
XFILLER_31_100 VPWR VGND sg13cmos5l_fill_2
XFILLER_12_391 VPWR VGND sg13cmos5l_fill_1
X_3790_ WW4BEG[7] WW4END[11] VPWR VGND sg13cmos5l_buf_1
X_2810_ _2950_/D _2675_/X _2950_/Q _2811_/S VPWR VGND sg13cmos5l_mux2_1
X_2741_ _2898_/D _2675_/X _2898_/Q _2742_/S VPWR VGND sg13cmos5l_mux2_1
X_2672_ _2674_/B _3106_/Q _2672_/B _2672_/C VPWR VGND sg13cmos5l_nand3_1
XANTENNA__3663__X S2BEGb[1] VPWR VGND sg13cmos5l_antennanp
X_1485_ _1485_/Y _3331_/Q VPWR VGND sg13cmos5l_inv_1
X_1554_ _1554_/X S2END[6] W1END[0] _3262_/Q VPWR VGND sg13cmos5l_mux2_1
X_1623_ _1623_/Y _1766_/A _1766_/B VPWR VGND sg13cmos5l_nor2_1
X_3224_ _3224_/Q FrameData[14] FrameStrobe[5] VPWR VGND sg13cmos5l_dlhq_1
.ends
